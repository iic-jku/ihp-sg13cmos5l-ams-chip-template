* PEX produced on Mon Aug 24 05:09:38 PM CEST 2026 using /foss/tools/sak/sak-pex.sh with m=3 and s=1 (extresist threshold=10000 mOhm, minres=1000 mOhm, mindelay=1 ps)
* NGSPICE file created from inverter_pex.ext - technology: ihp-sg13cmos5l

.subckt inverter_pex VDD vin vout VSS
X0 vout vin VDD VDD sg13_lv_pmos ad=1.14p pd=6.38u as=1.14p ps=6.38u w=6u l=1u
X1 VDD vin vout VDD sg13_lv_pmos ad=1.14p pd=6.38u as=1.14p ps=6.38u w=6u l=1u
X2 vout vin VDD VDD sg13_lv_pmos ad=1.14p pd=6.38u as=1.14p ps=6.38u w=6u l=1u
X3 vout vin VSS.t15 VSS.t16 sg13_lv_nmos ad=0.19p pd=1.38u as=0.19p ps=1.38u w=1u l=1u
X4 vout vin VSS.t1 VSS.t0 sg13_lv_nmos ad=0.19p pd=1.38u as=0.19p ps=1.38u w=1u l=1u
X5 VSS.t33 VSS.t31 VSS.t1 VSS.t32 sg13_lv_nmos ad=0.34p pd=2.68u as=0 ps=0 w=1u l=1u
X6 VSS.t24 vin vout VSS.t23 sg13_lv_nmos ad=0.19p pd=1.38u as=0.19p ps=1.38u w=1u l=1u
X7 vout vin VDD VDD sg13_lv_pmos ad=1.14p pd=6.38u as=1.14p ps=6.38u w=6u l=1u
X8 VDD vin vout VDD sg13_lv_pmos ad=1.14p pd=6.38u as=1.14p ps=6.38u w=6u l=1u
X9 vout vin VSS.t21 VSS.t22 sg13_lv_nmos ad=0.19p pd=1.38u as=0.19p ps=1.38u w=1u l=1u
X10 vout vin VDD VDD sg13_lv_pmos ad=1.14p pd=6.38u as=1.14p ps=6.38u w=6u l=1u
X11 VSS.t9 vin vout VSS.t8 sg13_lv_nmos ad=0.19p pd=1.38u as=0.19p ps=1.38u w=1u l=1u
X12 VSS.t30 vin vout VSS.t29 sg13_lv_nmos ad=0.19p pd=1.38u as=0.19p ps=1.38u w=1u l=1u
X13 VDD vin vout VDD sg13_lv_pmos ad=1.14p pd=6.38u as=1.14p ps=6.38u w=6u l=1u
X14 vout vin VDD VDD sg13_lv_pmos ad=1.14p pd=6.38u as=1.14p ps=6.38u w=6u l=1u
X15 VDD vin vout VDD sg13_lv_pmos ad=1.14p pd=6.38u as=1.14p ps=6.38u w=6u l=1u
X16 vout vin VDD VDD sg13_lv_pmos ad=1.14p pd=6.38u as=1.14p ps=6.38u w=6u l=1u
X17 vout vin VSS.t27 VSS.t28 sg13_lv_nmos ad=0.19p pd=1.38u as=0.19p ps=1.38u w=1u l=1u
X18 VSS.t15 vin vout VSS.t14 sg13_lv_nmos ad=0.19p pd=1.38u as=0.19p ps=1.38u w=1u l=1u
X19 VDD vin vout VDD sg13_lv_pmos ad=1.14p pd=6.38u as=1.14p ps=6.38u w=6u l=1u
X20 vout vin VDD VDD sg13_lv_pmos ad=1.14p pd=6.38u as=1.14p ps=6.38u w=6u l=1u
X21 VDD VDD VDD VDD sg13_lv_pmos ad=2.04p pd=12.68u as=0.14199n ps=0.28418m w=6u l=1u
X22 vout vin VSS.t6 VSS.t7 sg13_lv_nmos ad=0.19p pd=1.38u as=0.19p ps=1.38u w=1u l=1u
X23 VSS.t21 vin vout VSS.t20 sg13_lv_nmos ad=0.19p pd=1.38u as=0.19p ps=1.38u w=1u l=1u
X24 VDD vin vout VDD sg13_lv_pmos ad=1.14p pd=6.38u as=1.14p ps=6.38u w=6u l=1u
X25 VDD vin vout VDD sg13_lv_pmos ad=1.14p pd=6.38u as=1.14p ps=6.38u w=6u l=1u
X26 VSS.t6 vin vout VSS.t5 sg13_lv_nmos ad=0.19p pd=1.38u as=0.19p ps=1.38u w=1u l=1u
X27 vout vin VDD VDD sg13_lv_pmos ad=1.14p pd=6.38u as=1.14p ps=6.38u w=6u l=1u
X28 VSS.t3 vin vout VSS.t2 sg13_lv_nmos ad=0.19p pd=1.38u as=0.19p ps=1.38u w=1u l=1u
X29 vout vin VSS.t12 VSS.t13 sg13_lv_nmos ad=0.19p pd=1.38u as=0.19p ps=1.38u w=1u l=1u
X30 VSS.t27 vin vout VSS.t26 sg13_lv_nmos ad=0.19p pd=1.38u as=0.19p ps=1.38u w=1u l=1u
X31 vout vin VSS.t3 VSS.t4 sg13_lv_nmos ad=0.19p pd=1.38u as=0.19p ps=1.38u w=1u l=1u
X32 VDD vin vout VDD sg13_lv_pmos ad=1.14p pd=6.38u as=1.14p ps=6.38u w=6u l=1u
X33 vout vin VSS.t24 VSS.t25 sg13_lv_nmos ad=0.19p pd=1.38u as=0.19p ps=1.38u w=1u l=1u
X34 vout vin VDD VDD sg13_lv_pmos ad=1.14p pd=6.38u as=1.14p ps=6.38u w=6u l=1u
X35 VSS.t12 vin vout VSS.t11 sg13_lv_nmos ad=0.19p pd=1.38u as=0.19p ps=1.38u w=1u l=1u
X36 VDD vin vout VDD sg13_lv_pmos ad=1.14p pd=6.38u as=1.14p ps=6.38u w=6u l=1u
X37 VDD VDD VDD VDD sg13_lv_pmos ad=1.14p pd=6.38u as=0 ps=0 w=6u l=1u
X38 VDD vin vout VDD sg13_lv_pmos ad=1.14p pd=6.38u as=1.14p ps=6.38u w=6u l=1u
X39 vout vin VSS.t9 VSS.t10 sg13_lv_nmos ad=0.19p pd=1.38u as=0.19p ps=1.38u w=1u l=1u
X40 vout vin VSS.t18 VSS.t19 sg13_lv_nmos ad=0.19p pd=1.38u as=0.19p ps=1.38u w=1u l=1u
X41 vout vin VDD VDD sg13_lv_pmos ad=1.14p pd=6.38u as=1.14p ps=6.38u w=6u l=1u
X42 VSS.t18 vin vout VSS.t17 sg13_lv_nmos ad=0.19p pd=1.38u as=0.19p ps=1.38u w=1u l=1u
X43 VSS.t30 VSS.t34 VSS.t36 VSS.t35 sg13_lv_nmos ad=0.19p pd=1.38u as=0 ps=0 w=1u l=1u
R0 VSS.t0 VSS.n90 177.45
R1 VSS.n121 VSS.t29 177.45
R2 VSS.t2 VSS.n89 166.359
R3 VSS.n119 VSS.t28 166.359
R4 VSS.t4 VSS.n87 155.268
R5 VSS.n117 VSS.t26 155.268
R6 VSS.t5 VSS.n85 144.178
R7 VSS.n116 VSS.t25 144.178
R8 VSS.t7 VSS.n83 133.088
R9 VSS.n114 VSS.t23 133.088
R10 VSS.t8 VSS.n81 121.996
R11 VSS.n112 VSS.t22 121.996
R12 VSS.t10 VSS.n79 110.906
R13 VSS.n103 VSS.t14 110.906
R14 VSS.t16 VSS.n71 110.906
R15 VSS.n110 VSS.t20 110.906
R16 VSS.t11 VSS.n77 99.8157
R17 VSS.n102 VSS.t13 99.8157
R18 VSS.t17 VSS.n70 99.8157
R19 VSS.n108 VSS.t19 99.8157
R20 VSS.n101 VSS.t11 88.7251
R21 VSS.t13 VSS.n75 88.7251
R22 VSS.n106 VSS.t17 88.7251
R23 VSS.t19 VSS.n69 88.7251
R24 VSS.n100 VSS.t10 77.6345
R25 VSS.t14 VSS.n73 77.6345
R26 VSS.n104 VSS.t16 77.6345
R27 VSS.t20 VSS.n68 77.6345
R28 VSS.n99 VSS.t8 66.5439
R29 VSS.t22 VSS.n67 66.5439
R30 VSS.n98 VSS.t7 55.4534
R31 VSS.t23 VSS.n66 55.4534
R32 VSS.n97 VSS.t5 44.3628
R33 VSS.t25 VSS.n65 44.3628
R34 VSS.n96 VSS.t4 33.2722
R35 VSS.t26 VSS.n63 33.2722
R36 VSS.n72 VSS.n38 29.2386
R37 VSS.n72 VSS.n39 29.2386
R38 VSS.n64 VSS.n52 28.8069
R39 VSS.n74 VSS.n36 28.8069
R40 VSS.n76 VSS.n34 28.8069
R41 VSS.n78 VSS.n32 28.8069
R42 VSS.n80 VSS.n30 28.8069
R43 VSS.n82 VSS.n28 28.8069
R44 VSS.n84 VSS.n26 28.8069
R45 VSS.n86 VSS.n24 28.8069
R46 VSS.n88 VSS.n22 28.8069
R47 VSS.n122 VSS.n59 28.8069
R48 VSS.n91 VSS.n18 28.8069
R49 VSS.n92 VSS.n18 28.8069
R50 VSS.n92 VSS.n19 28.8069
R51 VSS.n94 VSS.n20 28.8069
R52 VSS.n94 VSS.n21 28.8069
R53 VSS.n88 VSS.n23 28.8069
R54 VSS.n86 VSS.n25 28.8069
R55 VSS.n84 VSS.n27 28.8069
R56 VSS.n82 VSS.n29 28.8069
R57 VSS.n80 VSS.n31 28.8069
R58 VSS.n78 VSS.n33 28.8069
R59 VSS.n76 VSS.n35 28.8069
R60 VSS.n74 VSS.n37 28.8069
R61 VSS.n105 VSS.n40 28.8069
R62 VSS.n105 VSS.n41 28.8069
R63 VSS.n107 VSS.n42 28.8069
R64 VSS.n107 VSS.n43 28.8069
R65 VSS.n109 VSS.n44 28.8069
R66 VSS.n109 VSS.n45 28.8069
R67 VSS.n111 VSS.n46 28.8069
R68 VSS.n111 VSS.n47 28.8069
R69 VSS.n113 VSS.n48 28.8069
R70 VSS.n113 VSS.n49 28.8069
R71 VSS.n115 VSS.n50 28.8069
R72 VSS.n115 VSS.n51 28.8069
R73 VSS.n64 VSS.n53 28.8069
R74 VSS.n118 VSS.n54 28.8069
R75 VSS.n118 VSS.n55 28.8069
R76 VSS.n120 VSS.n56 28.8069
R77 VSS.n120 VSS.n57 28.8069
R78 VSS.n61 VSS.n59 28.8069
R79 VSS.n122 VSS.n60 28.8069
R80 VSS.n6 VSS.t35 15.6491
R81 VSS.n95 VSS.t2 22.1816
R82 VSS.t28 VSS.n62 22.1816
R83 VSS.n6 VSS.n121 17.0005
R84 VSS.n6 VSS.n62 17.0005
R85 VSS.n6 VSS.n119 17.0005
R86 VSS.n6 VSS.n63 17.0005
R87 VSS.n6 VSS.n117 17.0005
R88 VSS.n6 VSS.n65 17.0005
R89 VSS.n6 VSS.n116 17.0005
R90 VSS.n6 VSS.n66 17.0005
R91 VSS.n6 VSS.n114 17.0005
R92 VSS.n6 VSS.n67 17.0005
R93 VSS.n6 VSS.n112 17.0005
R94 VSS.n6 VSS.n68 17.0005
R95 VSS.n6 VSS.n110 17.0005
R96 VSS.n6 VSS.n69 17.0005
R97 VSS.n6 VSS.n108 17.0005
R98 VSS.n6 VSS.n70 17.0005
R99 VSS.n6 VSS.n106 17.0005
R100 VSS.n6 VSS.n71 17.0005
R101 VSS.n6 VSS.n104 17.0005
R102 VSS.n6 VSS.n73 17.0005
R103 VSS.n6 VSS.n103 17.0005
R104 VSS.n6 VSS.n75 17.0005
R105 VSS.n6 VSS.n102 17.0005
R106 VSS.n6 VSS.n77 17.0005
R107 VSS.n6 VSS.n101 17.0005
R108 VSS.n6 VSS.n79 17.0005
R109 VSS.n6 VSS.n100 17.0005
R110 VSS.n6 VSS.n81 17.0005
R111 VSS.n6 VSS.n99 17.0005
R112 VSS.n6 VSS.n83 17.0005
R113 VSS.n6 VSS.n98 17.0005
R114 VSS.n6 VSS.n85 17.0005
R115 VSS.n6 VSS.n97 17.0005
R116 VSS.n6 VSS.n87 17.0005
R117 VSS.n6 VSS.n96 17.0005
R118 VSS.n6 VSS.n89 17.0005
R119 VSS.n6 VSS.n95 17.0005
R120 VSS.n6 VSS.n90 17.0005
R121 VSS.n6 VSS.n93 17.0005
R122 VSS.n8 VSS.t34 0.00573464
R123 VSS.n6 VSS.n8 0.859865
R124 VSS.n9 VSS.n13 17.0005
R125 VSS.n13 VSS.n10 0.00600978
R126 VSS.n2 VSS.n9 0.00618224
R127 VSS.n2 VSS.t30 5.66455
R128 VSS.n2 VSS.n0 0.00359016
R129 VSS.n0 VSS.n1 0.00876575
R130 VSS.n1 VSS.t36 5.66109
R131 VSS.n13 VSS.n58 17.0005
R132 VSS.n11 VSS.n5 0.0194007
R133 VSS.n13 VSS.n11 8.49747
R134 VSS.t33 VSS.n5 5.66266
R135 VSS.n5 VSS.n3 0.00641486
R136 VSS.n4 VSS.n3 0.00359052
R137 VSS.n4 VSS.t1 5.66533
R138 VSS.n10 VSS.n4 1.28141
R139 VSS.n93 VSS.n19 14.4037
R140 VSS.n95 VSS.n21 14.4037
R141 VSS.n96 VSS.n23 14.4037
R142 VSS.n97 VSS.n25 14.4037
R143 VSS.n98 VSS.n27 14.4037
R144 VSS.n99 VSS.n29 14.4037
R145 VSS.n100 VSS.n31 14.4037
R146 VSS.n101 VSS.n33 14.4037
R147 VSS.n102 VSS.n35 14.4037
R148 VSS.n103 VSS.n37 14.4037
R149 VSS.n104 VSS.n39 14.4037
R150 VSS.n106 VSS.n41 14.4037
R151 VSS.n108 VSS.n43 14.4037
R152 VSS.n110 VSS.n45 14.4037
R153 VSS.n112 VSS.n47 14.4037
R154 VSS.n114 VSS.n49 14.4037
R155 VSS.n116 VSS.n51 14.4037
R156 VSS.n117 VSS.n53 14.4037
R157 VSS.n119 VSS.n55 14.4037
R158 VSS.n121 VSS.n57 14.4037
R159 VSS.t35 VSS.n60 14.4037
R160 VSS.n91 VSS.t32 14.4037
R161 VSS.n90 VSS.n20 14.4037
R162 VSS.n89 VSS.n22 14.4037
R163 VSS.n87 VSS.n24 14.4037
R164 VSS.n85 VSS.n26 14.4037
R165 VSS.n83 VSS.n28 14.4037
R166 VSS.n81 VSS.n30 14.4037
R167 VSS.n79 VSS.n32 14.4037
R168 VSS.n77 VSS.n34 14.4037
R169 VSS.n75 VSS.n36 14.4037
R170 VSS.n73 VSS.n38 14.4037
R171 VSS.n71 VSS.n40 14.4037
R172 VSS.n70 VSS.n42 14.4037
R173 VSS.n69 VSS.n44 14.4037
R174 VSS.n68 VSS.n46 14.4037
R175 VSS.n67 VSS.n48 14.4037
R176 VSS.n66 VSS.n50 14.4037
R177 VSS.n65 VSS.n52 14.4037
R178 VSS.n63 VSS.n54 14.4037
R179 VSS.n62 VSS.n56 14.4037
R180 VSS.n61 VSS.n58 14.4037
R181 VSS.n93 VSS.t0 11.0911
R182 VSS.t29 VSS.n58 11.0911
R183 VSS.n12 VSS.n6 0.90942
R184 VSS.n123 VSS.t34 3.0005
R185 VSS.n142 VSS.t31 3.0005
R186 VSS.n143 VSS.t3 2.48177
R187 VSS.n144 VSS.t6 2.48177
R188 VSS.n145 VSS.t9 2.48177
R189 VSS.n17 VSS.t12 2.48177
R190 VSS.t18 VSS.n16 2.48177
R191 VSS.t21 VSS.n126 2.48177
R192 VSS.n125 VSS.t24 2.48177
R193 VSS.n124 VSS.t27 2.48177
R194 VSS.n140 VSS.n6 2.09947
R195 VSS.n138 VSS.n6 2.09947
R196 VSS.n136 VSS.n6 2.09947
R197 VSS.n134 VSS.n6 2.09947
R198 VSS.n14 VSS.n6 2.09947
R199 VSS.n132 VSS.n6 2.09947
R200 VSS.n130 VSS.n6 2.09947
R201 VSS.n128 VSS.n6 2.09947
R202 VSS.n127 VSS.n12 0.146533
R203 VSS.n142 VSS.n3 1.52811
R204 VSS.n123 VSS.n0 1.52811
R205 VSS.n6 VSS.n61 1.29964
R206 VSS.n6 VSS.n120 1.29964
R207 VSS.n6 VSS.n118 1.29964
R208 VSS.n6 VSS.n64 1.29964
R209 VSS.n6 VSS.n115 1.29964
R210 VSS.n6 VSS.n113 1.29964
R211 VSS.n6 VSS.n111 1.29964
R212 VSS.n6 VSS.n109 1.29964
R213 VSS.n6 VSS.n107 1.29964
R214 VSS.n6 VSS.n105 1.29964
R215 VSS.n6 VSS.n74 1.29964
R216 VSS.n6 VSS.n76 1.29964
R217 VSS.n6 VSS.n78 1.29964
R218 VSS.n6 VSS.n80 1.29964
R219 VSS.n6 VSS.n82 1.29964
R220 VSS.n6 VSS.n84 1.29964
R221 VSS.n6 VSS.n86 1.29964
R222 VSS.n6 VSS.n88 1.29964
R223 VSS.n6 VSS.n94 1.29964
R224 VSS.n6 VSS.n7 0.007478
R225 VSS.n6 VSS.n122 1.29964
R226 VSS.n13 VSS.n7 0.00130245
R227 VSS.n13 VSS.n18 1.29964
R228 VSS.n13 VSS.n19 1.29964
R229 VSS.n13 VSS.n20 1.29964
R230 VSS.n13 VSS.n21 1.29964
R231 VSS.n13 VSS.n22 1.29964
R232 VSS.n13 VSS.n23 1.29964
R233 VSS.n13 VSS.n24 1.29964
R234 VSS.n13 VSS.n25 1.29964
R235 VSS.n13 VSS.n26 1.29964
R236 VSS.n13 VSS.n27 1.29964
R237 VSS.n13 VSS.n28 1.29964
R238 VSS.n13 VSS.n29 1.29964
R239 VSS.n13 VSS.n30 1.29964
R240 VSS.n13 VSS.n31 1.29964
R241 VSS.n13 VSS.n32 1.29964
R242 VSS.n13 VSS.n33 1.29964
R243 VSS.n13 VSS.n34 1.29964
R244 VSS.n13 VSS.n35 1.29964
R245 VSS.n13 VSS.n36 1.29964
R246 VSS.n13 VSS.n37 1.29964
R247 VSS.n13 VSS.n38 1.29964
R248 VSS.n13 VSS.n39 1.29964
R249 VSS.n13 VSS.n40 1.29964
R250 VSS.n13 VSS.n41 1.29964
R251 VSS.n13 VSS.n42 1.29964
R252 VSS.n13 VSS.n43 1.29964
R253 VSS.n13 VSS.n44 1.29964
R254 VSS.n13 VSS.n45 1.29964
R255 VSS.n13 VSS.n46 1.29964
R256 VSS.n13 VSS.n47 1.29964
R257 VSS.n13 VSS.n48 1.29964
R258 VSS.n13 VSS.n49 1.29964
R259 VSS.n13 VSS.n50 1.29964
R260 VSS.n13 VSS.n51 1.29964
R261 VSS.n13 VSS.n52 1.29964
R262 VSS.n13 VSS.n53 1.29964
R263 VSS.n13 VSS.n54 1.29964
R264 VSS.n13 VSS.n55 1.29964
R265 VSS.n13 VSS.n56 1.29964
R266 VSS.n13 VSS.n57 1.29964
R267 VSS.n13 VSS.n59 1.29964
R268 VSS.n13 VSS.n60 1.29964
R269 VSS.n6 VSS.n92 1.29964
R270 VSS.n6 VSS.n91 1.29964
R271 VSS.n6 VSS.n72 1.08379
R272 VSS.n141 VSS.t34 0.147554
R273 VSS.n143 VSS.n142 0.209825
R274 VSS.n124 VSS.n123 0.209825
R275 VSS.n127 VSS.t3 0.200997
R276 VSS.n129 VSS.t6 0.200997
R277 VSS.n131 VSS.t9 0.200997
R278 VSS.n133 VSS.t12 0.200997
R279 VSS.n135 VSS.t18 0.200997
R280 VSS.n137 VSS.t21 0.200997
R281 VSS.n139 VSS.t24 0.200997
R282 VSS.n141 VSS.t27 0.200997
R283 VSS.n144 VSS.n143 0.16242
R284 VSS.n145 VSS.n144 0.16242
R285 VSS.n17 VSS.n145 0.16242
R286 VSS.n15 VSS.n17 0.16242
R287 VSS.n15 VSS.n16 0.16242
R288 VSS.n126 VSS.n16 0.16242
R289 VSS.n126 VSS.n125 0.16242
R290 VSS.n125 VSS.n124 0.16242
R291 VSS.n128 VSS.n127 0.0952183
R292 VSS.n130 VSS.n129 0.0927738
R293 VSS.n141 VSS.n140 0.0925656
R294 VSS.n132 VSS.n131 0.0903294
R295 VSS.n134 VSS.t15 0.0903294
R296 VSS.n139 VSS.n138 0.0901212
R297 VSS.n14 VSS.n133 0.0878849
R298 VSS.n136 VSS.n135 0.0878849
R299 VSS.t15 VSS.n14 0.0876767
R300 VSS.n137 VSS.n136 0.0876767
R301 VSS.n138 VSS.n137 0.0854405
R302 VSS.n133 VSS.n132 0.0852323
R303 VSS.n135 VSS.n134 0.0852323
R304 VSS.n140 VSS.n139 0.082996
R305 VSS.n131 VSS.n130 0.0827878
R306 VSS.n129 VSS.n128 0.0803434
R307 VSS VSS.n15 0.0682949
R308 VSS.t15 VSS.n15 0.0394177
R309 VSS.t31 VSS.n12 0.082206
R310 VSS.n9 VSS.n8 0.0965628
R311 VSS.n11 VSS.t31 0.0209593
R312 VSS.n7 VSS.t32 15.6502
R313 VSS.n1 VSS.n10 1.34187
C0 vout VDD 11.0395f
C1 vin vout 15.9308f
C2 vin VDD 26.3364f
C3 vout VSS 10.12635f
.ends
