* PEX produced on Tue Aug 25 10:59:00 AM CEST 2026 using /foss/tools/sak/sak-pex.sh with m=3 and s=1 (extresist threshold=10000 mOhm, minres=1000 mOhm, mindelay=1 ps)
* NGSPICE file created from inverter_pex.ext - technology: ihp-sg13cmos5l

.subckt inverter_pex VDD vin vout VSS
X0 vout vin VDD VDD sg13_lv_pmos ad=1.14p pd=6.38u as=1.14p ps=6.38u w=6u l=1u
X1 VDD vin vout VDD sg13_lv_pmos ad=1.14p pd=6.38u as=1.14p ps=6.38u w=6u l=1u
X2 vout vin VDD VDD sg13_lv_pmos ad=1.14p pd=6.38u as=1.14p ps=6.38u w=6u l=1u
X3 vout vin VSS.t15 VSS.t16 sg13_lv_nmos ad=0.19p pd=1.38u as=0.19p ps=1.38u w=1u l=1u
X4 vout vin VSS.t1 VSS.t0 sg13_lv_nmos ad=0.19p pd=1.38u as=0.19p ps=1.38u w=1u l=1u
X5 VSS.t33 VSS.t31 VSS.t1 VSS.t32 sg13_lv_nmos ad=0.34p pd=2.68u as=0 ps=0 w=1u l=1u
X6 VSS.t24 vin vout VSS.t23 sg13_lv_nmos ad=0.19p pd=1.38u as=0.19p ps=1.38u w=1u l=1u
X7 vout vin VDD VDD sg13_lv_pmos ad=1.14p pd=6.38u as=1.14p ps=6.38u w=6u l=1u
X8 VDD vin vout VDD sg13_lv_pmos ad=1.14p pd=6.38u as=1.14p ps=6.38u w=6u l=1u
X9 vout vin VSS.t21 VSS.t22 sg13_lv_nmos ad=0.19p pd=1.38u as=0.19p ps=1.38u w=1u l=1u
X10 vout vin VDD VDD sg13_lv_pmos ad=1.14p pd=6.38u as=1.14p ps=6.38u w=6u l=1u
X11 VSS.t9 vin vout VSS.t8 sg13_lv_nmos ad=0.19p pd=1.38u as=0.19p ps=1.38u w=1u l=1u
X12 VSS.t30 vin vout VSS.t29 sg13_lv_nmos ad=0.19p pd=1.38u as=0.19p ps=1.38u w=1u l=1u
X13 VDD vin vout VDD sg13_lv_pmos ad=1.14p pd=6.38u as=1.14p ps=6.38u w=6u l=1u
X14 vout vin VDD VDD sg13_lv_pmos ad=1.14p pd=6.38u as=1.14p ps=6.38u w=6u l=1u
X15 VDD vin vout VDD sg13_lv_pmos ad=1.14p pd=6.38u as=1.14p ps=6.38u w=6u l=1u
X16 vout vin VDD VDD sg13_lv_pmos ad=1.14p pd=6.38u as=1.14p ps=6.38u w=6u l=1u
X17 vout vin VSS.t27 VSS.t28 sg13_lv_nmos ad=0.19p pd=1.38u as=0.19p ps=1.38u w=1u l=1u
X18 VSS.t15 vin vout VSS.t14 sg13_lv_nmos ad=0.19p pd=1.38u as=0.19p ps=1.38u w=1u l=1u
X19 VDD vin vout VDD sg13_lv_pmos ad=1.14p pd=6.38u as=1.14p ps=6.38u w=6u l=1u
X20 vout vin VDD VDD sg13_lv_pmos ad=1.14p pd=6.38u as=1.14p ps=6.38u w=6u l=1u
X21 VDD VDD VDD VDD sg13_lv_pmos ad=2.04p pd=12.68u as=0.14199n ps=0.28418m w=6u l=1u
X22 vout vin VSS.t6 VSS.t7 sg13_lv_nmos ad=0.19p pd=1.38u as=0.19p ps=1.38u w=1u l=1u
X23 VSS.t21 vin vout VSS.t20 sg13_lv_nmos ad=0.19p pd=1.38u as=0.19p ps=1.38u w=1u l=1u
X24 VDD vin vout VDD sg13_lv_pmos ad=1.14p pd=6.38u as=1.14p ps=6.38u w=6u l=1u
X25 VDD vin vout VDD sg13_lv_pmos ad=1.14p pd=6.38u as=1.14p ps=6.38u w=6u l=1u
X26 VSS.t6 vin vout VSS.t5 sg13_lv_nmos ad=0.19p pd=1.38u as=0.19p ps=1.38u w=1u l=1u
X27 vout vin VDD VDD sg13_lv_pmos ad=1.14p pd=6.38u as=1.14p ps=6.38u w=6u l=1u
X28 VSS.t3 vin vout VSS.t2 sg13_lv_nmos ad=0.19p pd=1.38u as=0.19p ps=1.38u w=1u l=1u
X29 vout vin VSS.t12 VSS.t13 sg13_lv_nmos ad=0.19p pd=1.38u as=0.19p ps=1.38u w=1u l=1u
X30 VSS.t27 vin vout VSS.t26 sg13_lv_nmos ad=0.19p pd=1.38u as=0.19p ps=1.38u w=1u l=1u
X31 vout vin VSS.t3 VSS.t4 sg13_lv_nmos ad=0.19p pd=1.38u as=0.19p ps=1.38u w=1u l=1u
X32 VDD vin vout VDD sg13_lv_pmos ad=1.14p pd=6.38u as=1.14p ps=6.38u w=6u l=1u
X33 vout vin VSS.t24 VSS.t25 sg13_lv_nmos ad=0.19p pd=1.38u as=0.19p ps=1.38u w=1u l=1u
X34 vout vin VDD VDD sg13_lv_pmos ad=1.14p pd=6.38u as=1.14p ps=6.38u w=6u l=1u
X35 VSS.t12 vin vout VSS.t11 sg13_lv_nmos ad=0.19p pd=1.38u as=0.19p ps=1.38u w=1u l=1u
X36 VDD vin vout VDD sg13_lv_pmos ad=1.14p pd=6.38u as=1.14p ps=6.38u w=6u l=1u
X37 VDD VDD VDD VDD sg13_lv_pmos ad=1.14p pd=6.38u as=0 ps=0 w=6u l=1u
X38 VDD vin vout VDD sg13_lv_pmos ad=1.14p pd=6.38u as=1.14p ps=6.38u w=6u l=1u
X39 vout vin VSS.t9 VSS.t10 sg13_lv_nmos ad=0.19p pd=1.38u as=0.19p ps=1.38u w=1u l=1u
X40 vout vin VSS.t18 VSS.t19 sg13_lv_nmos ad=0.19p pd=1.38u as=0.19p ps=1.38u w=1u l=1u
X41 vout vin VDD VDD sg13_lv_pmos ad=1.14p pd=6.38u as=1.14p ps=6.38u w=6u l=1u
X42 VSS.t18 vin vout VSS.t17 sg13_lv_nmos ad=0.19p pd=1.38u as=0.19p ps=1.38u w=1u l=1u
X43 VSS.t30 VSS.t34 VSS.t36 VSS.t35 sg13_lv_nmos ad=0.19p pd=1.38u as=0 ps=0 w=1u l=1u
R0 VSS.n0 VSS.t29 17.4353
R1 VSS.n0 VSS.t28 25.8413
R2 VSS.n0 VSS.t26 33.0473
R3 VSS.n0 VSS.t22 47.4581
R4 VSS.n0 VSS.t16 49.8592
R5 VSS.t13 VSS.n0 51.0606
R6 VSS.t14 VSS.n0 49.8597
R7 VSS.n0 VSS.t17 51.0613
R8 VSS.n0 VSS.t23 43.8551
R9 VSS.n0 VSS.t20 49.8593
R10 VSS.n12 VSS.t10 49.8593
R11 VSS.n0 VSS.n12 0.0016513
R12 VSS.n12 VSS.t8 130.148
R13 VSS.n0 VSS.t2 25.8408
R14 VSS.n9 VSS.t34 0.013442
R15 VSS.n9 VSS.n0 5.66307
R16 VSS.n0 VSS.n10 0.00962253
R17 VSS.n5 VSS.n9 0.0164358
R18 VSS.n5 VSS.t30 5.66455
R19 VSS.n5 VSS.n3 0.00359016
R20 VSS.n3 VSS.n4 0.00876575
R21 VSS.n4 VSS.t36 5.66109
R22 VSS.n0 VSS.n2 0.814983
R23 VSS.t33 VSS.n8 5.66266
R24 VSS.n8 VSS.n6 0.00641486
R25 VSS.n7 VSS.n6 0.00359052
R26 VSS.n7 VSS.t1 5.66533
R27 VSS.n10 VSS.n7 1.28031
R28 VSS.n11 VSS.n0 0.00464578
R29 VSS.t25 VSS.n0 39.0515
R30 VSS.n11 VSS.t32 7.82536
R31 VSS.t0 VSS.n11 17.4377
R32 VSS.t5 VSS.n0 39.0514
R33 VSS.t7 VSS.n1 43.8505
R34 VSS.t11 VSS.n0 51.0603
R35 VSS.t19 VSS.n0 51.0611
R36 VSS.n18 VSS.t34 3.0005
R37 VSS.n37 VSS.t31 3.0005
R38 VSS.n38 VSS.t3 2.48177
R39 VSS.n39 VSS.t6 2.48177
R40 VSS.n40 VSS.t9 2.48177
R41 VSS.n17 VSS.t12 2.48177
R42 VSS.t18 VSS.n16 2.48177
R43 VSS.t21 VSS.n21 2.48177
R44 VSS.n20 VSS.t24 2.48177
R45 VSS.n19 VSS.t27 2.48177
R46 VSS.n35 VSS.n0 2.09947
R47 VSS.n33 VSS.n0 2.09947
R48 VSS.n31 VSS.n0 2.09947
R49 VSS.n29 VSS.n0 2.09947
R50 VSS.n14 VSS.n0 2.09947
R51 VSS.n27 VSS.n0 2.09947
R52 VSS.n25 VSS.n0 2.09947
R53 VSS.n23 VSS.n0 2.09947
R54 VSS.n22 VSS.n2 0.155604
R55 VSS.n37 VSS.n6 1.52811
R56 VSS.n18 VSS.n3 1.52811
R57 VSS.n0 VSS.t35 7.82581
R58 VSS.n0 VSS.t4 33.0467
R59 VSS.n0 VSS.n1 0.00778214
R60 VSS.n13 VSS.n0 0.965651
R61 VSS.n38 VSS.n37 0.209825
R62 VSS.n19 VSS.n18 0.209825
R63 VSS.n22 VSS.t3 0.200997
R64 VSS.n24 VSS.t6 0.200997
R65 VSS.n26 VSS.t9 0.200997
R66 VSS.n28 VSS.t12 0.200997
R67 VSS.n30 VSS.t18 0.200997
R68 VSS.n32 VSS.t21 0.200997
R69 VSS.n34 VSS.t24 0.200997
R70 VSS.n36 VSS.t27 0.200997
R71 VSS.n39 VSS.n38 0.16242
R72 VSS.n40 VSS.n39 0.16242
R73 VSS.n17 VSS.n40 0.16242
R74 VSS.n15 VSS.n17 0.16242
R75 VSS.n15 VSS.n16 0.16242
R76 VSS.n21 VSS.n16 0.16242
R77 VSS.n21 VSS.n20 0.16242
R78 VSS.n20 VSS.n19 0.16242
R79 VSS.n13 VSS.n36 0.142565
R80 VSS.n23 VSS.n22 0.0952183
R81 VSS.n25 VSS.n24 0.0927738
R82 VSS.n36 VSS.n35 0.0925656
R83 VSS.n27 VSS.n26 0.0903294
R84 VSS.n29 VSS.t15 0.0903294
R85 VSS.n34 VSS.n33 0.0901212
R86 VSS.n14 VSS.n28 0.0878849
R87 VSS.n31 VSS.n30 0.0878849
R88 VSS.t15 VSS.n14 0.0876767
R89 VSS.n32 VSS.n31 0.0876767
R90 VSS.n33 VSS.n32 0.0854405
R91 VSS.n28 VSS.n27 0.0852323
R92 VSS.n30 VSS.n29 0.0852323
R93 VSS.t34 VSS.n13 0.0844554
R94 VSS.n35 VSS.n34 0.082996
R95 VSS.n26 VSS.n25 0.0827878
R96 VSS.n24 VSS.n23 0.0803434
R97 VSS VSS.n15 0.0682949
R98 VSS.t15 VSS.n15 0.0394177
R99 VSS.t31 VSS.n2 0.0744017
R100 VSS.n4 VSS.n10 1.34316
R101 VSS.t31 VSS.n8 0.03986
R102 VSS.n1 VSS.t8 74.7088
C0 VDD vin 26.3364f
C1 vout VDD 11.0395f
C2 vout vin 15.9308f
C3 vout VSS 10.12635f
.ends
