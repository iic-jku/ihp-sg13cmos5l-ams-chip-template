* PEX produced on Fri Jul 31 11:51:33 PM CEST 2026 using /foss/tools/sak/sak-pex.sh with m=3 and s=1 (extresist threshold=10000 mOhm, minres=1000 mOhm, mindelay=1 ps)
* NGSPICE file created from inverter_pex.ext - technology: ihp-sg13cmos5l

.subckt inverter_pex VDD vin vout VSS
X0 vout vin VDD VDD sg13_lv_pmos ad=1.14p pd=6.38u as=1.14p ps=6.38u w=6u l=1u
X1 VDD vin vout VDD sg13_lv_pmos ad=1.14p pd=6.38u as=1.14p ps=6.38u w=6u l=1u
X2 vout vin VDD VDD sg13_lv_pmos ad=1.14p pd=6.38u as=1.14p ps=6.38u w=6u l=1u
X3 vout vin VSS.t15 VSS.t16 sg13_lv_nmos ad=0.19p pd=1.38u as=0.19p ps=1.38u w=1u l=1u
X4 vout vin VSS.t1 VSS.t0 sg13_lv_nmos ad=0.19p pd=1.38u as=0.19p ps=1.38u w=1u l=1u
X5 VSS.t33 VSS.t31 VSS.t1 VSS.t32 sg13_lv_nmos ad=0.34p pd=2.68u as=0 ps=0 w=1u l=1u
X6 VSS.t24 vin vout VSS.t23 sg13_lv_nmos ad=0.19p pd=1.38u as=0.19p ps=1.38u w=1u l=1u
X7 vout vin VDD VDD sg13_lv_pmos ad=1.14p pd=6.38u as=1.14p ps=6.38u w=6u l=1u
X8 VDD vin vout VDD sg13_lv_pmos ad=1.14p pd=6.38u as=1.14p ps=6.38u w=6u l=1u
X9 vout vin VSS.t21 VSS.t22 sg13_lv_nmos ad=0.19p pd=1.38u as=0.19p ps=1.38u w=1u l=1u
X10 vout vin VDD VDD sg13_lv_pmos ad=1.14p pd=6.38u as=1.14p ps=6.38u w=6u l=1u
X11 VSS.t9 vin vout VSS.t8 sg13_lv_nmos ad=0.19p pd=1.38u as=0.19p ps=1.38u w=1u l=1u
X12 VSS.t30 vin vout VSS.t29 sg13_lv_nmos ad=0.19p pd=1.38u as=0.19p ps=1.38u w=1u l=1u
X13 VDD vin vout VDD sg13_lv_pmos ad=1.14p pd=6.38u as=1.14p ps=6.38u w=6u l=1u
X14 vout vin VDD VDD sg13_lv_pmos ad=1.14p pd=6.38u as=1.14p ps=6.38u w=6u l=1u
X15 VDD vin vout VDD sg13_lv_pmos ad=1.14p pd=6.38u as=1.14p ps=6.38u w=6u l=1u
X16 vout vin VDD VDD sg13_lv_pmos ad=1.14p pd=6.38u as=1.14p ps=6.38u w=6u l=1u
X17 vout vin VSS.t27 VSS.t28 sg13_lv_nmos ad=0.19p pd=1.38u as=0.19p ps=1.38u w=1u l=1u
X18 VSS.t15 vin vout VSS.t14 sg13_lv_nmos ad=0.19p pd=1.38u as=0.19p ps=1.38u w=1u l=1u
X19 VDD vin vout VDD sg13_lv_pmos ad=1.14p pd=6.38u as=1.14p ps=6.38u w=6u l=1u
X20 vout vin VDD VDD sg13_lv_pmos ad=1.14p pd=6.38u as=1.14p ps=6.38u w=6u l=1u
X21 VDD VDD VDD VDD sg13_lv_pmos ad=2.04p pd=12.68u as=0.14199n ps=0.28418m w=6u l=1u
X22 vout vin VSS.t6 VSS.t7 sg13_lv_nmos ad=0.19p pd=1.38u as=0.19p ps=1.38u w=1u l=1u
X23 VSS.t21 vin vout VSS.t20 sg13_lv_nmos ad=0.19p pd=1.38u as=0.19p ps=1.38u w=1u l=1u
X24 VDD vin vout VDD sg13_lv_pmos ad=1.14p pd=6.38u as=1.14p ps=6.38u w=6u l=1u
X25 VDD vin vout VDD sg13_lv_pmos ad=1.14p pd=6.38u as=1.14p ps=6.38u w=6u l=1u
X26 VSS.t6 vin vout VSS.t5 sg13_lv_nmos ad=0.19p pd=1.38u as=0.19p ps=1.38u w=1u l=1u
X27 vout vin VDD VDD sg13_lv_pmos ad=1.14p pd=6.38u as=1.14p ps=6.38u w=6u l=1u
X28 VSS.t3 vin vout VSS.t2 sg13_lv_nmos ad=0.19p pd=1.38u as=0.19p ps=1.38u w=1u l=1u
X29 vout vin VSS.t12 VSS.t13 sg13_lv_nmos ad=0.19p pd=1.38u as=0.19p ps=1.38u w=1u l=1u
X30 VSS.t27 vin vout VSS.t26 sg13_lv_nmos ad=0.19p pd=1.38u as=0.19p ps=1.38u w=1u l=1u
X31 vout vin VSS.t3 VSS.t4 sg13_lv_nmos ad=0.19p pd=1.38u as=0.19p ps=1.38u w=1u l=1u
X32 VDD vin vout VDD sg13_lv_pmos ad=1.14p pd=6.38u as=1.14p ps=6.38u w=6u l=1u
X33 vout vin VSS.t24 VSS.t25 sg13_lv_nmos ad=0.19p pd=1.38u as=0.19p ps=1.38u w=1u l=1u
X34 vout vin VDD VDD sg13_lv_pmos ad=1.14p pd=6.38u as=1.14p ps=6.38u w=6u l=1u
X35 VSS.t12 vin vout VSS.t11 sg13_lv_nmos ad=0.19p pd=1.38u as=0.19p ps=1.38u w=1u l=1u
X36 VDD vin vout VDD sg13_lv_pmos ad=1.14p pd=6.38u as=1.14p ps=6.38u w=6u l=1u
X37 VDD VDD VDD VDD sg13_lv_pmos ad=1.14p pd=6.38u as=0 ps=0 w=6u l=1u
X38 VDD vin vout VDD sg13_lv_pmos ad=1.14p pd=6.38u as=1.14p ps=6.38u w=6u l=1u
X39 vout vin VSS.t9 VSS.t10 sg13_lv_nmos ad=0.19p pd=1.38u as=0.19p ps=1.38u w=1u l=1u
X40 vout vin VSS.t18 VSS.t19 sg13_lv_nmos ad=0.19p pd=1.38u as=0.19p ps=1.38u w=1u l=1u
X41 vout vin VDD VDD sg13_lv_pmos ad=1.14p pd=6.38u as=1.14p ps=6.38u w=6u l=1u
X42 VSS.t18 vin vout VSS.t17 sg13_lv_nmos ad=0.19p pd=1.38u as=0.19p ps=1.38u w=1u l=1u
X43 VSS.t30 VSS.t34 VSS.t36 VSS.t35 sg13_lv_nmos ad=0.19p pd=1.38u as=0 ps=0 w=1u l=1u
R0 VSS.t32 VSS.n57 188.541
R1 VSS.t0 VSS.n56 177.45
R2 VSS.n118 VSS.t29 177.45
R3 VSS.t2 VSS.n53 166.359
R4 VSS.n113 VSS.t28 166.359
R5 VSS.t4 VSS.n50 155.268
R6 VSS.n111 VSS.t26 155.268
R7 VSS.t5 VSS.n49 144.178
R8 VSS.n109 VSS.t25 144.178
R9 VSS.t7 VSS.n48 133.088
R10 VSS.n107 VSS.t23 133.088
R11 VSS.t8 VSS.n45 121.996
R12 VSS.n103 VSS.t22 121.996
R13 VSS.t10 VSS.n42 110.906
R14 VSS.n87 VSS.t14 110.906
R15 VSS.t16 VSS.n36 110.906
R16 VSS.n101 VSS.t20 110.906
R17 VSS.t11 VSS.n41 99.8157
R18 VSS.n83 VSS.t13 99.8157
R19 VSS.t17 VSS.n35 99.8157
R20 VSS.n97 VSS.t19 99.8157
R21 VSS.n81 VSS.t11 88.7251
R22 VSS.t13 VSS.n38 88.7251
R23 VSS.n95 VSS.t17 88.7251
R24 VSS.t19 VSS.n32 88.7251
R25 VSS.n77 VSS.t10 77.6345
R26 VSS.t14 VSS.n37 77.6345
R27 VSS.n91 VSS.t16 77.6345
R28 VSS.t20 VSS.n31 77.6345
R29 VSS.n75 VSS.t8 66.5439
R30 VSS.t22 VSS.n28 66.5439
R31 VSS.n73 VSS.t7 55.4534
R32 VSS.t23 VSS.n27 55.4534
R33 VSS.n69 VSS.t5 44.3628
R34 VSS.t25 VSS.n24 44.3628
R35 VSS.n65 VSS.t4 33.2722
R36 VSS.t26 VSS.n21 33.2722
R37 VSS.n89 VSS.n88 29.2386
R38 VSS.n90 VSS.n89 29.2386
R39 VSS.n20 VSS.n19 28.8069
R40 VSS.n23 VSS.n22 28.8069
R41 VSS.n26 VSS.n25 28.8069
R42 VSS.n30 VSS.n29 28.8069
R43 VSS.n34 VSS.n33 28.8069
R44 VSS.n40 VSS.n39 28.8069
R45 VSS.n44 VSS.n43 28.8069
R46 VSS.n47 VSS.n46 28.8069
R47 VSS.n52 VSS.n51 28.8069
R48 VSS.n55 VSS.n54 28.8069
R49 VSS.n121 VSS.n120 28.8069
R50 VSS.n59 VSS.n58 28.8069
R51 VSS.n60 VSS.n59 28.8069
R52 VSS.n62 VSS.n54 28.8069
R53 VSS.n64 VSS.n51 28.8069
R54 VSS.n67 VSS.n66 28.8069
R55 VSS.n68 VSS.n67 28.8069
R56 VSS.n71 VSS.n70 28.8069
R57 VSS.n72 VSS.n71 28.8069
R58 VSS.n74 VSS.n46 28.8069
R59 VSS.n76 VSS.n43 28.8069
R60 VSS.n79 VSS.n78 28.8069
R61 VSS.n80 VSS.n79 28.8069
R62 VSS.n82 VSS.n39 28.8069
R63 VSS.n85 VSS.n84 28.8069
R64 VSS.n86 VSS.n85 28.8069
R65 VSS.n93 VSS.n92 28.8069
R66 VSS.n94 VSS.n93 28.8069
R67 VSS.n96 VSS.n33 28.8069
R68 VSS.n99 VSS.n98 28.8069
R69 VSS.n100 VSS.n99 28.8069
R70 VSS.n102 VSS.n29 28.8069
R71 VSS.n105 VSS.n104 28.8069
R72 VSS.n106 VSS.n105 28.8069
R73 VSS.n108 VSS.n25 28.8069
R74 VSS.n110 VSS.n22 28.8069
R75 VSS.n112 VSS.n19 28.8069
R76 VSS.n115 VSS.n114 28.8069
R77 VSS.n117 VSS.n115 28.8069
R78 VSS.n120 VSS.n17 28.8069
R79 VSS.n121 VSS.n119 28.8069
R80 VSS.n63 VSS.t2 22.1816
R81 VSS.t28 VSS.n18 22.1816
R82 VSS.n2 VSS.n118 17.0005
R83 VSS.n2 VSS.n18 17.0005
R84 VSS.n2 VSS.n113 17.0005
R85 VSS.n2 VSS.n21 17.0005
R86 VSS.n2 VSS.n111 17.0005
R87 VSS.n2 VSS.n24 17.0005
R88 VSS.n2 VSS.n109 17.0005
R89 VSS.n2 VSS.n27 17.0005
R90 VSS.n2 VSS.n107 17.0005
R91 VSS.n2 VSS.n28 17.0005
R92 VSS.n2 VSS.n103 17.0005
R93 VSS.n2 VSS.n31 17.0005
R94 VSS.n2 VSS.n101 17.0005
R95 VSS.n2 VSS.n32 17.0005
R96 VSS.n2 VSS.n97 17.0005
R97 VSS.n2 VSS.n35 17.0005
R98 VSS.n2 VSS.n95 17.0005
R99 VSS.n2 VSS.n36 17.0005
R100 VSS.n2 VSS.n91 17.0005
R101 VSS.n2 VSS.n37 17.0005
R102 VSS.n2 VSS.n87 17.0005
R103 VSS.n2 VSS.n38 17.0005
R104 VSS.n2 VSS.n83 17.0005
R105 VSS.n2 VSS.n41 17.0005
R106 VSS.n2 VSS.n81 17.0005
R107 VSS.n2 VSS.n42 17.0005
R108 VSS.n2 VSS.n77 17.0005
R109 VSS.n2 VSS.n45 17.0005
R110 VSS.n2 VSS.n75 17.0005
R111 VSS.n2 VSS.n48 17.0005
R112 VSS.n2 VSS.n73 17.0005
R113 VSS.n2 VSS.n49 17.0005
R114 VSS.n2 VSS.n69 17.0005
R115 VSS.n2 VSS.n50 17.0005
R116 VSS.n2 VSS.n65 17.0005
R117 VSS.n2 VSS.n53 17.0005
R118 VSS.n2 VSS.n63 17.0005
R119 VSS.n2 VSS.n56 17.0005
R120 VSS.n2 VSS.n61 17.0005
R121 VSS.n2 VSS.n7 17.0005
R122 VSS.n0 VSS.n6 17.0005
R123 VSS.n0 VSS.n5 17.0005
R124 VSS.t30 VSS.n15 17.0005
R125 VSS.t30 VSS.n140 17.0005
R126 VSS.n141 VSS.t30 17.0005
R127 VSS.n15 VSS.t36 17.0005
R128 VSS.n140 VSS.t36 17.0005
R129 VSS.n141 VSS.t36 17.0005
R130 VSS.n1 VSS.n0 0.00606728
R131 VSS.n116 VSS.n0 17.0005
R132 VSS.n2 VSS.n57 17.0005
R133 VSS.n2 VSS.n146 17.0005
R134 VSS.n143 VSS.n2 17.0005
R135 VSS.n2 VSS.n9 17.0005
R136 VSS.t33 VSS.n144 17.0005
R137 VSS.t33 VSS.n14 17.0005
R138 VSS.n145 VSS.t33 17.0005
R139 VSS.n144 VSS.t1 17.0005
R140 VSS.t1 VSS.n14 17.0005
R141 VSS.n145 VSS.t1 17.0005
R142 VSS.t35 VSS.n2 15.6492
R143 VSS.n61 VSS.n60 14.4037
R144 VSS.n63 VSS.n62 14.4037
R145 VSS.n65 VSS.n64 14.4037
R146 VSS.n69 VSS.n68 14.4037
R147 VSS.n73 VSS.n72 14.4037
R148 VSS.n75 VSS.n74 14.4037
R149 VSS.n77 VSS.n76 14.4037
R150 VSS.n81 VSS.n80 14.4037
R151 VSS.n83 VSS.n82 14.4037
R152 VSS.n87 VSS.n86 14.4037
R153 VSS.n91 VSS.n90 14.4037
R154 VSS.n95 VSS.n94 14.4037
R155 VSS.n97 VSS.n96 14.4037
R156 VSS.n101 VSS.n100 14.4037
R157 VSS.n103 VSS.n102 14.4037
R158 VSS.n107 VSS.n106 14.4037
R159 VSS.n109 VSS.n108 14.4037
R160 VSS.n111 VSS.n110 14.4037
R161 VSS.n113 VSS.n112 14.4037
R162 VSS.n118 VSS.n117 14.4037
R163 VSS.n119 VSS.t35 14.4037
R164 VSS.n1 VSS.t32 8.14676
R165 VSS.n58 VSS.n57 14.4037
R166 VSS.n56 VSS.n55 14.4037
R167 VSS.n53 VSS.n52 14.4037
R168 VSS.n66 VSS.n50 14.4037
R169 VSS.n70 VSS.n49 14.4037
R170 VSS.n48 VSS.n47 14.4037
R171 VSS.n45 VSS.n44 14.4037
R172 VSS.n78 VSS.n42 14.4037
R173 VSS.n41 VSS.n40 14.4037
R174 VSS.n84 VSS.n38 14.4037
R175 VSS.n88 VSS.n37 14.4037
R176 VSS.n92 VSS.n36 14.4037
R177 VSS.n35 VSS.n34 14.4037
R178 VSS.n98 VSS.n32 14.4037
R179 VSS.n31 VSS.n30 14.4037
R180 VSS.n104 VSS.n28 14.4037
R181 VSS.n27 VSS.n26 14.4037
R182 VSS.n24 VSS.n23 14.4037
R183 VSS.n21 VSS.n20 14.4037
R184 VSS.n114 VSS.n18 14.4037
R185 VSS.n116 VSS.n17 14.4037
R186 VSS.n61 VSS.t0 11.0911
R187 VSS.t29 VSS.n116 11.0911
R188 VSS.n8 VSS.n2 0.909905
R189 VSS.n4 VSS.n0 0.00667303
R190 VSS.n2 VSS.n3 0.909128
R191 VSS.n2 VSS.n142 5.61281
R192 VSS.n139 VSS.t34 3.0005
R193 VSS.n147 VSS.t31 3.0005
R194 VSS.n148 VSS.t3 2.48177
R195 VSS.n149 VSS.t6 2.48177
R196 VSS.n150 VSS.t9 2.48177
R197 VSS.n13 VSS.t12 2.48177
R198 VSS.t18 VSS.n12 2.48177
R199 VSS.t21 VSS.n123 2.48177
R200 VSS.n122 VSS.t24 2.48177
R201 VSS.t27 VSS.n16 2.48177
R202 VSS.n137 VSS.n2 2.09947
R203 VSS.n135 VSS.n2 2.09947
R204 VSS.n133 VSS.n2 2.09947
R205 VSS.n131 VSS.n2 2.09947
R206 VSS.n10 VSS.n2 2.09947
R207 VSS.n129 VSS.n2 2.09947
R208 VSS.n127 VSS.n2 2.09947
R209 VSS.n125 VSS.n2 2.09947
R210 VSS.n124 VSS.n3 0.146746
R211 VSS.n4 VSS.n141 1.43533
R212 VSS.n147 VSS.n14 1.52811
R213 VSS.n140 VSS.n139 1.52811
R214 VSS.n2 VSS.n17 1.29964
R215 VSS.n2 VSS.n115 1.29964
R216 VSS.n2 VSS.n19 1.29964
R217 VSS.n2 VSS.n22 1.29964
R218 VSS.n2 VSS.n25 1.29964
R219 VSS.n2 VSS.n105 1.29964
R220 VSS.n2 VSS.n29 1.29964
R221 VSS.n2 VSS.n99 1.29964
R222 VSS.n2 VSS.n33 1.29964
R223 VSS.n2 VSS.n93 1.29964
R224 VSS.n2 VSS.n85 1.29964
R225 VSS.n2 VSS.n39 1.29964
R226 VSS.n2 VSS.n79 1.29964
R227 VSS.n2 VSS.n43 1.29964
R228 VSS.n2 VSS.n46 1.29964
R229 VSS.n2 VSS.n71 1.29964
R230 VSS.n2 VSS.n67 1.29964
R231 VSS.n2 VSS.n51 1.29964
R232 VSS.n2 VSS.n54 1.29964
R233 VSS.n2 VSS.n121 1.29964
R234 VSS.n2 VSS.n1 0.00652807
R235 VSS.n58 VSS.n0 1.29964
R236 VSS.n60 VSS.n0 1.29964
R237 VSS.n55 VSS.n0 1.29964
R238 VSS.n62 VSS.n0 1.29964
R239 VSS.n52 VSS.n0 1.29964
R240 VSS.n64 VSS.n0 1.29964
R241 VSS.n66 VSS.n0 1.29964
R242 VSS.n68 VSS.n0 1.29964
R243 VSS.n70 VSS.n0 1.29964
R244 VSS.n72 VSS.n0 1.29964
R245 VSS.n47 VSS.n0 1.29964
R246 VSS.n74 VSS.n0 1.29964
R247 VSS.n44 VSS.n0 1.29964
R248 VSS.n76 VSS.n0 1.29964
R249 VSS.n78 VSS.n0 1.29964
R250 VSS.n80 VSS.n0 1.29964
R251 VSS.n40 VSS.n0 1.29964
R252 VSS.n82 VSS.n0 1.29964
R253 VSS.n84 VSS.n0 1.29964
R254 VSS.n86 VSS.n0 1.29964
R255 VSS.n88 VSS.n0 1.29964
R256 VSS.n90 VSS.n0 1.29964
R257 VSS.n92 VSS.n0 1.29964
R258 VSS.n94 VSS.n0 1.29964
R259 VSS.n34 VSS.n0 1.29964
R260 VSS.n96 VSS.n0 1.29964
R261 VSS.n98 VSS.n0 1.29964
R262 VSS.n100 VSS.n0 1.29964
R263 VSS.n30 VSS.n0 1.29964
R264 VSS.n102 VSS.n0 1.29964
R265 VSS.n104 VSS.n0 1.29964
R266 VSS.n106 VSS.n0 1.29964
R267 VSS.n26 VSS.n0 1.29964
R268 VSS.n108 VSS.n0 1.29964
R269 VSS.n23 VSS.n0 1.29964
R270 VSS.n110 VSS.n0 1.29964
R271 VSS.n20 VSS.n0 1.29964
R272 VSS.n112 VSS.n0 1.29964
R273 VSS.n114 VSS.n0 1.29964
R274 VSS.n117 VSS.n0 1.29964
R275 VSS.n120 VSS.n0 1.29964
R276 VSS.n119 VSS.n0 1.29964
R277 VSS.n2 VSS.n59 1.29964
R278 VSS.n2 VSS.n89 1.08379
R279 VSS.n138 VSS.n8 0.147383
R280 VSS.n148 VSS.n147 0.209825
R281 VSS.n139 VSS.n16 0.209825
R282 VSS.n124 VSS.t3 0.200997
R283 VSS.n126 VSS.t6 0.200997
R284 VSS.n128 VSS.t9 0.200997
R285 VSS.n130 VSS.t12 0.200997
R286 VSS.n132 VSS.t18 0.200997
R287 VSS.n134 VSS.t21 0.200997
R288 VSS.n136 VSS.t24 0.200997
R289 VSS.n138 VSS.t27 0.200997
R290 VSS.n149 VSS.n148 0.16242
R291 VSS.n150 VSS.n149 0.16242
R292 VSS.n13 VSS.n150 0.16242
R293 VSS.n11 VSS.n13 0.16242
R294 VSS.n11 VSS.n12 0.16242
R295 VSS.n123 VSS.n12 0.16242
R296 VSS.n123 VSS.n122 0.16242
R297 VSS.n122 VSS.n16 0.16242
R298 VSS.n145 VSS.n142 0.138997
R299 VSS.n125 VSS.n124 0.0952183
R300 VSS.n127 VSS.n126 0.0927738
R301 VSS.n138 VSS.n137 0.0925656
R302 VSS.n129 VSS.n128 0.0903294
R303 VSS.n131 VSS.t15 0.0903294
R304 VSS.n136 VSS.n135 0.0901212
R305 VSS.n10 VSS.n130 0.0878849
R306 VSS.n133 VSS.n132 0.0878849
R307 VSS.t15 VSS.n10 0.0876767
R308 VSS.n134 VSS.n133 0.0876767
R309 VSS.n135 VSS.n134 0.0854405
R310 VSS.n130 VSS.n129 0.0852323
R311 VSS.n132 VSS.n131 0.0852323
R312 VSS.n137 VSS.n136 0.082996
R313 VSS.n128 VSS.n127 0.0827878
R314 VSS.n126 VSS.n125 0.0803434
R315 VSS VSS.n11 0.0682949
R316 VSS.t15 VSS.n11 0.0394177
R317 VSS.t31 VSS.n3 0.082967
R318 VSS.t34 VSS.n7 0.0133922
R319 VSS.t31 VSS.n9 0.0133922
R320 VSS.t34 VSS.n8 0.0815134
R321 VSS.n140 VSS.n6 0.00798582
R322 VSS.n140 VSS.n5 0.00798582
R323 VSS.n143 VSS.n14 0.00798582
R324 VSS.n146 VSS.n14 0.00798582
R325 VSS.n7 VSS.n15 0.00756994
R326 VSS.n6 VSS.n15 0.00756994
R327 VSS.n141 VSS.n5 0.00756994
R328 VSS.n144 VSS.n9 0.00756994
R329 VSS.n144 VSS.n143 0.00756994
R330 VSS.n146 VSS.n145 0.00756994
R331 VSS.n142 VSS.n4 1.59072
C0 VDD vin 29.702f
C1 vout VDD 19.3894f
C2 vout vin 18.6541f
C3 vout VSS 13.72425f
.ends
