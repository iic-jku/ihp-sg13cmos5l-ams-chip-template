* PEX produced on Wed Aug 26 09:49:16 AM CEST 2026 using /foss/tools/sak/sak-pex.sh with m=3 and s=1 (extresist threshold=10000 mOhm, minres=1000 mOhm, mindelay=1 ps)
* NGSPICE file created from inverter_top_pex.ext - technology: ihp-sg13cmos5l

.subckt inverter_top_pex VDD vin4 vout4 VSS vin3 vout3 vin2 vout2 vout1 vin1
X0 vout4 vin4 VDD VDD sg13_lv_pmos ad=1.14p pd=6.38u as=1.14p ps=6.38u w=6u l=1u
X1 VDD vin2 vout2 VDD sg13_lv_pmos ad=1.14p pd=6.38u as=1.14p ps=6.38u w=6u l=1u
X2 VSS.t119 vin2 vout2 VSS.t43 sg13_lv_nmos ad=0.19p pd=1.38u as=0.19p ps=1.38u w=1u l=1u
X3 vout2 vin2 VSS.t121 VSS.t48 sg13_lv_nmos ad=0.19p pd=1.38u as=0.19p ps=1.38u w=1u l=1u
X4 vout2 vin2 VDD VDD sg13_lv_pmos ad=1.14p pd=6.38u as=1.14p ps=6.38u w=6u l=1u
X5 VSS.t87 vin4 vout4 VSS.t86 sg13_lv_nmos ad=0.19p pd=1.38u as=0.19p ps=1.38u w=1u l=1u
X6 vout1 vin1 VSS.t24 VSS.t25 sg13_lv_nmos ad=0.19p pd=1.38u as=0.19p ps=1.38u w=1u l=1u
X7 VDD vin2 vout2 VDD sg13_lv_pmos ad=1.14p pd=6.38u as=1.14p ps=6.38u w=6u l=1u
X8 vout4 vin4 VSS.t59 VSS.t79 sg13_lv_nmos ad=0.19p pd=1.38u as=0.19p ps=1.38u w=1u l=1u
X9 VDD vin2 vout2 VDD sg13_lv_pmos ad=1.14p pd=6.38u as=1.14p ps=6.38u w=6u l=1u
X10 VSS.t53 vin3 vout3 VSS.t52 sg13_lv_nmos ad=0.19p pd=1.38u as=0.19p ps=1.38u w=1u l=1u
X11 vout4 vin4 VSS.t96 VSS.t97 sg13_lv_nmos ad=0.19p pd=1.38u as=0.19p ps=1.38u w=1u l=1u
X12 VDD vin3 vout3 VDD sg13_lv_pmos ad=1.14p pd=6.38u as=1.14p ps=6.38u w=6u l=1u
X13 VSS.t90 vin4 vout4 VSS.t89 sg13_lv_nmos ad=0.19p pd=1.38u as=0.19p ps=1.38u w=1u l=1u
X14 VDD vin2 vout2 VDD sg13_lv_pmos ad=1.14p pd=6.38u as=1.14p ps=6.38u w=6u l=1u
X15 vout3 vin3 VDD VDD sg13_lv_pmos ad=1.14p pd=6.38u as=1.14p ps=6.38u w=6u l=1u
X16 vout2 vin2 VDD VDD sg13_lv_pmos ad=1.14p pd=6.38u as=1.14p ps=6.38u w=6u l=1u
X17 VSS.t32 vin2 vout2 VSS.t39 sg13_lv_nmos ad=0.19p pd=1.38u as=0.19p ps=1.38u w=1u l=1u
X18 VDD vin3 vout3 VDD sg13_lv_pmos ad=1.14p pd=6.38u as=1.14p ps=6.38u w=6u l=1u
X19 VSS.t32 VSS.t65 VSS.t32 VSS.t66 sg13_lv_nmos ad=0.34p pd=2.68u as=0 ps=0 w=1u l=1u
X20 vout2 vin2 VSS.t117 VSS.t42 sg13_lv_nmos ad=0.19p pd=1.38u as=0.19p ps=1.38u w=1u l=1u
X21 vout1 vin1 VSS.t18 VSS.t19 sg13_lv_nmos ad=0.19p pd=1.38u as=0.19p ps=1.38u w=1u l=1u
X22 VSS.t121 vin2 vout2 VSS.t46 sg13_lv_nmos ad=0.19p pd=1.38u as=0.19p ps=1.38u w=1u l=1u
X23 vout4 vin4 VSS.t93 VSS.t94 sg13_lv_nmos ad=0.19p pd=1.38u as=0.19p ps=1.38u w=1u l=1u
X24 vout1 vin1 VDD VDD sg13_lv_pmos ad=1.14p pd=6.38u as=1.14p ps=6.38u w=6u l=1u
X25 vout1 vin1 VSS.t12 VSS.t13 sg13_lv_nmos ad=0.19p pd=1.38u as=0.19p ps=1.38u w=1u l=1u
X26 VSS.t99 vin4 vout4 VSS.t98 sg13_lv_nmos ad=0.19p pd=1.38u as=0.19p ps=1.38u w=1u l=1u
X27 VDD VDD VDD VDD sg13_lv_pmos ad=1.14p pd=6.38u as=0.56797n ps=1.006m w=6u l=1u
X28 VSS.t18 vin1 vout1 VSS.t17 sg13_lv_nmos ad=0.19p pd=1.38u as=0.19p ps=1.38u w=1u l=1u
X29 vout2 vin2 VDD VDD sg13_lv_pmos ad=1.14p pd=6.38u as=1.14p ps=6.38u w=6u l=1u
X30 VDD vin4 vout4 VDD sg13_lv_pmos ad=1.14p pd=6.38u as=1.14p ps=6.38u w=6u l=1u
X31 vout1 vin1 VSS.t21 VSS.t22 sg13_lv_nmos ad=0.19p pd=1.38u as=0.19p ps=1.38u w=1u l=1u
X32 vout3 vin3 VSS.t50 VSS.t51 sg13_lv_nmos ad=0.19p pd=1.38u as=0.19p ps=1.38u w=1u l=1u
X33 vout4 vin4 VDD VDD sg13_lv_pmos ad=1.14p pd=6.38u as=1.14p ps=6.38u w=6u l=1u
X34 VDD vin3 vout3 VDD sg13_lv_pmos ad=1.14p pd=6.38u as=1.14p ps=6.38u w=6u l=1u
X35 VDD vin4 vout4 VDD sg13_lv_pmos ad=1.14p pd=6.38u as=1.14p ps=6.38u w=6u l=1u
X36 vout3 vin3 VDD VDD sg13_lv_pmos ad=1.14p pd=6.38u as=1.14p ps=6.38u w=6u l=1u
X37 VDD vin3 vout3 VDD sg13_lv_pmos ad=1.14p pd=6.38u as=1.14p ps=6.38u w=6u l=1u
X38 VSS.t64 VSS.t61 VSS.t63 VSS.t62 sg13_lv_nmos ad=0.19p pd=1.38u as=0 ps=0 w=1u l=1u
X39 VDD vin4 vout4 VDD sg13_lv_pmos ad=1.14p pd=6.38u as=1.14p ps=6.38u w=6u l=1u
X40 VDD vin2 vout2 VDD sg13_lv_pmos ad=1.14p pd=6.38u as=1.14p ps=6.38u w=6u l=1u
X41 VSS.t102 vin4 vout4 VSS.t101 sg13_lv_nmos ad=0.19p pd=1.38u as=0.19p ps=1.38u w=1u l=1u
X42 VDD vin3 vout3 VDD sg13_lv_pmos ad=1.14p pd=6.38u as=1.14p ps=6.38u w=6u l=1u
X43 VSS.t12 vin1 vout1 VSS.t11 sg13_lv_nmos ad=0.19p pd=1.38u as=0.19p ps=1.38u w=1u l=1u
X44 VDD vin1 vout1 VDD sg13_lv_pmos ad=1.14p pd=6.38u as=1.14p ps=6.38u w=6u l=1u
X45 vout4 vin4 VSS.t105 VSS.t106 sg13_lv_nmos ad=0.19p pd=1.38u as=0.19p ps=1.38u w=1u l=1u
X46 vout4 vin4 VDD VDD sg13_lv_pmos ad=1.14p pd=6.38u as=1.14p ps=6.38u w=6u l=1u
X47 vout1 vin1 VSS.t15 VSS.t16 sg13_lv_nmos ad=0.19p pd=1.38u as=0.19p ps=1.38u w=1u l=1u
X48 vout1 vin1 VDD VDD sg13_lv_pmos ad=1.14p pd=6.38u as=1.14p ps=6.38u w=6u l=1u
X49 VDD vin1 vout1 VDD sg13_lv_pmos ad=1.14p pd=6.38u as=1.14p ps=6.38u w=6u l=1u
X50 vout3 vin3 VSS.t44 VSS.t45 sg13_lv_nmos ad=0.19p pd=1.38u as=0.19p ps=1.38u w=1u l=1u
X51 VSS.t21 vin1 vout1 VSS.t20 sg13_lv_nmos ad=0.19p pd=1.38u as=0.19p ps=1.38u w=1u l=1u
X52 VDD VDD VDD VDD sg13_lv_pmos ad=2.04p pd=12.68u as=0 ps=0 w=6u l=1u
X53 vout4 vin4 VDD VDD sg13_lv_pmos ad=1.14p pd=6.38u as=1.14p ps=6.38u w=6u l=1u
X54 VDD vin3 vout3 VDD sg13_lv_pmos ad=1.14p pd=6.38u as=1.14p ps=6.38u w=6u l=1u
X55 VDD vin4 vout4 VDD sg13_lv_pmos ad=1.14p pd=6.38u as=1.14p ps=6.38u w=6u l=1u
X56 vout3 vin3 VSS.t32 VSS.t40 sg13_lv_nmos ad=0.19p pd=1.38u as=0.19p ps=1.38u w=1u l=1u
X57 vout3 vin3 VDD VDD sg13_lv_pmos ad=1.14p pd=6.38u as=1.14p ps=6.38u w=6u l=1u
X58 VSS.t44 vin3 vout3 VSS.t43 sg13_lv_nmos ad=0.19p pd=1.38u as=0.19p ps=1.38u w=1u l=1u
X59 VDD VDD VDD VDD sg13_lv_pmos ad=1.14p pd=6.38u as=0 ps=0 w=6u l=1u
X60 vout3 vin3 VSS.t47 VSS.t48 sg13_lv_nmos ad=0.19p pd=1.38u as=0.19p ps=1.38u w=1u l=1u
X61 vout4 vin4 VDD VDD sg13_lv_pmos ad=1.14p pd=6.38u as=1.14p ps=6.38u w=6u l=1u
X62 vout3 vin3 VDD VDD sg13_lv_pmos ad=1.14p pd=6.38u as=1.14p ps=6.38u w=6u l=1u
X63 VDD vin1 vout1 VDD sg13_lv_pmos ad=1.14p pd=6.38u as=1.14p ps=6.38u w=6u l=1u
X64 vout2 vin2 VDD VDD sg13_lv_pmos ad=1.14p pd=6.38u as=1.14p ps=6.38u w=6u l=1u
X65 vout1 vin1 VDD VDD sg13_lv_pmos ad=1.14p pd=6.38u as=1.14p ps=6.38u w=6u l=1u
X66 VDD vin1 vout1 VDD sg13_lv_pmos ad=1.14p pd=6.38u as=1.14p ps=6.38u w=6u l=1u
X67 vout2 vin2 VSS.t32 VSS.t36 sg13_lv_nmos ad=0.19p pd=1.38u as=0.19p ps=1.38u w=1u l=1u
X68 VDD vin1 vout1 VDD sg13_lv_pmos ad=1.14p pd=6.38u as=1.14p ps=6.38u w=6u l=1u
X69 VDD vin3 vout3 VDD sg13_lv_pmos ad=1.14p pd=6.38u as=1.14p ps=6.38u w=6u l=1u
X70 VSS.t32 vin3 vout3 VSS.t39 sg13_lv_nmos ad=0.19p pd=1.38u as=0.19p ps=1.38u w=1u l=1u
X71 vout3 vin3 VSS.t32 VSS.t42 sg13_lv_nmos ad=0.19p pd=1.38u as=0.19p ps=1.38u w=1u l=1u
X72 VSS.t84 vin4 vout4 VSS.t83 sg13_lv_nmos ad=0.19p pd=1.38u as=0.19p ps=1.38u w=1u l=1u
X73 VDD vin4 vout4 VDD sg13_lv_pmos ad=1.14p pd=6.38u as=1.14p ps=6.38u w=6u l=1u
X74 VSS.t47 vin3 vout3 VSS.t46 sg13_lv_nmos ad=0.19p pd=1.38u as=0.19p ps=1.38u w=1u l=1u
X75 vout4 vin4 VSS.t87 VSS.t88 sg13_lv_nmos ad=0.19p pd=1.38u as=0.19p ps=1.38u w=1u l=1u
X76 VDD vin1 vout1 VDD sg13_lv_pmos ad=1.14p pd=6.38u as=1.14p ps=6.38u w=6u l=1u
X77 vout2 vin2 VDD VDD sg13_lv_pmos ad=1.14p pd=6.38u as=1.14p ps=6.38u w=6u l=1u
X78 vout1 vin1 VDD VDD sg13_lv_pmos ad=1.14p pd=6.38u as=1.14p ps=6.38u w=6u l=1u
X79 VSS.t81 vin4 vout4 VSS.t80 sg13_lv_nmos ad=0.19p pd=1.38u as=0.19p ps=1.38u w=1u l=1u
X80 VDD VDD VDD VDD sg13_lv_pmos ad=2.04p pd=12.68u as=0 ps=0 w=6u l=1u
X81 vout2 vin2 VDD VDD sg13_lv_pmos ad=1.14p pd=6.38u as=1.14p ps=6.38u w=6u l=1u
X82 VDD vin2 vout2 VDD sg13_lv_pmos ad=1.14p pd=6.38u as=1.14p ps=6.38u w=6u l=1u
X83 VSS.t32 vin2 vout2 VSS.t35 sg13_lv_nmos ad=0.19p pd=1.38u as=0.19p ps=1.38u w=1u l=1u
X84 VSS.t93 vin4 vout4 VSS.t92 sg13_lv_nmos ad=0.19p pd=1.38u as=0.19p ps=1.38u w=1u l=1u
X85 VDD VDD VDD VDD sg13_lv_pmos ad=2.04p pd=12.68u as=0 ps=0 w=6u l=1u
X86 vout2 vin2 VDD VDD sg13_lv_pmos ad=1.14p pd=6.38u as=1.14p ps=6.38u w=6u l=1u
X87 vout2 vin2 VSS.t32 VSS.t38 sg13_lv_nmos ad=0.19p pd=1.38u as=0.19p ps=1.38u w=1u l=1u
X88 VSS.t117 vin2 vout2 VSS.t41 sg13_lv_nmos ad=0.19p pd=1.38u as=0.19p ps=1.38u w=1u l=1u
X89 vout1 vin1 VDD VDD sg13_lv_pmos ad=1.14p pd=6.38u as=1.14p ps=6.38u w=6u l=1u
X90 vout1 vin1 VSS.t6 VSS.t7 sg13_lv_nmos ad=0.19p pd=1.38u as=0.19p ps=1.38u w=1u l=1u
X91 vout4 vin4 VSS.t90 VSS.t91 sg13_lv_nmos ad=0.19p pd=1.38u as=0.19p ps=1.38u w=1u l=1u
X92 vout3 vin3 VDD VDD sg13_lv_pmos ad=1.14p pd=6.38u as=1.14p ps=6.38u w=6u l=1u
X93 vout4 vin4 VSS.t102 VSS.t103 sg13_lv_nmos ad=0.19p pd=1.38u as=0.19p ps=1.38u w=1u l=1u
X94 VSS.t56 VSS.t71 VSS.t56 VSS.t68 sg13_lv_nmos ad=0.19p pd=1.38u as=0 ps=0 w=1u l=1u
X95 VSS.t96 vin4 vout4 VSS.t95 sg13_lv_nmos ad=0.19p pd=1.38u as=0.19p ps=1.38u w=1u l=1u
X96 VDD vin1 vout1 VDD sg13_lv_pmos ad=1.14p pd=6.38u as=1.14p ps=6.38u w=6u l=1u
X97 VSS.t56 vin2 vout2 VSS.t55 sg13_lv_nmos ad=0.19p pd=1.38u as=0.19p ps=1.38u w=1u l=1u
X98 VDD vin2 vout2 VDD sg13_lv_pmos ad=1.14p pd=6.38u as=1.14p ps=6.38u w=6u l=1u
X99 vout4 vin4 VSS.t99 VSS.t100 sg13_lv_nmos ad=0.19p pd=1.38u as=0.19p ps=1.38u w=1u l=1u
X100 vout4 vin4 VDD VDD sg13_lv_pmos ad=1.14p pd=6.38u as=1.14p ps=6.38u w=6u l=1u
X101 vout2 vin2 VDD VDD sg13_lv_pmos ad=1.14p pd=6.38u as=1.14p ps=6.38u w=6u l=1u
X102 vout2 vin2 VSS.t32 VSS.t34 sg13_lv_nmos ad=0.19p pd=1.38u as=0.19p ps=1.38u w=1u l=1u
X103 VDD vin2 vout2 VDD sg13_lv_pmos ad=1.14p pd=6.38u as=1.14p ps=6.38u w=6u l=1u
X104 VSS.t32 vin2 vout2 VSS.t37 sg13_lv_nmos ad=0.19p pd=1.38u as=0.19p ps=1.38u w=1u l=1u
X105 VDD vin4 vout4 VDD sg13_lv_pmos ad=1.14p pd=6.38u as=1.14p ps=6.38u w=6u l=1u
X106 VDD VDD VDD VDD sg13_lv_pmos ad=2.04p pd=12.68u as=0 ps=0 w=6u l=1u
X107 VSS.t32 vin2 vout2 VSS.t33 sg13_lv_nmos ad=0.19p pd=1.38u as=0.19p ps=1.38u w=1u l=1u
X108 VSS.t6 vin1 vout1 VSS.t5 sg13_lv_nmos ad=0.19p pd=1.38u as=0.19p ps=1.38u w=1u l=1u
X109 vout3 vin3 VDD VDD sg13_lv_pmos ad=1.14p pd=6.38u as=1.14p ps=6.38u w=6u l=1u
X110 vout1 vin1 VSS.t9 VSS.t10 sg13_lv_nmos ad=0.19p pd=1.38u as=0.19p ps=1.38u w=1u l=1u
X111 VSS.t15 vin1 vout1 VSS.t14 sg13_lv_nmos ad=0.19p pd=1.38u as=0.19p ps=1.38u w=1u l=1u
X112 vout3 vin3 VDD VDD sg13_lv_pmos ad=1.14p pd=6.38u as=1.14p ps=6.38u w=6u l=1u
X113 VDD vin3 vout3 VDD sg13_lv_pmos ad=1.14p pd=6.38u as=1.14p ps=6.38u w=6u l=1u
X114 vout3 vin3 VDD VDD sg13_lv_pmos ad=1.14p pd=6.38u as=1.14p ps=6.38u w=6u l=1u
X115 vout3 vin3 VSS.t32 VSS.t36 sg13_lv_nmos ad=0.19p pd=1.38u as=0.19p ps=1.38u w=1u l=1u
X116 VSS.t123 vin2 vout2 VSS.t49 sg13_lv_nmos ad=0.19p pd=1.38u as=0.19p ps=1.38u w=1u l=1u
X117 vout2 vin2 VSS.t125 VSS.t54 sg13_lv_nmos ad=0.19p pd=1.38u as=0.19p ps=1.38u w=1u l=1u
X118 VSS.t64 vin4 vout4 VSS.t107 sg13_lv_nmos ad=0.19p pd=1.38u as=0.19p ps=1.38u w=1u l=1u
X119 vout1 vin1 VDD VDD sg13_lv_pmos ad=1.14p pd=6.38u as=1.14p ps=6.38u w=6u l=1u
X120 VSS.t30 VSS.t76 VSS.t78 VSS.t77 sg13_lv_nmos ad=0.19p pd=1.38u as=0 ps=0 w=1u l=1u
X121 VSS.t30 vin1 vout1 VSS.t29 sg13_lv_nmos ad=0.19p pd=1.38u as=0.19p ps=1.38u w=1u l=1u
X122 vout2 vin2 VSS.t32 VSS.t31 sg13_lv_nmos ad=0.19p pd=1.38u as=0.19p ps=1.38u w=1u l=1u
X123 VSS.t60 VSS.t57 VSS.t59 VSS.t58 sg13_lv_nmos ad=0.34p pd=2.68u as=0 ps=0 w=1u l=1u
X124 vout1 vin1 VSS.t3 VSS.t4 sg13_lv_nmos ad=0.19p pd=1.38u as=0.19p ps=1.38u w=1u l=1u
X125 VSS.t9 vin1 vout1 VSS.t8 sg13_lv_nmos ad=0.19p pd=1.38u as=0.19p ps=1.38u w=1u l=1u
X126 VDD vin3 vout3 VDD sg13_lv_pmos ad=1.14p pd=6.38u as=1.14p ps=6.38u w=6u l=1u
X127 VSS.t3 vin1 vout1 VSS.t2 sg13_lv_nmos ad=0.19p pd=1.38u as=0.19p ps=1.38u w=1u l=1u
X128 vout4 vin4 VDD VDD sg13_lv_pmos ad=1.14p pd=6.38u as=1.14p ps=6.38u w=6u l=1u
X129 vout3 vin3 VDD VDD sg13_lv_pmos ad=1.14p pd=6.38u as=1.14p ps=6.38u w=6u l=1u
X130 VDD vin3 vout3 VDD sg13_lv_pmos ad=1.14p pd=6.38u as=1.14p ps=6.38u w=6u l=1u
X131 VSS.t32 vin3 vout3 VSS.t35 sg13_lv_nmos ad=0.19p pd=1.38u as=0.19p ps=1.38u w=1u l=1u
X132 vout3 vin3 VSS.t32 VSS.t38 sg13_lv_nmos ad=0.19p pd=1.38u as=0.19p ps=1.38u w=1u l=1u
X133 vout1 vin1 VDD VDD sg13_lv_pmos ad=1.14p pd=6.38u as=1.14p ps=6.38u w=6u l=1u
X134 VSS.t125 vin2 vout2 VSS.t52 sg13_lv_nmos ad=0.19p pd=1.38u as=0.19p ps=1.38u w=1u l=1u
X135 VSS.t32 vin3 vout3 VSS.t41 sg13_lv_nmos ad=0.19p pd=1.38u as=0.19p ps=1.38u w=1u l=1u
X136 VDD vin4 vout4 VDD sg13_lv_pmos ad=1.14p pd=6.38u as=1.14p ps=6.38u w=6u l=1u
X137 vout1 vin1 VDD VDD sg13_lv_pmos ad=1.14p pd=6.38u as=1.14p ps=6.38u w=6u l=1u
X138 VDD vin1 vout1 VDD sg13_lv_pmos ad=1.14p pd=6.38u as=1.14p ps=6.38u w=6u l=1u
X139 vout4 vin4 VDD VDD sg13_lv_pmos ad=1.14p pd=6.38u as=1.14p ps=6.38u w=6u l=1u
X140 VSS.t24 vin1 vout1 VSS.t23 sg13_lv_nmos ad=0.19p pd=1.38u as=0.19p ps=1.38u w=1u l=1u
X141 vout1 vin1 VDD VDD sg13_lv_pmos ad=1.14p pd=6.38u as=1.14p ps=6.38u w=6u l=1u
X142 vout1 vin1 VSS.t27 VSS.t28 sg13_lv_nmos ad=0.19p pd=1.38u as=0.19p ps=1.38u w=1u l=1u
X143 vout2 vin2 VDD VDD sg13_lv_pmos ad=1.14p pd=6.38u as=1.14p ps=6.38u w=6u l=1u
X144 vout4 vin4 VSS.t84 VSS.t85 sg13_lv_nmos ad=0.19p pd=1.38u as=0.19p ps=1.38u w=1u l=1u
X145 VSS.t32 VSS.t69 VSS.t32 VSS.t66 sg13_lv_nmos ad=0.34p pd=2.68u as=0 ps=0 w=1u l=1u
X146 VSS.t56 VSS.t67 VSS.t56 VSS.t68 sg13_lv_nmos ad=0.19p pd=1.38u as=0 ps=0 w=1u l=1u
X147 vout4 vin4 VDD VDD sg13_lv_pmos ad=1.14p pd=6.38u as=1.14p ps=6.38u w=6u l=1u
X148 VSS.t56 vin3 vout3 VSS.t55 sg13_lv_nmos ad=0.19p pd=1.38u as=0.19p ps=1.38u w=1u l=1u
X149 VSS.t105 vin4 vout4 VSS.t104 sg13_lv_nmos ad=0.19p pd=1.38u as=0.19p ps=1.38u w=1u l=1u
X150 VDD vin4 vout4 VDD sg13_lv_pmos ad=1.14p pd=6.38u as=1.14p ps=6.38u w=6u l=1u
X151 vout1 vin1 VSS.t1 VSS.t0 sg13_lv_nmos ad=0.19p pd=1.38u as=0.19p ps=1.38u w=1u l=1u
X152 vout3 vin3 VSS.t32 VSS.t34 sg13_lv_nmos ad=0.19p pd=1.38u as=0.19p ps=1.38u w=1u l=1u
X153 VSS.t32 vin3 vout3 VSS.t37 sg13_lv_nmos ad=0.19p pd=1.38u as=0.19p ps=1.38u w=1u l=1u
X154 vout4 vin4 VDD VDD sg13_lv_pmos ad=1.14p pd=6.38u as=1.14p ps=6.38u w=6u l=1u
X155 vout2 vin2 VSS.t123 VSS.t51 sg13_lv_nmos ad=0.19p pd=1.38u as=0.19p ps=1.38u w=1u l=1u
X156 VSS.t32 vin3 vout3 VSS.t33 sg13_lv_nmos ad=0.19p pd=1.38u as=0.19p ps=1.38u w=1u l=1u
X157 VDD vin1 vout1 VDD sg13_lv_pmos ad=1.14p pd=6.38u as=1.14p ps=6.38u w=6u l=1u
X158 vout1 vin1 VDD VDD sg13_lv_pmos ad=1.14p pd=6.38u as=1.14p ps=6.38u w=6u l=1u
X159 VDD vin4 vout4 VDD sg13_lv_pmos ad=1.14p pd=6.38u as=1.14p ps=6.38u w=6u l=1u
X160 VDD vin1 vout1 VDD sg13_lv_pmos ad=1.14p pd=6.38u as=1.14p ps=6.38u w=6u l=1u
X161 VSS.t27 vin1 vout1 VSS.t26 sg13_lv_nmos ad=0.19p pd=1.38u as=0.19p ps=1.38u w=1u l=1u
X162 VDD vin2 vout2 VDD sg13_lv_pmos ad=1.14p pd=6.38u as=1.14p ps=6.38u w=6u l=1u
X163 vout2 vin2 VDD VDD sg13_lv_pmos ad=1.14p pd=6.38u as=1.14p ps=6.38u w=6u l=1u
X164 VDD vin2 vout2 VDD sg13_lv_pmos ad=1.14p pd=6.38u as=1.14p ps=6.38u w=6u l=1u
X165 VSS.t50 vin3 vout3 VSS.t49 sg13_lv_nmos ad=0.19p pd=1.38u as=0.19p ps=1.38u w=1u l=1u
X166 vout3 vin3 VSS.t53 VSS.t54 sg13_lv_nmos ad=0.19p pd=1.38u as=0.19p ps=1.38u w=1u l=1u
X167 VDD VDD VDD VDD sg13_lv_pmos ad=1.14p pd=6.38u as=0 ps=0 w=6u l=1u
X168 VSS.t75 VSS.t73 VSS.t1 VSS.t74 sg13_lv_nmos ad=0.34p pd=2.68u as=0 ps=0 w=1u l=1u
X169 VDD vin4 vout4 VDD sg13_lv_pmos ad=1.14p pd=6.38u as=1.14p ps=6.38u w=6u l=1u
X170 VDD VDD VDD VDD sg13_lv_pmos ad=1.14p pd=6.38u as=0 ps=0 w=6u l=1u
X171 vout2 vin2 VSS.t119 VSS.t45 sg13_lv_nmos ad=0.19p pd=1.38u as=0.19p ps=1.38u w=1u l=1u
X172 vout3 vin3 VDD VDD sg13_lv_pmos ad=1.14p pd=6.38u as=1.14p ps=6.38u w=6u l=1u
X173 vout4 vin4 VSS.t81 VSS.t82 sg13_lv_nmos ad=0.19p pd=1.38u as=0.19p ps=1.38u w=1u l=1u
X174 vout3 vin3 VSS.t32 VSS.t31 sg13_lv_nmos ad=0.19p pd=1.38u as=0.19p ps=1.38u w=1u l=1u
X175 vout2 vin2 VSS.t32 VSS.t40 sg13_lv_nmos ad=0.19p pd=1.38u as=0.19p ps=1.38u w=1u l=1u
R0 VSS.n46 VSS.n186 6777.49
R1 VSS.n216 VSS.n46 6777.49
R2 VSS.n186 VSS.n66 6777.49
R3 VSS.n186 VSS.n39 1581.07
R4 VSS.t31 VSS.n146 88.7251
R5 VSS.n121 VSS.t55 88.7251
R6 VSS.t33 VSS.n144 83.1798
R7 VSS.n163 VSS.t54 83.1798
R8 VSS.t34 VSS.n142 77.6345
R9 VSS.t52 VSS.n123 77.6345
R10 VSS.n46 VSS.t107 9.76925
R11 VSS.t35 VSS.n140 72.0892
R12 VSS.n162 VSS.t51 72.0892
R13 VSS.n46 VSS.t79 9.77299
R14 VSS.t36 VSS.n138 66.5439
R15 VSS.t49 VSS.n125 66.5439
R16 VSS.t106 VSS.n46 12.2976
R17 VSS.t37 VSS.n136 60.9987
R18 VSS.n127 VSS.t48 60.9987
R19 VSS.n46 VSS.t103 16.2707
R20 VSS.n148 VSS.t38 55.4534
R21 VSS.n133 VSS.t41 55.4534
R22 VSS.t42 VSS.n130 55.4534
R23 VSS.n161 VSS.t46 55.4534
R24 VSS.t101 VSS.n98 17.7154
R25 VSS.n46 VSS.t85 17.717
R26 VSS.t39 VSS.n149 49.9081
R27 VSS.n159 VSS.t40 49.9081
R28 VSS.n150 VSS.t43 49.9081
R29 VSS.n160 VSS.t45 49.9081
R30 VSS.t100 VSS.n45 49.3453
R31 VSS.n46 VSS.t86 18.8
R32 VSS.n100 VSS.t25 56.9328
R33 VSS.t98 VSS.n44 45.5502
R34 VSS.t92 VSS.n46 19.5199
R35 VSS.n158 VSS.t39 44.3628
R36 VSS.t40 VSS.n134 44.3628
R37 VSS.t43 VSS.n129 44.3628
R38 VSS.t45 VSS.n151 44.3628
R39 VSS.t97 VSS.n48 41.7612
R40 VSS.n47 VSS.t89 19.8769
R41 VSS.n48 VSS.t95 19.8825
R42 VSS.t38 VSS.n135 38.8175
R43 VSS.t41 VSS.n132 38.8175
R44 VSS.n131 VSS.t42 38.8175
R45 VSS.t46 VSS.n128 38.8175
R46 VSS.n48 VSS.n46 0.00610339
R47 VSS.n47 VSS.n46 0.0194104
R48 VSS.n44 VSS.t97 37.9555
R49 VSS.t94 VSS.n46 19.5206
R50 VSS.t88 VSS.n46 19.5219
R51 VSS.n45 VSS.t98 34.1604
R52 VSS.n104 VSS.t13 41.7518
R53 VSS.n137 VSS.t37 33.2722
R54 VSS.t48 VSS.n126 33.2722
R55 VSS.n102 VSS.t11 37.9567
R56 VSS.n105 VSS.t17 37.9574
R57 VSS.n139 VSS.t36 27.7269
R58 VSS.n156 VSS.t49 27.7269
R59 VSS.t83 VSS.n46 16.2727
R60 VSS.n107 VSS.t8 30.3666
R61 VSS.n106 VSS.t23 53.1379
R62 VSS.n99 VSS.t10 34.1626
R63 VSS.t77 VSS.n66 6.87996
R64 VSS.t16 VSS.n105 45.5462
R65 VSS.t23 VSS.n100 26.5709
R66 VSS.t25 VSS.n97 22.7844
R67 VSS.n141 VSS.t35 22.1816
R68 VSS.t51 VSS.n124 22.1816
R69 VSS.t82 VSS.n46 14.4672
R70 VSS.n66 VSS.t29 9.77002
R71 VSS.n66 VSS.n100 0.0111485
R72 VSS.n110 VSS.t20 34.162
R73 VSS.n66 VSS.n108 0.0109013
R74 VSS.n101 VSS.t17 41.7521
R75 VSS.n66 VSS.n105 0.0111485
R76 VSS.n66 VSS.n109 0.0093246
R77 VSS.n103 VSS.t13 37.957
R78 VSS.n104 VSS.t11 41.7521
R79 VSS.n66 VSS.n107 0.0109013
R80 VSS.n107 VSS.t7 53.1373
R81 VSS.t76 VSS.n60 0.0213927
R82 VSS.n66 VSS.n60 1.03961
R83 VSS.n60 VSS.t30 17.0005
R84 VSS.n61 VSS.n59 0.00513447
R85 VSS.t30 VSS.n61 8.50175
R86 VSS.n60 VSS.t78 17.0005
R87 VSS.t78 VSS.n61 8.501
R88 VSS.n66 VSS.n62 0.816093
R89 VSS.t75 VSS.n56 5.66244
R90 VSS.n57 VSS.t1 5.66128
R91 VSS.n56 VSS.n57 0.0183293
R92 VSS.n70 VSS.n39 0.650675
R93 VSS.n15 VSS.n70 14.4044
R94 VSS.n16 VSS.n68 14.4044
R95 VSS.n120 VSS.n39 8.49985
R96 VSS.n75 VSS.n39 0.650675
R97 VSS.n0 VSS.n75 14.4044
R98 VSS.n163 VSS.n81 7.20256
R99 VSS.n85 VSS.n39 0.650675
R100 VSS.n157 VSS.n85 7.20256
R101 VSS.n96 VSS.n39 0.650675
R102 VSS.t56 VSS.n42 0.00443652
R103 VSS.n19 VSS.n96 14.4044
R104 VSS.n162 VSS.n95 7.20256
R105 VSS.n95 VSS.n39 0.650675
R106 VSS.n72 VSS.n39 0.650675
R107 VSS.n156 VSS.n72 7.20256
R108 VSS.n86 VSS.n39 0.650675
R109 VSS.n21 VSS.n86 14.4044
R110 VSS.n127 VSS.n39 8.50232
R111 VSS.n3 VSS.n94 14.4044
R112 VSS.n42 VSS.n39 0.302285
R113 VSS.n94 VSS.n39 0.650675
R114 VSS.n161 VSS.n92 7.20256
R115 VSS.n92 VSS.n39 0.650675
R116 VSS.n151 VSS.n88 7.20256
R117 VSS.n160 VSS.n87 7.20256
R118 VSS.n87 VSS.n39 0.650675
R119 VSS.n64 VSS.n39 5.66421
R120 VSS.n73 VSS.n39 0.650675
R121 VSS.n150 VSS.n73 7.20256
R122 VSS.n7 VSS.n91 14.4044
R123 VSS.t32 VSS.n37 0.218569
R124 VSS.n24 VSS.n83 14.6203
R125 VSS.n133 VSS.n39 8.50038
R126 VSS.n9 VSS.n74 14.4044
R127 VSS.n79 VSS.n39 0.650675
R128 VSS.n10 VSS.n79 14.4044
R129 VSS.n77 VSS.n39 0.650675
R130 VSS.n149 VSS.n77 7.20256
R131 VSS.n11 VSS.n90 14.4044
R132 VSS.n82 VSS.n39 0.650675
R133 VSS.n148 VSS.n82 7.20256
R134 VSS.n135 VSS.n39 8.50001
R135 VSS.n76 VSS.n39 0.650675
R136 VSS.n25 VSS.n76 14.4044
R137 VSS.n84 VSS.n39 0.650675
R138 VSS.n27 VSS.n84 14.4044
R139 VSS.n139 VSS.n39 8.499
R140 VSS.n89 VSS.n39 0.650675
R141 VSS.n28 VSS.n89 14.4044
R142 VSS.n30 VSS.n69 14.4044
R143 VSS.n142 VSS.n39 8.49977
R144 VSS.n31 VSS.n78 14.4044
R145 VSS.n144 VSS.n39 8.49671
R146 VSS.n145 VSS.n39 8.49988
R147 VSS.n71 VSS.n39 0.650675
R148 VSS.n33 VSS.n71 14.4044
R149 VSS.n35 VSS.n80 14.4044
R150 VSS.n93 VSS.n39 0.650675
R151 VSS.t66 VSS.n93 7.20256
R152 VSS.n38 VSS.n39 0.416393
R153 VSS.n39 VSS.n121 8.49935
R154 VSS.n39 VSS.n122 8.49538
R155 VSS.n39 VSS.n123 8.4991
R156 VSS.n39 VSS.n124 8.4996
R157 VSS.n39 VSS.n125 8.49885
R158 VSS.n39 VSS.n126 8.49562
R159 VSS.n39 VSS.n128 8.49587
R160 VSS.n39 VSS.n129 8.4986
R161 VSS.n39 VSS.n130 8.49612
R162 VSS.n39 VSS.n131 8.49835
R163 VSS.n39 VSS.n132 8.49636
R164 VSS.n39 VSS.n134 8.49661
R165 VSS.n39 VSS.n136 8.49686
R166 VSS.n39 VSS.n137 8.4981
R167 VSS.n39 VSS.n138 8.49711
R168 VSS.n39 VSS.n140 8.49725
R169 VSS.n39 VSS.n141 8.49785
R170 VSS.n39 VSS.n143 8.49873
R171 VSS.n39 VSS.n146 8.49736
R172 VSS.n39 VSS.n147 8.4976
R173 VSS.n40 VSS.n42 0.0306683
R174 VSS.n37 VSS.n63 0.0559302
R175 VSS.n53 VSS.n46 1.13461
R176 VSS.n51 VSS.n46 1.10869
R177 VSS.n52 VSS.t63 5.67335
R178 VSS.n51 VSS.n52 0.00850267
R179 VSS.n54 VSS.t60 5.67335
R180 VSS.n53 VSS.n54 0.00850269
R181 VSS.t59 VSS.n54 5.66343
R182 VSS.n143 VSS.t34 16.6364
R183 VSS.n157 VSS.t52 16.6364
R184 VSS.t80 VSS.n46 12.3005
R185 VSS.t32 VSS.t69 4.99233
R186 VSS.t32 VSS.t65 4.99233
R187 VSS.t56 VSS.t67 4.99233
R188 VSS.t56 VSS.t71 4.99233
R189 VSS.t68 VSS.n70 7.20324
R190 VSS.n6 VSS.n91 14.4051
R191 VSS.n8 VSS.n74 14.4051
R192 VSS.n14 VSS.n78 14.4051
R193 VSS.n158 VSS.n90 7.20324
R194 VSS.n159 VSS.n79 7.20324
R195 VSS.n5 VSS.n87 14.4051
R196 VSS.n4 VSS.n92 14.4051
R197 VSS.n22 VSS.n94 14.4051
R198 VSS.n2 VSS.n95 14.4051
R199 VSS.n1 VSS.n81 14.4051
R200 VSS.t32 VSS.n38 0.0182644
R201 VSS.n110 VSS.t22 49.3419
R202 VSS.n101 VSS.t19 41.7518
R203 VSS.n103 VSS.t14 45.5468
R204 VSS.n66 VSS.t0 9.76978
R205 VSS.n66 VSS.t2 12.2982
R206 VSS.n66 VSS.t4 14.4658
R207 VSS.n67 VSS.t5 16.2711
R208 VSS.n99 VSS.t8 49.3419
R209 VSS.n102 VSS.t10 45.5478
R210 VSS.n109 VSS.t14 34.1648
R211 VSS.n108 VSS.t19 37.9567
R212 VSS.n106 VSS.t22 30.3666
R213 VSS.n97 VSS.t26 14.4657
R214 VSS.n66 VSS.t28 12.2981
R215 VSS.n145 VSS.t33 11.0911
R216 VSS.t54 VSS.n122 11.0911
R217 VSS.n216 VSS.t32 1581.16
R218 VSS.t32 VSS.n163 8.5005
R219 VSS.t32 VSS.n162 8.5005
R220 VSS.t32 VSS.n161 8.5005
R221 VSS.t32 VSS.n160 8.5005
R222 VSS.t32 VSS.n159 8.5005
R223 VSS.t32 VSS.n158 8.5005
R224 VSS.t32 VSS.n157 8.5005
R225 VSS.t32 VSS.n156 8.5005
R226 VSS.t32 VSS.n151 8.5005
R227 VSS.t32 VSS.n150 8.5005
R228 VSS.t32 VSS.n149 8.5005
R229 VSS.t32 VSS.n148 8.5005
R230 VSS.n155 VSS.n39 8.4984
R231 VSS.n153 VSS.n39 8.4984
R232 VSS.n152 VSS.n64 0.0161786
R233 VSS.n37 VSS.n39 1.87775
R234 VSS.n41 VSS.n40 0.0267633
R235 VSS.t32 VSS.n41 0.27896
R236 VSS.t32 VSS.n154 8.4984
R237 VSS.t32 VSS.n152 8.4984
R238 VSS.t73 VSS.n62 0.0757845
R239 VSS.n46 VSS.t62 6.87897
R240 VSS.n46 VSS.t58 6.87872
R241 VSS.n17 VSS.n121 7.20236
R242 VSS.n18 VSS.n123 7.20236
R243 VSS.n20 VSS.n125 7.20236
R244 VSS.n23 VSS.n131 7.20236
R245 VSS.n26 VSS.n137 7.20236
R246 VSS.n29 VSS.n141 7.20236
R247 VSS.n32 VSS.n145 7.20236
R248 VSS.n34 VSS.n147 7.20236
R249 VSS.n0 VSS.n122 7.20236
R250 VSS.n7 VSS.n130 7.20236
R251 VSS.n9 VSS.n134 7.20236
R252 VSS.n12 VSS.n76 14.4051
R253 VSS.n13 VSS.n89 14.4051
R254 VSS.n35 VSS.n93 14.4051
R255 VSS.n34 VSS.n80 14.4051
R256 VSS.n33 VSS.n146 7.20236
R257 VSS.n32 VSS.n71 14.4051
R258 VSS.n31 VSS.n144 7.20236
R259 VSS.n14 VSS.n143 7.20236
R260 VSS.n30 VSS.n142 7.20236
R261 VSS.n29 VSS.n69 14.4051
R262 VSS.n28 VSS.n140 7.20236
R263 VSS.n13 VSS.n139 7.20236
R264 VSS.n27 VSS.n138 7.20236
R265 VSS.n26 VSS.n84 14.4051
R266 VSS.n25 VSS.n136 7.20236
R267 VSS.n12 VSS.n135 7.20236
R268 VSS.n11 VSS.n82 14.4051
R269 VSS.n10 VSS.n77 14.4051
R270 VSS.n8 VSS.n133 7.20236
R271 VSS.n24 VSS.n132 7.20236
R272 VSS.n23 VSS.n83 14.6209
R273 VSS.n6 VSS.n129 7.20236
R274 VSS.n5 VSS.n73 14.4051
R275 VSS.n4 VSS.n88 14.4051
R276 VSS.n22 VSS.n128 7.20236
R277 VSS.n3 VSS.n127 7.20236
R278 VSS.n21 VSS.n126 7.20236
R279 VSS.n20 VSS.n86 14.4051
R280 VSS.n2 VSS.n72 14.4051
R281 VSS.n19 VSS.n124 7.20236
R282 VSS.n18 VSS.n96 14.4051
R283 VSS.n1 VSS.n85 14.4051
R284 VSS.n17 VSS.n75 14.4051
R285 VSS.n16 VSS.n120 7.20236
R286 VSS.n15 VSS.n68 14.4051
R287 VSS.t32 VSS.t68 7.80746
R288 VSS.n147 VSS.t31 5.54579
R289 VSS.t55 VSS.n120 5.54579
R290 VSS.n216 VSS.n66 6777.49
R291 VSS.n220 VSS.n114 3.77525
R292 VSS.n221 VSS.n220 3.77525
R293 VSS.n210 VSS.n209 3.77525
R294 VSS.n209 VSS.n165 3.77525
R295 VSS.t76 VSS.n185 3.0005
R296 VSS.n58 VSS.t73 0.019456
R297 VSS.t61 VSS.n50 0.00951816
R298 VSS.t57 VSS.n55 0.00951816
R299 VSS.n108 VSS.t20 45.5472
R300 VSS.n66 VSS.n106 0.0108886
R301 VSS.n66 VSS.n110 0.0109013
R302 VSS.n66 VSS.n101 0.0109013
R303 VSS.n66 VSS.n103 0.0109013
R304 VSS.n66 VSS.n104 0.0109013
R305 VSS.n66 VSS.n102 0.0108886
R306 VSS.n66 VSS.n99 0.0108886
R307 VSS.n67 VSS.t7 26.5794
R308 VSS.n66 VSS.n67 0.00396884
R309 VSS.n66 VSS.t74 6.87996
R310 VSS.n165 VSS.n164 2.92212
R311 VSS.n109 VSS.t16 34.1651
R312 VSS.n223 VSS.n222 2.52012
R313 VSS.n49 VSS.t105 2.48177
R314 VSS.t102 VSS.n191 2.48177
R315 VSS.t99 VSS.n192 2.48177
R316 VSS.t96 VSS.n166 2.48177
R317 VSS.t90 VSS.n167 2.48177
R318 VSS.n187 VSS.t87 2.48177
R319 VSS.n188 VSS.t84 2.48177
R320 VSS.n189 VSS.t81 2.48177
R321 VSS.n212 VSS.t119 2.48177
R322 VSS.n213 VSS.t121 2.48177
R323 VSS.n214 VSS.t123 2.48177
R324 VSS.n215 VSS.t125 2.48177
R325 VSS.n217 VSS.t3 2.48177
R326 VSS.n218 VSS.t6 2.48177
R327 VSS.n219 VSS.t9 2.48177
R328 VSS.n119 VSS.t12 2.48177
R329 VSS.t18 VSS.n118 2.48177
R330 VSS.n182 VSS.t21 2.48177
R331 VSS.n183 VSS.t24 2.48177
R332 VSS.n184 VSS.t27 2.48177
R333 VSS.n212 VSS.t44 2.48177
R334 VSS.n213 VSS.t47 2.48177
R335 VSS.n214 VSS.t50 2.48177
R336 VSS.n215 VSS.n43 0.466971
R337 VSS.n39 VSS.n68 0.650675
R338 VSS.n39 VSS.n81 0.650675
R339 VSS.n39 VSS.n88 0.650675
R340 VSS.n39 VSS.n91 0.650675
R341 VSS.n39 VSS.n74 0.650675
R342 VSS.n39 VSS.n90 0.650675
R343 VSS.n39 VSS.n69 0.650675
R344 VSS.n39 VSS.n78 0.650675
R345 VSS.n39 VSS.n80 0.650675
R346 VSS.n66 VSS.n178 2.09947
R347 VSS.n66 VSS.n111 2.09947
R348 VSS.n180 VSS.n66 2.09947
R349 VSS.n66 VSS.n176 2.09947
R350 VSS.n66 VSS.n116 2.09947
R351 VSS.n66 VSS.n174 2.09947
R352 VSS.n66 VSS.n172 2.09947
R353 VSS.n66 VSS.n170 2.09947
R354 VSS.n206 VSS.n46 2.09901
R355 VSS.n194 VSS.n46 2.09887
R356 VSS.n198 VSS.n46 2.09874
R357 VSS.n196 VSS.n46 2.09865
R358 VSS.n46 VSS.n113 2.0986
R359 VSS.n204 VSS.n46 2.09849
R360 VSS.n208 VSS.n46 2.09849
R361 VSS.n202 VSS.n46 2.09849
R362 VSS.n39 VSS.n83 0.542754
R363 VSS.n36 VSS.n211 1.88787
R364 VSS.n36 VSS.n115 1.88787
R365 VSS.n66 VSS.n56 1.31711
R366 VSS.n217 VSS.n58 1.2163
R367 VSS.n185 VSS.n59 1.52811
R368 VSS.n211 VSS.n114 1.1929
R369 VSS.n211 VSS.n210 1.1929
R370 VSS.n221 VSS.n115 1.1929
R371 VSS.n165 VSS.n115 1.1929
R372 VSS.n66 VSS.n65 0.96569
R373 VSS.n200 VSS.n46 0.910334
R374 VSS.n190 VSS.n46 0.908988
R375 VSS.n210 VSS.n164 0.841009
R376 VSS.t32 VSS.n0 0.650322
R377 VSS.t32 VSS.n1 0.650322
R378 VSS.t32 VSS.n2 0.650322
R379 VSS.t32 VSS.n3 0.650322
R380 VSS.t32 VSS.n4 0.650322
R381 VSS.t32 VSS.n5 0.650322
R382 VSS.t32 VSS.n6 0.650322
R383 VSS.t32 VSS.n7 0.650322
R384 VSS.t32 VSS.n8 0.650322
R385 VSS.t32 VSS.n9 0.650322
R386 VSS.t32 VSS.n10 0.650322
R387 VSS.t32 VSS.n11 0.650322
R388 VSS.t32 VSS.n12 0.650322
R389 VSS.t32 VSS.n13 0.650322
R390 VSS.t32 VSS.n14 0.650322
R391 VSS.n38 VSS.t66 7.81013
R392 VSS.t32 VSS.n15 0.650322
R393 VSS.t32 VSS.n16 0.650322
R394 VSS.t32 VSS.n17 0.650322
R395 VSS.t32 VSS.n18 0.650322
R396 VSS.t32 VSS.n19 0.650322
R397 VSS.t32 VSS.n20 0.650322
R398 VSS.t32 VSS.n21 0.650322
R399 VSS.t32 VSS.n22 0.650322
R400 VSS.t32 VSS.n23 0.650322
R401 VSS.t32 VSS.n24 0.650322
R402 VSS.t32 VSS.n25 0.650322
R403 VSS.t32 VSS.n26 0.650322
R404 VSS.t32 VSS.n27 0.650322
R405 VSS.t32 VSS.n28 0.650322
R406 VSS.t32 VSS.n29 0.650322
R407 VSS.t32 VSS.n30 0.650322
R408 VSS.t32 VSS.n31 0.650322
R409 VSS.t32 VSS.n32 0.650322
R410 VSS.t32 VSS.n33 0.650322
R411 VSS.t32 VSS.n34 0.650322
R412 VSS.t32 VSS.n35 0.650322
R413 VSS.n224 VSS.n223 0.439009
R414 VSS.n224 VSS.n114 0.4025
R415 VSS.n222 VSS.n221 0.4025
R416 VSS.n50 VSS.n49 1.21965
R417 VSS.n55 VSS.n189 1.21965
R418 VSS.n185 VSS.n184 0.209825
R419 VSS.n112 VSS.t3 0.200997
R420 VSS.n171 VSS.t6 0.200997
R421 VSS.n173 VSS.t9 0.200997
R422 VSS.n175 VSS.t12 0.200997
R423 VSS.n169 VSS.t18 0.200997
R424 VSS.t21 VSS.n181 0.200997
R425 VSS.n177 VSS.t24 0.200997
R426 VSS.n179 VSS.t27 0.200997
R427 VSS.n63 VSS.t44 0.200997
R428 VSS.n40 VSS.t47 0.200997
R429 VSS.t56 VSS.t50 0.200997
R430 VSS.n43 VSS.t53 0.15167
R431 VSS.t105 VSS.n199 0.200995
R432 VSS.n197 VSS.t102 0.200995
R433 VSS.n195 VSS.t99 0.200995
R434 VSS.n193 VSS.t96 0.200995
R435 VSS.n207 VSS.t90 0.200995
R436 VSS.n205 VSS.t87 0.200995
R437 VSS.n203 VSS.t84 0.200995
R438 VSS.n201 VSS.t81 0.200995
R439 VSS.t119 VSS.n63 0.200995
R440 VSS.t121 VSS.n40 0.200995
R441 VSS.t123 VSS.t56 0.200995
R442 VSS.t125 VSS.t56 0.200995
R443 VSS.t32 VSS.t117 0.185126
R444 VSS.n218 VSS.n217 0.16242
R445 VSS.n219 VSS.n218 0.16242
R446 VSS.n119 VSS.n219 0.16242
R447 VSS.n117 VSS.n119 0.16242
R448 VSS.n117 VSS.n118 0.16242
R449 VSS.n182 VSS.n118 0.16242
R450 VSS.n183 VSS.n182 0.16242
R451 VSS.n184 VSS.n183 0.16242
R452 VSS.n189 VSS.n188 0.16242
R453 VSS.n188 VSS.n187 0.16242
R454 VSS.n187 VSS.n167 0.16242
R455 VSS.n168 VSS.n167 0.16242
R456 VSS.n168 VSS.n166 0.16242
R457 VSS.n192 VSS.n166 0.16242
R458 VSS.n192 VSS.n191 0.16242
R459 VSS.n49 VSS.n191 0.16242
R460 VSS.n199 VSS.n190 0.147608
R461 VSS.n201 VSS.n200 0.145358
R462 VSS.n65 VSS.n179 0.143085
R463 VSS.n170 VSS.n112 0.0952183
R464 VSS.n202 VSS.n201 0.0936887
R465 VSS.n199 VSS.n198 0.0934382
R466 VSS.n172 VSS.n171 0.0927738
R467 VSS.n179 VSS.n178 0.0925656
R468 VSS.n197 VSS.n196 0.0915017
R469 VSS.n204 VSS.n203 0.0914366
R470 VSS.n174 VSS.n173 0.0903294
R471 VSS.n176 VSS.t15 0.0903294
R472 VSS.n177 VSS.n111 0.0901212
R473 VSS.n206 VSS.n205 0.0897551
R474 VSS.t93 VSS.n113 0.0891211
R475 VSS.t93 VSS.n208 0.0889922
R476 VSS.n195 VSS.n194 0.0884223
R477 VSS.n116 VSS.n175 0.0878849
R478 VSS.n180 VSS.n169 0.0878849
R479 VSS.t15 VSS.n116 0.0876767
R480 VSS.n181 VSS.n180 0.0876767
R481 VSS.n194 VSS.n193 0.0871182
R482 VSS.n208 VSS.n207 0.0865477
R483 VSS.n193 VSS.n113 0.0864162
R484 VSS.n207 VSS.n206 0.0857922
R485 VSS.n181 VSS.n111 0.0854405
R486 VSS.n175 VSS.n174 0.0852323
R487 VSS.n176 VSS.n169 0.0852323
R488 VSS.n65 VSS.t76 0.0849321
R489 VSS.n62 VSS.n112 0.153348
R490 VSS.n205 VSS.n204 0.0841033
R491 VSS.n196 VSS.n195 0.0840349
R492 VSS.n200 VSS.t57 0.0834709
R493 VSS.n178 VSS.n177 0.082996
R494 VSS.n173 VSS.n172 0.0827878
R495 VSS.n198 VSS.n197 0.0821061
R496 VSS.t61 VSS.n190 0.0820995
R497 VSS.n203 VSS.n202 0.0818468
R498 VSS.n212 VSS.t32 0.08146
R499 VSS.n213 VSS.n212 0.08146
R500 VSS.n214 VSS.n213 0.08146
R501 VSS.n215 VSS.n214 0.08146
R502 VSS.n171 VSS.n170 0.0803434
R503 VSS.n164 VSS 0.045455
R504 VSS.n223 VSS 0.045455
R505 VSS VSS.n224 0.0445
R506 VSS.n222 VSS 0.0445
R507 VSS.t15 VSS.n117 0.0394177
R508 VSS.n168 VSS.t93 0.0394177
R509 VSS.n220 VSS.n117 0.0389615
R510 VSS.n209 VSS.n168 0.0389615
R511 VSS.n43 VSS.t56 0.0386523
R512 VSS.t32 VSS.n36 0.0197308
R513 VSS.n51 VSS.n50 0.00533749
R514 VSS.n55 VSS.n53 0.00533749
R515 VSS.n154 VSS.n153 0.0118857
R516 VSS.n64 VSS.n63 0.00858771
R517 VSS.n153 VSS.n152 0.0118857
R518 VSS.n155 VSS.n154 0.0118857
R519 VSS.n41 VSS.n155 0.360656
R520 VSS.n47 VSS.t91 19.903
R521 VSS.n46 VSS.n44 0.0112168
R522 VSS.n46 VSS.n45 0.0112168
R523 VSS.n98 VSS.t100 30.373
R524 VSS.n46 VSS.t104 14.4648
R525 VSS.n46 VSS.n98 0.0320944
R526 VSS.n66 VSS.n97 0.0306182
R527 VSS.n58 VSS.n57 0.0195611
R528 VSS.n60 VSS.n59 0.0183418
R529 VSS.n52 VSS.t64 5.66343
C0 VDD vout4 11.7272f
C1 vin2 vout2 16.0649f
C2 vout1 vin1 16.0649f
C3 vin2 VDD 26.9696f
C4 vin2 vin3 0.12731f
C5 VDD vin1 26.9799f
C6 VDD vout1 11.7272f
C7 VDD vout2 11.7272f
C8 VDD vin4 26.9799f
C9 vout3 VDD 11.7272f
C10 vin3 vin4 0.11002f
C11 vin4 vout4 16.0649f
C12 vin2 vin1 0.11002f
C13 vin3 vout3 16.0649f
C14 vin3 VDD 26.9696f
C15 vout1 VSS 11.99485f
C16 vout2 VSS 11.97725f
C17 vout3 VSS 11.97725f
C18 vout4 VSS 11.99485f
C19 VSS.t53 VSS 7.1315f
C20 VSS.t24 VSS 7.1491f
.ends
