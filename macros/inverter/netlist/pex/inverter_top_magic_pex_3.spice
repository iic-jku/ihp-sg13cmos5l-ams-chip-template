* PEX produced on Mon Aug 24 05:09:40 PM CEST 2026 using /foss/tools/sak/sak-pex.sh with m=3 and s=1 (extresist threshold=10000 mOhm, minres=1000 mOhm, mindelay=1 ps)
* NGSPICE file created from inverter_top_pex.ext - technology: ihp-sg13cmos5l

.subckt inverter_top_pex VDD vin4 vout4 VSS vin3 vout3 vin2 vout2 vout1 vin1
X0 vout4 vin4 VDD VDD sg13_lv_pmos ad=1.14p pd=6.38u as=1.14p ps=6.38u w=6u l=1u
X1 VDD vin2 vout2 VDD sg13_lv_pmos ad=1.14p pd=6.38u as=1.14p ps=6.38u w=6u l=1u
X2 VSS.t32 vin2 vout2 VSS.t43 sg13_lv_nmos ad=0.19p pd=1.38u as=0.19p ps=1.38u w=1u l=1u
X3 vout2 vin2 VSS.t32 VSS.t46 sg13_lv_nmos ad=0.19p pd=1.38u as=0.19p ps=1.38u w=1u l=1u
X4 vout2 vin2 VDD VDD sg13_lv_pmos ad=1.14p pd=6.38u as=1.14p ps=6.38u w=6u l=1u
X5 VSS.t52 vin4 vout4 VSS.t78 sg13_lv_nmos ad=0.19p pd=1.38u as=0.19p ps=1.38u w=1u l=1u
X6 vout1 vin1 VSS.t24 VSS.t25 sg13_lv_nmos ad=0.19p pd=1.38u as=0.19p ps=1.38u w=1u l=1u
X7 VDD vin2 vout2 VDD sg13_lv_pmos ad=1.14p pd=6.38u as=1.14p ps=6.38u w=6u l=1u
X8 vout4 vin4 VSS.t54 VSS.t73 sg13_lv_nmos ad=0.19p pd=1.38u as=0.19p ps=1.38u w=1u l=1u
X9 VDD vin2 vout2 VDD sg13_lv_pmos ad=1.14p pd=6.38u as=1.14p ps=6.38u w=6u l=1u
X10 VSS.t32 vin3 vout3 VSS.t49 sg13_lv_nmos ad=0.19p pd=1.38u as=0.19p ps=1.38u w=1u l=1u
X11 vout4 vin4 VSS.t52 VSS.t85 sg13_lv_nmos ad=0.19p pd=1.38u as=0.19p ps=1.38u w=1u l=1u
X12 VDD vin3 vout3 VDD sg13_lv_pmos ad=1.14p pd=6.38u as=1.14p ps=6.38u w=6u l=1u
X13 VSS.t52 vin4 vout4 VSS.t80 sg13_lv_nmos ad=0.19p pd=1.38u as=0.19p ps=1.38u w=1u l=1u
X14 VDD vin2 vout2 VDD sg13_lv_pmos ad=1.14p pd=6.38u as=1.14p ps=6.38u w=6u l=1u
X15 vout3 vin3 VDD VDD sg13_lv_pmos ad=1.14p pd=6.38u as=1.14p ps=6.38u w=6u l=1u
X16 vout2 vin2 VDD VDD sg13_lv_pmos ad=1.14p pd=6.38u as=1.14p ps=6.38u w=6u l=1u
X17 VSS.t32 vin2 vout2 VSS.t39 sg13_lv_nmos ad=0.19p pd=1.38u as=0.19p ps=1.38u w=1u l=1u
X18 VDD vin3 vout3 VDD sg13_lv_pmos ad=1.14p pd=6.38u as=1.14p ps=6.38u w=6u l=1u
X19 VSS.t32 VSS.t59 VSS.t32 VSS.t60 sg13_lv_nmos ad=0.34p pd=2.68u as=0 ps=0 w=1u l=1u
X20 vout2 vin2 VSS.t32 VSS.t42 sg13_lv_nmos ad=0.19p pd=1.38u as=0.19p ps=1.38u w=1u l=1u
X21 vout1 vin1 VSS.t18 VSS.t19 sg13_lv_nmos ad=0.19p pd=1.38u as=0.19p ps=1.38u w=1u l=1u
X22 VSS.t32 vin2 vout2 VSS.t45 sg13_lv_nmos ad=0.19p pd=1.38u as=0.19p ps=1.38u w=1u l=1u
X23 vout4 vin4 VSS.t52 VSS.t83 sg13_lv_nmos ad=0.19p pd=1.38u as=0.19p ps=1.38u w=1u l=1u
X24 vout1 vin1 VDD VDD sg13_lv_pmos ad=1.14p pd=6.38u as=1.14p ps=6.38u w=6u l=1u
X25 vout1 vin1 VSS.t12 VSS.t13 sg13_lv_nmos ad=0.19p pd=1.38u as=0.19p ps=1.38u w=1u l=1u
X26 VSS.t52 vin4 vout4 VSS.t86 sg13_lv_nmos ad=0.19p pd=1.38u as=0.19p ps=1.38u w=1u l=1u
X27 VDD VDD VDD VDD sg13_lv_pmos ad=1.14p pd=6.38u as=0.56797n ps=1.006m w=6u l=1u
X28 VSS.t18 vin1 vout1 VSS.t17 sg13_lv_nmos ad=0.19p pd=1.38u as=0.19p ps=1.38u w=1u l=1u
X29 vout2 vin2 VDD VDD sg13_lv_pmos ad=1.14p pd=6.38u as=1.14p ps=6.38u w=6u l=1u
X30 VDD vin4 vout4 VDD sg13_lv_pmos ad=1.14p pd=6.38u as=1.14p ps=6.38u w=6u l=1u
X31 vout1 vin1 VSS.t21 VSS.t22 sg13_lv_nmos ad=0.19p pd=1.38u as=0.19p ps=1.38u w=1u l=1u
X32 vout3 vin3 VSS.t32 VSS.t48 sg13_lv_nmos ad=0.19p pd=1.38u as=0.19p ps=1.38u w=1u l=1u
X33 vout4 vin4 VDD VDD sg13_lv_pmos ad=1.14p pd=6.38u as=1.14p ps=6.38u w=6u l=1u
X34 VDD vin3 vout3 VDD sg13_lv_pmos ad=1.14p pd=6.38u as=1.14p ps=6.38u w=6u l=1u
X35 VDD vin4 vout4 VDD sg13_lv_pmos ad=1.14p pd=6.38u as=1.14p ps=6.38u w=6u l=1u
X36 vout3 vin3 VDD VDD sg13_lv_pmos ad=1.14p pd=6.38u as=1.14p ps=6.38u w=6u l=1u
X37 VDD vin3 vout3 VDD sg13_lv_pmos ad=1.14p pd=6.38u as=1.14p ps=6.38u w=6u l=1u
X38 VSS.t58 VSS.t52 VSS.t57 VSS.t56 sg13_lv_nmos ad=0.19p pd=1.38u as=0 ps=0 w=1u l=1u
X39 VDD vin4 vout4 VDD sg13_lv_pmos ad=1.14p pd=6.38u as=1.14p ps=6.38u w=6u l=1u
X40 VDD vin2 vout2 VDD sg13_lv_pmos ad=1.14p pd=6.38u as=1.14p ps=6.38u w=6u l=1u
X41 VSS.t52 vin4 vout4 VSS.t88 sg13_lv_nmos ad=0.19p pd=1.38u as=0.19p ps=1.38u w=1u l=1u
X42 VDD vin3 vout3 VDD sg13_lv_pmos ad=1.14p pd=6.38u as=1.14p ps=6.38u w=6u l=1u
X43 VSS.t12 vin1 vout1 VSS.t11 sg13_lv_nmos ad=0.19p pd=1.38u as=0.19p ps=1.38u w=1u l=1u
X44 VDD vin1 vout1 VDD sg13_lv_pmos ad=1.14p pd=6.38u as=1.14p ps=6.38u w=6u l=1u
X45 vout4 vin4 VSS.t52 VSS.t91 sg13_lv_nmos ad=0.19p pd=1.38u as=0.19p ps=1.38u w=1u l=1u
X46 vout4 vin4 VDD VDD sg13_lv_pmos ad=1.14p pd=6.38u as=1.14p ps=6.38u w=6u l=1u
X47 vout1 vin1 VSS.t15 VSS.t16 sg13_lv_nmos ad=0.19p pd=1.38u as=0.19p ps=1.38u w=1u l=1u
X48 vout1 vin1 VDD VDD sg13_lv_pmos ad=1.14p pd=6.38u as=1.14p ps=6.38u w=6u l=1u
X49 VDD vin1 vout1 VDD sg13_lv_pmos ad=1.14p pd=6.38u as=1.14p ps=6.38u w=6u l=1u
X50 vout3 vin3 VSS.t32 VSS.t44 sg13_lv_nmos ad=0.19p pd=1.38u as=0.19p ps=1.38u w=1u l=1u
X51 VSS.t21 vin1 vout1 VSS.t20 sg13_lv_nmos ad=0.19p pd=1.38u as=0.19p ps=1.38u w=1u l=1u
X52 VDD VDD VDD VDD sg13_lv_pmos ad=2.04p pd=12.68u as=0 ps=0 w=6u l=1u
X53 vout4 vin4 VDD VDD sg13_lv_pmos ad=1.14p pd=6.38u as=1.14p ps=6.38u w=6u l=1u
X54 VDD vin3 vout3 VDD sg13_lv_pmos ad=1.14p pd=6.38u as=1.14p ps=6.38u w=6u l=1u
X55 VDD vin4 vout4 VDD sg13_lv_pmos ad=1.14p pd=6.38u as=1.14p ps=6.38u w=6u l=1u
X56 vout3 vin3 VSS.t32 VSS.t40 sg13_lv_nmos ad=0.19p pd=1.38u as=0.19p ps=1.38u w=1u l=1u
X57 vout3 vin3 VDD VDD sg13_lv_pmos ad=1.14p pd=6.38u as=1.14p ps=6.38u w=6u l=1u
X58 VSS.t32 vin3 vout3 VSS.t43 sg13_lv_nmos ad=0.19p pd=1.38u as=0.19p ps=1.38u w=1u l=1u
X59 VDD VDD VDD VDD sg13_lv_pmos ad=1.14p pd=6.38u as=0 ps=0 w=6u l=1u
X60 vout3 vin3 VSS.t32 VSS.t46 sg13_lv_nmos ad=0.19p pd=1.38u as=0.19p ps=1.38u w=1u l=1u
X61 vout4 vin4 VDD VDD sg13_lv_pmos ad=1.14p pd=6.38u as=1.14p ps=6.38u w=6u l=1u
X62 vout3 vin3 VDD VDD sg13_lv_pmos ad=1.14p pd=6.38u as=1.14p ps=6.38u w=6u l=1u
X63 VDD vin1 vout1 VDD sg13_lv_pmos ad=1.14p pd=6.38u as=1.14p ps=6.38u w=6u l=1u
X64 vout2 vin2 VDD VDD sg13_lv_pmos ad=1.14p pd=6.38u as=1.14p ps=6.38u w=6u l=1u
X65 vout1 vin1 VDD VDD sg13_lv_pmos ad=1.14p pd=6.38u as=1.14p ps=6.38u w=6u l=1u
X66 VDD vin1 vout1 VDD sg13_lv_pmos ad=1.14p pd=6.38u as=1.14p ps=6.38u w=6u l=1u
X67 vout2 vin2 VSS.t32 VSS.t36 sg13_lv_nmos ad=0.19p pd=1.38u as=0.19p ps=1.38u w=1u l=1u
X68 VDD vin1 vout1 VDD sg13_lv_pmos ad=1.14p pd=6.38u as=1.14p ps=6.38u w=6u l=1u
X69 VDD vin3 vout3 VDD sg13_lv_pmos ad=1.14p pd=6.38u as=1.14p ps=6.38u w=6u l=1u
X70 VSS.t32 vin3 vout3 VSS.t39 sg13_lv_nmos ad=0.19p pd=1.38u as=0.19p ps=1.38u w=1u l=1u
X71 vout3 vin3 VSS.t32 VSS.t42 sg13_lv_nmos ad=0.19p pd=1.38u as=0.19p ps=1.38u w=1u l=1u
X72 VSS.t52 vin4 vout4 VSS.t76 sg13_lv_nmos ad=0.19p pd=1.38u as=0.19p ps=1.38u w=1u l=1u
X73 VDD vin4 vout4 VDD sg13_lv_pmos ad=1.14p pd=6.38u as=1.14p ps=6.38u w=6u l=1u
X74 VSS.t32 vin3 vout3 VSS.t45 sg13_lv_nmos ad=0.19p pd=1.38u as=0.19p ps=1.38u w=1u l=1u
X75 vout4 vin4 VSS.t52 VSS.t79 sg13_lv_nmos ad=0.19p pd=1.38u as=0.19p ps=1.38u w=1u l=1u
X76 VDD vin1 vout1 VDD sg13_lv_pmos ad=1.14p pd=6.38u as=1.14p ps=6.38u w=6u l=1u
X77 vout2 vin2 VDD VDD sg13_lv_pmos ad=1.14p pd=6.38u as=1.14p ps=6.38u w=6u l=1u
X78 vout1 vin1 VDD VDD sg13_lv_pmos ad=1.14p pd=6.38u as=1.14p ps=6.38u w=6u l=1u
X79 VSS.t52 vin4 vout4 VSS.t74 sg13_lv_nmos ad=0.19p pd=1.38u as=0.19p ps=1.38u w=1u l=1u
X80 VDD VDD VDD VDD sg13_lv_pmos ad=2.04p pd=12.68u as=0 ps=0 w=6u l=1u
X81 vout2 vin2 VDD VDD sg13_lv_pmos ad=1.14p pd=6.38u as=1.14p ps=6.38u w=6u l=1u
X82 VDD vin2 vout2 VDD sg13_lv_pmos ad=1.14p pd=6.38u as=1.14p ps=6.38u w=6u l=1u
X83 VSS.t32 vin2 vout2 VSS.t35 sg13_lv_nmos ad=0.19p pd=1.38u as=0.19p ps=1.38u w=1u l=1u
X84 VSS.t52 vin4 vout4 VSS.t82 sg13_lv_nmos ad=0.19p pd=1.38u as=0.19p ps=1.38u w=1u l=1u
X85 VDD VDD VDD VDD sg13_lv_pmos ad=2.04p pd=12.68u as=0 ps=0 w=6u l=1u
X86 vout2 vin2 VDD VDD sg13_lv_pmos ad=1.14p pd=6.38u as=1.14p ps=6.38u w=6u l=1u
X87 vout2 vin2 VSS.t32 VSS.t38 sg13_lv_nmos ad=0.19p pd=1.38u as=0.19p ps=1.38u w=1u l=1u
X88 VSS.t32 vin2 vout2 VSS.t41 sg13_lv_nmos ad=0.19p pd=1.38u as=0.19p ps=1.38u w=1u l=1u
X89 vout1 vin1 VDD VDD sg13_lv_pmos ad=1.14p pd=6.38u as=1.14p ps=6.38u w=6u l=1u
X90 vout1 vin1 VSS.t6 VSS.t7 sg13_lv_nmos ad=0.19p pd=1.38u as=0.19p ps=1.38u w=1u l=1u
X91 vout4 vin4 VSS.t52 VSS.t81 sg13_lv_nmos ad=0.19p pd=1.38u as=0.19p ps=1.38u w=1u l=1u
X92 vout3 vin3 VDD VDD sg13_lv_pmos ad=1.14p pd=6.38u as=1.14p ps=6.38u w=6u l=1u
X93 vout4 vin4 VSS.t52 VSS.t89 sg13_lv_nmos ad=0.19p pd=1.38u as=0.19p ps=1.38u w=1u l=1u
X94 VSS.t32 VSS.t65 VSS.t32 VSS.t62 sg13_lv_nmos ad=0.19p pd=1.38u as=0 ps=0 w=1u l=1u
X95 VSS.t52 vin4 vout4 VSS.t84 sg13_lv_nmos ad=0.19p pd=1.38u as=0.19p ps=1.38u w=1u l=1u
X96 VDD vin1 vout1 VDD sg13_lv_pmos ad=1.14p pd=6.38u as=1.14p ps=6.38u w=6u l=1u
X97 VSS.t32 vin2 vout2 VSS.t51 sg13_lv_nmos ad=0.19p pd=1.38u as=0.19p ps=1.38u w=1u l=1u
X98 VDD vin2 vout2 VDD sg13_lv_pmos ad=1.14p pd=6.38u as=1.14p ps=6.38u w=6u l=1u
X99 vout4 vin4 VSS.t52 VSS.t87 sg13_lv_nmos ad=0.19p pd=1.38u as=0.19p ps=1.38u w=1u l=1u
X100 vout4 vin4 VDD VDD sg13_lv_pmos ad=1.14p pd=6.38u as=1.14p ps=6.38u w=6u l=1u
X101 vout2 vin2 VDD VDD sg13_lv_pmos ad=1.14p pd=6.38u as=1.14p ps=6.38u w=6u l=1u
X102 vout2 vin2 VSS.t32 VSS.t34 sg13_lv_nmos ad=0.19p pd=1.38u as=0.19p ps=1.38u w=1u l=1u
X103 VDD vin2 vout2 VDD sg13_lv_pmos ad=1.14p pd=6.38u as=1.14p ps=6.38u w=6u l=1u
X104 VSS.t32 vin2 vout2 VSS.t37 sg13_lv_nmos ad=0.19p pd=1.38u as=0.19p ps=1.38u w=1u l=1u
X105 VDD vin4 vout4 VDD sg13_lv_pmos ad=1.14p pd=6.38u as=1.14p ps=6.38u w=6u l=1u
X106 VDD VDD VDD VDD sg13_lv_pmos ad=2.04p pd=12.68u as=0 ps=0 w=6u l=1u
X107 VSS.t32 vin2 vout2 VSS.t33 sg13_lv_nmos ad=0.19p pd=1.38u as=0.19p ps=1.38u w=1u l=1u
X108 VSS.t6 vin1 vout1 VSS.t5 sg13_lv_nmos ad=0.19p pd=1.38u as=0.19p ps=1.38u w=1u l=1u
X109 vout3 vin3 VDD VDD sg13_lv_pmos ad=1.14p pd=6.38u as=1.14p ps=6.38u w=6u l=1u
X110 vout1 vin1 VSS.t9 VSS.t10 sg13_lv_nmos ad=0.19p pd=1.38u as=0.19p ps=1.38u w=1u l=1u
X111 VSS.t15 vin1 vout1 VSS.t14 sg13_lv_nmos ad=0.19p pd=1.38u as=0.19p ps=1.38u w=1u l=1u
X112 vout3 vin3 VDD VDD sg13_lv_pmos ad=1.14p pd=6.38u as=1.14p ps=6.38u w=6u l=1u
X113 VDD vin3 vout3 VDD sg13_lv_pmos ad=1.14p pd=6.38u as=1.14p ps=6.38u w=6u l=1u
X114 vout3 vin3 VDD VDD sg13_lv_pmos ad=1.14p pd=6.38u as=1.14p ps=6.38u w=6u l=1u
X115 vout3 vin3 VSS.t32 VSS.t36 sg13_lv_nmos ad=0.19p pd=1.38u as=0.19p ps=1.38u w=1u l=1u
X116 VSS.t32 vin2 vout2 VSS.t47 sg13_lv_nmos ad=0.19p pd=1.38u as=0.19p ps=1.38u w=1u l=1u
X117 vout2 vin2 VSS.t32 VSS.t50 sg13_lv_nmos ad=0.19p pd=1.38u as=0.19p ps=1.38u w=1u l=1u
X118 VSS.t58 vin4 vout4 VSS.t92 sg13_lv_nmos ad=0.19p pd=1.38u as=0.19p ps=1.38u w=1u l=1u
X119 vout1 vin1 VDD VDD sg13_lv_pmos ad=1.14p pd=6.38u as=1.14p ps=6.38u w=6u l=1u
X120 VSS.t30 VSS.t70 VSS.t72 VSS.t71 sg13_lv_nmos ad=0.19p pd=1.38u as=0 ps=0 w=1u l=1u
X121 VSS.t30 vin1 vout1 VSS.t29 sg13_lv_nmos ad=0.19p pd=1.38u as=0.19p ps=1.38u w=1u l=1u
X122 vout2 vin2 VSS.t32 VSS.t31 sg13_lv_nmos ad=0.19p pd=1.38u as=0.19p ps=1.38u w=1u l=1u
X123 VSS.t55 VSS.t52 VSS.t54 VSS.t53 sg13_lv_nmos ad=0.34p pd=2.68u as=0 ps=0 w=1u l=1u
X124 vout1 vin1 VSS.t3 VSS.t4 sg13_lv_nmos ad=0.19p pd=1.38u as=0.19p ps=1.38u w=1u l=1u
X125 VSS.t9 vin1 vout1 VSS.t8 sg13_lv_nmos ad=0.19p pd=1.38u as=0.19p ps=1.38u w=1u l=1u
X126 VDD vin3 vout3 VDD sg13_lv_pmos ad=1.14p pd=6.38u as=1.14p ps=6.38u w=6u l=1u
X127 VSS.t3 vin1 vout1 VSS.t2 sg13_lv_nmos ad=0.19p pd=1.38u as=0.19p ps=1.38u w=1u l=1u
X128 vout4 vin4 VDD VDD sg13_lv_pmos ad=1.14p pd=6.38u as=1.14p ps=6.38u w=6u l=1u
X129 vout3 vin3 VDD VDD sg13_lv_pmos ad=1.14p pd=6.38u as=1.14p ps=6.38u w=6u l=1u
X130 VDD vin3 vout3 VDD sg13_lv_pmos ad=1.14p pd=6.38u as=1.14p ps=6.38u w=6u l=1u
X131 VSS.t32 vin3 vout3 VSS.t35 sg13_lv_nmos ad=0.19p pd=1.38u as=0.19p ps=1.38u w=1u l=1u
X132 vout3 vin3 VSS.t32 VSS.t38 sg13_lv_nmos ad=0.19p pd=1.38u as=0.19p ps=1.38u w=1u l=1u
X133 vout1 vin1 VDD VDD sg13_lv_pmos ad=1.14p pd=6.38u as=1.14p ps=6.38u w=6u l=1u
X134 VSS.t32 vin2 vout2 VSS.t49 sg13_lv_nmos ad=0.19p pd=1.38u as=0.19p ps=1.38u w=1u l=1u
X135 VSS.t32 vin3 vout3 VSS.t41 sg13_lv_nmos ad=0.19p pd=1.38u as=0.19p ps=1.38u w=1u l=1u
X136 VDD vin4 vout4 VDD sg13_lv_pmos ad=1.14p pd=6.38u as=1.14p ps=6.38u w=6u l=1u
X137 vout1 vin1 VDD VDD sg13_lv_pmos ad=1.14p pd=6.38u as=1.14p ps=6.38u w=6u l=1u
X138 VDD vin1 vout1 VDD sg13_lv_pmos ad=1.14p pd=6.38u as=1.14p ps=6.38u w=6u l=1u
X139 vout4 vin4 VDD VDD sg13_lv_pmos ad=1.14p pd=6.38u as=1.14p ps=6.38u w=6u l=1u
X140 VSS.t24 vin1 vout1 VSS.t23 sg13_lv_nmos ad=0.19p pd=1.38u as=0.19p ps=1.38u w=1u l=1u
X141 vout1 vin1 VDD VDD sg13_lv_pmos ad=1.14p pd=6.38u as=1.14p ps=6.38u w=6u l=1u
X142 vout1 vin1 VSS.t27 VSS.t28 sg13_lv_nmos ad=0.19p pd=1.38u as=0.19p ps=1.38u w=1u l=1u
X143 vout2 vin2 VDD VDD sg13_lv_pmos ad=1.14p pd=6.38u as=1.14p ps=6.38u w=6u l=1u
X144 vout4 vin4 VSS.t52 VSS.t77 sg13_lv_nmos ad=0.19p pd=1.38u as=0.19p ps=1.38u w=1u l=1u
X145 VSS.t32 VSS.t63 VSS.t32 VSS.t60 sg13_lv_nmos ad=0.34p pd=2.68u as=0 ps=0 w=1u l=1u
X146 VSS.t32 VSS.t61 VSS.t32 VSS.t62 sg13_lv_nmos ad=0.19p pd=1.38u as=0 ps=0 w=1u l=1u
X147 vout4 vin4 VDD VDD sg13_lv_pmos ad=1.14p pd=6.38u as=1.14p ps=6.38u w=6u l=1u
X148 VSS.t32 vin3 vout3 VSS.t51 sg13_lv_nmos ad=0.19p pd=1.38u as=0.19p ps=1.38u w=1u l=1u
X149 VSS.t52 vin4 vout4 VSS.t90 sg13_lv_nmos ad=0.19p pd=1.38u as=0.19p ps=1.38u w=1u l=1u
X150 VDD vin4 vout4 VDD sg13_lv_pmos ad=1.14p pd=6.38u as=1.14p ps=6.38u w=6u l=1u
X151 vout1 vin1 VSS.t1 VSS.t0 sg13_lv_nmos ad=0.19p pd=1.38u as=0.19p ps=1.38u w=1u l=1u
X152 vout3 vin3 VSS.t32 VSS.t34 sg13_lv_nmos ad=0.19p pd=1.38u as=0.19p ps=1.38u w=1u l=1u
X153 VSS.t32 vin3 vout3 VSS.t37 sg13_lv_nmos ad=0.19p pd=1.38u as=0.19p ps=1.38u w=1u l=1u
X154 vout4 vin4 VDD VDD sg13_lv_pmos ad=1.14p pd=6.38u as=1.14p ps=6.38u w=6u l=1u
X155 vout2 vin2 VSS.t32 VSS.t48 sg13_lv_nmos ad=0.19p pd=1.38u as=0.19p ps=1.38u w=1u l=1u
X156 VSS.t32 vin3 vout3 VSS.t33 sg13_lv_nmos ad=0.19p pd=1.38u as=0.19p ps=1.38u w=1u l=1u
X157 VDD vin1 vout1 VDD sg13_lv_pmos ad=1.14p pd=6.38u as=1.14p ps=6.38u w=6u l=1u
X158 vout1 vin1 VDD VDD sg13_lv_pmos ad=1.14p pd=6.38u as=1.14p ps=6.38u w=6u l=1u
X159 VDD vin4 vout4 VDD sg13_lv_pmos ad=1.14p pd=6.38u as=1.14p ps=6.38u w=6u l=1u
X160 VDD vin1 vout1 VDD sg13_lv_pmos ad=1.14p pd=6.38u as=1.14p ps=6.38u w=6u l=1u
X161 VSS.t27 vin1 vout1 VSS.t26 sg13_lv_nmos ad=0.19p pd=1.38u as=0.19p ps=1.38u w=1u l=1u
X162 VDD vin2 vout2 VDD sg13_lv_pmos ad=1.14p pd=6.38u as=1.14p ps=6.38u w=6u l=1u
X163 vout2 vin2 VDD VDD sg13_lv_pmos ad=1.14p pd=6.38u as=1.14p ps=6.38u w=6u l=1u
X164 VDD vin2 vout2 VDD sg13_lv_pmos ad=1.14p pd=6.38u as=1.14p ps=6.38u w=6u l=1u
X165 VSS.t32 vin3 vout3 VSS.t47 sg13_lv_nmos ad=0.19p pd=1.38u as=0.19p ps=1.38u w=1u l=1u
X166 vout3 vin3 VSS.t32 VSS.t50 sg13_lv_nmos ad=0.19p pd=1.38u as=0.19p ps=1.38u w=1u l=1u
X167 VDD VDD VDD VDD sg13_lv_pmos ad=1.14p pd=6.38u as=0 ps=0 w=6u l=1u
X168 VSS.t69 VSS.t67 VSS.t1 VSS.t68 sg13_lv_nmos ad=0.34p pd=2.68u as=0 ps=0 w=1u l=1u
X169 VDD vin4 vout4 VDD sg13_lv_pmos ad=1.14p pd=6.38u as=1.14p ps=6.38u w=6u l=1u
X170 VDD VDD VDD VDD sg13_lv_pmos ad=1.14p pd=6.38u as=0 ps=0 w=6u l=1u
X171 vout2 vin2 VSS.t32 VSS.t44 sg13_lv_nmos ad=0.19p pd=1.38u as=0.19p ps=1.38u w=1u l=1u
X172 vout3 vin3 VDD VDD sg13_lv_pmos ad=1.14p pd=6.38u as=1.14p ps=6.38u w=6u l=1u
X173 vout4 vin4 VSS.t52 VSS.t75 sg13_lv_nmos ad=0.19p pd=1.38u as=0.19p ps=1.38u w=1u l=1u
X174 vout3 vin3 VSS.t32 VSS.t31 sg13_lv_nmos ad=0.19p pd=1.38u as=0.19p ps=1.38u w=1u l=1u
X175 vout2 vin2 VSS.t32 VSS.t40 sg13_lv_nmos ad=0.19p pd=1.38u as=0.19p ps=1.38u w=1u l=1u
R0 VSS.t52 VSS.n13 6777.49
R1 VSS.n35 VSS.t52 6777.49
R2 VSS.n13 VSS.n9 6777.49
R3 VSS.t32 VSS.n13 1581.18
R4 VSS.t32 VSS.t50 12.9215
R5 VSS.t92 VSS.t52 9.76925
R6 VSS.t32 VSS.t47 21.9287
R7 VSS.t52 VSS.t74 12.3005
R8 VSS.t90 VSS.t52 14.4648
R9 VSS.n9 VSS.t29 9.76975
R10 VSS.t52 VSS.t88 17.7154
R11 VSS.t52 VSS.t76 16.2727
R12 VSS.n2 VSS.t41 24.9316
R13 VSS.t32 VSS.n1 0.00140876
R14 VSS.t52 VSS.t77 17.717
R15 VSS.n0 VSS.t43 25.5284
R16 VSS.t87 VSS.t52 18.799
R17 VSS.t52 VSS.t85 19.8823
R18 VSS.t82 VSS.t52 19.5213
R19 VSS.n9 VSS.t23 17.7158
R20 VSS.n0 VSS.t32 0.00704499
R21 VSS.t81 VSS.t52 19.8818
R22 VSS.n9 VSS.t22 18.7988
R23 VSS.t32 VSS.t42 24.9303
R24 VSS.t84 VSS.t52 19.9322
R25 VSS.t80 VSS.t52 19.8825
R26 VSS.t83 VSS.t52 19.5044
R27 VSS.t79 VSS.t52 19.5219
R28 VSS.n9 VSS.t19 19.8819
R29 VSS.t78 VSS.t52 18.8
R30 VSS.n9 VSS.t17 19.8819
R31 VSS.t71 VSS.n9 6.88018
R32 VSS.t75 VSS.t52 14.4672
R33 VSS.n9 VSS.t28 12.2984
R34 VSS.t14 VSS.n10 19.5617
R35 VSS.n9 VSS.t11 19.8822
R36 VSS.n9 VSS.t8 18.799
R37 VSS.t7 VSS.n9 17.7156
R38 VSS.n9 VSS.t5 16.271
R39 VSS.n9 VSS.t4 14.465
R40 VSS.n9 VSS.t2 12.2988
R41 VSS.n8 VSS.n6 0.00449242
R42 VSS.n7 VSS.n6 0.045111
R43 VSS.n6 VSS.t30 5.66087
R44 VSS.t72 VSS.n7 5.73423
R45 VSS.n7 VSS.n9 0.471495
R46 VSS.n9 VSS.n11 0.479012
R47 VSS.t69 VSS.t67 5.66244
R48 VSS.t67 VSS.t1 5.66522
R49 VSS.n11 VSS.t67 0.0741766
R50 VSS.n1 VSS.t46 23.7295
R51 VSS.t32 VSS.t37 23.7299
R52 VSS.t32 VSS.t36 21.9292
R53 VSS.t32 VSS.t35 19.5275
R54 VSS.t32 VSS.t60 3.91342
R55 VSS.t32 VSS.t48 19.5264
R56 VSS.n2 VSS.t40 25.5311
R57 VSS.t52 VSS.t58 5.66621
R58 VSS.t55 VSS.t52 5.66521
R59 VSS.t52 VSS.t54 5.66621
R60 VSS.t63 VSS.t32 4.99233
R61 VSS.t32 VSS.t59 4.99233
R62 VSS.t32 VSS.t65 4.99233
R63 VSS.t62 VSS.t32 3.83947
R64 VSS.t73 VSS.t52 9.77299
R65 VSS.n35 VSS.n9 6777.49
R66 VSS.t16 VSS.n10 19.5022
R67 VSS.n9 VSS.n10 0.0543981
R68 VSS.n9 VSS.t25 16.2715
R69 VSS.n9 VSS.t26 14.4652
R70 VSS.t33 VSS.t32 12.922
R71 VSS.t32 VSS.n3 0.00149943
R72 VSS.t52 VSS.t56 6.87897
R73 VSS.t52 VSS.t53 6.87896
R74 VSS.t61 VSS.t32 4.99463
R75 VSS.t32 VSS.t31 8.71872
R76 VSS.t32 VSS.t34 16.5253
R77 VSS.n3 VSS.t38 24.9317
R78 VSS.n3 VSS.t39 25.5314
R79 VSS.n0 VSS.t44 25.5384
R80 VSS.n1 VSS.t45 24.931
R81 VSS VSS.n5 1.26279
R82 VSS.n15 VSS.n5 2.39594
R83 VSS.t52 VSS 5.97525
R84 VSS VSS.t52 5.97525
R85 VSS.t51 VSS.t32 8.71808
R86 VSS.t70 VSS.n8 0.00785858
R87 VSS.t32 VSS 2.98787
R88 VSS.t32 VSS 2.98787
R89 VSS.n9 VSS.t20 19.5212
R90 VSS.n9 VSS.t10 19.5209
R91 VSS.n9 VSS.t13 19.8815
R92 VSS.t0 VSS.n9 9.76971
R93 VSS.n9 VSS.t68 6.8802
R94 VSS VSS.n4 2.71193
R95 VSS.n36 VSS.t3 2.48177
R96 VSS.n37 VSS.t6 2.48177
R97 VSS.n38 VSS.t9 2.48177
R98 VSS.n17 VSS.t12 2.48177
R99 VSS.t18 VSS.n16 2.48177
R100 VSS.n32 VSS.t21 2.48177
R101 VSS.n33 VSS.t24 2.48177
R102 VSS.n34 VSS.t27 2.48177
R103 VSS.t32 VSS.t49 16.5247
R104 VSS.t32 VSS.n2 0.00144432
R105 VSS.n9 VSS.n29 2.09947
R106 VSS.n9 VSS.n28 2.09947
R107 VSS.n9 VSS.n27 2.09947
R108 VSS.n9 VSS.n25 2.09947
R109 VSS.n9 VSS.n14 2.09947
R110 VSS.n9 VSS.n23 2.09947
R111 VSS.n9 VSS.n21 2.09947
R112 VSS.n9 VSS.n19 2.09947
R113 VSS.n35 VSS.t32 1581.12
R114 VSS.n36 VSS.t67 1.21239
R115 VSS.n34 VSS.n8 1.22021
R116 VSS.n11 VSS.n18 0.198665
R117 VSS.t70 VSS.n12 0.1481
R118 VSS.n18 VSS.t3 0.200997
R119 VSS.n20 VSS.t6 0.200997
R120 VSS.n22 VSS.t9 0.200997
R121 VSS.n24 VSS.t12 0.200997
R122 VSS.n26 VSS.t18 0.200997
R123 VSS.t21 VSS.n31 0.200997
R124 VSS.t24 VSS.n30 0.200997
R125 VSS.t27 VSS.n12 0.200997
R126 VSS.n37 VSS.n36 0.16242
R127 VSS.n38 VSS.n37 0.16242
R128 VSS.n17 VSS.n38 0.16242
R129 VSS.n15 VSS.n17 0.16242
R130 VSS.n15 VSS.n16 0.16242
R131 VSS.n32 VSS.n16 0.16242
R132 VSS.n33 VSS.n32 0.16242
R133 VSS.n34 VSS.n33 0.16242
R134 VSS.n19 VSS.n18 0.0952183
R135 VSS.n21 VSS.n20 0.0927738
R136 VSS.n12 VSS.n29 0.0925656
R137 VSS.n23 VSS.n22 0.0903294
R138 VSS.n25 VSS.t15 0.0903294
R139 VSS.n30 VSS.n28 0.0901212
R140 VSS.n14 VSS.n24 0.0878849
R141 VSS.n27 VSS.n26 0.0878849
R142 VSS.t15 VSS.n14 0.0876767
R143 VSS.n31 VSS.n27 0.0876767
R144 VSS.n31 VSS.n28 0.0854405
R145 VSS.n24 VSS.n23 0.0852323
R146 VSS.n26 VSS.n25 0.0852323
R147 VSS.n30 VSS.n29 0.082996
R148 VSS.n22 VSS.n21 0.0827878
R149 VSS.n20 VSS.n19 0.0803434
R150 VSS.n4 VSS 0.0445
R151 VSS.t15 VSS.n15 0.0394177
R152 VSS.t52 VSS.t86 19.5212
R153 VSS.t52 VSS.t89 16.2707
R154 VSS.t52 VSS.t91 12.2976
R155 VSS.t52 VSS.t57 6.08705
R156 VSS.n5 VSS 1.26279
R157 VSS VSS.n4 1.12053
C0 vin3 vin4 0.11002f
C1 VDD vout2 11.4398f
C2 vin3 vout3 16.0649f
C3 VDD vout1 11.4454f
C4 VDD vin2 26.9106f
C5 vin3 vin2 0.12731f
C6 vout1 vin1 16.0649f
C7 vin2 vin1 0.11002f
C8 vin2 vout2 16.0649f
C9 VDD vout4 11.4454f
C10 vin3 VDD 26.9106f
C11 VDD vin1 26.9418f
C12 VDD vin4 26.9418f
C13 vin4 vout4 16.0649f
C14 VDD vout3 11.4398f
C15 vout1 VSS 11.68952f
C16 vout2 VSS 11.67145f
C17 vout3 VSS 11.67145f
C18 vout4 VSS 11.68952f
C19 VSS.t32 VSS 7.1013f
C20 VSS.t24 VSS 7.11905f
.ends
