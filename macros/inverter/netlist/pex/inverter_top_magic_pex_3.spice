* PEX produced on Fri Jul 31 11:51:35 PM CEST 2026 using /foss/tools/sak/sak-pex.sh with m=3 and s=1 (extresist threshold=10000 mOhm, minres=1000 mOhm, mindelay=1 ps)
* NGSPICE file created from inverter_top_pex.ext - technology: ihp-sg13cmos5l

.subckt inverter_top_pex VDD vin4 vout4 VSS vin3 vout3 vin2 vout2 vout1 vin1
X0 vout4 vin4 VDD VDD sg13_lv_pmos ad=1.14p pd=6.38u as=1.14p ps=6.38u w=6u l=1u
X1 VDD vin2 vout2 VDD sg13_lv_pmos ad=1.14p pd=6.38u as=1.14p ps=6.38u w=6u l=1u
X2 VSS.t123 vin2 vout2 VSS.t48 sg13_lv_nmos ad=0.19p pd=1.38u as=0.19p ps=1.38u w=1u l=1u
X3 vout2 vin2 VSS.t125 VSS.t52 sg13_lv_nmos ad=0.19p pd=1.38u as=0.19p ps=1.38u w=1u l=1u
X4 vout2 vin2 VDD VDD sg13_lv_pmos ad=1.14p pd=6.38u as=1.14p ps=6.38u w=6u l=1u
X5 VSS.t91 vin4 vout4 VSS.t90 sg13_lv_nmos ad=0.19p pd=1.38u as=0.19p ps=1.38u w=1u l=1u
X6 vout1 vin1 VSS.t24 VSS.t25 sg13_lv_nmos ad=0.19p pd=1.38u as=0.19p ps=1.38u w=1u l=1u
X7 VDD vin2 vout2 VDD sg13_lv_pmos ad=1.14p pd=6.38u as=1.14p ps=6.38u w=6u l=1u
X8 vout4 vin4 VSS.t61 VSS.t83 sg13_lv_nmos ad=0.19p pd=1.38u as=0.19p ps=1.38u w=1u l=1u
X9 VDD vin2 vout2 VDD sg13_lv_pmos ad=1.14p pd=6.38u as=1.14p ps=6.38u w=6u l=1u
X10 VSS.t46 vin3 vout3 VSS.t56 sg13_lv_nmos ad=0.19p pd=1.38u as=0.19p ps=1.38u w=1u l=1u
X11 vout4 vin4 VSS.t100 VSS.t101 sg13_lv_nmos ad=0.19p pd=1.38u as=0.19p ps=1.38u w=1u l=1u
X12 VDD vin3 vout3 VDD sg13_lv_pmos ad=1.14p pd=6.38u as=1.14p ps=6.38u w=6u l=1u
X13 VSS.t94 vin4 vout4 VSS.t93 sg13_lv_nmos ad=0.19p pd=1.38u as=0.19p ps=1.38u w=1u l=1u
X14 VDD vin2 vout2 VDD sg13_lv_pmos ad=1.14p pd=6.38u as=1.14p ps=6.38u w=6u l=1u
X15 vout3 vin3 VDD VDD sg13_lv_pmos ad=1.14p pd=6.38u as=1.14p ps=6.38u w=6u l=1u
X16 vout2 vin2 VDD VDD sg13_lv_pmos ad=1.14p pd=6.38u as=1.14p ps=6.38u w=6u l=1u
X17 VSS.t46 vin2 vout2 VSS.t42 sg13_lv_nmos ad=0.19p pd=1.38u as=0.19p ps=1.38u w=1u l=1u
X18 VDD vin3 vout3 VDD sg13_lv_pmos ad=1.14p pd=6.38u as=1.14p ps=6.38u w=6u l=1u
X19 VSS.t69 VSS.t67 VSS.t32 VSS.t68 sg13_lv_nmos ad=0.34p pd=2.68u as=0 ps=0 w=1u l=1u
X20 vout2 vin2 VSS.t121 VSS.t47 sg13_lv_nmos ad=0.19p pd=1.38u as=0.19p ps=1.38u w=1u l=1u
X21 vout1 vin1 VSS.t18 VSS.t19 sg13_lv_nmos ad=0.19p pd=1.38u as=0.19p ps=1.38u w=1u l=1u
X22 VSS.t125 vin2 vout2 VSS.t51 sg13_lv_nmos ad=0.19p pd=1.38u as=0.19p ps=1.38u w=1u l=1u
X23 vout4 vin4 VSS.t97 VSS.t98 sg13_lv_nmos ad=0.19p pd=1.38u as=0.19p ps=1.38u w=1u l=1u
X24 vout1 vin1 VDD VDD sg13_lv_pmos ad=1.14p pd=6.38u as=1.14p ps=6.38u w=6u l=1u
X25 vout1 vin1 VSS.t12 VSS.t13 sg13_lv_nmos ad=0.19p pd=1.38u as=0.19p ps=1.38u w=1u l=1u
X26 VSS.t103 vin4 vout4 VSS.t102 sg13_lv_nmos ad=0.19p pd=1.38u as=0.19p ps=1.38u w=1u l=1u
X27 VDD VDD VDD VDD sg13_lv_pmos ad=1.14p pd=6.38u as=0.56797n ps=1.006m w=6u l=1u
X28 VSS.t18 vin1 vout1 VSS.t17 sg13_lv_nmos ad=0.19p pd=1.38u as=0.19p ps=1.38u w=1u l=1u
X29 vout2 vin2 VDD VDD sg13_lv_pmos ad=1.14p pd=6.38u as=1.14p ps=6.38u w=6u l=1u
X30 VDD vin4 vout4 VDD sg13_lv_pmos ad=1.14p pd=6.38u as=1.14p ps=6.38u w=6u l=1u
X31 vout1 vin1 VSS.t21 VSS.t22 sg13_lv_nmos ad=0.19p pd=1.38u as=0.19p ps=1.38u w=1u l=1u
X32 vout3 vin3 VSS.t54 VSS.t55 sg13_lv_nmos ad=0.19p pd=1.38u as=0.19p ps=1.38u w=1u l=1u
X33 vout4 vin4 VDD VDD sg13_lv_pmos ad=1.14p pd=6.38u as=1.14p ps=6.38u w=6u l=1u
X34 VDD vin3 vout3 VDD sg13_lv_pmos ad=1.14p pd=6.38u as=1.14p ps=6.38u w=6u l=1u
X35 VDD vin4 vout4 VDD sg13_lv_pmos ad=1.14p pd=6.38u as=1.14p ps=6.38u w=6u l=1u
X36 vout3 vin3 VDD VDD sg13_lv_pmos ad=1.14p pd=6.38u as=1.14p ps=6.38u w=6u l=1u
X37 VDD vin3 vout3 VDD sg13_lv_pmos ad=1.14p pd=6.38u as=1.14p ps=6.38u w=6u l=1u
X38 VSS.t66 VSS.t63 VSS.t65 VSS.t64 sg13_lv_nmos ad=0.19p pd=1.38u as=0 ps=0 w=1u l=1u
X39 VDD vin4 vout4 VDD sg13_lv_pmos ad=1.14p pd=6.38u as=1.14p ps=6.38u w=6u l=1u
X40 VDD vin2 vout2 VDD sg13_lv_pmos ad=1.14p pd=6.38u as=1.14p ps=6.38u w=6u l=1u
X41 VSS.t106 vin4 vout4 VSS.t105 sg13_lv_nmos ad=0.19p pd=1.38u as=0.19p ps=1.38u w=1u l=1u
X42 VDD vin3 vout3 VDD sg13_lv_pmos ad=1.14p pd=6.38u as=1.14p ps=6.38u w=6u l=1u
X43 VSS.t12 vin1 vout1 VSS.t11 sg13_lv_nmos ad=0.19p pd=1.38u as=0.19p ps=1.38u w=1u l=1u
X44 VDD vin1 vout1 VDD sg13_lv_pmos ad=1.14p pd=6.38u as=1.14p ps=6.38u w=6u l=1u
X45 vout4 vin4 VSS.t109 VSS.t110 sg13_lv_nmos ad=0.19p pd=1.38u as=0.19p ps=1.38u w=1u l=1u
X46 vout4 vin4 VDD VDD sg13_lv_pmos ad=1.14p pd=6.38u as=1.14p ps=6.38u w=6u l=1u
X47 vout1 vin1 VSS.t15 VSS.t16 sg13_lv_nmos ad=0.19p pd=1.38u as=0.19p ps=1.38u w=1u l=1u
X48 vout1 vin1 VDD VDD sg13_lv_pmos ad=1.14p pd=6.38u as=1.14p ps=6.38u w=6u l=1u
X49 VDD vin1 vout1 VDD sg13_lv_pmos ad=1.14p pd=6.38u as=1.14p ps=6.38u w=6u l=1u
X50 vout3 vin3 VSS.t49 VSS.t50 sg13_lv_nmos ad=0.19p pd=1.38u as=0.19p ps=1.38u w=1u l=1u
X51 VSS.t21 vin1 vout1 VSS.t20 sg13_lv_nmos ad=0.19p pd=1.38u as=0.19p ps=1.38u w=1u l=1u
X52 VDD VDD VDD VDD sg13_lv_pmos ad=2.04p pd=12.68u as=0 ps=0 w=6u l=1u
X53 vout4 vin4 VDD VDD sg13_lv_pmos ad=1.14p pd=6.38u as=1.14p ps=6.38u w=6u l=1u
X54 VDD vin3 vout3 VDD sg13_lv_pmos ad=1.14p pd=6.38u as=1.14p ps=6.38u w=6u l=1u
X55 VDD vin4 vout4 VDD sg13_lv_pmos ad=1.14p pd=6.38u as=1.14p ps=6.38u w=6u l=1u
X56 vout3 vin3 VSS.t43 VSS.t44 sg13_lv_nmos ad=0.19p pd=1.38u as=0.19p ps=1.38u w=1u l=1u
X57 vout3 vin3 VDD VDD sg13_lv_pmos ad=1.14p pd=6.38u as=1.14p ps=6.38u w=6u l=1u
X58 VSS.t49 vin3 vout3 VSS.t48 sg13_lv_nmos ad=0.19p pd=1.38u as=0.19p ps=1.38u w=1u l=1u
X59 VDD VDD VDD VDD sg13_lv_pmos ad=1.14p pd=6.38u as=0 ps=0 w=6u l=1u
X60 vout3 vin3 VSS.t46 VSS.t52 sg13_lv_nmos ad=0.19p pd=1.38u as=0.19p ps=1.38u w=1u l=1u
X61 vout4 vin4 VDD VDD sg13_lv_pmos ad=1.14p pd=6.38u as=1.14p ps=6.38u w=6u l=1u
X62 vout3 vin3 VDD VDD sg13_lv_pmos ad=1.14p pd=6.38u as=1.14p ps=6.38u w=6u l=1u
X63 VDD vin1 vout1 VDD sg13_lv_pmos ad=1.14p pd=6.38u as=1.14p ps=6.38u w=6u l=1u
X64 vout2 vin2 VDD VDD sg13_lv_pmos ad=1.14p pd=6.38u as=1.14p ps=6.38u w=6u l=1u
X65 vout1 vin1 VDD VDD sg13_lv_pmos ad=1.14p pd=6.38u as=1.14p ps=6.38u w=6u l=1u
X66 VDD vin1 vout1 VDD sg13_lv_pmos ad=1.14p pd=6.38u as=1.14p ps=6.38u w=6u l=1u
X67 vout2 vin2 VSS.t115 VSS.t38 sg13_lv_nmos ad=0.19p pd=1.38u as=0.19p ps=1.38u w=1u l=1u
X68 VDD vin1 vout1 VDD sg13_lv_pmos ad=1.14p pd=6.38u as=1.14p ps=6.38u w=6u l=1u
X69 VDD vin3 vout3 VDD sg13_lv_pmos ad=1.14p pd=6.38u as=1.14p ps=6.38u w=6u l=1u
X70 VSS.t43 vin3 vout3 VSS.t42 sg13_lv_nmos ad=0.19p pd=1.38u as=0.19p ps=1.38u w=1u l=1u
X71 vout3 vin3 VSS.t46 VSS.t47 sg13_lv_nmos ad=0.19p pd=1.38u as=0.19p ps=1.38u w=1u l=1u
X72 VSS.t88 vin4 vout4 VSS.t87 sg13_lv_nmos ad=0.19p pd=1.38u as=0.19p ps=1.38u w=1u l=1u
X73 VDD vin4 vout4 VDD sg13_lv_pmos ad=1.14p pd=6.38u as=1.14p ps=6.38u w=6u l=1u
X74 VSS.t46 vin3 vout3 VSS.t51 sg13_lv_nmos ad=0.19p pd=1.38u as=0.19p ps=1.38u w=1u l=1u
X75 vout4 vin4 VSS.t91 VSS.t92 sg13_lv_nmos ad=0.19p pd=1.38u as=0.19p ps=1.38u w=1u l=1u
X76 VDD vin1 vout1 VDD sg13_lv_pmos ad=1.14p pd=6.38u as=1.14p ps=6.38u w=6u l=1u
X77 vout2 vin2 VDD VDD sg13_lv_pmos ad=1.14p pd=6.38u as=1.14p ps=6.38u w=6u l=1u
X78 vout1 vin1 VDD VDD sg13_lv_pmos ad=1.14p pd=6.38u as=1.14p ps=6.38u w=6u l=1u
X79 VSS.t85 vin4 vout4 VSS.t84 sg13_lv_nmos ad=0.19p pd=1.38u as=0.19p ps=1.38u w=1u l=1u
X80 VDD VDD VDD VDD sg13_lv_pmos ad=2.04p pd=12.68u as=0 ps=0 w=6u l=1u
X81 vout2 vin2 VDD VDD sg13_lv_pmos ad=1.14p pd=6.38u as=1.14p ps=6.38u w=6u l=1u
X82 VDD vin2 vout2 VDD sg13_lv_pmos ad=1.14p pd=6.38u as=1.14p ps=6.38u w=6u l=1u
X83 VSS.t115 vin2 vout2 VSS.t36 sg13_lv_nmos ad=0.19p pd=1.38u as=0.19p ps=1.38u w=1u l=1u
X84 VSS.t97 vin4 vout4 VSS.t96 sg13_lv_nmos ad=0.19p pd=1.38u as=0.19p ps=1.38u w=1u l=1u
X85 VDD VDD VDD VDD sg13_lv_pmos ad=2.04p pd=12.68u as=0 ps=0 w=6u l=1u
X86 vout2 vin2 VDD VDD sg13_lv_pmos ad=1.14p pd=6.38u as=1.14p ps=6.38u w=6u l=1u
X87 vout2 vin2 VSS.t117 VSS.t41 sg13_lv_nmos ad=0.19p pd=1.38u as=0.19p ps=1.38u w=1u l=1u
X88 VSS.t121 vin2 vout2 VSS.t45 sg13_lv_nmos ad=0.19p pd=1.38u as=0.19p ps=1.38u w=1u l=1u
X89 vout1 vin1 VDD VDD sg13_lv_pmos ad=1.14p pd=6.38u as=1.14p ps=6.38u w=6u l=1u
X90 vout1 vin1 VSS.t6 VSS.t7 sg13_lv_nmos ad=0.19p pd=1.38u as=0.19p ps=1.38u w=1u l=1u
X91 vout4 vin4 VSS.t94 VSS.t95 sg13_lv_nmos ad=0.19p pd=1.38u as=0.19p ps=1.38u w=1u l=1u
X92 vout3 vin3 VDD VDD sg13_lv_pmos ad=1.14p pd=6.38u as=1.14p ps=6.38u w=6u l=1u
X93 vout4 vin4 VSS.t106 VSS.t107 sg13_lv_nmos ad=0.19p pd=1.38u as=0.19p ps=1.38u w=1u l=1u
X94 VSS.t46 VSS.t75 VSS.t46 VSS.t71 sg13_lv_nmos ad=0.19p pd=1.38u as=0 ps=0 w=1u l=1u
X95 VSS.t100 vin4 vout4 VSS.t99 sg13_lv_nmos ad=0.19p pd=1.38u as=0.19p ps=1.38u w=1u l=1u
X96 VDD vin1 vout1 VDD sg13_lv_pmos ad=1.14p pd=6.38u as=1.14p ps=6.38u w=6u l=1u
X97 VSS.t46 vin2 vout2 VSS.t58 sg13_lv_nmos ad=0.19p pd=1.38u as=0.19p ps=1.38u w=1u l=1u
X98 VDD vin2 vout2 VDD sg13_lv_pmos ad=1.14p pd=6.38u as=1.14p ps=6.38u w=6u l=1u
X99 vout4 vin4 VSS.t103 VSS.t104 sg13_lv_nmos ad=0.19p pd=1.38u as=0.19p ps=1.38u w=1u l=1u
X100 vout4 vin4 VDD VDD sg13_lv_pmos ad=1.14p pd=6.38u as=1.14p ps=6.38u w=6u l=1u
X101 vout2 vin2 VDD VDD sg13_lv_pmos ad=1.14p pd=6.38u as=1.14p ps=6.38u w=6u l=1u
X102 vout2 vin2 VSS.t113 VSS.t35 sg13_lv_nmos ad=0.19p pd=1.38u as=0.19p ps=1.38u w=1u l=1u
X103 VDD vin2 vout2 VDD sg13_lv_pmos ad=1.14p pd=6.38u as=1.14p ps=6.38u w=6u l=1u
X104 VSS.t117 vin2 vout2 VSS.t39 sg13_lv_nmos ad=0.19p pd=1.38u as=0.19p ps=1.38u w=1u l=1u
X105 VDD vin4 vout4 VDD sg13_lv_pmos ad=1.14p pd=6.38u as=1.14p ps=6.38u w=6u l=1u
X106 VDD VDD VDD VDD sg13_lv_pmos ad=2.04p pd=12.68u as=0 ps=0 w=6u l=1u
X107 VSS.t113 vin2 vout2 VSS.t33 sg13_lv_nmos ad=0.19p pd=1.38u as=0.19p ps=1.38u w=1u l=1u
X108 VSS.t6 vin1 vout1 VSS.t5 sg13_lv_nmos ad=0.19p pd=1.38u as=0.19p ps=1.38u w=1u l=1u
X109 vout3 vin3 VDD VDD sg13_lv_pmos ad=1.14p pd=6.38u as=1.14p ps=6.38u w=6u l=1u
X110 vout1 vin1 VSS.t9 VSS.t10 sg13_lv_nmos ad=0.19p pd=1.38u as=0.19p ps=1.38u w=1u l=1u
X111 VSS.t15 vin1 vout1 VSS.t14 sg13_lv_nmos ad=0.19p pd=1.38u as=0.19p ps=1.38u w=1u l=1u
X112 vout3 vin3 VDD VDD sg13_lv_pmos ad=1.14p pd=6.38u as=1.14p ps=6.38u w=6u l=1u
X113 VDD vin3 vout3 VDD sg13_lv_pmos ad=1.14p pd=6.38u as=1.14p ps=6.38u w=6u l=1u
X114 vout3 vin3 VDD VDD sg13_lv_pmos ad=1.14p pd=6.38u as=1.14p ps=6.38u w=6u l=1u
X115 vout3 vin3 VSS.t37 VSS.t38 sg13_lv_nmos ad=0.19p pd=1.38u as=0.19p ps=1.38u w=1u l=1u
X116 VSS.t127 vin2 vout2 VSS.t53 sg13_lv_nmos ad=0.19p pd=1.38u as=0.19p ps=1.38u w=1u l=1u
X117 vout2 vin2 VSS.t46 VSS.t57 sg13_lv_nmos ad=0.19p pd=1.38u as=0.19p ps=1.38u w=1u l=1u
X118 VSS.t66 vin4 vout4 VSS.t111 sg13_lv_nmos ad=0.19p pd=1.38u as=0.19p ps=1.38u w=1u l=1u
X119 vout1 vin1 VDD VDD sg13_lv_pmos ad=1.14p pd=6.38u as=1.14p ps=6.38u w=6u l=1u
X120 VSS.t30 VSS.t80 VSS.t82 VSS.t81 sg13_lv_nmos ad=0.19p pd=1.38u as=0 ps=0 w=1u l=1u
X121 VSS.t30 vin1 vout1 VSS.t29 sg13_lv_nmos ad=0.19p pd=1.38u as=0.19p ps=1.38u w=1u l=1u
X122 vout2 vin2 VSS.t73 VSS.t31 sg13_lv_nmos ad=0.19p pd=1.38u as=0.19p ps=1.38u w=1u l=1u
X123 VSS.t62 VSS.t59 VSS.t61 VSS.t60 sg13_lv_nmos ad=0.34p pd=2.68u as=0 ps=0 w=1u l=1u
X124 vout1 vin1 VSS.t3 VSS.t4 sg13_lv_nmos ad=0.19p pd=1.38u as=0.19p ps=1.38u w=1u l=1u
X125 VSS.t9 vin1 vout1 VSS.t8 sg13_lv_nmos ad=0.19p pd=1.38u as=0.19p ps=1.38u w=1u l=1u
X126 VDD vin3 vout3 VDD sg13_lv_pmos ad=1.14p pd=6.38u as=1.14p ps=6.38u w=6u l=1u
X127 VSS.t3 vin1 vout1 VSS.t2 sg13_lv_nmos ad=0.19p pd=1.38u as=0.19p ps=1.38u w=1u l=1u
X128 vout4 vin4 VDD VDD sg13_lv_pmos ad=1.14p pd=6.38u as=1.14p ps=6.38u w=6u l=1u
X129 vout3 vin3 VDD VDD sg13_lv_pmos ad=1.14p pd=6.38u as=1.14p ps=6.38u w=6u l=1u
X130 VDD vin3 vout3 VDD sg13_lv_pmos ad=1.14p pd=6.38u as=1.14p ps=6.38u w=6u l=1u
X131 VSS.t37 vin3 vout3 VSS.t36 sg13_lv_nmos ad=0.19p pd=1.38u as=0.19p ps=1.38u w=1u l=1u
X132 vout3 vin3 VSS.t40 VSS.t41 sg13_lv_nmos ad=0.19p pd=1.38u as=0.19p ps=1.38u w=1u l=1u
X133 vout1 vin1 VDD VDD sg13_lv_pmos ad=1.14p pd=6.38u as=1.14p ps=6.38u w=6u l=1u
X134 VSS.t46 vin2 vout2 VSS.t56 sg13_lv_nmos ad=0.19p pd=1.38u as=0.19p ps=1.38u w=1u l=1u
X135 VSS.t46 vin3 vout3 VSS.t45 sg13_lv_nmos ad=0.19p pd=1.38u as=0.19p ps=1.38u w=1u l=1u
X136 VDD vin4 vout4 VDD sg13_lv_pmos ad=1.14p pd=6.38u as=1.14p ps=6.38u w=6u l=1u
X137 vout1 vin1 VDD VDD sg13_lv_pmos ad=1.14p pd=6.38u as=1.14p ps=6.38u w=6u l=1u
X138 VDD vin1 vout1 VDD sg13_lv_pmos ad=1.14p pd=6.38u as=1.14p ps=6.38u w=6u l=1u
X139 vout4 vin4 VDD VDD sg13_lv_pmos ad=1.14p pd=6.38u as=1.14p ps=6.38u w=6u l=1u
X140 VSS.t24 vin1 vout1 VSS.t23 sg13_lv_nmos ad=0.19p pd=1.38u as=0.19p ps=1.38u w=1u l=1u
X141 vout1 vin1 VDD VDD sg13_lv_pmos ad=1.14p pd=6.38u as=1.14p ps=6.38u w=6u l=1u
X142 vout1 vin1 VSS.t27 VSS.t28 sg13_lv_nmos ad=0.19p pd=1.38u as=0.19p ps=1.38u w=1u l=1u
X143 vout2 vin2 VDD VDD sg13_lv_pmos ad=1.14p pd=6.38u as=1.14p ps=6.38u w=6u l=1u
X144 vout4 vin4 VSS.t88 VSS.t89 sg13_lv_nmos ad=0.19p pd=1.38u as=0.19p ps=1.38u w=1u l=1u
X145 VSS.t74 VSS.t72 VSS.t73 VSS.t68 sg13_lv_nmos ad=0.34p pd=2.68u as=0 ps=0 w=1u l=1u
X146 VSS.t46 VSS.t70 VSS.t46 VSS.t71 sg13_lv_nmos ad=0.19p pd=1.38u as=0 ps=0 w=1u l=1u
X147 vout4 vin4 VDD VDD sg13_lv_pmos ad=1.14p pd=6.38u as=1.14p ps=6.38u w=6u l=1u
X148 VSS.t46 vin3 vout3 VSS.t58 sg13_lv_nmos ad=0.19p pd=1.38u as=0.19p ps=1.38u w=1u l=1u
X149 VSS.t109 vin4 vout4 VSS.t108 sg13_lv_nmos ad=0.19p pd=1.38u as=0.19p ps=1.38u w=1u l=1u
X150 VDD vin4 vout4 VDD sg13_lv_pmos ad=1.14p pd=6.38u as=1.14p ps=6.38u w=6u l=1u
X151 vout1 vin1 VSS.t1 VSS.t0 sg13_lv_nmos ad=0.19p pd=1.38u as=0.19p ps=1.38u w=1u l=1u
X152 vout3 vin3 VSS.t34 VSS.t35 sg13_lv_nmos ad=0.19p pd=1.38u as=0.19p ps=1.38u w=1u l=1u
X153 VSS.t40 vin3 vout3 VSS.t39 sg13_lv_nmos ad=0.19p pd=1.38u as=0.19p ps=1.38u w=1u l=1u
X154 vout4 vin4 VDD VDD sg13_lv_pmos ad=1.14p pd=6.38u as=1.14p ps=6.38u w=6u l=1u
X155 vout2 vin2 VSS.t127 VSS.t55 sg13_lv_nmos ad=0.19p pd=1.38u as=0.19p ps=1.38u w=1u l=1u
X156 VSS.t34 vin3 vout3 VSS.t33 sg13_lv_nmos ad=0.19p pd=1.38u as=0.19p ps=1.38u w=1u l=1u
X157 VDD vin1 vout1 VDD sg13_lv_pmos ad=1.14p pd=6.38u as=1.14p ps=6.38u w=6u l=1u
X158 vout1 vin1 VDD VDD sg13_lv_pmos ad=1.14p pd=6.38u as=1.14p ps=6.38u w=6u l=1u
X159 VDD vin4 vout4 VDD sg13_lv_pmos ad=1.14p pd=6.38u as=1.14p ps=6.38u w=6u l=1u
X160 VDD vin1 vout1 VDD sg13_lv_pmos ad=1.14p pd=6.38u as=1.14p ps=6.38u w=6u l=1u
X161 VSS.t27 vin1 vout1 VSS.t26 sg13_lv_nmos ad=0.19p pd=1.38u as=0.19p ps=1.38u w=1u l=1u
X162 VDD vin2 vout2 VDD sg13_lv_pmos ad=1.14p pd=6.38u as=1.14p ps=6.38u w=6u l=1u
X163 vout2 vin2 VDD VDD sg13_lv_pmos ad=1.14p pd=6.38u as=1.14p ps=6.38u w=6u l=1u
X164 VDD vin2 vout2 VDD sg13_lv_pmos ad=1.14p pd=6.38u as=1.14p ps=6.38u w=6u l=1u
X165 VSS.t54 vin3 vout3 VSS.t53 sg13_lv_nmos ad=0.19p pd=1.38u as=0.19p ps=1.38u w=1u l=1u
X166 vout3 vin3 VSS.t46 VSS.t57 sg13_lv_nmos ad=0.19p pd=1.38u as=0.19p ps=1.38u w=1u l=1u
X167 VDD VDD VDD VDD sg13_lv_pmos ad=1.14p pd=6.38u as=0 ps=0 w=6u l=1u
X168 VSS.t79 VSS.t77 VSS.t1 VSS.t78 sg13_lv_nmos ad=0.34p pd=2.68u as=0 ps=0 w=1u l=1u
X169 VDD vin4 vout4 VDD sg13_lv_pmos ad=1.14p pd=6.38u as=1.14p ps=6.38u w=6u l=1u
X170 VDD VDD VDD VDD sg13_lv_pmos ad=1.14p pd=6.38u as=0 ps=0 w=6u l=1u
X171 vout2 vin2 VSS.t123 VSS.t50 sg13_lv_nmos ad=0.19p pd=1.38u as=0.19p ps=1.38u w=1u l=1u
X172 vout3 vin3 VDD VDD sg13_lv_pmos ad=1.14p pd=6.38u as=1.14p ps=6.38u w=6u l=1u
X173 vout4 vin4 VSS.t85 VSS.t86 sg13_lv_nmos ad=0.19p pd=1.38u as=0.19p ps=1.38u w=1u l=1u
X174 vout3 vin3 VSS.t32 VSS.t31 sg13_lv_nmos ad=0.19p pd=1.38u as=0.19p ps=1.38u w=1u l=1u
X175 vout2 vin2 VSS.t46 VSS.t44 sg13_lv_nmos ad=0.19p pd=1.38u as=0.19p ps=1.38u w=1u l=1u
R0 VSS.n22 VSS.n12 6777.49
R1 VSS.n86 VSS.n22 6777.49
R2 VSS.n20 VSS.n12 6777.49
R3 VSS.t46 VSS.n12 1581.1
R4 VSS.t64 VSS.n22 6.87897
R5 VSS.t46 VSS.t55 19.5263
R6 VSS.n22 VSS.t110 12.2976
R7 VSS.t46 VSS.t53 21.9286
R8 VSS.n22 VSS.t108 14.4648
R9 VSS.n22 VSS.t86 14.4672
R10 VSS.t107 VSS.n22 16.2707
R11 VSS.n22 VSS.t87 16.2727
R12 VSS.n8 VSS.t51 59.5298
R13 VSS.t105 VSS.n22 17.7154
R14 VSS.n22 VSS.t89 17.717
R15 VSS.n5 VSS.t50 53.9825
R16 VSS.n22 VSS.t102 19.5212
R17 VSS.n22 VSS.t101 19.8823
R18 VSS.t96 VSS.n21 19.5591
R19 VSS.n22 VSS.t92 19.5219
R20 VSS.t46 VSS.n1 0.00138733
R21 VSS.n10 VSS.t48 48.439
R22 VSS.t95 VSS.n22 19.8818
R23 VSS.n22 VSS.t93 19.8825
R24 VSS.t39 VSS.n2 65.0734
R25 VSS.n4 VSS.t47 42.8926
R26 VSS.t99 VSS.n22 19.882
R27 VSS.t98 VSS.n21 19.5044
R28 VSS.n3 VSS.t39 37.3487
R29 VSS.t90 VSS.n22 18.8
R30 VSS.n3 VSS.t38 21.9282
R31 VSS.t29 VSS.n20 9.77004
R32 VSS.t78 VSS.n20 6.88019
R33 VSS.n20 VSS.t4 14.4653
R34 VSS.n20 VSS.t20 19.5209
R35 VSS.t81 VSS.n20 6.87996
R36 VSS.t26 VSS.n20 14.4654
R37 VSS.t22 VSS.n20 18.7991
R38 VSS.t19 VSS.n20 19.8822
R39 VSS.n20 VSS.t14 19.504
R40 VSS.t13 VSS.n20 19.8818
R41 VSS.t10 VSS.n20 19.5211
R42 VSS.t8 VSS.n20 18.799
R43 VSS.t7 VSS.n20 17.7156
R44 VSS.t5 VSS.n20 16.2715
R45 VSS.n20 VSS.t2 12.2982
R46 VSS.n20 VSS.n90 17.0005
R47 VSS.n91 VSS.n20 17.0005
R48 VSS.t30 VSS.n89 17.0005
R49 VSS.t30 VSS.n96 17.0005
R50 VSS.n97 VSS.t30 17.0005
R51 VSS.n89 VSS.t82 17.0005
R52 VSS.n96 VSS.t82 17.0005
R53 VSS.n97 VSS.t82 17.0005
R54 VSS.n20 VSS.n88 17.0005
R55 VSS.n20 VSS.n30 17.0005
R56 VSS.n87 VSS.t79 17.0005
R57 VSS.t79 VSS.n18 17.0005
R58 VSS.t79 VSS.n17 17.0005
R59 VSS.n87 VSS.t1 17.0005
R60 VSS.t1 VSS.n18 17.0005
R61 VSS.t1 VSS.n17 17.0005
R62 VSS.n0 VSS.t52 23.728
R63 VSS.t46 VSS.n5 0.00131894
R64 VSS.t46 VSS.n4 0.00151456
R65 VSS.n7 VSS.t44 48.4383
R66 VSS.n1 VSS.t44 53.984
R67 VSS.n1 VSS.t42 25.5305
R68 VSS.t46 VSS.n2 0.00162098
R69 VSS.n9 VSS.n26 0.0705904
R70 VSS.t46 VSS.n3 0.00133176
R71 VSS.t36 VSS.t46 19.5265
R72 VSS.t46 VSS.t35 16.5243
R73 VSS.t46 VSS.t33 12.9217
R74 VSS.t46 VSS.t68 3.87447
R75 VSS.t57 VSS.t46 12.9217
R76 VSS.n0 VSS.t46 0.00412678
R77 VSS.n14 VSS.t46 0.280191
R78 VSS.n43 VSS.n22 17.0005
R79 VSS.n47 VSS.n22 17.0005
R80 VSS.n28 VSS.n22 1.31136
R81 VSS.n29 VSS.n22 1.27589
R82 VSS.n62 VSS.n22 17.0005
R83 VSS.n61 VSS.n22 17.0005
R84 VSS.n64 VSS.t66 17.0005
R85 VSS.t66 VSS.n48 17.0005
R86 VSS.t66 VSS.n63 17.0005
R87 VSS.n64 VSS.t65 17.0005
R88 VSS.n48 VSS.t65 17.0005
R89 VSS.n63 VSS.t65 17.0005
R90 VSS.n65 VSS.t62 17.0005
R91 VSS.n67 VSS.t62 17.0005
R92 VSS.n66 VSS.t62 17.0005
R93 VSS.t61 VSS.n65 17.0005
R94 VSS.n67 VSS.t61 17.0005
R95 VSS.t61 VSS.n66 17.0005
R96 VSS.t84 VSS.n22 12.3005
R97 VSS.t72 VSS.n24 15.0005
R98 VSS.n84 VSS.t67 15.0005
R99 VSS.t46 VSS.t71 3.99516
R100 VSS.t83 VSS.n22 9.77299
R101 VSS.t23 VSS.n20 17.7157
R102 VSS.t17 VSS.n20 19.8814
R103 VSS.n20 VSS.t11 19.8819
R104 VSS.t16 VSS.n20 19.5585
R105 VSS.n20 VSS.t25 16.271
R106 VSS.n20 VSS.t28 12.2982
R107 VSS.n86 VSS.n20 6777.49
R108 VSS.n86 VSS.t46 1581.13
R109 VSS.n7 VSS.t45 59.5299
R110 VSS.t46 VSS.n8 0.00156876
R111 VSS.t46 VSS.n10 0.00156876
R112 VSS.t46 VSS.n7 0.00131411
R113 VSS.t46 VSS.n11 1.1173
R114 VSS.n6 VSS.n23 0.106884
R115 VSS.t46 VSS.n6 0.321885
R116 VSS.t46 VSS.n9 0.976429
R117 VSS.n11 VSS.n23 0.0357428
R118 VSS.n22 VSS.t60 6.87896
R119 VSS.n83 VSS.t72 7.49606
R120 VSS.t67 VSS.n81 7.49606
R121 VSS.t46 VSS.t70 4.99463
R122 VSS.t75 VSS.t46 4.99463
R123 VSS.n2 VSS.t41 24.9304
R124 VSS.n4 VSS.t45 42.8912
R125 VSS.n10 VSS.t47 59.5282
R126 VSS.n5 VSS.t48 53.9822
R127 VSS.n8 VSS.t50 48.4376
R128 VSS.t46 VSS.t56 16.5238
R129 VSS.n119 VSS.n118 5.97525
R130 VSS.n118 VSS.n33 5.97525
R131 VSS.n78 VSS.n39 5.97525
R132 VSS.n79 VSS.n78 5.97525
R133 VSS.t46 VSS.t31 8.71848
R134 VSS.t46 VSS.t73 4.5005
R135 VSS.t32 VSS.t46 4.5005
R136 VSS.n95 VSS.t80 3.0005
R137 VSS.n114 VSS.t77 3.0005
R138 VSS.t63 VSS.n60 3.0005
R139 VSS.t59 VSS.n68 3.0005
R140 VSS.n82 VSS.t46 3.0005
R141 VSS.t46 VSS.n85 3.0005
R142 VSS.t46 VSS.n15 2.98787
R143 VSS.t46 VSS.n80 2.98787
R144 VSS.n20 VSS.t0 9.76976
R145 VSS.n79 VSS.n38 2.71193
R146 VSS.n121 VSS.n32 2.6297
R147 VSS.n59 VSS.t109 2.48177
R148 VSS.t106 VSS.n50 2.48177
R149 VSS.t103 VSS.n51 2.48177
R150 VSS.t100 VSS.n40 2.48177
R151 VSS.t94 VSS.n41 2.48177
R152 VSS.n44 VSS.t91 2.48177
R153 VSS.n45 VSS.t88 2.48177
R154 VSS.n46 VSS.t85 2.48177
R155 VSS.t46 VSS.t113 2.48177
R156 VSS.t46 VSS.t115 2.48177
R157 VSS.t46 VSS.t117 2.48177
R158 VSS.t46 VSS.t123 0.18107
R159 VSS.n115 VSS.t3 2.48177
R160 VSS.n116 VSS.t6 2.48177
R161 VSS.n117 VSS.t9 2.48177
R162 VSS.n37 VSS.t12 2.48177
R163 VSS.t18 VSS.n36 2.48177
R164 VSS.n92 VSS.t21 2.48177
R165 VSS.n93 VSS.t24 2.48177
R166 VSS.n94 VSS.t27 2.48177
R167 VSS.t46 VSS.t34 2.48177
R168 VSS.t46 VSS.t37 2.48177
R169 VSS.n14 VSS.t40 0.165634
R170 VSS.t46 VSS.t43 0.179917
R171 VSS.t58 VSS.t46 8.7168
R172 VSS.n13 VSS.t46 0.524568
R173 VSS.t69 VSS.n13 0.00316691
R174 VSS.n99 VSS.n20 2.09947
R175 VSS.n101 VSS.n20 2.09947
R176 VSS.n103 VSS.n20 2.09947
R177 VSS.n34 VSS.n20 2.09947
R178 VSS.n105 VSS.n20 2.09947
R179 VSS.n107 VSS.n20 2.09947
R180 VSS.n109 VSS.n20 2.09947
R181 VSS.n111 VSS.n20 2.09947
R182 VSS.n53 VSS.n22 2.09887
R183 VSS.n57 VSS.n22 2.09887
R184 VSS.n71 VSS.n22 2.09868
R185 VSS.n73 VSS.n22 2.09868
R186 VSS.n75 VSS.n22 2.09868
R187 VSS.n77 VSS.n22 2.09868
R188 VSS.n22 VSS.n31 2.09868
R189 VSS.n55 VSS.n22 2.09849
R190 VSS.n114 VSS.n18 1.52811
R191 VSS.n60 VSS.n48 1.52811
R192 VSS.n68 VSS.n67 1.52811
R193 VSS.n96 VSS.n95 1.52811
R194 VSS.n65 VSS.n28 0.00154495
R195 VSS.n29 VSS.n64 0.0015302
R196 VSS.n113 VSS.n20 0.91152
R197 VSS.n69 VSS.n22 0.910334
R198 VSS.n49 VSS.n22 0.909653
R199 VSS.n39 VSS.n38 0.632727
R200 VSS.n121 VSS.n120 0.5505
R201 VSS.n119 VSS.n15 0.2444
R202 VSS.n39 VSS.n15 0.2444
R203 VSS.n80 VSS.n33 0.2444
R204 VSS.n80 VSS.n79 0.2444
R205 VSS.n115 VSS.n114 0.209825
R206 VSS.n60 VSS.n59 0.209825
R207 VSS.n68 VSS.n46 0.209825
R208 VSS.n95 VSS.n94 0.209825
R209 VSS.n112 VSS.t3 0.200997
R210 VSS.n110 VSS.t6 0.200997
R211 VSS.n108 VSS.t9 0.200997
R212 VSS.n106 VSS.t12 0.200997
R213 VSS.n104 VSS.t18 0.200997
R214 VSS.n102 VSS.t21 0.200997
R215 VSS.n100 VSS.t24 0.200997
R216 VSS.n98 VSS.t27 0.200997
R217 VSS.n23 VSS.t34 0.200997
R218 VSS.n25 VSS.t37 0.200997
R219 VSS.n26 VSS.n14 0.0235598
R220 VSS.t46 VSS.t49 0.181577
R221 VSS.t46 VSS.t54 0.39224
R222 VSS.t109 VSS.n58 0.200995
R223 VSS.n56 VSS.t106 0.200995
R224 VSS.n54 VSS.t103 0.200995
R225 VSS.n52 VSS.t100 0.200995
R226 VSS.n76 VSS.t94 0.200995
R227 VSS.n74 VSS.t91 0.200995
R228 VSS.n72 VSS.t88 0.200995
R229 VSS.n70 VSS.t85 0.200995
R230 VSS.t113 VSS.n23 0.200995
R231 VSS.t115 VSS.n25 0.200995
R232 VSS.t117 VSS.n26 0.200995
R233 VSS.t125 VSS.t46 0.177943
R234 VSS.t127 VSS.t46 0.181352
R235 VSS.t46 VSS.t121 0.185126
R236 VSS.n116 VSS.n115 0.16242
R237 VSS.n117 VSS.n116 0.16242
R238 VSS.n37 VSS.n117 0.16242
R239 VSS.n35 VSS.n37 0.16242
R240 VSS.n35 VSS.n36 0.16242
R241 VSS.n92 VSS.n36 0.16242
R242 VSS.n93 VSS.n92 0.16242
R243 VSS.n94 VSS.n93 0.16242
R244 VSS.n46 VSS.n45 0.16242
R245 VSS.n45 VSS.n44 0.16242
R246 VSS.n44 VSS.n41 0.16242
R247 VSS.n42 VSS.n41 0.16242
R248 VSS.n42 VSS.n40 0.16242
R249 VSS.n51 VSS.n40 0.16242
R250 VSS.n51 VSS.n50 0.16242
R251 VSS.n59 VSS.n50 0.16242
R252 VSS.n58 VSS.n49 0.146415
R253 VSS.n70 VSS.n69 0.145358
R254 VSS.n113 VSS.n112 0.144129
R255 VSS.n112 VSS.n111 0.0952183
R256 VSS.n71 VSS.n70 0.0942639
R257 VSS.n58 VSS.n57 0.0933111
R258 VSS.n110 VSS.n109 0.0927738
R259 VSS.n99 VSS.n98 0.0925656
R260 VSS.n73 VSS.n72 0.0918194
R261 VSS.n56 VSS.n55 0.0916245
R262 VSS.n108 VSS.n107 0.0903294
R263 VSS.t15 VSS.n34 0.0903294
R264 VSS.n101 VSS.n100 0.0901212
R265 VSS.t97 VSS.n31 0.089375
R266 VSS.n75 VSS.n74 0.0886728
R267 VSS.t97 VSS.n77 0.0886118
R268 VSS.n54 VSS.n53 0.0884223
R269 VSS.n106 VSS.n105 0.0878849
R270 VSS.n104 VSS.n103 0.0878849
R271 VSS.n105 VSS.t15 0.0876767
R272 VSS.n103 VSS.n102 0.0876767
R273 VSS.n53 VSS.n52 0.0871182
R274 VSS.n77 VSS.n76 0.0869305
R275 VSS.n76 VSS.n75 0.0868664
R276 VSS.n52 VSS.n31 0.0861674
R277 VSS.n102 VSS.n101 0.0854405
R278 VSS.n107 VSS.n106 0.0852323
R279 VSS.n34 VSS.n104 0.0852323
R280 VSS.t77 VSS.n113 0.0847768
R281 VSS.n55 VSS.n54 0.083911
R282 VSS.n74 VSS.n73 0.083723
R283 VSS.n69 VSS.t59 0.0834709
R284 VSS.t63 VSS.n49 0.0833265
R285 VSS.n100 VSS.n99 0.082996
R286 VSS.n109 VSS.n108 0.0827878
R287 VSS.n120 VSS.n119 0.0827273
R288 VSS.n33 VSS.n32 0.0827273
R289 VSS.n57 VSS.n56 0.0822293
R290 VSS.n98 VSS.n27 0.148049
R291 VSS.n72 VSS.n71 0.0812785
R292 VSS.n111 VSS.n110 0.0803434
R293 VSS.n20 VSS.n19 1.32552
R294 VSS VSS.n121 0.0445
R295 VSS.n38 VSS 0.0445
R296 VSS.t15 VSS.n35 0.0394177
R297 VSS.n42 VSS.t97 0.0394177
R298 VSS.n118 VSS.n35 0.0389615
R299 VSS.n78 VSS.n42 0.0389615
R300 VSS.t73 VSS.n83 0.031258
R301 VSS.n81 VSS.t32 0.031258
R302 VSS.n82 VSS.n24 0.0202884
R303 VSS.n85 VSS.n84 0.0202884
R304 VSS.n90 VSS.t80 0.0133922
R305 VSS.t77 VSS.n30 0.0133922
R306 VSS.n61 VSS.t63 0.0133922
R307 VSS.t59 VSS.n43 0.0133922
R308 VSS.n11 VSS.n25 0.0339647
R309 VSS.t74 VSS.n6 0.0292602
R310 VSS.n25 VSS.n9 0.0537754
R311 VSS.t74 VSS.n24 0.0115582
R312 VSS.n84 VSS.t74 0.0115582
R313 VSS.n22 VSS.n21 0.0507274
R314 VSS.n22 VSS.t104 18.799
R315 VSS.n22 VSS.t111 9.76925
R316 VSS.n83 VSS.n82 0.0108877
R317 VSS.n85 VSS.n81 0.0108877
R318 VSS.t74 VSS.n13 0.00811581
R319 VSS.n120 VSS 0.0095
R320 VSS.n32 VSS 0.0095
R321 VSS.n27 VSS.t80 0.0818274
R322 VSS.n96 VSS.n91 0.00798582
R323 VSS.n96 VSS.n16 0.0150237
R324 VSS.n88 VSS.n18 0.00798582
R325 VSS.n19 VSS.n18 0.0150022
R326 VSS.n48 VSS.n29 0.0150228
R327 VSS.n62 VSS.n48 0.00798582
R328 VSS.n67 VSS.n28 0.0150081
R329 VSS.n67 VSS.n47 0.00798582
R330 VSS.n90 VSS.n89 0.00756994
R331 VSS.n91 VSS.n89 0.00756994
R332 VSS.n97 VSS.n16 0.00152939
R333 VSS.n87 VSS.n30 0.00756994
R334 VSS.n88 VSS.n87 0.00756994
R335 VSS.n19 VSS.n17 0.00155084
R336 VSS.n63 VSS.n62 0.00756994
R337 VSS.n63 VSS.n61 0.00756994
R338 VSS.n66 VSS.n47 0.00756994
R339 VSS.n66 VSS.n43 0.00756994
R340 VSS.n20 VSS.n16 1.27394
R341 VSS.n27 VSS.n20 0.965636
R342 VSS.n0 VSS.t51 42.8985
C0 vout2 vin2 18.7881f
C1 vin1 vout1 18.7881f
C2 vout4 vin4 18.7881f
C3 vin3 vin2 0.25462f
C4 VDD vin4 30.3788f
C5 VDD vout2 19.8293f
C6 vin1 vin2 0.22004f
C7 VDD vout1 19.8349f
C8 vin3 vout3 18.7881f
C9 vin3 VDD 30.3477f
C10 VDD vin1 30.3788f
C11 VDD vin2 30.3477f
C12 VDD vout4 19.8349f
C13 vin3 vin4 0.22004f
C14 vout3 VDD 19.8293f
C15 vout1 VSS 15.47065f
C16 vout2 VSS 15.45263f
C17 vout3 VSS 15.45263f
C18 vout4 VSS 15.47065f
C19 VSS.t46 VSS 8.57785f
C20 VSS.t24 VSS 8.59555f
.ends
