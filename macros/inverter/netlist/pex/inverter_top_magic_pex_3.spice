* PEX produced on Tue Aug 25 10:59:01 AM CEST 2026 using /foss/tools/sak/sak-pex.sh with m=3 and s=1 (extresist threshold=10000 mOhm, minres=1000 mOhm, mindelay=1 ps)
* NGSPICE file created from inverter_top_pex.ext - technology: ihp-sg13cmos5l

.subckt inverter_top_pex VDD vin4 vout4 VSS vin3 vout3 vin2 vout2 vout1 vin1
X0 vout4 vin4 VDD VDD sg13_lv_pmos ad=1.14p pd=6.38u as=1.14p ps=6.38u w=6u l=1u
X1 VDD vin2 vout2 VDD sg13_lv_pmos ad=1.14p pd=6.38u as=1.14p ps=6.38u w=6u l=1u
X2 VSS.t128 vin2 vout2 VSS.t48 sg13_lv_nmos ad=0.19p pd=1.38u as=0.19p ps=1.38u w=1u l=1u
X3 vout2 vin2 VSS.t130 VSS.t53 sg13_lv_nmos ad=0.19p pd=1.38u as=0.19p ps=1.38u w=1u l=1u
X4 vout2 vin2 VDD VDD sg13_lv_pmos ad=1.14p pd=6.38u as=1.14p ps=6.38u w=6u l=1u
X5 VSS.t96 vin4 vout4 VSS.t95 sg13_lv_nmos ad=0.19p pd=1.38u as=0.19p ps=1.38u w=1u l=1u
X6 vout1 vin1 VSS.t24 VSS.t25 sg13_lv_nmos ad=0.19p pd=1.38u as=0.19p ps=1.38u w=1u l=1u
X7 VDD vin2 vout2 VDD sg13_lv_pmos ad=1.14p pd=6.38u as=1.14p ps=6.38u w=6u l=1u
X8 vout4 vin4 VSS.t64 VSS.t88 sg13_lv_nmos ad=0.19p pd=1.38u as=0.19p ps=1.38u w=1u l=1u
X9 VDD vin2 vout2 VDD sg13_lv_pmos ad=1.14p pd=6.38u as=1.14p ps=6.38u w=6u l=1u
X10 VSS.t58 vin3 vout3 VSS.t57 sg13_lv_nmos ad=0.19p pd=1.38u as=0.19p ps=1.38u w=1u l=1u
X11 vout4 vin4 VSS.t105 VSS.t106 sg13_lv_nmos ad=0.19p pd=1.38u as=0.19p ps=1.38u w=1u l=1u
X12 VDD vin3 vout3 VDD sg13_lv_pmos ad=1.14p pd=6.38u as=1.14p ps=6.38u w=6u l=1u
X13 VSS.t99 vin4 vout4 VSS.t98 sg13_lv_nmos ad=0.19p pd=1.38u as=0.19p ps=1.38u w=1u l=1u
X14 VDD vin2 vout2 VDD sg13_lv_pmos ad=1.14p pd=6.38u as=1.14p ps=6.38u w=6u l=1u
X15 vout3 vin3 VDD VDD sg13_lv_pmos ad=1.14p pd=6.38u as=1.14p ps=6.38u w=6u l=1u
X16 vout2 vin2 VDD VDD sg13_lv_pmos ad=1.14p pd=6.38u as=1.14p ps=6.38u w=6u l=1u
X17 VSS.t124 vin2 vout2 VSS.t42 sg13_lv_nmos ad=0.19p pd=1.38u as=0.19p ps=1.38u w=1u l=1u
X18 VDD vin3 vout3 VDD sg13_lv_pmos ad=1.14p pd=6.38u as=1.14p ps=6.38u w=6u l=1u
X19 VSS.t72 VSS.t70 VSS.t32 VSS.t71 sg13_lv_nmos ad=0.34p pd=2.68u as=0 ps=0 w=1u l=1u
X20 vout2 vin2 VSS.t126 VSS.t47 sg13_lv_nmos ad=0.19p pd=1.38u as=0.19p ps=1.38u w=1u l=1u
X21 vout1 vin1 VSS.t18 VSS.t19 sg13_lv_nmos ad=0.19p pd=1.38u as=0.19p ps=1.38u w=1u l=1u
X22 VSS.t130 vin2 vout2 VSS.t51 sg13_lv_nmos ad=0.19p pd=1.38u as=0.19p ps=1.38u w=1u l=1u
X23 vout4 vin4 VSS.t102 VSS.t103 sg13_lv_nmos ad=0.19p pd=1.38u as=0.19p ps=1.38u w=1u l=1u
X24 vout1 vin1 VDD VDD sg13_lv_pmos ad=1.14p pd=6.38u as=1.14p ps=6.38u w=6u l=1u
X25 vout1 vin1 VSS.t12 VSS.t13 sg13_lv_nmos ad=0.19p pd=1.38u as=0.19p ps=1.38u w=1u l=1u
X26 VSS.t108 vin4 vout4 VSS.t107 sg13_lv_nmos ad=0.19p pd=1.38u as=0.19p ps=1.38u w=1u l=1u
X27 VDD VDD VDD VDD sg13_lv_pmos ad=1.14p pd=6.38u as=0.56797n ps=1.006m w=6u l=1u
X28 VSS.t18 vin1 vout1 VSS.t17 sg13_lv_nmos ad=0.19p pd=1.38u as=0.19p ps=1.38u w=1u l=1u
X29 vout2 vin2 VDD VDD sg13_lv_pmos ad=1.14p pd=6.38u as=1.14p ps=6.38u w=6u l=1u
X30 VDD vin4 vout4 VDD sg13_lv_pmos ad=1.14p pd=6.38u as=1.14p ps=6.38u w=6u l=1u
X31 vout1 vin1 VSS.t21 VSS.t22 sg13_lv_nmos ad=0.19p pd=1.38u as=0.19p ps=1.38u w=1u l=1u
X32 vout3 vin3 VSS.t55 VSS.t56 sg13_lv_nmos ad=0.19p pd=1.38u as=0.19p ps=1.38u w=1u l=1u
X33 vout4 vin4 VDD VDD sg13_lv_pmos ad=1.14p pd=6.38u as=1.14p ps=6.38u w=6u l=1u
X34 VDD vin3 vout3 VDD sg13_lv_pmos ad=1.14p pd=6.38u as=1.14p ps=6.38u w=6u l=1u
X35 VDD vin4 vout4 VDD sg13_lv_pmos ad=1.14p pd=6.38u as=1.14p ps=6.38u w=6u l=1u
X36 vout3 vin3 VDD VDD sg13_lv_pmos ad=1.14p pd=6.38u as=1.14p ps=6.38u w=6u l=1u
X37 VDD vin3 vout3 VDD sg13_lv_pmos ad=1.14p pd=6.38u as=1.14p ps=6.38u w=6u l=1u
X38 VSS.t69 VSS.t66 VSS.t68 VSS.t67 sg13_lv_nmos ad=0.19p pd=1.38u as=0 ps=0 w=1u l=1u
X39 VDD vin4 vout4 VDD sg13_lv_pmos ad=1.14p pd=6.38u as=1.14p ps=6.38u w=6u l=1u
X40 VDD vin2 vout2 VDD sg13_lv_pmos ad=1.14p pd=6.38u as=1.14p ps=6.38u w=6u l=1u
X41 VSS.t111 vin4 vout4 VSS.t110 sg13_lv_nmos ad=0.19p pd=1.38u as=0.19p ps=1.38u w=1u l=1u
X42 VDD vin3 vout3 VDD sg13_lv_pmos ad=1.14p pd=6.38u as=1.14p ps=6.38u w=6u l=1u
X43 VSS.t12 vin1 vout1 VSS.t11 sg13_lv_nmos ad=0.19p pd=1.38u as=0.19p ps=1.38u w=1u l=1u
X44 VDD vin1 vout1 VDD sg13_lv_pmos ad=1.14p pd=6.38u as=1.14p ps=6.38u w=6u l=1u
X45 vout4 vin4 VSS.t114 VSS.t115 sg13_lv_nmos ad=0.19p pd=1.38u as=0.19p ps=1.38u w=1u l=1u
X46 vout4 vin4 VDD VDD sg13_lv_pmos ad=1.14p pd=6.38u as=1.14p ps=6.38u w=6u l=1u
X47 vout1 vin1 VSS.t15 VSS.t16 sg13_lv_nmos ad=0.19p pd=1.38u as=0.19p ps=1.38u w=1u l=1u
X48 vout1 vin1 VDD VDD sg13_lv_pmos ad=1.14p pd=6.38u as=1.14p ps=6.38u w=6u l=1u
X49 VDD vin1 vout1 VDD sg13_lv_pmos ad=1.14p pd=6.38u as=1.14p ps=6.38u w=6u l=1u
X50 vout3 vin3 VSS.t49 VSS.t50 sg13_lv_nmos ad=0.19p pd=1.38u as=0.19p ps=1.38u w=1u l=1u
X51 VSS.t21 vin1 vout1 VSS.t20 sg13_lv_nmos ad=0.19p pd=1.38u as=0.19p ps=1.38u w=1u l=1u
X52 VDD VDD VDD VDD sg13_lv_pmos ad=2.04p pd=12.68u as=0 ps=0 w=6u l=1u
X53 vout4 vin4 VDD VDD sg13_lv_pmos ad=1.14p pd=6.38u as=1.14p ps=6.38u w=6u l=1u
X54 VDD vin3 vout3 VDD sg13_lv_pmos ad=1.14p pd=6.38u as=1.14p ps=6.38u w=6u l=1u
X55 VDD vin4 vout4 VDD sg13_lv_pmos ad=1.14p pd=6.38u as=1.14p ps=6.38u w=6u l=1u
X56 vout3 vin3 VSS.t43 VSS.t44 sg13_lv_nmos ad=0.19p pd=1.38u as=0.19p ps=1.38u w=1u l=1u
X57 vout3 vin3 VDD VDD sg13_lv_pmos ad=1.14p pd=6.38u as=1.14p ps=6.38u w=6u l=1u
X58 VSS.t49 vin3 vout3 VSS.t48 sg13_lv_nmos ad=0.19p pd=1.38u as=0.19p ps=1.38u w=1u l=1u
X59 VDD VDD VDD VDD sg13_lv_pmos ad=1.14p pd=6.38u as=0 ps=0 w=6u l=1u
X60 vout3 vin3 VSS.t52 VSS.t53 sg13_lv_nmos ad=0.19p pd=1.38u as=0.19p ps=1.38u w=1u l=1u
X61 vout4 vin4 VDD VDD sg13_lv_pmos ad=1.14p pd=6.38u as=1.14p ps=6.38u w=6u l=1u
X62 vout3 vin3 VDD VDD sg13_lv_pmos ad=1.14p pd=6.38u as=1.14p ps=6.38u w=6u l=1u
X63 VDD vin1 vout1 VDD sg13_lv_pmos ad=1.14p pd=6.38u as=1.14p ps=6.38u w=6u l=1u
X64 vout2 vin2 VDD VDD sg13_lv_pmos ad=1.14p pd=6.38u as=1.14p ps=6.38u w=6u l=1u
X65 vout1 vin1 VDD VDD sg13_lv_pmos ad=1.14p pd=6.38u as=1.14p ps=6.38u w=6u l=1u
X66 VDD vin1 vout1 VDD sg13_lv_pmos ad=1.14p pd=6.38u as=1.14p ps=6.38u w=6u l=1u
X67 vout2 vin2 VSS.t120 VSS.t38 sg13_lv_nmos ad=0.19p pd=1.38u as=0.19p ps=1.38u w=1u l=1u
X68 VDD vin1 vout1 VDD sg13_lv_pmos ad=1.14p pd=6.38u as=1.14p ps=6.38u w=6u l=1u
X69 VDD vin3 vout3 VDD sg13_lv_pmos ad=1.14p pd=6.38u as=1.14p ps=6.38u w=6u l=1u
X70 VSS.t43 vin3 vout3 VSS.t42 sg13_lv_nmos ad=0.19p pd=1.38u as=0.19p ps=1.38u w=1u l=1u
X71 vout3 vin3 VSS.t46 VSS.t47 sg13_lv_nmos ad=0.19p pd=1.38u as=0.19p ps=1.38u w=1u l=1u
X72 VSS.t93 vin4 vout4 VSS.t92 sg13_lv_nmos ad=0.19p pd=1.38u as=0.19p ps=1.38u w=1u l=1u
X73 VDD vin4 vout4 VDD sg13_lv_pmos ad=1.14p pd=6.38u as=1.14p ps=6.38u w=6u l=1u
X74 VSS.t52 vin3 vout3 VSS.t51 sg13_lv_nmos ad=0.19p pd=1.38u as=0.19p ps=1.38u w=1u l=1u
X75 vout4 vin4 VSS.t96 VSS.t97 sg13_lv_nmos ad=0.19p pd=1.38u as=0.19p ps=1.38u w=1u l=1u
X76 VDD vin1 vout1 VDD sg13_lv_pmos ad=1.14p pd=6.38u as=1.14p ps=6.38u w=6u l=1u
X77 vout2 vin2 VDD VDD sg13_lv_pmos ad=1.14p pd=6.38u as=1.14p ps=6.38u w=6u l=1u
X78 vout1 vin1 VDD VDD sg13_lv_pmos ad=1.14p pd=6.38u as=1.14p ps=6.38u w=6u l=1u
X79 VSS.t90 vin4 vout4 VSS.t89 sg13_lv_nmos ad=0.19p pd=1.38u as=0.19p ps=1.38u w=1u l=1u
X80 VDD VDD VDD VDD sg13_lv_pmos ad=2.04p pd=12.68u as=0 ps=0 w=6u l=1u
X81 vout2 vin2 VDD VDD sg13_lv_pmos ad=1.14p pd=6.38u as=1.14p ps=6.38u w=6u l=1u
X82 VDD vin2 vout2 VDD sg13_lv_pmos ad=1.14p pd=6.38u as=1.14p ps=6.38u w=6u l=1u
X83 VSS.t120 vin2 vout2 VSS.t36 sg13_lv_nmos ad=0.19p pd=1.38u as=0.19p ps=1.38u w=1u l=1u
X84 VSS.t102 vin4 vout4 VSS.t101 sg13_lv_nmos ad=0.19p pd=1.38u as=0.19p ps=1.38u w=1u l=1u
X85 VDD VDD VDD VDD sg13_lv_pmos ad=2.04p pd=12.68u as=0 ps=0 w=6u l=1u
X86 vout2 vin2 VDD VDD sg13_lv_pmos ad=1.14p pd=6.38u as=1.14p ps=6.38u w=6u l=1u
X87 vout2 vin2 VSS.t122 VSS.t41 sg13_lv_nmos ad=0.19p pd=1.38u as=0.19p ps=1.38u w=1u l=1u
X88 VSS.t126 vin2 vout2 VSS.t45 sg13_lv_nmos ad=0.19p pd=1.38u as=0.19p ps=1.38u w=1u l=1u
X89 vout1 vin1 VDD VDD sg13_lv_pmos ad=1.14p pd=6.38u as=1.14p ps=6.38u w=6u l=1u
X90 vout1 vin1 VSS.t6 VSS.t7 sg13_lv_nmos ad=0.19p pd=1.38u as=0.19p ps=1.38u w=1u l=1u
X91 vout4 vin4 VSS.t99 VSS.t100 sg13_lv_nmos ad=0.19p pd=1.38u as=0.19p ps=1.38u w=1u l=1u
X92 vout3 vin3 VDD VDD sg13_lv_pmos ad=1.14p pd=6.38u as=1.14p ps=6.38u w=6u l=1u
X93 vout4 vin4 VSS.t111 VSS.t112 sg13_lv_nmos ad=0.19p pd=1.38u as=0.19p ps=1.38u w=1u l=1u
X94 VSS.t81 VSS.t79 VSS.t80 VSS.t74 sg13_lv_nmos ad=0.19p pd=1.38u as=0 ps=0 w=1u l=1u
X95 VSS.t105 vin4 vout4 VSS.t104 sg13_lv_nmos ad=0.19p pd=1.38u as=0.19p ps=1.38u w=1u l=1u
X96 VDD vin1 vout1 VDD sg13_lv_pmos ad=1.14p pd=6.38u as=1.14p ps=6.38u w=6u l=1u
X97 VSS.t81 vin2 vout2 VSS.t60 sg13_lv_nmos ad=0.19p pd=1.38u as=0.19p ps=1.38u w=1u l=1u
X98 VDD vin2 vout2 VDD sg13_lv_pmos ad=1.14p pd=6.38u as=1.14p ps=6.38u w=6u l=1u
X99 vout4 vin4 VSS.t108 VSS.t109 sg13_lv_nmos ad=0.19p pd=1.38u as=0.19p ps=1.38u w=1u l=1u
X100 vout4 vin4 VDD VDD sg13_lv_pmos ad=1.14p pd=6.38u as=1.14p ps=6.38u w=6u l=1u
X101 vout2 vin2 VDD VDD sg13_lv_pmos ad=1.14p pd=6.38u as=1.14p ps=6.38u w=6u l=1u
X102 vout2 vin2 VSS.t118 VSS.t35 sg13_lv_nmos ad=0.19p pd=1.38u as=0.19p ps=1.38u w=1u l=1u
X103 VDD vin2 vout2 VDD sg13_lv_pmos ad=1.14p pd=6.38u as=1.14p ps=6.38u w=6u l=1u
X104 VSS.t122 vin2 vout2 VSS.t39 sg13_lv_nmos ad=0.19p pd=1.38u as=0.19p ps=1.38u w=1u l=1u
X105 VDD vin4 vout4 VDD sg13_lv_pmos ad=1.14p pd=6.38u as=1.14p ps=6.38u w=6u l=1u
X106 VDD VDD VDD VDD sg13_lv_pmos ad=2.04p pd=12.68u as=0 ps=0 w=6u l=1u
X107 VSS.t118 vin2 vout2 VSS.t33 sg13_lv_nmos ad=0.19p pd=1.38u as=0.19p ps=1.38u w=1u l=1u
X108 VSS.t6 vin1 vout1 VSS.t5 sg13_lv_nmos ad=0.19p pd=1.38u as=0.19p ps=1.38u w=1u l=1u
X109 vout3 vin3 VDD VDD sg13_lv_pmos ad=1.14p pd=6.38u as=1.14p ps=6.38u w=6u l=1u
X110 vout1 vin1 VSS.t9 VSS.t10 sg13_lv_nmos ad=0.19p pd=1.38u as=0.19p ps=1.38u w=1u l=1u
X111 VSS.t15 vin1 vout1 VSS.t14 sg13_lv_nmos ad=0.19p pd=1.38u as=0.19p ps=1.38u w=1u l=1u
X112 vout3 vin3 VDD VDD sg13_lv_pmos ad=1.14p pd=6.38u as=1.14p ps=6.38u w=6u l=1u
X113 VDD vin3 vout3 VDD sg13_lv_pmos ad=1.14p pd=6.38u as=1.14p ps=6.38u w=6u l=1u
X114 vout3 vin3 VDD VDD sg13_lv_pmos ad=1.14p pd=6.38u as=1.14p ps=6.38u w=6u l=1u
X115 vout3 vin3 VSS.t37 VSS.t38 sg13_lv_nmos ad=0.19p pd=1.38u as=0.19p ps=1.38u w=1u l=1u
X116 VSS.t132 vin2 vout2 VSS.t54 sg13_lv_nmos ad=0.19p pd=1.38u as=0.19p ps=1.38u w=1u l=1u
X117 vout2 vin2 VSS.t134 VSS.t59 sg13_lv_nmos ad=0.19p pd=1.38u as=0.19p ps=1.38u w=1u l=1u
X118 VSS.t69 vin4 vout4 VSS.t116 sg13_lv_nmos ad=0.19p pd=1.38u as=0.19p ps=1.38u w=1u l=1u
X119 vout1 vin1 VDD VDD sg13_lv_pmos ad=1.14p pd=6.38u as=1.14p ps=6.38u w=6u l=1u
X120 VSS.t30 VSS.t85 VSS.t87 VSS.t86 sg13_lv_nmos ad=0.19p pd=1.38u as=0 ps=0 w=1u l=1u
X121 VSS.t30 vin1 vout1 VSS.t29 sg13_lv_nmos ad=0.19p pd=1.38u as=0.19p ps=1.38u w=1u l=1u
X122 vout2 vin2 VSS.t77 VSS.t31 sg13_lv_nmos ad=0.19p pd=1.38u as=0.19p ps=1.38u w=1u l=1u
X123 VSS.t65 VSS.t62 VSS.t64 VSS.t63 sg13_lv_nmos ad=0.34p pd=2.68u as=0 ps=0 w=1u l=1u
X124 vout1 vin1 VSS.t3 VSS.t4 sg13_lv_nmos ad=0.19p pd=1.38u as=0.19p ps=1.38u w=1u l=1u
X125 VSS.t9 vin1 vout1 VSS.t8 sg13_lv_nmos ad=0.19p pd=1.38u as=0.19p ps=1.38u w=1u l=1u
X126 VDD vin3 vout3 VDD sg13_lv_pmos ad=1.14p pd=6.38u as=1.14p ps=6.38u w=6u l=1u
X127 VSS.t3 vin1 vout1 VSS.t2 sg13_lv_nmos ad=0.19p pd=1.38u as=0.19p ps=1.38u w=1u l=1u
X128 vout4 vin4 VDD VDD sg13_lv_pmos ad=1.14p pd=6.38u as=1.14p ps=6.38u w=6u l=1u
X129 vout3 vin3 VDD VDD sg13_lv_pmos ad=1.14p pd=6.38u as=1.14p ps=6.38u w=6u l=1u
X130 VDD vin3 vout3 VDD sg13_lv_pmos ad=1.14p pd=6.38u as=1.14p ps=6.38u w=6u l=1u
X131 VSS.t37 vin3 vout3 VSS.t36 sg13_lv_nmos ad=0.19p pd=1.38u as=0.19p ps=1.38u w=1u l=1u
X132 vout3 vin3 VSS.t40 VSS.t41 sg13_lv_nmos ad=0.19p pd=1.38u as=0.19p ps=1.38u w=1u l=1u
X133 vout1 vin1 VDD VDD sg13_lv_pmos ad=1.14p pd=6.38u as=1.14p ps=6.38u w=6u l=1u
X134 VSS.t134 vin2 vout2 VSS.t57 sg13_lv_nmos ad=0.19p pd=1.38u as=0.19p ps=1.38u w=1u l=1u
X135 VSS.t46 vin3 vout3 VSS.t45 sg13_lv_nmos ad=0.19p pd=1.38u as=0.19p ps=1.38u w=1u l=1u
X136 VDD vin4 vout4 VDD sg13_lv_pmos ad=1.14p pd=6.38u as=1.14p ps=6.38u w=6u l=1u
X137 vout1 vin1 VDD VDD sg13_lv_pmos ad=1.14p pd=6.38u as=1.14p ps=6.38u w=6u l=1u
X138 VDD vin1 vout1 VDD sg13_lv_pmos ad=1.14p pd=6.38u as=1.14p ps=6.38u w=6u l=1u
X139 vout4 vin4 VDD VDD sg13_lv_pmos ad=1.14p pd=6.38u as=1.14p ps=6.38u w=6u l=1u
X140 VSS.t24 vin1 vout1 VSS.t23 sg13_lv_nmos ad=0.19p pd=1.38u as=0.19p ps=1.38u w=1u l=1u
X141 vout1 vin1 VDD VDD sg13_lv_pmos ad=1.14p pd=6.38u as=1.14p ps=6.38u w=6u l=1u
X142 vout1 vin1 VSS.t27 VSS.t28 sg13_lv_nmos ad=0.19p pd=1.38u as=0.19p ps=1.38u w=1u l=1u
X143 vout2 vin2 VDD VDD sg13_lv_pmos ad=1.14p pd=6.38u as=1.14p ps=6.38u w=6u l=1u
X144 vout4 vin4 VSS.t93 VSS.t94 sg13_lv_nmos ad=0.19p pd=1.38u as=0.19p ps=1.38u w=1u l=1u
X145 VSS.t78 VSS.t76 VSS.t77 VSS.t71 sg13_lv_nmos ad=0.34p pd=2.68u as=0 ps=0 w=1u l=1u
X146 VSS.t61 VSS.t73 VSS.t75 VSS.t74 sg13_lv_nmos ad=0.19p pd=1.38u as=0 ps=0 w=1u l=1u
X147 vout4 vin4 VDD VDD sg13_lv_pmos ad=1.14p pd=6.38u as=1.14p ps=6.38u w=6u l=1u
X148 VSS.t61 vin3 vout3 VSS.t60 sg13_lv_nmos ad=0.19p pd=1.38u as=0.19p ps=1.38u w=1u l=1u
X149 VSS.t114 vin4 vout4 VSS.t113 sg13_lv_nmos ad=0.19p pd=1.38u as=0.19p ps=1.38u w=1u l=1u
X150 VDD vin4 vout4 VDD sg13_lv_pmos ad=1.14p pd=6.38u as=1.14p ps=6.38u w=6u l=1u
X151 vout1 vin1 VSS.t1 VSS.t0 sg13_lv_nmos ad=0.19p pd=1.38u as=0.19p ps=1.38u w=1u l=1u
X152 vout3 vin3 VSS.t34 VSS.t35 sg13_lv_nmos ad=0.19p pd=1.38u as=0.19p ps=1.38u w=1u l=1u
X153 VSS.t40 vin3 vout3 VSS.t39 sg13_lv_nmos ad=0.19p pd=1.38u as=0.19p ps=1.38u w=1u l=1u
X154 vout4 vin4 VDD VDD sg13_lv_pmos ad=1.14p pd=6.38u as=1.14p ps=6.38u w=6u l=1u
X155 vout2 vin2 VSS.t132 VSS.t56 sg13_lv_nmos ad=0.19p pd=1.38u as=0.19p ps=1.38u w=1u l=1u
X156 VSS.t34 vin3 vout3 VSS.t33 sg13_lv_nmos ad=0.19p pd=1.38u as=0.19p ps=1.38u w=1u l=1u
X157 VDD vin1 vout1 VDD sg13_lv_pmos ad=1.14p pd=6.38u as=1.14p ps=6.38u w=6u l=1u
X158 vout1 vin1 VDD VDD sg13_lv_pmos ad=1.14p pd=6.38u as=1.14p ps=6.38u w=6u l=1u
X159 VDD vin4 vout4 VDD sg13_lv_pmos ad=1.14p pd=6.38u as=1.14p ps=6.38u w=6u l=1u
X160 VDD vin1 vout1 VDD sg13_lv_pmos ad=1.14p pd=6.38u as=1.14p ps=6.38u w=6u l=1u
X161 VSS.t27 vin1 vout1 VSS.t26 sg13_lv_nmos ad=0.19p pd=1.38u as=0.19p ps=1.38u w=1u l=1u
X162 VDD vin2 vout2 VDD sg13_lv_pmos ad=1.14p pd=6.38u as=1.14p ps=6.38u w=6u l=1u
X163 vout2 vin2 VDD VDD sg13_lv_pmos ad=1.14p pd=6.38u as=1.14p ps=6.38u w=6u l=1u
X164 VDD vin2 vout2 VDD sg13_lv_pmos ad=1.14p pd=6.38u as=1.14p ps=6.38u w=6u l=1u
X165 VSS.t55 vin3 vout3 VSS.t54 sg13_lv_nmos ad=0.19p pd=1.38u as=0.19p ps=1.38u w=1u l=1u
X166 vout3 vin3 VSS.t58 VSS.t59 sg13_lv_nmos ad=0.19p pd=1.38u as=0.19p ps=1.38u w=1u l=1u
X167 VDD VDD VDD VDD sg13_lv_pmos ad=1.14p pd=6.38u as=0 ps=0 w=6u l=1u
X168 VSS.t84 VSS.t82 VSS.t1 VSS.t83 sg13_lv_nmos ad=0.34p pd=2.68u as=0 ps=0 w=1u l=1u
X169 VDD vin4 vout4 VDD sg13_lv_pmos ad=1.14p pd=6.38u as=1.14p ps=6.38u w=6u l=1u
X170 VDD VDD VDD VDD sg13_lv_pmos ad=1.14p pd=6.38u as=0 ps=0 w=6u l=1u
X171 vout2 vin2 VSS.t128 VSS.t50 sg13_lv_nmos ad=0.19p pd=1.38u as=0.19p ps=1.38u w=1u l=1u
X172 vout3 vin3 VDD VDD sg13_lv_pmos ad=1.14p pd=6.38u as=1.14p ps=6.38u w=6u l=1u
X173 vout4 vin4 VSS.t90 VSS.t91 sg13_lv_nmos ad=0.19p pd=1.38u as=0.19p ps=1.38u w=1u l=1u
X174 vout3 vin3 VSS.t32 VSS.t31 sg13_lv_nmos ad=0.19p pd=1.38u as=0.19p ps=1.38u w=1u l=1u
X175 vout2 vin2 VSS.t124 VSS.t44 sg13_lv_nmos ad=0.19p pd=1.38u as=0.19p ps=1.38u w=1u l=1u
R0 VSS.n101 VSS.n105 6777.49
R1 VSS.n54 VSS.n105 6777.49
R2 VSS.n353 VSS.n352 1580.41
R3 VSS.n351 VSS.n105 1580.41
R4 VSS.n219 VSS.t31 88.7251
R5 VSS.n256 VSS.t60 88.7251
R6 VSS.t33 VSS.n221 83.1798
R7 VSS.n254 VSS.t59 83.1798
R8 VSS.n131 VSS.t35 77.6345
R9 VSS.t57 VSS.n250 77.6345
R10 VSS.t63 VSS.n103 6.87896
R11 VSS.n99 VSS.t116 11.4002
R12 VSS.n226 VSS.t36 72.0892
R13 VSS.n248 VSS.t56 72.0892
R14 VSS.t116 VSS.n97 68.3206
R15 VSS.n102 VSS.t88 9.77299
R16 VSS.n229 VSS.t38 66.5439
R17 VSS.n244 VSS.t54 66.5439
R18 VSS.t115 VSS.n96 64.5255
R19 VSS.n79 VSS.t89 64.5209
R20 VSS.n145 VSS.t39 60.9987
R21 VSS.t53 VSS.n193 60.9987
R22 VSS.t113 VSS.n95 60.7305
R23 VSS.n81 VSS.t91 60.7259
R24 VSS.t29 VSS.n66 68.3172
R25 VSS.t112 VSS.n94 56.9354
R26 VSS.n82 VSS.t92 56.9308
R27 VSS.t28 VSS.n62 64.5222
R28 VSS.t41 VSS.n150 55.4534
R29 VSS.n239 VSS.t45 55.4534
R30 VSS.n167 VSS.t47 55.4534
R31 VSS.t51 VSS.n186 55.4534
R32 VSS.t110 VSS.n93 53.1403
R33 VSS.n83 VSS.t94 53.1357
R34 VSS.t42 VSS.n157 49.9081
R35 VSS.t44 VSS.n236 49.9081
R36 VSS.n173 VSS.t48 49.9081
R37 VSS.n242 VSS.t50 49.9081
R38 VSS.t109 VSS.n92 49.3453
R39 VSS.n84 VSS.t95 49.3407
R40 VSS.t25 VSS.n61 56.932
R41 VSS.t107 VSS.n91 45.5502
R42 VSS.t101 VSS.n87 45.5502
R43 VSS.n89 VSS.t103 45.5456
R44 VSS.n85 VSS.t97 45.5456
R45 VSS.t23 VSS.n58 53.137
R46 VSS.n234 VSS.t42 44.3628
R47 VSS.n237 VSS.t44 44.3628
R48 VSS.t48 VSS.n172 44.3628
R49 VSS.t50 VSS.n241 44.3628
R50 VSS.t106 VSS.n90 41.7551
R51 VSS.t100 VSS.n86 41.7551
R52 VSS.n90 VSS.t104 41.7505
R53 VSS.n86 VSS.t98 41.7505
R54 VSS.t22 VSS.n55 49.3419
R55 VSS.n231 VSS.t41 38.8175
R56 VSS.t45 VSS.n1 40.8369
R57 VSS.t47 VSS.n2 40.8364
R58 VSS.n187 VSS.t51 38.8175
R59 VSS.t104 VSS.n89 37.9601
R60 VSS.t98 VSS.n85 37.9601
R61 VSS.n91 VSS.t106 37.9555
R62 VSS.n87 VSS.t100 37.9555
R63 VSS.t103 VSS.n88 34.1682
R64 VSS.t97 VSS.n84 34.165
R65 VSS.n88 VSS.t101 34.1635
R66 VSS.n92 VSS.t107 34.1604
R67 VSS.t13 VSS.n69 41.7518
R68 VSS.t39 VSS.n144 33.2722
R69 VSS.n194 VSS.t53 33.2722
R70 VSS.t95 VSS.n83 30.3699
R71 VSS.n93 VSS.t109 30.3653
R72 VSS.t11 VSS.n76 37.9567
R73 VSS.t38 VSS.n228 27.7269
R74 VSS.t54 VSS.n198 27.7269
R75 VSS.t94 VSS.n82 26.5749
R76 VSS.n94 VSS.t110 26.5703
R77 VSS.t16 VSS.n71 34.1648
R78 VSS.t92 VSS.n81 22.7798
R79 VSS.n95 VSS.t112 22.7752
R80 VSS.t8 VSS.n59 30.3673
R81 VSS.t26 VSS.n74 60.7281
R82 VSS.t20 VSS.n68 45.5478
R83 VSS.t4 VSS.n65 18.9824
R84 VSS.t83 VSS.n73 13.7582
R85 VSS.n59 VSS.t7 53.1364
R86 VSS.t14 VSS.n56 45.5478
R87 VSS.t86 VSS.n54 13.76
R88 VSS.t36 VSS.n225 22.1816
R89 VSS.t56 VSS.n247 22.1816
R90 VSS.t91 VSS.n79 18.9847
R91 VSS.n96 VSS.t113 18.9801
R92 VSS.t7 VSS.n57 26.5715
R93 VSS.t29 VSS.n70 11.3996
R94 VSS.n66 VSS.n53 0.0109013
R95 VSS.t28 VSS.n66 15.1866
R96 VSS.n61 VSS.n53 0.0109013
R97 VSS.t23 VSS.n61 26.5718
R98 VSS.n58 VSS.n53 0.0108886
R99 VSS.t20 VSS.n55 34.162
R100 VSS.n68 VSS.n53 0.0108886
R101 VSS.t17 VSS.n64 41.7521
R102 VSS.n72 VSS.n53 0.0109013
R103 VSS.t14 VSS.n71 34.1651
R104 VSS.n69 VSS.n53 0.0109013
R105 VSS.t11 VSS.n69 41.7521
R106 VSS.n76 VSS.n53 0.0109013
R107 VSS.t10 VSS.n76 45.5472
R108 VSS.t8 VSS.n67 49.3422
R109 VSS.n59 VSS.n53 0.0111485
R110 VSS.n57 VSS.n53 0.0109013
R111 VSS.t5 VSS.n57 56.9324
R112 VSS.n75 VSS.n53 0.0109013
R113 VSS.t4 VSS.n75 60.7274
R114 VSS.n63 VSS.n53 0.0109013
R115 VSS.t0 VSS.n63 68.3176
R116 VSS.t85 VSS.n78 0.008067
R117 VSS.n53 VSS.n78 8.49747
R118 VSS.n359 VSS.n53 17.0005
R119 VSS.n53 VSS.n107 17.0005
R120 VSS.t30 VSS.n358 17.0005
R121 VSS.t30 VSS.n364 17.0005
R122 VSS.n365 VSS.t30 17.0005
R123 VSS.n358 VSS.t87 17.0005
R124 VSS.n364 VSS.t87 17.0005
R125 VSS.n365 VSS.t87 17.0005
R126 VSS.n53 VSS.n77 0.00896246
R127 VSS.n354 VSS.n53 17.0005
R128 VSS.n53 VSS.n357 17.0005
R129 VSS.n53 VSS.n104 17.0005
R130 VSS.n356 VSS.t84 17.0005
R131 VSS.t84 VSS.n114 17.0005
R132 VSS.t84 VSS.n355 17.0005
R133 VSS.n356 VSS.t1 17.0005
R134 VSS.t1 VSS.n114 17.0005
R135 VSS.n355 VSS.t1 17.0005
R136 VSS.n213 VSS.n17 14.4044
R137 VSS.n39 VSS.n0 1.20771
R138 VSS.n280 VSS.n0 17.0005
R139 VSS.n211 VSS.n0 17.0005
R140 VSS.n23 VSS.n0 0.650675
R141 VSS.n208 VSS.n28 14.4044
R142 VSS.n28 VSS.n0 0.650675
R143 VSS.n256 VSS.n0 8.49992
R144 VSS.n257 VSS.n34 14.4044
R145 VSS.n254 VSS.n0 8.49875
R146 VSS.n252 VSS.n14 14.4044
R147 VSS.n7 VSS.n0 2.4234
R148 VSS.n251 VSS.n0 8.49967
R149 VSS.n199 VSS.n31 14.4044
R150 VSS.n248 VSS.n32 7.20256
R151 VSS.n32 VSS.n0 0.650675
R152 VSS.n15 VSS.n0 0.650675
R153 VSS.n198 VSS.n15 7.20256
R154 VSS.n195 VSS.n26 14.4044
R155 VSS.n196 VSS.n0 17.0005
R156 VSS.n194 VSS.n0 8.49942
R157 VSS.n193 VSS.n0 8.49917
R158 VSS.n11 VSS.n0 0.650675
R159 VSS.n271 VSS.n0 17.0005
R160 VSS.n188 VSS.n11 14.4044
R161 VSS.n272 VSS.n0 17.0005
R162 VSS.n187 VSS.n0 8.49892
R163 VSS.n186 VSS.n0 8.49867
R164 VSS.n27 VSS.n0 0.650675
R165 VSS.n178 VSS.n27 14.4044
R166 VSS.n242 VSS.n0 8.49842
R167 VSS.n243 VSS.n18 14.4044
R168 VSS.n268 VSS.n0 17.0005
R169 VSS.n18 VSS.n0 0.650675
R170 VSS.n269 VSS.n0 17.0005
R171 VSS.n173 VSS.n0 8.49776
R172 VSS.n9 VSS.n0 0.650675
R173 VSS.n168 VSS.n9 14.4044
R174 VSS.n167 VSS.n0 8.49817
R175 VSS.n48 VSS.n0 4.24736
R176 VSS.n1 VSS.n0 4.09933
R177 VSS.n165 VSS.n0 17.0005
R178 VSS.n239 VSS.n0 8.49768
R179 VSS.n238 VSS.n33 14.4044
R180 VSS.n161 VSS.n0 17.0005
R181 VSS.n237 VSS.n0 8.49743
R182 VSS.n236 VSS.n35 7.20256
R183 VSS.n263 VSS.n0 17.0005
R184 VSS.n10 VSS.n0 0.650675
R185 VSS.n264 VSS.n0 17.0005
R186 VSS.n157 VSS.n10 7.20256
R187 VSS.n234 VSS.n30 7.20256
R188 VSS.n30 VSS.n0 0.650675
R189 VSS.n153 VSS.n0 17.0005
R190 VSS.n29 VSS.n0 0.650675
R191 VSS.n150 VSS.n29 7.20256
R192 VSS.n25 VSS.n0 0.650675
R193 VSS.n146 VSS.n25 14.4044
R194 VSS.n261 VSS.n0 17.0005
R195 VSS.n145 VSS.n0 8.49718
R196 VSS.n142 VSS.n0 17.0005
R197 VSS.n144 VSS.n0 8.49693
R198 VSS.n16 VSS.n0 0.650675
R199 VSS.n230 VSS.n16 14.4044
R200 VSS.n24 VSS.n0 0.650675
R201 VSS.n227 VSS.n24 14.4044
R202 VSS.n50 VSS.n45 0.00806492
R203 VSS.n226 VSS.n0 8.49669
R204 VSS.n45 VSS.n44 0.0128063
R205 VSS.n12 VSS.n0 0.650675
R206 VSS.n132 VSS.n12 14.4044
R207 VSS.n131 VSS.n0 8.50017
R208 VSS.n126 VSS.n13 14.4044
R209 VSS.n52 VSS.n42 0.0074543
R210 VSS.n221 VSS.n0 8.49644
R211 VSS.n42 VSS.n41 0.012502
R212 VSS.n22 VSS.n0 0.650675
R213 VSS.n220 VSS.n22 14.4044
R214 VSS.n219 VSS.n0 8.49619
R215 VSS.n218 VSS.n21 7.20256
R216 VSS.n21 VSS.n0 0.650675
R217 VSS.n19 VSS.n0 0.650675
R218 VSS.n216 VSS.n19 14.4044
R219 VSS.n215 VSS.n20 14.4044
R220 VSS.n115 VSS.n38 14.3619
R221 VSS.t74 VSS.n37 6.69134
R222 VSS.n253 VSS.n0 8.49996
R223 VSS.n250 VSS.n0 8.50042
R224 VSS.n247 VSS.n0 8.50025
R225 VSS.n244 VSS.n0 8.49674
R226 VSS.n241 VSS.n0 8.49926
R227 VSS.n172 VSS.n0 8.5
R228 VSS.n231 VSS.n0 8.49975
R229 VSS.n229 VSS.n0 8.50038
R230 VSS.n228 VSS.n0 8.50056
R231 VSS.n225 VSS.n0 8.50026
R232 VSS.n130 VSS.n0 8.50227
R233 VSS.n222 VSS.n0 8.50036
R234 VSS.n36 VSS.n0 1.20771
R235 VSS.n349 VSS.n210 17.0005
R236 VSS.n349 VSS.n4 2.4234
R237 VSS.n349 VSS.n192 17.0005
R238 VSS.n349 VSS.n164 17.0005
R239 VSS.n349 VSS.n160 17.0005
R240 VSS.n349 VSS.n152 17.0005
R241 VSS.n349 VSS.n147 17.0005
R242 VSS.n349 VSS.n141 17.0005
R243 VSS.n49 VSS.n135 0.0117843
R244 VSS.n349 VSS.n45 17.0005
R245 VSS.n51 VSS.n128 0.0125987
R246 VSS.n349 VSS.n42 17.0005
R247 VSS.n349 VSS.n118 17.0005
R248 VSS.n101 VSS.n328 17.0005
R249 VSS.n101 VSS.n317 17.0005
R250 VSS.n101 VSS.n316 17.0005
R251 VSS.n101 VSS.n305 17.0005
R252 VSS.n101 VSS.n304 17.0005
R253 VSS.n101 VSS.n303 17.0005
R254 VSS.n315 VSS.t69 17.0005
R255 VSS.t69 VSS.n313 17.0005
R256 VSS.t69 VSS.n314 17.0005
R257 VSS.n315 VSS.t68 17.0005
R258 VSS.n313 VSS.t68 17.0005
R259 VSS.n314 VSS.t68 17.0005
R260 VSS.t65 VSS.n326 17.0005
R261 VSS.t65 VSS.n325 17.0005
R262 VSS.n327 VSS.t65 17.0005
R263 VSS.n326 VSS.t64 17.0005
R264 VSS.n325 VSS.t64 17.0005
R265 VSS.n327 VSS.t64 17.0005
R266 VSS.t35 VSS.n130 16.6364
R267 VSS.n251 VSS.t57 16.6364
R268 VSS.t89 VSS.n102 15.1993
R269 VSS.n97 VSS.t115 15.1851
R270 VSS.t5 VSS.n75 22.7764
R271 VSS.t76 VSS.n345 15.0005
R272 VSS.n339 VSS.t70 15.0005
R273 VSS.t73 VSS.n278 15.0005
R274 VSS.n283 VSS.t79 15.0005
R275 VSS.n36 VSS.n116 13.3823
R276 VSS.n17 VSS.n350 14.8738
R277 VSS.n255 VSS.n14 14.4051
R278 VSS.n249 VSS.n31 14.4051
R279 VSS.n245 VSS.n26 14.4051
R280 VSS.n240 VSS.n33 14.4051
R281 VSS.n116 VSS.n38 13.3823
R282 VSS.t71 VSS.n20 7.20324
R283 VSS.n21 VSS.n217 14.4051
R284 VSS.n30 VSS.n233 14.4051
R285 VSS.n35 VSS.n235 14.4051
R286 VSS.n18 VSS.n174 14.4051
R287 VSS.n32 VSS.n246 14.4051
R288 VSS.n34 VSS.n201 14.4051
R289 VSS.n28 VSS.n205 7.20324
R290 VSS.n23 VSS.n208 14.4044
R291 VSS.n259 VSS.n37 13.3823
R292 VSS.n102 VSS.n101 0.00253296
R293 VSS.t19 VSS.n64 41.7518
R294 VSS.t10 VSS.n67 34.1616
R295 VSS.n353 VSS.n60 6777.49
R296 VSS.n65 VSS.t2 64.5222
R297 VSS.n56 VSS.t13 37.9567
R298 VSS.n72 VSS.t16 45.5468
R299 VSS.n68 VSS.t19 37.9567
R300 VSS.n58 VSS.t22 30.3676
R301 VSS.n74 VSS.t25 22.7764
R302 VSS.n62 VSS.t26 18.9824
R303 VSS.t86 VSS.n70 13.7582
R304 VSS.n222 VSS.t33 11.0911
R305 VSS.t59 VSS.n253 11.0911
R306 VSS.n60 VSS.n53 0.00105051
R307 VSS.n0 VSS.n351 1.69985
R308 VSS.n352 VSS.n0 1.70049
R309 VSS.n349 VSS.n259 8.5005
R310 VSS.n349 VSS.n248 8.5005
R311 VSS.n349 VSS.n236 8.5005
R312 VSS.n349 VSS.n234 8.5005
R313 VSS.n349 VSS.n218 8.5005
R314 VSS.n349 VSS.n205 8.5005
R315 VSS.n349 VSS.n198 8.5005
R316 VSS.n349 VSS.n157 8.5005
R317 VSS.n349 VSS.n150 8.5005
R318 VSS.n349 VSS.n116 8.5005
R319 VSS.n209 VSS.n0 8.4984
R320 VSS.n206 VSS.n0 8.4984
R321 VSS.n203 VSS.n0 8.4984
R322 VSS.n202 VSS.n7 0.0262321
R323 VSS.n200 VSS.n0 8.4984
R324 VSS.n4 VSS.n3 0.00653337
R325 VSS.n3 VSS.n5 0.0157515
R326 VSS.n5 VSS.n0 2.41741
R327 VSS.n191 VSS.n0 8.4984
R328 VSS.n184 VSS.n0 8.4984
R329 VSS.n181 VSS.n0 8.4984
R330 VSS.n179 VSS.n0 8.4984
R331 VSS.n175 VSS.n0 8.4984
R332 VSS.n169 VSS.n0 8.4984
R333 VSS.n166 VSS.n48 0.0180744
R334 VSS.n163 VSS.n0 8.4984
R335 VSS.n159 VSS.n0 8.4984
R336 VSS.n155 VSS.n0 8.4984
R337 VSS.n151 VSS.n0 8.4984
R338 VSS.n148 VSS.n0 8.4984
R339 VSS.n140 VSS.n0 8.4984
R340 VSS.n137 VSS.n0 8.4984
R341 VSS.n135 VSS.n0 8.4984
R342 VSS.n44 VSS.n0 4.24381
R343 VSS.n133 VSS.n0 8.4984
R344 VSS.n128 VSS.n0 8.4984
R345 VSS.n41 VSS.n0 4.24404
R346 VSS.n125 VSS.n0 8.4984
R347 VSS.n123 VSS.n0 8.4984
R348 VSS.n121 VSS.n0 8.4984
R349 VSS.n119 VSS.n0 8.4984
R350 VSS.n349 VSS.n212 8.4984
R351 VSS.n349 VSS.n207 8.4984
R352 VSS.n349 VSS.n204 8.4984
R353 VSS.n349 VSS.n202 8.4984
R354 VSS.n8 VSS.n6 0.0157515
R355 VSS.n349 VSS.n8 2.41741
R356 VSS.n349 VSS.n197 8.4984
R357 VSS.n349 VSS.n189 8.4984
R358 VSS.n349 VSS.n185 8.4984
R359 VSS.n349 VSS.n182 8.4984
R360 VSS.n349 VSS.n180 8.4984
R361 VSS.n349 VSS.n177 8.4984
R362 VSS.n349 VSS.n176 8.4984
R363 VSS.n349 VSS.n170 8.4984
R364 VSS.n349 VSS.n166 8.4984
R365 VSS.n47 VSS.t46 0.0145827
R366 VSS.n349 VSS.n47 4.24316
R367 VSS.n349 VSS.n162 8.4984
R368 VSS.n349 VSS.n158 8.4984
R369 VSS.n349 VSS.n156 8.4984
R370 VSS.n349 VSS.n154 8.4984
R371 VSS.n349 VSS.n149 8.4984
R372 VSS.n349 VSS.n143 8.4984
R373 VSS.n349 VSS.n138 8.4984
R374 VSS.n349 VSS.n136 8.4984
R375 VSS.n349 VSS.n49 5.66504
R376 VSS.n349 VSS.n43 8.4984
R377 VSS.n349 VSS.n129 8.4984
R378 VSS.n349 VSS.n51 5.66477
R379 VSS.n349 VSS.n40 8.4984
R380 VSS.n349 VSS.n124 8.4984
R381 VSS.n349 VSS.n122 8.4984
R382 VSS.n349 VSS.n120 8.4984
R383 VSS.n99 VSS.t67 6.87897
R384 VSS.n101 VSS.n103 0.00129054
R385 VSS.t2 VSS.n63 15.1863
R386 VSS.n346 VSS.t76 7.49606
R387 VSS.t70 VSS.n338 7.49606
R388 VSS.n279 VSS.t73 7.49606
R389 VSS.t79 VSS.n282 7.49606
R390 VSS.n193 VSS.n190 7.20236
R391 VSS.n186 VSS.n183 7.20236
R392 VSS.n172 VSS.n171 7.20236
R393 VSS.n2 VSS.n349 4.12362
R394 VSS.n144 VSS.n139 7.20236
R395 VSS.n228 VSS.n134 7.20236
R396 VSS.n130 VSS.n127 7.20236
R397 VSS.t74 VSS.n258 7.20236
R398 VSS.n252 VSS.n251 7.20236
R399 VSS.n238 VSS.n237 7.20236
R400 VSS.n232 VSS.n25 14.4051
R401 VSS.n230 VSS.n229 7.20236
R402 VSS.n227 VSS.n226 7.20236
R403 VSS.n224 VSS.n12 14.4051
R404 VSS.n223 VSS.n22 14.4051
R405 VSS.n220 VSS.n219 7.20236
R406 VSS.n215 VSS.n36 13.8932
R407 VSS.n216 VSS.t71 7.20236
R408 VSS.n217 VSS.n19 14.4051
R409 VSS.n223 VSS.n222 7.20236
R410 VSS.n221 VSS.n126 7.20236
R411 VSS.n127 VSS.n13 14.4051
R412 VSS.n132 VSS.n131 7.20236
R413 VSS.n225 VSS.n224 7.20236
R414 VSS.n24 VSS.n134 14.4051
R415 VSS.n16 VSS.n139 14.4051
R416 VSS.n146 VSS.n145 7.20236
R417 VSS.n232 VSS.n231 7.20236
R418 VSS.n233 VSS.n29 14.4051
R419 VSS.n235 VSS.n10 14.4051
R420 VSS.n240 VSS.n239 7.20236
R421 VSS.n1 VSS.n349 4.12324
R422 VSS.n2 VSS.n0 4.09853
R423 VSS.n168 VSS.n167 7.20236
R424 VSS.n171 VSS.n9 14.4051
R425 VSS.n174 VSS.n173 7.20236
R426 VSS.n243 VSS.n242 7.20236
R427 VSS.n241 VSS.n178 7.20236
R428 VSS.n183 VSS.n27 14.4051
R429 VSS.n188 VSS.n187 7.20236
R430 VSS.n190 VSS.n11 14.4051
R431 VSS.n195 VSS.n194 7.20236
R432 VSS.n245 VSS.n244 7.20236
R433 VSS.n246 VSS.n15 14.4051
R434 VSS.n247 VSS.n199 7.20236
R435 VSS.n250 VSS.n249 7.20236
R436 VSS.n255 VSS.n254 7.20236
R437 VSS.n253 VSS.n201 7.20236
R438 VSS.n257 VSS.n256 7.20236
R439 VSS.n258 VSS.n23 14.4051
R440 VSS.n39 VSS.n213 13.8932
R441 VSS.t31 VSS.n218 5.54579
R442 VSS.t60 VSS.n205 5.54579
R443 VSS.n347 VSS.t77 4.5005
R444 VSS.t32 VSS.n337 4.5005
R445 VSS.t81 VSS.n275 4.5005
R446 VSS.t61 VSS.n277 4.5005
R447 VSS.n349 VSS.n117 4.25247
R448 VSS.n214 VSS.n0 4.25206
R449 VSS.n349 VSS.n214 4.25175
R450 VSS.n117 VSS.n0 4.25172
R451 VSS.t0 VSS.n73 11.3996
R452 VSS.n387 VSS.n109 3.77525
R453 VSS.n388 VSS.n387 3.77525
R454 VSS.n331 VSS.n330 3.77525
R455 VSS.n330 VSS.n291 3.77525
R456 VSS.n363 VSS.t85 3.0005
R457 VSS.n383 VSS.t82 3.0005
R458 VSS.n312 VSS.t66 3.0005
R459 VSS.n324 VSS.t62 3.0005
R460 VSS.n344 VSS.n343 3.0005
R461 VSS.n341 VSS.n340 3.0005
R462 VSS.n285 VSS.n284 3.0005
R463 VSS.n276 VSS.n274 3.0005
R464 VSS.t17 VSS.n72 37.957
R465 VSS.n54 VSS.n53 0.00104911
R466 VSS.n70 VSS.n53 0.00289146
R467 VSS.n53 VSS.n62 0.0108886
R468 VSS.n53 VSS.n74 0.0108886
R469 VSS.n53 VSS.n55 0.0109013
R470 VSS.n53 VSS.n64 0.0109013
R471 VSS.n53 VSS.n71 0.0093246
R472 VSS.n53 VSS.n56 0.0108886
R473 VSS.n53 VSS.n67 0.0109013
R474 VSS.n53 VSS.n65 0.0108886
R475 VSS.n53 VSS.n73 0.00289146
R476 VSS.t83 VSS.n60 13.7601
R477 VSS.n311 VSS.t114 2.48177
R478 VSS.n309 VSS.t111 2.48177
R479 VSS.n308 VSS.t108 2.48177
R480 VSS.t105 VSS.n292 2.48177
R481 VSS.t99 VSS.n293 2.48177
R482 VSS.n321 VSS.t96 2.48177
R483 VSS.n322 VSS.t93 2.48177
R484 VSS.n323 VSS.t90 2.48177
R485 VSS.n336 VSS.t118 2.48177
R486 VSS.n335 VSS.t120 2.48177
R487 VSS.n334 VSS.t122 2.48177
R488 VSS.n333 VSS.t124 2.48177
R489 VSS.n266 VSS.t128 2.48177
R490 VSS.n289 VSS.t130 2.48177
R491 VSS.n288 VSS.t132 2.48177
R492 VSS.n287 VSS.t134 2.48177
R493 VSS.n384 VSS.t3 2.48177
R494 VSS.n385 VSS.t6 2.48177
R495 VSS.n386 VSS.t9 2.48177
R496 VSS.n113 VSS.t12 2.48177
R497 VSS.t18 VSS.n112 2.48177
R498 VSS.n360 VSS.t21 2.48177
R499 VSS.n361 VSS.t24 2.48177
R500 VSS.n362 VSS.t27 2.48177
R501 VSS.n336 VSS.t34 2.48177
R502 VSS.n335 VSS.t37 2.48177
R503 VSS.n334 VSS.t40 2.48177
R504 VSS.n333 VSS.t43 2.48177
R505 VSS.n266 VSS.t49 2.48177
R506 VSS.n289 VSS.t52 2.48177
R507 VSS.n288 VSS.t55 2.48177
R508 VSS.n287 VSS.t58 2.48177
R509 VSS.n291 VSS.n290 2.4377
R510 VSS.n37 VSS.n0 1.20771
R511 VSS.n17 VSS.n0 0.650675
R512 VSS.n259 VSS.n39 13.3823
R513 VSS.n14 VSS.n0 0.650675
R514 VSS.n31 VSS.n0 0.650675
R515 VSS.n26 VSS.n0 0.650675
R516 VSS.n33 VSS.n0 0.650675
R517 VSS.n35 VSS.n0 0.650675
R518 VSS.n13 VSS.n0 0.650675
R519 VSS.n20 VSS.n0 0.650675
R520 VSS.n38 VSS.n0 1.20771
R521 VSS.t78 VSS.n347 2.2505
R522 VSS.n337 VSS.t72 2.2505
R523 VSS.n275 VSS.t80 2.2505
R524 VSS.n277 VSS.t75 2.2505
R525 VSS.n368 VSS.n53 2.09947
R526 VSS.n370 VSS.n53 2.09947
R527 VSS.n372 VSS.n53 2.09947
R528 VSS.n110 VSS.n53 2.09947
R529 VSS.n374 VSS.n53 2.09947
R530 VSS.n376 VSS.n53 2.09947
R531 VSS.n378 VSS.n53 2.09947
R532 VSS.n380 VSS.n53 2.09947
R533 VSS.n101 VSS.n298 2.09901
R534 VSS.n101 VSS.n301 2.09885
R535 VSS.n101 VSS.n302 2.0988
R536 VSS.n101 VSS.n296 2.09874
R537 VSS.n101 VSS.n297 2.09868
R538 VSS.n329 VSS.n101 2.09868
R539 VSS.n101 VSS.n300 2.09862
R540 VSS.n101 VSS.n106 2.09849
R541 VSS.n267 VSS.n332 1.88787
R542 VSS.n267 VSS.n108 1.88787
R543 VSS.n352 VSS.n115 1.53502
R544 VSS.n351 VSS.n350 1.53502
R545 VSS.n383 VSS.n114 1.52811
R546 VSS.n313 VSS.n312 1.52811
R547 VSS.n325 VSS.n324 1.52811
R548 VSS.n364 VSS.n363 1.52811
R549 VSS.n326 VSS.n100 1.42159
R550 VSS.n100 VSS.n315 1.37894
R551 VSS.n388 VSS.n108 1.1929
R552 VSS.n291 VSS.n108 1.1929
R553 VSS.n332 VSS.n109 1.1929
R554 VSS.n332 VSS.n331 1.1929
R555 VSS.n348 VSS.t78 1.12521
R556 VSS.n348 VSS.t80 1.03559
R557 VSS.n366 VSS.n53 0.96569
R558 VSS.n382 VSS.n53 0.91152
R559 VSS.n101 VSS.n80 0.910334
R560 VSS.n101 VSS.n98 0.909345
R561 VSS.n349 VSS.n258 0.650322
R562 VSS.n349 VSS.n257 0.650322
R563 VSS.n349 VSS.n255 0.650322
R564 VSS.n349 VSS.n252 0.650322
R565 VSS.n349 VSS.n249 0.650322
R566 VSS.n349 VSS.n246 0.650322
R567 VSS.n349 VSS.n245 0.650322
R568 VSS.n349 VSS.n243 0.650322
R569 VSS.n349 VSS.n240 0.650322
R570 VSS.n349 VSS.n238 0.650322
R571 VSS.n349 VSS.n235 0.650322
R572 VSS.n349 VSS.n233 0.650322
R573 VSS.n349 VSS.n232 0.650322
R574 VSS.n349 VSS.n230 0.650322
R575 VSS.n349 VSS.n227 0.650322
R576 VSS.n349 VSS.n224 0.650322
R577 VSS.n349 VSS.n223 0.650322
R578 VSS.n349 VSS.n220 0.650322
R579 VSS.n349 VSS.n217 0.650322
R580 VSS.n349 VSS.n216 0.650322
R581 VSS.n349 VSS.n215 0.650322
R582 VSS.n349 VSS.n213 0.650322
R583 VSS.n349 VSS.n208 0.650322
R584 VSS.n349 VSS.n201 0.650322
R585 VSS.n349 VSS.n199 0.650322
R586 VSS.n349 VSS.n195 0.650322
R587 VSS.n349 VSS.n190 0.650322
R588 VSS.n349 VSS.n188 0.650322
R589 VSS.n349 VSS.n183 0.650322
R590 VSS.n349 VSS.n178 0.650322
R591 VSS.n349 VSS.n174 0.650322
R592 VSS.n349 VSS.n171 0.650322
R593 VSS.n349 VSS.n168 0.650322
R594 VSS.n349 VSS.n146 0.650322
R595 VSS.n349 VSS.n139 0.650322
R596 VSS.n349 VSS.n134 0.650322
R597 VSS.n349 VSS.n132 0.650322
R598 VSS.n349 VSS.n127 0.650322
R599 VSS.n349 VSS.n126 0.650322
R600 VSS VSS.n388 0.3585
R601 VSS.n109 VSS 0.3585
R602 VSS.n331 VSS.n290 0.3585
R603 VSS.n384 VSS.n383 0.209825
R604 VSS.n312 VSS.n311 0.209825
R605 VSS.n324 VSS.n323 0.209825
R606 VSS.n363 VSS.n362 0.209825
R607 VSS.n381 VSS.t3 0.200997
R608 VSS.n379 VSS.t6 0.200997
R609 VSS.n377 VSS.t9 0.200997
R610 VSS.n375 VSS.t12 0.200997
R611 VSS.n373 VSS.t18 0.200997
R612 VSS.n371 VSS.t21 0.200997
R613 VSS.n369 VSS.t24 0.200997
R614 VSS.n367 VSS.t27 0.200997
R615 VSS.n52 VSS.t34 0.200997
R616 VSS.n50 VSS.t37 0.200997
R617 VSS.n262 VSS.t40 0.200997
R618 VSS.n265 VSS.t43 0.200997
R619 VSS.n270 VSS.t49 0.200997
R620 VSS.n273 VSS.t52 0.200997
R621 VSS.n3 VSS.t55 0.200997
R622 VSS.n6 VSS.t58 0.200997
R623 VSS.t114 VSS.n310 0.200995
R624 VSS.t111 VSS.n306 0.200995
R625 VSS.t108 VSS.n307 0.200995
R626 VSS.n299 VSS.t105 0.200995
R627 VSS.n295 VSS.t99 0.200995
R628 VSS.t96 VSS.n320 0.200995
R629 VSS.t93 VSS.n319 0.200995
R630 VSS.t90 VSS.n318 0.200995
R631 VSS.t118 VSS.n52 0.200995
R632 VSS.t120 VSS.n50 0.200995
R633 VSS.t122 VSS.n262 0.200995
R634 VSS.t124 VSS.n265 0.200995
R635 VSS.t128 VSS.n270 0.200995
R636 VSS.t130 VSS.n273 0.200995
R637 VSS.t132 VSS.n3 0.200995
R638 VSS.t134 VSS.n6 0.200995
R639 VSS.n77 VSS.n355 1.42723
R640 VSS.t46 VSS.t126 0.185126
R641 VSS.n385 VSS.n384 0.16242
R642 VSS.n386 VSS.n385 0.16242
R643 VSS.n113 VSS.n386 0.16242
R644 VSS.n111 VSS.n113 0.16242
R645 VSS.n111 VSS.n112 0.16242
R646 VSS.n360 VSS.n112 0.16242
R647 VSS.n361 VSS.n360 0.16242
R648 VSS.n362 VSS.n361 0.16242
R649 VSS.n323 VSS.n322 0.16242
R650 VSS.n322 VSS.n321 0.16242
R651 VSS.n321 VSS.n293 0.16242
R652 VSS.n294 VSS.n293 0.16242
R653 VSS.n294 VSS.n292 0.16242
R654 VSS.n308 VSS.n292 0.16242
R655 VSS.n309 VSS.n308 0.16242
R656 VSS.n311 VSS.n309 0.16242
R657 VSS.n310 VSS.n98 0.146868
R658 VSS.n318 VSS.n80 0.145358
R659 VSS.n382 VSS.n381 0.144129
R660 VSS.n367 VSS.n366 0.143085
R661 VSS.n350 VSS.n349 0.139317
R662 VSS.n349 VSS.n115 0.139317
R663 VSS.n342 VSS.n336 0.117247
R664 VSS.n287 VSS.n286 0.1171
R665 VSS.n381 VSS.n380 0.0952183
R666 VSS.n318 VSS.n296 0.0943283
R667 VSS.n310 VSS.n302 0.0933751
R668 VSS.n379 VSS.n378 0.0927738
R669 VSS.n368 VSS.n367 0.0925656
R670 VSS.n319 VSS.n297 0.0918194
R671 VSS.n306 VSS.n301 0.0909912
R672 VSS.n377 VSS.n376 0.0903294
R673 VSS.t15 VSS.n110 0.0903294
R674 VSS.n370 VSS.n369 0.0901212
R675 VSS.n320 VSS.n298 0.0897551
R676 VSS.t102 VSS.n106 0.0890531
R677 VSS.n307 VSS.n300 0.0888618
R678 VSS.t102 VSS.n329 0.0886118
R679 VSS.n375 VSS.n374 0.0878849
R680 VSS.n373 VSS.n372 0.0878849
R681 VSS.n374 VSS.t15 0.0876767
R682 VSS.n372 VSS.n371 0.0876767
R683 VSS.n329 VSS.n295 0.0869305
R684 VSS.n300 VSS.n299 0.0866755
R685 VSS.n299 VSS.n106 0.0864836
R686 VSS.n298 VSS.n295 0.0857922
R687 VSS.n371 VSS.n370 0.0854405
R688 VSS.n376 VSS.n375 0.0852323
R689 VSS.n110 VSS.n373 0.0852323
R690 VSS.n366 VSS.t85 0.0849321
R691 VSS.t82 VSS.n382 0.0847768
R692 VSS.n307 VSS.n301 0.084548
R693 VSS.n320 VSS.n297 0.083723
R694 VSS.t62 VSS.n80 0.0834709
R695 VSS.n369 VSS.n368 0.082996
R696 VSS.t66 VSS.n98 0.0828674
R697 VSS.n378 VSS.n377 0.0827878
R698 VSS.n306 VSS.n302 0.0821685
R699 VSS.n336 VSS.n335 0.08146
R700 VSS.n335 VSS.n334 0.08146
R701 VSS.n334 VSS.n333 0.08146
R702 VSS.n333 VSS.n46 0.08146
R703 VSS.n46 VSS.n266 0.08146
R704 VSS.n266 VSS.n289 0.08146
R705 VSS.n289 VSS.n288 0.08146
R706 VSS.n288 VSS.n287 0.08146
R707 VSS.n319 VSS.n296 0.081216
R708 VSS.n380 VSS.n379 0.0803434
R709 VSS.n0 VSS.t75 1.03812
R710 VSS.t72 VSS.n0 1.05427
R711 VSS.n290 VSS 0.0445
R712 VSS.t15 VSS.n111 0.0394177
R713 VSS.n294 VSS.t102 0.0394177
R714 VSS.n387 VSS.n111 0.0389615
R715 VSS.n330 VSS.n294 0.0389615
R716 VSS.t77 VSS.n346 0.031258
R717 VSS.n338 VSS.t32 0.031258
R718 VSS.n342 VSS.n341 0.0291125
R719 VSS.n286 VSS.n285 0.0291125
R720 VSS.n286 VSS.n274 0.0291125
R721 VSS.n343 VSS.n342 0.0291125
R722 VSS.n341 VSS.n337 0.0281144
R723 VSS.n285 VSS.n275 0.0281144
R724 VSS.n277 VSS.n274 0.0281144
R725 VSS.n347 VSS.n343 0.0281144
R726 VSS.n281 VSS.n279 0.0216549
R727 VSS.n282 VSS.n281 0.0216549
R728 VSS.n278 VSS.t61 0.0208704
R729 VSS.n283 VSS.t81 0.0208704
R730 VSS.n345 VSS.n344 0.0202884
R731 VSS.n340 VSS.n339 0.0202884
R732 VSS.n278 VSS.n276 0.0202884
R733 VSS.n284 VSS.n283 0.0202884
R734 VSS.n46 VSS.n267 0.0197308
R735 VSS.t46 VSS.n46 0.0194533
R736 VSS.n281 VSS.n214 0.0162424
R737 VSS.n260 VSS.n117 0.0158083
R738 VSS.t82 VSS.n104 0.0133922
R739 VSS.t66 VSS.n303 0.0133922
R740 VSS.n328 VSS.t62 0.0133922
R741 VSS.n209 VSS.n207 0.0118857
R742 VSS.n206 VSS.n204 0.0118857
R743 VSS.n203 VSS.n202 0.0118857
R744 VSS.n191 VSS.n189 0.0118857
R745 VSS.n184 VSS.n182 0.0118857
R746 VSS.n180 VSS.n179 0.0118857
R747 VSS.n179 VSS.n177 0.0118857
R748 VSS.n176 VSS.n175 0.0118857
R749 VSS.n175 VSS.n170 0.0118857
R750 VSS.n169 VSS.n166 0.0118857
R751 VSS.n48 VSS.t46 0.00668938
R752 VSS.n163 VSS.n162 0.0118857
R753 VSS.n159 VSS.n158 0.0118857
R754 VSS.n155 VSS.n154 0.0118857
R755 VSS.n151 VSS.n149 0.0118857
R756 VSS.n140 VSS.n138 0.0118857
R757 VSS.n137 VSS.n136 0.0118857
R758 VSS.n44 VSS.n43 0.0241933
R759 VSS.n133 VSS.n129 0.0118857
R760 VSS.n41 VSS.n40 0.0238886
R761 VSS.n125 VSS.n124 0.0118857
R762 VSS.n123 VSS.n122 0.0118857
R763 VSS.n121 VSS.n120 0.0118857
R764 VSS.n120 VSS.n119 0.0118857
R765 VSS.n122 VSS.n121 0.0118857
R766 VSS.n124 VSS.n123 0.0118857
R767 VSS.n40 VSS.n125 0.0118857
R768 VSS.n129 VSS.n128 0.0118857
R769 VSS.n43 VSS.n133 0.0118857
R770 VSS.n136 VSS.n135 0.0118857
R771 VSS.n138 VSS.n137 0.0118857
R772 VSS.n149 VSS.n148 0.0118857
R773 VSS.n156 VSS.n155 0.0118857
R774 VSS.n170 VSS.n169 0.0118857
R775 VSS.n181 VSS.n180 0.0118857
R776 VSS.n182 VSS.n181 0.0118857
R777 VSS.n185 VSS.n184 0.0118857
R778 VSS.n5 VSS.n197 0.0492861
R779 VSS.n200 VSS.n4 0.0262321
R780 VSS.n8 VSS.n200 0.0492861
R781 VSS.n7 VSS.n6 0.00653337
R782 VSS.n204 VSS.n203 0.0118857
R783 VSS.n207 VSS.n206 0.0118857
R784 VSS.n345 VSS.n260 0.0115582
R785 VSS.n339 VSS.n260 0.0115582
R786 VSS.n101 VSS.n79 0.0112168
R787 VSS.n101 VSS.n81 0.0112168
R788 VSS.n101 VSS.n82 0.0112168
R789 VSS.n101 VSS.n83 0.0112168
R790 VSS.n101 VSS.n84 0.0112168
R791 VSS.n101 VSS.n85 0.0112168
R792 VSS.n101 VSS.n86 0.0112168
R793 VSS.n101 VSS.n87 0.0112168
R794 VSS.n101 VSS.n89 0.0112168
R795 VSS.n101 VSS.n90 0.0112168
R796 VSS.n101 VSS.n91 0.0112168
R797 VSS.n101 VSS.n92 0.0112168
R798 VSS.n101 VSS.n93 0.0112168
R799 VSS.n101 VSS.n94 0.0112168
R800 VSS.n101 VSS.n95 0.0112168
R801 VSS.n101 VSS.n96 0.0112168
R802 VSS.n101 VSS.n97 0.0112168
R803 VSS.n142 VSS.n141 0.0108889
R804 VSS.n153 VSS.n152 0.0108889
R805 VSS.n161 VSS.n160 0.0108889
R806 VSS.n165 VSS.n164 0.0108889
R807 VSS.n196 VSS.n192 0.0108889
R808 VSS.n211 VSS.n210 0.0108889
R809 VSS.n346 VSS.n344 0.0108877
R810 VSS.n340 VSS.n338 0.0108877
R811 VSS.n279 VSS.n276 0.0108877
R812 VSS.n284 VSS.n282 0.0108877
R813 VSS.n281 VSS.t75 0.0101032
R814 VSS.n281 VSS.t80 0.0101032
R815 VSS.t78 VSS.n260 0.00981217
R816 VSS.t72 VSS.n260 0.00981217
R817 VSS.n101 VSS.n88 0.00963963
R818 VSS.n52 VSS.n51 0.00395219
R819 VSS.n50 VSS.n49 0.00354511
R820 VSS.n364 VSS.n359 0.00798582
R821 VSS.n364 VSS.n107 0.00798582
R822 VSS.n357 VSS.n114 0.00798582
R823 VSS.n354 VSS.n114 0.00798582
R824 VSS.n313 VSS.n305 0.00798582
R825 VSS.n313 VSS.n304 0.00798582
R826 VSS.n325 VSS.n316 0.00798582
R827 VSS.n325 VSS.n317 0.00798582
R828 VSS.n358 VSS.n78 0.0151369
R829 VSS.n359 VSS.n358 0.00756994
R830 VSS.n365 VSS.n107 0.00756994
R831 VSS.n356 VSS.n104 0.00756994
R832 VSS.n357 VSS.n356 0.00756994
R833 VSS.n355 VSS.n354 0.00756994
R834 VSS.n315 VSS.n305 0.00756994
R835 VSS.n314 VSS.n304 0.00756994
R836 VSS.n314 VSS.n303 0.00756994
R837 VSS.n326 VSS.n316 0.00756994
R838 VSS.n327 VSS.n317 0.00756994
R839 VSS.n328 VSS.n327 0.00756994
R840 VSS.n262 VSS.n147 0.00691667
R841 VSS.n273 VSS.n272 0.00691667
R842 VSS.n260 VSS.n118 0.00630556
R843 VSS.n148 VSS.n147 0.00619286
R844 VSS.n119 VSS.n118 0.00619286
R845 VSS.n280 VSS.n212 0.00619286
R846 VSS.n197 VSS.n196 0.00619286
R847 VSS.n272 VSS.n185 0.00619286
R848 VSS.n264 VSS.n156 0.00619286
R849 VSS.n261 VSS.n143 0.00619286
R850 VSS.n141 VSS.n140 0.00619286
R851 VSS.n143 VSS.n142 0.00619286
R852 VSS.n152 VSS.n151 0.00619286
R853 VSS.n154 VSS.n153 0.00619286
R854 VSS.n263 VSS.n158 0.00619286
R855 VSS.n160 VSS.n159 0.00619286
R856 VSS.n162 VSS.n161 0.00619286
R857 VSS.n164 VSS.n163 0.00619286
R858 VSS.n47 VSS.n165 0.0202756
R859 VSS.n269 VSS.n176 0.00619286
R860 VSS.n268 VSS.n177 0.00619286
R861 VSS.n271 VSS.n189 0.00619286
R862 VSS.n192 VSS.n191 0.00619286
R863 VSS.n210 VSS.n209 0.00619286
R864 VSS.n212 VSS.n211 0.00619286
R865 VSS.n281 VSS.n280 0.00615278
R866 VSS.n265 VSS.n264 0.00569444
R867 VSS.n265 VSS.n263 0.00569444
R868 VSS.n270 VSS.n269 0.00569444
R869 VSS.n270 VSS.n268 0.00569444
R870 VSS.n101 VSS.n99 0.00482001
R871 VSS.n349 VSS.n348 0.00467494
R872 VSS.n262 VSS.n261 0.00447222
R873 VSS.n273 VSS.n271 0.00447222
R874 VSS.n101 VSS.n100 0.00378454
R875 VSS.n103 VSS.n353 6777.49
R876 VSS.n77 VSS.n365 1.3783
R877 VSS.n34 VSS.n0 1.20228
C0 VDD vin3 26.9696f
C1 vin2 vout2 16.0649f
C2 VDD vin2 26.9696f
C3 vin3 vout3 16.0649f
C4 VDD vin1 27.0009f
C5 vin3 vin4 0.11002f
C6 VDD vout4 11.7328f
C7 VDD vout2 11.7272f
C8 vin1 vout1 16.0649f
C9 vin3 vin2 0.12731f
C10 vout4 vin4 16.0649f
C11 VDD vout3 11.7272f
C12 vin2 vin1 0.11002f
C13 VDD vout1 11.7328f
C14 VDD vin4 27.0009f
C15 vout1 VSS 11.99485f
C16 vout2 VSS 11.97725f
C17 vout3 VSS 11.97725f
C18 vout4 VSS 11.99485f
C19 VSS.t58 VSS 7.1315f
C20 VSS.t24 VSS 7.1491f
.ends
