* PEX produced on Sat Nov  7 03:28:51 PM CET 2026 using /foss/tools/sak/sak-pex.sh with m=3 and s=1 (extresist threshold=10000 mOhm, minres=1000 mOhm, mindelay=1 ps)
* NGSPICE file created from inverter_top_pex.ext - technology: ihp-sg13cmos5l

.subckt inverter_top_pex VDD vin4 vout4 VSS vin3 vout3 vin2 vout2 vout1 vin1
X0 vout4 vin4 VDD VDD sg13_lv_pmos ad=1.14p pd=6.38u as=1.14p ps=6.38u w=6u l=1u
X1 VDD vin2 vout2 VDD sg13_lv_pmos ad=1.14p pd=6.38u as=1.14p ps=6.38u w=6u l=1u
X2 VSS.t99 vin2 vout2 VSS.t48 sg13_lv_nmos ad=0.19p pd=1.38u as=0.19p ps=1.38u w=1u l=1u
X3 vout2 vin2 VSS.t101 VSS.t53 sg13_lv_nmos ad=0.19p pd=1.38u as=0.19p ps=1.38u w=1u l=1u
X4 vout2 vin2 VDD VDD sg13_lv_pmos ad=1.14p pd=6.38u as=1.14p ps=6.38u w=6u l=1u
X5 VSS.t116 vin4 vout4 VSS.t115 sg13_lv_nmos ad=0.19p pd=1.38u as=0.19p ps=1.38u w=1u l=1u
X6 vout1 vin1 VSS.t24 VSS.t25 sg13_lv_nmos ad=0.19p pd=1.38u as=0.19p ps=1.38u w=1u l=1u
X7 VDD vin2 vout2 VDD sg13_lv_pmos ad=1.14p pd=6.38u as=1.14p ps=6.38u w=6u l=1u
X8 vout4 vin4 VSS.t64 VSS.t108 sg13_lv_nmos ad=0.19p pd=1.38u as=0.19p ps=1.38u w=1u l=1u
X9 VDD vin2 vout2 VDD sg13_lv_pmos ad=1.14p pd=6.38u as=1.14p ps=6.38u w=6u l=1u
X10 VSS.t58 vin3 vout3 VSS.t57 sg13_lv_nmos ad=0.19p pd=1.38u as=0.19p ps=1.38u w=1u l=1u
X11 vout4 vin4 VSS.t125 VSS.t126 sg13_lv_nmos ad=0.19p pd=1.38u as=0.19p ps=1.38u w=1u l=1u
X12 VDD vin3 vout3 VDD sg13_lv_pmos ad=1.14p pd=6.38u as=1.14p ps=6.38u w=6u l=1u
X13 VSS.t119 vin4 vout4 VSS.t118 sg13_lv_nmos ad=0.19p pd=1.38u as=0.19p ps=1.38u w=1u l=1u
X14 VDD vin2 vout2 VDD sg13_lv_pmos ad=1.14p pd=6.38u as=1.14p ps=6.38u w=6u l=1u
X15 vout3 vin3 VDD VDD sg13_lv_pmos ad=1.14p pd=6.38u as=1.14p ps=6.38u w=6u l=1u
X16 vout2 vin2 VDD VDD sg13_lv_pmos ad=1.14p pd=6.38u as=1.14p ps=6.38u w=6u l=1u
X17 VSS.t95 vin2 vout2 VSS.t42 sg13_lv_nmos ad=0.19p pd=1.38u as=0.19p ps=1.38u w=1u l=1u
X18 VDD vin3 vout3 VDD sg13_lv_pmos ad=1.14p pd=6.38u as=1.14p ps=6.38u w=6u l=1u
X19 VSS.t72 VSS.t70 VSS.t32 VSS.t71 sg13_lv_nmos ad=0.34p pd=2.68u as=0 ps=0 w=1u l=1u
X20 vout2 vin2 VSS.t97 VSS.t47 sg13_lv_nmos ad=0.19p pd=1.38u as=0.19p ps=1.38u w=1u l=1u
X21 vout1 vin1 VSS.t18 VSS.t19 sg13_lv_nmos ad=0.19p pd=1.38u as=0.19p ps=1.38u w=1u l=1u
X22 VSS.t101 vin2 vout2 VSS.t51 sg13_lv_nmos ad=0.19p pd=1.38u as=0.19p ps=1.38u w=1u l=1u
X23 vout4 vin4 VSS.t122 VSS.t123 sg13_lv_nmos ad=0.19p pd=1.38u as=0.19p ps=1.38u w=1u l=1u
X24 vout1 vin1 VDD VDD sg13_lv_pmos ad=1.14p pd=6.38u as=1.14p ps=6.38u w=6u l=1u
X25 vout1 vin1 VSS.t12 VSS.t13 sg13_lv_nmos ad=0.19p pd=1.38u as=0.19p ps=1.38u w=1u l=1u
X26 VSS.t128 vin4 vout4 VSS.t127 sg13_lv_nmos ad=0.19p pd=1.38u as=0.19p ps=1.38u w=1u l=1u
X27 VDD VDD VDD VDD sg13_lv_pmos ad=1.14p pd=6.38u as=0.56797n ps=1.006m w=6u l=1u
X28 VSS.t18 vin1 vout1 VSS.t17 sg13_lv_nmos ad=0.19p pd=1.38u as=0.19p ps=1.38u w=1u l=1u
X29 vout2 vin2 VDD VDD sg13_lv_pmos ad=1.14p pd=6.38u as=1.14p ps=6.38u w=6u l=1u
X30 VDD vin4 vout4 VDD sg13_lv_pmos ad=1.14p pd=6.38u as=1.14p ps=6.38u w=6u l=1u
X31 vout1 vin1 VSS.t21 VSS.t22 sg13_lv_nmos ad=0.19p pd=1.38u as=0.19p ps=1.38u w=1u l=1u
X32 vout3 vin3 VSS.t55 VSS.t56 sg13_lv_nmos ad=0.19p pd=1.38u as=0.19p ps=1.38u w=1u l=1u
X33 vout4 vin4 VDD VDD sg13_lv_pmos ad=1.14p pd=6.38u as=1.14p ps=6.38u w=6u l=1u
X34 VDD vin3 vout3 VDD sg13_lv_pmos ad=1.14p pd=6.38u as=1.14p ps=6.38u w=6u l=1u
X35 VDD vin4 vout4 VDD sg13_lv_pmos ad=1.14p pd=6.38u as=1.14p ps=6.38u w=6u l=1u
X36 vout3 vin3 VDD VDD sg13_lv_pmos ad=1.14p pd=6.38u as=1.14p ps=6.38u w=6u l=1u
X37 VDD vin3 vout3 VDD sg13_lv_pmos ad=1.14p pd=6.38u as=1.14p ps=6.38u w=6u l=1u
X38 VSS.t69 VSS.t66 VSS.t68 VSS.t67 sg13_lv_nmos ad=0.19p pd=1.38u as=0 ps=0 w=1u l=1u
X39 VDD vin4 vout4 VDD sg13_lv_pmos ad=1.14p pd=6.38u as=1.14p ps=6.38u w=6u l=1u
X40 VDD vin2 vout2 VDD sg13_lv_pmos ad=1.14p pd=6.38u as=1.14p ps=6.38u w=6u l=1u
X41 VSS.t131 vin4 vout4 VSS.t130 sg13_lv_nmos ad=0.19p pd=1.38u as=0.19p ps=1.38u w=1u l=1u
X42 VDD vin3 vout3 VDD sg13_lv_pmos ad=1.14p pd=6.38u as=1.14p ps=6.38u w=6u l=1u
X43 VSS.t12 vin1 vout1 VSS.t11 sg13_lv_nmos ad=0.19p pd=1.38u as=0.19p ps=1.38u w=1u l=1u
X44 VDD vin1 vout1 VDD sg13_lv_pmos ad=1.14p pd=6.38u as=1.14p ps=6.38u w=6u l=1u
X45 vout4 vin4 VSS.t134 VSS.t135 sg13_lv_nmos ad=0.19p pd=1.38u as=0.19p ps=1.38u w=1u l=1u
X46 vout4 vin4 VDD VDD sg13_lv_pmos ad=1.14p pd=6.38u as=1.14p ps=6.38u w=6u l=1u
X47 vout1 vin1 VSS.t15 VSS.t16 sg13_lv_nmos ad=0.19p pd=1.38u as=0.19p ps=1.38u w=1u l=1u
X48 vout1 vin1 VDD VDD sg13_lv_pmos ad=1.14p pd=6.38u as=1.14p ps=6.38u w=6u l=1u
X49 VDD vin1 vout1 VDD sg13_lv_pmos ad=1.14p pd=6.38u as=1.14p ps=6.38u w=6u l=1u
X50 vout3 vin3 VSS.t49 VSS.t50 sg13_lv_nmos ad=0.19p pd=1.38u as=0.19p ps=1.38u w=1u l=1u
X51 VSS.t21 vin1 vout1 VSS.t20 sg13_lv_nmos ad=0.19p pd=1.38u as=0.19p ps=1.38u w=1u l=1u
X52 VDD VDD VDD VDD sg13_lv_pmos ad=2.04p pd=12.68u as=0 ps=0 w=6u l=1u
X53 vout4 vin4 VDD VDD sg13_lv_pmos ad=1.14p pd=6.38u as=1.14p ps=6.38u w=6u l=1u
X54 VDD vin3 vout3 VDD sg13_lv_pmos ad=1.14p pd=6.38u as=1.14p ps=6.38u w=6u l=1u
X55 VDD vin4 vout4 VDD sg13_lv_pmos ad=1.14p pd=6.38u as=1.14p ps=6.38u w=6u l=1u
X56 vout3 vin3 VSS.t43 VSS.t44 sg13_lv_nmos ad=0.19p pd=1.38u as=0.19p ps=1.38u w=1u l=1u
X57 vout3 vin3 VDD VDD sg13_lv_pmos ad=1.14p pd=6.38u as=1.14p ps=6.38u w=6u l=1u
X58 VSS.t49 vin3 vout3 VSS.t48 sg13_lv_nmos ad=0.19p pd=1.38u as=0.19p ps=1.38u w=1u l=1u
X59 VDD VDD VDD VDD sg13_lv_pmos ad=1.14p pd=6.38u as=0 ps=0 w=6u l=1u
X60 vout3 vin3 VSS.t52 VSS.t53 sg13_lv_nmos ad=0.19p pd=1.38u as=0.19p ps=1.38u w=1u l=1u
X61 vout4 vin4 VDD VDD sg13_lv_pmos ad=1.14p pd=6.38u as=1.14p ps=6.38u w=6u l=1u
X62 vout3 vin3 VDD VDD sg13_lv_pmos ad=1.14p pd=6.38u as=1.14p ps=6.38u w=6u l=1u
X63 VDD vin1 vout1 VDD sg13_lv_pmos ad=1.14p pd=6.38u as=1.14p ps=6.38u w=6u l=1u
X64 vout2 vin2 VDD VDD sg13_lv_pmos ad=1.14p pd=6.38u as=1.14p ps=6.38u w=6u l=1u
X65 vout1 vin1 VDD VDD sg13_lv_pmos ad=1.14p pd=6.38u as=1.14p ps=6.38u w=6u l=1u
X66 VDD vin1 vout1 VDD sg13_lv_pmos ad=1.14p pd=6.38u as=1.14p ps=6.38u w=6u l=1u
X67 vout2 vin2 VSS.t91 VSS.t38 sg13_lv_nmos ad=0.19p pd=1.38u as=0.19p ps=1.38u w=1u l=1u
X68 VDD vin1 vout1 VDD sg13_lv_pmos ad=1.14p pd=6.38u as=1.14p ps=6.38u w=6u l=1u
X69 VDD vin3 vout3 VDD sg13_lv_pmos ad=1.14p pd=6.38u as=1.14p ps=6.38u w=6u l=1u
X70 VSS.t43 vin3 vout3 VSS.t42 sg13_lv_nmos ad=0.19p pd=1.38u as=0.19p ps=1.38u w=1u l=1u
X71 vout3 vin3 VSS.t46 VSS.t47 sg13_lv_nmos ad=0.19p pd=1.38u as=0.19p ps=1.38u w=1u l=1u
X72 VSS.t113 vin4 vout4 VSS.t112 sg13_lv_nmos ad=0.19p pd=1.38u as=0.19p ps=1.38u w=1u l=1u
X73 VDD vin4 vout4 VDD sg13_lv_pmos ad=1.14p pd=6.38u as=1.14p ps=6.38u w=6u l=1u
X74 VSS.t52 vin3 vout3 VSS.t51 sg13_lv_nmos ad=0.19p pd=1.38u as=0.19p ps=1.38u w=1u l=1u
X75 vout4 vin4 VSS.t116 VSS.t117 sg13_lv_nmos ad=0.19p pd=1.38u as=0.19p ps=1.38u w=1u l=1u
X76 VDD vin1 vout1 VDD sg13_lv_pmos ad=1.14p pd=6.38u as=1.14p ps=6.38u w=6u l=1u
X77 vout2 vin2 VDD VDD sg13_lv_pmos ad=1.14p pd=6.38u as=1.14p ps=6.38u w=6u l=1u
X78 vout1 vin1 VDD VDD sg13_lv_pmos ad=1.14p pd=6.38u as=1.14p ps=6.38u w=6u l=1u
X79 VSS.t110 vin4 vout4 VSS.t109 sg13_lv_nmos ad=0.19p pd=1.38u as=0.19p ps=1.38u w=1u l=1u
X80 VDD VDD VDD VDD sg13_lv_pmos ad=2.04p pd=12.68u as=0 ps=0 w=6u l=1u
X81 vout2 vin2 VDD VDD sg13_lv_pmos ad=1.14p pd=6.38u as=1.14p ps=6.38u w=6u l=1u
X82 VDD vin2 vout2 VDD sg13_lv_pmos ad=1.14p pd=6.38u as=1.14p ps=6.38u w=6u l=1u
X83 VSS.t91 vin2 vout2 VSS.t36 sg13_lv_nmos ad=0.19p pd=1.38u as=0.19p ps=1.38u w=1u l=1u
X84 VSS.t122 vin4 vout4 VSS.t121 sg13_lv_nmos ad=0.19p pd=1.38u as=0.19p ps=1.38u w=1u l=1u
X85 VDD VDD VDD VDD sg13_lv_pmos ad=2.04p pd=12.68u as=0 ps=0 w=6u l=1u
X86 vout2 vin2 VDD VDD sg13_lv_pmos ad=1.14p pd=6.38u as=1.14p ps=6.38u w=6u l=1u
X87 vout2 vin2 VSS.t93 VSS.t41 sg13_lv_nmos ad=0.19p pd=1.38u as=0.19p ps=1.38u w=1u l=1u
X88 VSS.t97 vin2 vout2 VSS.t45 sg13_lv_nmos ad=0.19p pd=1.38u as=0.19p ps=1.38u w=1u l=1u
X89 vout1 vin1 VDD VDD sg13_lv_pmos ad=1.14p pd=6.38u as=1.14p ps=6.38u w=6u l=1u
X90 vout1 vin1 VSS.t6 VSS.t7 sg13_lv_nmos ad=0.19p pd=1.38u as=0.19p ps=1.38u w=1u l=1u
X91 vout4 vin4 VSS.t119 VSS.t120 sg13_lv_nmos ad=0.19p pd=1.38u as=0.19p ps=1.38u w=1u l=1u
X92 vout3 vin3 VDD VDD sg13_lv_pmos ad=1.14p pd=6.38u as=1.14p ps=6.38u w=6u l=1u
X93 vout4 vin4 VSS.t131 VSS.t132 sg13_lv_nmos ad=0.19p pd=1.38u as=0.19p ps=1.38u w=1u l=1u
X94 VSS.t81 VSS.t79 VSS.t80 VSS.t74 sg13_lv_nmos ad=0.19p pd=1.38u as=0 ps=0 w=1u l=1u
X95 VSS.t125 vin4 vout4 VSS.t124 sg13_lv_nmos ad=0.19p pd=1.38u as=0.19p ps=1.38u w=1u l=1u
X96 VDD vin1 vout1 VDD sg13_lv_pmos ad=1.14p pd=6.38u as=1.14p ps=6.38u w=6u l=1u
X97 VSS.t81 vin2 vout2 VSS.t60 sg13_lv_nmos ad=0.19p pd=1.38u as=0.19p ps=1.38u w=1u l=1u
X98 VDD vin2 vout2 VDD sg13_lv_pmos ad=1.14p pd=6.38u as=1.14p ps=6.38u w=6u l=1u
X99 vout4 vin4 VSS.t128 VSS.t129 sg13_lv_nmos ad=0.19p pd=1.38u as=0.19p ps=1.38u w=1u l=1u
X100 vout4 vin4 VDD VDD sg13_lv_pmos ad=1.14p pd=6.38u as=1.14p ps=6.38u w=6u l=1u
X101 vout2 vin2 VDD VDD sg13_lv_pmos ad=1.14p pd=6.38u as=1.14p ps=6.38u w=6u l=1u
X102 vout2 vin2 VSS.t89 VSS.t35 sg13_lv_nmos ad=0.19p pd=1.38u as=0.19p ps=1.38u w=1u l=1u
X103 VDD vin2 vout2 VDD sg13_lv_pmos ad=1.14p pd=6.38u as=1.14p ps=6.38u w=6u l=1u
X104 VSS.t93 vin2 vout2 VSS.t39 sg13_lv_nmos ad=0.19p pd=1.38u as=0.19p ps=1.38u w=1u l=1u
X105 VDD vin4 vout4 VDD sg13_lv_pmos ad=1.14p pd=6.38u as=1.14p ps=6.38u w=6u l=1u
X106 VDD VDD VDD VDD sg13_lv_pmos ad=2.04p pd=12.68u as=0 ps=0 w=6u l=1u
X107 VSS.t89 vin2 vout2 VSS.t33 sg13_lv_nmos ad=0.19p pd=1.38u as=0.19p ps=1.38u w=1u l=1u
X108 VSS.t6 vin1 vout1 VSS.t5 sg13_lv_nmos ad=0.19p pd=1.38u as=0.19p ps=1.38u w=1u l=1u
X109 vout3 vin3 VDD VDD sg13_lv_pmos ad=1.14p pd=6.38u as=1.14p ps=6.38u w=6u l=1u
X110 vout1 vin1 VSS.t9 VSS.t10 sg13_lv_nmos ad=0.19p pd=1.38u as=0.19p ps=1.38u w=1u l=1u
X111 VSS.t15 vin1 vout1 VSS.t14 sg13_lv_nmos ad=0.19p pd=1.38u as=0.19p ps=1.38u w=1u l=1u
X112 vout3 vin3 VDD VDD sg13_lv_pmos ad=1.14p pd=6.38u as=1.14p ps=6.38u w=6u l=1u
X113 VDD vin3 vout3 VDD sg13_lv_pmos ad=1.14p pd=6.38u as=1.14p ps=6.38u w=6u l=1u
X114 vout3 vin3 VDD VDD sg13_lv_pmos ad=1.14p pd=6.38u as=1.14p ps=6.38u w=6u l=1u
X115 vout3 vin3 VSS.t37 VSS.t38 sg13_lv_nmos ad=0.19p pd=1.38u as=0.19p ps=1.38u w=1u l=1u
X116 VSS.t103 vin2 vout2 VSS.t54 sg13_lv_nmos ad=0.19p pd=1.38u as=0.19p ps=1.38u w=1u l=1u
X117 vout2 vin2 VSS.t105 VSS.t59 sg13_lv_nmos ad=0.19p pd=1.38u as=0.19p ps=1.38u w=1u l=1u
X118 VSS.t69 vin4 vout4 VSS.t136 sg13_lv_nmos ad=0.19p pd=1.38u as=0.19p ps=1.38u w=1u l=1u
X119 vout1 vin1 VDD VDD sg13_lv_pmos ad=1.14p pd=6.38u as=1.14p ps=6.38u w=6u l=1u
X120 VSS.t30 VSS.t85 VSS.t87 VSS.t86 sg13_lv_nmos ad=0.19p pd=1.38u as=0 ps=0 w=1u l=1u
X121 VSS.t30 vin1 vout1 VSS.t29 sg13_lv_nmos ad=0.19p pd=1.38u as=0.19p ps=1.38u w=1u l=1u
X122 vout2 vin2 VSS.t77 VSS.t31 sg13_lv_nmos ad=0.19p pd=1.38u as=0.19p ps=1.38u w=1u l=1u
X123 VSS.t65 VSS.t62 VSS.t64 VSS.t63 sg13_lv_nmos ad=0.34p pd=2.68u as=0 ps=0 w=1u l=1u
X124 vout1 vin1 VSS.t3 VSS.t4 sg13_lv_nmos ad=0.19p pd=1.38u as=0.19p ps=1.38u w=1u l=1u
X125 VSS.t9 vin1 vout1 VSS.t8 sg13_lv_nmos ad=0.19p pd=1.38u as=0.19p ps=1.38u w=1u l=1u
X126 VDD vin3 vout3 VDD sg13_lv_pmos ad=1.14p pd=6.38u as=1.14p ps=6.38u w=6u l=1u
X127 VSS.t3 vin1 vout1 VSS.t2 sg13_lv_nmos ad=0.19p pd=1.38u as=0.19p ps=1.38u w=1u l=1u
X128 vout4 vin4 VDD VDD sg13_lv_pmos ad=1.14p pd=6.38u as=1.14p ps=6.38u w=6u l=1u
X129 vout3 vin3 VDD VDD sg13_lv_pmos ad=1.14p pd=6.38u as=1.14p ps=6.38u w=6u l=1u
X130 VDD vin3 vout3 VDD sg13_lv_pmos ad=1.14p pd=6.38u as=1.14p ps=6.38u w=6u l=1u
X131 VSS.t37 vin3 vout3 VSS.t36 sg13_lv_nmos ad=0.19p pd=1.38u as=0.19p ps=1.38u w=1u l=1u
X132 vout3 vin3 VSS.t40 VSS.t41 sg13_lv_nmos ad=0.19p pd=1.38u as=0.19p ps=1.38u w=1u l=1u
X133 vout1 vin1 VDD VDD sg13_lv_pmos ad=1.14p pd=6.38u as=1.14p ps=6.38u w=6u l=1u
X134 VSS.t105 vin2 vout2 VSS.t57 sg13_lv_nmos ad=0.19p pd=1.38u as=0.19p ps=1.38u w=1u l=1u
X135 VSS.t46 vin3 vout3 VSS.t45 sg13_lv_nmos ad=0.19p pd=1.38u as=0.19p ps=1.38u w=1u l=1u
X136 VDD vin4 vout4 VDD sg13_lv_pmos ad=1.14p pd=6.38u as=1.14p ps=6.38u w=6u l=1u
X137 vout1 vin1 VDD VDD sg13_lv_pmos ad=1.14p pd=6.38u as=1.14p ps=6.38u w=6u l=1u
X138 VDD vin1 vout1 VDD sg13_lv_pmos ad=1.14p pd=6.38u as=1.14p ps=6.38u w=6u l=1u
X139 vout4 vin4 VDD VDD sg13_lv_pmos ad=1.14p pd=6.38u as=1.14p ps=6.38u w=6u l=1u
X140 VSS.t24 vin1 vout1 VSS.t23 sg13_lv_nmos ad=0.19p pd=1.38u as=0.19p ps=1.38u w=1u l=1u
X141 vout1 vin1 VDD VDD sg13_lv_pmos ad=1.14p pd=6.38u as=1.14p ps=6.38u w=6u l=1u
X142 vout1 vin1 VSS.t27 VSS.t28 sg13_lv_nmos ad=0.19p pd=1.38u as=0.19p ps=1.38u w=1u l=1u
X143 vout2 vin2 VDD VDD sg13_lv_pmos ad=1.14p pd=6.38u as=1.14p ps=6.38u w=6u l=1u
X144 vout4 vin4 VSS.t113 VSS.t114 sg13_lv_nmos ad=0.19p pd=1.38u as=0.19p ps=1.38u w=1u l=1u
X145 VSS.t78 VSS.t76 VSS.t77 VSS.t71 sg13_lv_nmos ad=0.34p pd=2.68u as=0 ps=0 w=1u l=1u
X146 VSS.t61 VSS.t73 VSS.t75 VSS.t74 sg13_lv_nmos ad=0.19p pd=1.38u as=0 ps=0 w=1u l=1u
X147 vout4 vin4 VDD VDD sg13_lv_pmos ad=1.14p pd=6.38u as=1.14p ps=6.38u w=6u l=1u
X148 VSS.t61 vin3 vout3 VSS.t60 sg13_lv_nmos ad=0.19p pd=1.38u as=0.19p ps=1.38u w=1u l=1u
X149 VSS.t134 vin4 vout4 VSS.t133 sg13_lv_nmos ad=0.19p pd=1.38u as=0.19p ps=1.38u w=1u l=1u
X150 VDD vin4 vout4 VDD sg13_lv_pmos ad=1.14p pd=6.38u as=1.14p ps=6.38u w=6u l=1u
X151 vout1 vin1 VSS.t1 VSS.t0 sg13_lv_nmos ad=0.19p pd=1.38u as=0.19p ps=1.38u w=1u l=1u
X152 vout3 vin3 VSS.t34 VSS.t35 sg13_lv_nmos ad=0.19p pd=1.38u as=0.19p ps=1.38u w=1u l=1u
X153 VSS.t40 vin3 vout3 VSS.t39 sg13_lv_nmos ad=0.19p pd=1.38u as=0.19p ps=1.38u w=1u l=1u
X154 vout4 vin4 VDD VDD sg13_lv_pmos ad=1.14p pd=6.38u as=1.14p ps=6.38u w=6u l=1u
X155 vout2 vin2 VSS.t103 VSS.t56 sg13_lv_nmos ad=0.19p pd=1.38u as=0.19p ps=1.38u w=1u l=1u
X156 VSS.t34 vin3 vout3 VSS.t33 sg13_lv_nmos ad=0.19p pd=1.38u as=0.19p ps=1.38u w=1u l=1u
X157 VDD vin1 vout1 VDD sg13_lv_pmos ad=1.14p pd=6.38u as=1.14p ps=6.38u w=6u l=1u
X158 vout1 vin1 VDD VDD sg13_lv_pmos ad=1.14p pd=6.38u as=1.14p ps=6.38u w=6u l=1u
X159 VDD vin4 vout4 VDD sg13_lv_pmos ad=1.14p pd=6.38u as=1.14p ps=6.38u w=6u l=1u
X160 VDD vin1 vout1 VDD sg13_lv_pmos ad=1.14p pd=6.38u as=1.14p ps=6.38u w=6u l=1u
X161 VSS.t27 vin1 vout1 VSS.t26 sg13_lv_nmos ad=0.19p pd=1.38u as=0.19p ps=1.38u w=1u l=1u
X162 VDD vin2 vout2 VDD sg13_lv_pmos ad=1.14p pd=6.38u as=1.14p ps=6.38u w=6u l=1u
X163 vout2 vin2 VDD VDD sg13_lv_pmos ad=1.14p pd=6.38u as=1.14p ps=6.38u w=6u l=1u
X164 VDD vin2 vout2 VDD sg13_lv_pmos ad=1.14p pd=6.38u as=1.14p ps=6.38u w=6u l=1u
X165 VSS.t55 vin3 vout3 VSS.t54 sg13_lv_nmos ad=0.19p pd=1.38u as=0.19p ps=1.38u w=1u l=1u
X166 vout3 vin3 VSS.t58 VSS.t59 sg13_lv_nmos ad=0.19p pd=1.38u as=0.19p ps=1.38u w=1u l=1u
X167 VDD VDD VDD VDD sg13_lv_pmos ad=1.14p pd=6.38u as=0 ps=0 w=6u l=1u
X168 VSS.t84 VSS.t82 VSS.t1 VSS.t83 sg13_lv_nmos ad=0.34p pd=2.68u as=0 ps=0 w=1u l=1u
X169 VDD vin4 vout4 VDD sg13_lv_pmos ad=1.14p pd=6.38u as=1.14p ps=6.38u w=6u l=1u
X170 VDD VDD VDD VDD sg13_lv_pmos ad=1.14p pd=6.38u as=0 ps=0 w=6u l=1u
X171 vout2 vin2 VSS.t99 VSS.t50 sg13_lv_nmos ad=0.19p pd=1.38u as=0.19p ps=1.38u w=1u l=1u
X172 vout3 vin3 VDD VDD sg13_lv_pmos ad=1.14p pd=6.38u as=1.14p ps=6.38u w=6u l=1u
X173 vout4 vin4 VSS.t110 VSS.t111 sg13_lv_nmos ad=0.19p pd=1.38u as=0.19p ps=1.38u w=1u l=1u
X174 vout3 vin3 VSS.t32 VSS.t31 sg13_lv_nmos ad=0.19p pd=1.38u as=0.19p ps=1.38u w=1u l=1u
X175 vout2 vin2 VSS.t95 VSS.t44 sg13_lv_nmos ad=0.19p pd=1.38u as=0.19p ps=1.38u w=1u l=1u
R0 VSS.n48 VSS.n116 6777.49
R1 VSS.n239 VSS.n48 6777.49
R2 VSS.n239 VSS.n38 1581.06
R3 VSS.n238 VSS.n116 1580.41
R4 VSS.t31 VSS.n150 88.7251
R5 VSS.n78 VSS.t60 88.7251
R6 VSS.t33 VSS.n149 83.1798
R7 VSS.n165 VSS.t59 83.1798
R8 VSS.t35 VSS.n148 77.6345
R9 VSS.n164 VSS.t57 77.6345
R10 VSS.t67 VSS.n48 6.87897
R11 VSS.t36 VSS.n67 72.0892
R12 VSS.n163 VSS.t56 72.0892
R13 VSS.n48 VSS.t108 9.77299
R14 VSS.t38 VSS.n147 66.5439
R15 VSS.n162 VSS.t54 66.5439
R16 VSS.t135 VSS.n48 12.2976
R17 VSS.t39 VSS.n146 60.9987
R18 VSS.n77 VSS.t53 60.9987
R19 VSS.t133 VSS.n48 14.4648
R20 VSS.n48 VSS.t111 14.4672
R21 VSS.t132 VSS.n48 16.2707
R22 VSS.t28 VSS.n44 12.2983
R23 VSS.t41 VSS.n68 55.4534
R24 VSS.n157 VSS.t45 55.4534
R25 VSS.t47 VSS.n143 55.4534
R26 VSS.n161 VSS.t51 55.4534
R27 VSS.t130 VSS.n48 17.7154
R28 VSS.t26 VSS.n44 14.4658
R29 VSS.t42 VSS.n69 49.9081
R30 VSS.n76 VSS.t44 49.9081
R31 VSS.t48 VSS.n142 49.9081
R32 VSS.n160 VSS.t50 49.9081
R33 VSS.t129 VSS.n48 18.799
R34 VSS.n48 VSS.t115 18.8
R35 VSS.t25 VSS.n44 16.2712
R36 VSS.n48 VSS.t126 19.8823
R37 VSS.n49 VSS.n48 0.0490479
R38 VSS.n48 VSS.t117 19.5219
R39 VSS.n75 VSS.t42 44.3628
R40 VSS.t44 VSS.n145 44.3628
R41 VSS.n159 VSS.t48 44.3628
R42 VSS.t50 VSS.n141 44.3628
R43 VSS.t120 VSS.n48 19.8818
R44 VSS.n48 VSS.t118 19.8825
R45 VSS.n156 VSS.t41 38.8175
R46 VSS.t45 VSS.n144 38.8175
R47 VSS.n158 VSS.t47 38.8175
R48 VSS.t51 VSS.n70 38.8175
R49 VSS.t124 VSS.n48 19.882
R50 VSS.t123 VSS.n49 19.5585
R51 VSS.t19 VSS.n44 19.8822
R52 VSS.n155 VSS.t39 33.2722
R53 VSS.t53 VSS.n140 33.2722
R54 VSS.t17 VSS.n44 19.8811
R55 VSS.n74 VSS.t38 27.7269
R56 VSS.t54 VSS.n139 27.7269
R57 VSS.t114 VSS.n48 17.717
R58 VSS.t16 VSS.n45 19.5611
R59 VSS.t112 VSS.n48 16.2727
R60 VSS.n116 VSS.n44 6777.49
R61 VSS.n44 VSS.t86 6.87971
R62 VSS.n154 VSS.t36 22.1816
R63 VSS.t56 VSS.n138 22.1816
R64 VSS.t29 VSS.n44 9.77002
R65 VSS.t23 VSS.n44 17.7154
R66 VSS.t14 VSS.n45 19.5026
R67 VSS.n44 VSS.t13 19.8814
R68 VSS.t10 VSS.n44 19.5211
R69 VSS.t8 VSS.n44 18.7991
R70 VSS.t4 VSS.n44 14.4652
R71 VSS.t2 VSS.n44 12.2982
R72 VSS.t0 VSS.n44 9.76976
R73 VSS.t85 VSS.n115 0.00575714
R74 VSS.n44 VSS.n115 0.859853
R75 VSS.n44 VSS.n126 17.0005
R76 VSS.t30 VSS.n128 17.0005
R77 VSS.t30 VSS.n133 17.0005
R78 VSS.n134 VSS.t30 17.0005
R79 VSS.n128 VSS.t87 17.0005
R80 VSS.n133 VSS.t87 17.0005
R81 VSS.n134 VSS.t87 17.0005
R82 VSS.n44 VSS.n111 1.31753
R83 VSS.n44 VSS.n127 17.0005
R84 VSS.n44 VSS.n118 17.0005
R85 VSS.t84 VSS.n135 17.0005
R86 VSS.t84 VSS.n125 17.0005
R87 VSS.n136 VSS.t84 17.0005
R88 VSS.n135 VSS.t1 17.0005
R89 VSS.t1 VSS.n125 17.0005
R90 VSS.n136 VSS.t1 17.0005
R91 VSS.n39 VSS.t74 7.66734
R92 VSS.n102 VSS.n0 14.4044
R93 VSS.n84 VSS.n72 7.20256
R94 VSS.n103 VSS.n1 14.4044
R95 VSS.n89 VSS.n71 7.20256
R96 VSS.n88 VSS.n17 14.4044
R97 VSS.n65 VSS.n94 0.650675
R98 VSS.n94 VSS.n19 14.4044
R99 VSS.n41 VSS.n42 0.0322214
R100 VSS.n65 VSS.n138 8.49631
R101 VSS.n65 VSS.n163 8.50017
R102 VSS.n100 VSS.n2 14.4044
R103 VSS.n65 VSS.n100 0.650675
R104 VSS.n65 VSS.n82 0.650675
R105 VSS.n82 VSS.n22 14.4044
R106 VSS.n65 VSS.n51 1.29876
R107 VSS.n65 VSS.n140 8.4983
R108 VSS.n98 VSS.n3 14.4044
R109 VSS.n65 VSS.n85 0.650675
R110 VSS.n85 VSS.n70 7.20256
R111 VSS.n65 VSS.n107 0.650675
R112 VSS.n65 VSS.n62 5.66421
R113 VSS.n65 VSS.n141 8.4973
R114 VSS.n97 VSS.n25 14.4044
R115 VSS.n65 VSS.n55 2.4168
R116 VSS.n55 VSS.n54 0.0269458
R117 VSS.n93 VSS.n27 14.4044
R118 VSS.n65 VSS.n91 0.542754
R119 VSS.n91 VSS.n5 14.6203
R120 VSS.n65 VSS.n79 2.42322
R121 VSS.n99 VSS.n6 14.4044
R122 VSS.n65 VSS.n99 0.650675
R123 VSS.n65 VSS.n145 8.49929
R124 VSS.n65 VSS.n104 0.650675
R125 VSS.n104 VSS.n7 14.4044
R126 VSS.n65 VSS.n96 0.650675
R127 VSS.n96 VSS.n69 7.20256
R128 VSS.n65 VSS.n108 0.650675
R129 VSS.n108 VSS.n8 14.4044
R130 VSS.n65 VSS.n106 0.650675
R131 VSS.n106 VSS.n68 7.20256
R132 VSS.n95 VSS.n30 14.4044
R133 VSS.n65 VSS.n146 8.49879
R134 VSS.n65 VSS.n86 0.650675
R135 VSS.n86 VSS.n32 14.4044
R136 VSS.n101 VSS.n74 7.20256
R137 VSS.n65 VSS.n101 0.650675
R138 VSS.n65 VSS.n83 0.650675
R139 VSS.n83 VSS.n67 7.20256
R140 VSS.n65 VSS.n87 0.650675
R141 VSS.n87 VSS.n34 14.4044
R142 VSS.n105 VSS.n11 14.4044
R143 VSS.n65 VSS.n105 0.650675
R144 VSS.n60 VSS.n110 0.0170151
R145 VSS.n65 VSS.n149 8.4978
R146 VSS.n92 VSS.n13 14.4044
R147 VSS.n81 VSS.n14 14.4044
R148 VSS.n65 VSS.n90 0.650675
R149 VSS.n65 VSS.n40 0.166527
R150 VSS.n165 VSS.n65 8.49288
R151 VSS.n137 VSS.n65 8.49582
R152 VSS.n164 VSS.n65 8.49313
R153 VSS.n139 VSS.n65 8.49755
R154 VSS.n162 VSS.n65 8.49337
R155 VSS.n161 VSS.n65 8.49361
R156 VSS.n160 VSS.n65 8.49385
R157 VSS.n142 VSS.n65 8.49606
R158 VSS.n159 VSS.n65 8.4941
R159 VSS.n143 VSS.n65 8.49904
R160 VSS.n158 VSS.n65 8.49805
R161 VSS.n144 VSS.n65 8.49557
R162 VSS.n157 VSS.n65 8.49954
R163 VSS.n156 VSS.n65 8.49434
R164 VSS.n155 VSS.n65 8.49459
R165 VSS.n147 VSS.n65 8.49532
R166 VSS.n154 VSS.n65 8.49483
R167 VSS.n148 VSS.n65 8.49705
R168 VSS.n153 VSS.n65 8.49656
R169 VSS.n152 VSS.n65 8.49854
R170 VSS.n150 VSS.n65 8.49508
R171 VSS.n37 VSS.n63 3.39948
R172 VSS.n42 VSS.n109 0.0766053
R173 VSS.n37 VSS.n53 2.11163
R174 VSS.n37 VSS.n61 5.66316
R175 VSS.n58 VSS.n79 0.0402143
R176 VSS.n48 VSS.n218 17.0005
R177 VSS.n48 VSS.n207 17.0005
R178 VSS.n48 VSS.n114 1.31087
R179 VSS.n48 VSS.n113 1.27652
R180 VSS.n48 VSS.n196 17.0005
R181 VSS.n48 VSS.n195 17.0005
R182 VSS.n206 VSS.t69 17.0005
R183 VSS.t69 VSS.n204 17.0005
R184 VSS.t69 VSS.n205 17.0005
R185 VSS.n206 VSS.t68 17.0005
R186 VSS.n204 VSS.t68 17.0005
R187 VSS.n205 VSS.t68 17.0005
R188 VSS.t65 VSS.n216 17.0005
R189 VSS.t65 VSS.n215 17.0005
R190 VSS.n217 VSS.t65 17.0005
R191 VSS.n216 VSS.t64 17.0005
R192 VSS.n215 VSS.t64 17.0005
R193 VSS.n217 VSS.t64 17.0005
R194 VSS.n153 VSS.t35 16.6364
R195 VSS.t57 VSS.n137 16.6364
R196 VSS.t109 VSS.n48 12.3005
R197 VSS.t76 VSS.n235 15.0005
R198 VSS.n229 VSS.t70 15.0005
R199 VSS.t73 VSS.n173 15.0005
R200 VSS.n175 VSS.t79 15.0005
R201 VSS.n97 VSS.n4 14.4051
R202 VSS.n95 VSS.n9 14.4051
R203 VSS.n92 VSS.n12 14.4051
R204 VSS.n40 VSS.n37 3.99284
R205 VSS.t71 VSS.n40 7.66734
R206 VSS.n90 VSS.n36 14.4044
R207 VSS.n73 VSS.n81 7.20324
R208 VSS.n35 VSS.n105 14.4051
R209 VSS.n101 VSS.n10 14.4051
R210 VSS.n75 VSS.n108 7.20324
R211 VSS.n76 VSS.n104 7.20324
R212 VSS.n29 VSS.n99 14.4051
R213 VSS.n24 VSS.n107 14.4051
R214 VSS.n77 VSS.n98 7.20324
R215 VSS.n20 VSS.n100 14.4051
R216 VSS.n78 VSS.n103 7.20324
R217 VSS.n15 VSS.n102 14.4051
R218 VSS.n44 VSS.t7 17.716
R219 VSS.n45 VSS.n44 0.0532954
R220 VSS.n44 VSS.t20 19.5213
R221 VSS.n44 VSS.t22 18.7992
R222 VSS.n152 VSS.t33 11.0911
R223 VSS.t59 VSS.n71 11.0911
R224 VSS.n239 VSS.n44 6777.49
R225 VSS.n238 VSS.n65 1.70124
R226 VSS.n37 VSS.n78 8.5005
R227 VSS.n37 VSS.n77 8.5005
R228 VSS.n37 VSS.n76 8.5005
R229 VSS.n37 VSS.n75 8.5005
R230 VSS.n37 VSS.n74 8.5005
R231 VSS.n37 VSS.n73 8.5005
R232 VSS.n37 VSS.n72 8.5005
R233 VSS.n37 VSS.n71 8.5005
R234 VSS.n37 VSS.n70 8.5005
R235 VSS.n37 VSS.n69 8.5005
R236 VSS.n37 VSS.n68 8.5005
R237 VSS.n37 VSS.n67 8.5005
R238 VSS.n43 VSS.n66 0.111089
R239 VSS.n65 VSS.n43 0.968186
R240 VSS.n43 VSS.n41 0.0375267
R241 VSS.n51 VSS.n109 0.018437
R242 VSS.n62 VSS.n53 0.0417255
R243 VSS.n55 VSS.n61 0.0435511
R244 VSS.n65 VSS.n50 2.41712
R245 VSS.n65 VSS.n38 0.328303
R246 VSS.n65 VSS.n60 2.42299
R247 VSS.n65 VSS.n151 8.4984
R248 VSS.n65 VSS.n56 8.4984
R249 VSS.n65 VSS.n57 2.86088
R250 VSS.n37 VSS.n42 0.75184
R251 VSS.n53 VSS.n52 0.0477625
R252 VSS.n61 VSS.n62 0.014444
R253 VSS.n37 VSS.n58 2.42339
R254 VSS.n58 VSS.n54 0.00696502
R255 VSS.n50 VSS.t46 0.017005
R256 VSS.n37 VSS.n110 0.167208
R257 VSS.n59 VSS.n60 0.0273474
R258 VSS.n37 VSS.n59 3.39245
R259 VSS.n37 VSS.n166 8.4984
R260 VSS.n48 VSS.t63 6.87872
R261 VSS.n236 VSS.t76 7.49606
R262 VSS.t70 VSS.n228 7.49606
R263 VSS.n64 VSS.t73 7.49606
R264 VSS.t79 VSS.n174 7.49606
R265 VSS.n16 VSS.n165 7.20236
R266 VSS.n18 VSS.n164 7.20236
R267 VSS.n21 VSS.n162 7.20236
R268 VSS.n23 VSS.n161 7.20236
R269 VSS.n26 VSS.n159 7.20236
R270 VSS.n28 VSS.n158 7.20236
R271 VSS.n31 VSS.n155 7.20236
R272 VSS.n33 VSS.n154 7.20236
R273 VSS.n36 VSS.t71 7.20236
R274 VSS.n5 VSS.n144 7.20236
R275 VSS.n13 VSS.n150 7.20236
R276 VSS.n14 VSS.n90 14.4051
R277 VSS.n12 VSS.n152 7.20236
R278 VSS.n35 VSS.n149 7.20236
R279 VSS.n11 VSS.n153 7.20236
R280 VSS.n34 VSS.n148 7.20236
R281 VSS.n33 VSS.n87 14.4051
R282 VSS.n10 VSS.n83 14.4051
R283 VSS.n32 VSS.n147 7.20236
R284 VSS.n31 VSS.n86 14.4051
R285 VSS.n30 VSS.n146 7.20236
R286 VSS.n9 VSS.n156 7.20236
R287 VSS.n8 VSS.n106 14.4051
R288 VSS.n7 VSS.n96 14.4051
R289 VSS.n29 VSS.n145 7.20236
R290 VSS.n6 VSS.n157 7.20236
R291 VSS.n28 VSS.n91 14.6209
R292 VSS.n27 VSS.n143 7.20236
R293 VSS.n26 VSS.n93 14.4051
R294 VSS.n25 VSS.n142 7.20236
R295 VSS.n4 VSS.n160 7.20236
R296 VSS.n24 VSS.n141 7.20236
R297 VSS.n23 VSS.n107 14.4044
R298 VSS.n3 VSS.n85 14.4051
R299 VSS.n22 VSS.n140 7.20236
R300 VSS.n21 VSS.n82 14.4051
R301 VSS.n20 VSS.n139 7.20236
R302 VSS.n2 VSS.n163 7.20236
R303 VSS.n19 VSS.n138 7.20236
R304 VSS.n18 VSS.n94 14.4051
R305 VSS.n17 VSS.n137 7.20236
R306 VSS.n16 VSS.n88 14.4051
R307 VSS.n1 VSS.n89 14.4051
R308 VSS.n0 VSS.n84 14.4051
R309 VSS.n15 VSS.t74 7.20236
R310 VSS.n37 VSS.n39 3.99284
R311 VSS.n73 VSS.t31 5.54579
R312 VSS.t60 VSS.n72 5.54579
R313 VSS.n237 VSS.t77 4.5005
R314 VSS.t32 VSS.n227 4.5005
R315 VSS.t81 VSS.n170 4.5005
R316 VSS.t61 VSS.n172 4.5005
R317 VSS.n37 VSS.n57 0.762063
R318 VSS.n63 VSS.n65 4.2554
R319 VSS.n260 VSS.n119 3.77525
R320 VSS.n261 VSS.n260 3.77525
R321 VSS.n221 VSS.n220 3.77525
R322 VSS.n220 VSS.n183 3.77525
R323 VSS.n132 VSS.t85 3.0005
R324 VSS.n256 VSS.t82 3.0005
R325 VSS.n203 VSS.t66 3.0005
R326 VSS.n214 VSS.t62 3.0005
R327 VSS.n234 VSS.n233 3.0005
R328 VSS.n231 VSS.n230 3.0005
R329 VSS.n177 VSS.n176 3.0005
R330 VSS.n171 VSS.n169 3.0005
R331 VSS.t11 VSS.n44 19.8818
R332 VSS.t5 VSS.n44 16.2709
R333 VSS.t83 VSS.n44 6.87945
R334 VSS.n183 VSS.n182 2.92212
R335 VSS.n263 VSS.n262 2.52012
R336 VSS.n202 VSS.t134 2.48177
R337 VSS.n200 VSS.t131 2.48177
R338 VSS.n199 VSS.t128 2.48177
R339 VSS.t125 VSS.n184 2.48177
R340 VSS.t119 VSS.n185 2.48177
R341 VSS.n211 VSS.t116 2.48177
R342 VSS.n212 VSS.t113 2.48177
R343 VSS.n213 VSS.t110 2.48177
R344 VSS.n226 VSS.t89 2.48177
R345 VSS.n225 VSS.t91 2.48177
R346 VSS.n224 VSS.t93 2.48177
R347 VSS.n223 VSS.t95 2.48177
R348 VSS.n167 VSS.t99 2.48177
R349 VSS.n181 VSS.t101 2.48177
R350 VSS.n180 VSS.t103 2.48177
R351 VSS.n179 VSS.t105 2.48177
R352 VSS.n257 VSS.t3 2.48177
R353 VSS.n258 VSS.t6 2.48177
R354 VSS.n259 VSS.t9 2.48177
R355 VSS.n124 VSS.t12 2.48177
R356 VSS.t18 VSS.n123 2.48177
R357 VSS.n129 VSS.t21 2.48177
R358 VSS.n130 VSS.t24 2.48177
R359 VSS.n131 VSS.t27 2.48177
R360 VSS.n226 VSS.t34 2.48177
R361 VSS.n225 VSS.t37 2.48177
R362 VSS.n224 VSS.t40 2.48177
R363 VSS.n223 VSS.t43 2.48177
R364 VSS.n167 VSS.t49 2.48177
R365 VSS.n181 VSS.t52 2.48177
R366 VSS.n180 VSS.t55 2.48177
R367 VSS.n179 VSS.t58 2.48177
R368 VSS.n65 VSS.n39 0.166527
R369 VSS.n102 VSS.n65 0.650675
R370 VSS.n84 VSS.n65 0.650675
R371 VSS.n103 VSS.n65 0.650675
R372 VSS.n89 VSS.n65 0.650675
R373 VSS.n88 VSS.n65 0.650675
R374 VSS.n98 VSS.n65 0.650675
R375 VSS.n97 VSS.n65 0.650675
R376 VSS.n93 VSS.n65 0.650675
R377 VSS.n95 VSS.n65 0.650675
R378 VSS.n92 VSS.n65 0.650675
R379 VSS.n81 VSS.n65 0.650675
R380 VSS.t78 VSS.n237 2.2505
R381 VSS.n227 VSS.t72 2.2505
R382 VSS.n170 VSS.t80 2.2505
R383 VSS.n172 VSS.t75 2.2505
R384 VSS.n241 VSS.n44 2.09947
R385 VSS.n243 VSS.n44 2.09947
R386 VSS.n245 VSS.n44 2.09947
R387 VSS.n121 VSS.n44 2.09947
R388 VSS.n247 VSS.n44 2.09947
R389 VSS.n249 VSS.n44 2.09947
R390 VSS.n251 VSS.n44 2.09947
R391 VSS.n253 VSS.n44 2.09947
R392 VSS.n219 VSS.n48 2.09887
R393 VSS.n48 VSS.n117 2.09887
R394 VSS.n48 VSS.n190 2.09868
R395 VSS.n48 VSS.n193 2.09868
R396 VSS.n48 VSS.n194 2.09868
R397 VSS.n48 VSS.n192 2.09865
R398 VSS.n48 VSS.n188 2.09849
R399 VSS.n48 VSS.n189 2.09849
R400 VSS.n168 VSS.n222 1.88787
R401 VSS.n168 VSS.n120 1.88787
R402 VSS.n38 VSS.n37 0.296407
R403 VSS.n238 VSS.n37 1.53502
R404 VSS.n256 VSS.n125 1.52811
R405 VSS.n204 VSS.n203 1.52811
R406 VSS.n215 VSS.n214 1.52811
R407 VSS.n133 VSS.n132 1.52811
R408 VSS.n216 VSS.n114 0.00154475
R409 VSS.n113 VSS.n206 0.00153046
R410 VSS.n222 VSS.n119 1.1929
R411 VSS.n222 VSS.n221 1.1929
R412 VSS.n261 VSS.n120 1.1929
R413 VSS.n183 VSS.n120 1.1929
R414 VSS.n57 VSS.t78 0.0121434
R415 VSS.n37 VSS.t80 1.03559
R416 VSS.n240 VSS.t85 0.1481
R417 VSS.n255 VSS.n44 0.91152
R418 VSS.n48 VSS.n46 0.910334
R419 VSS.n48 VSS.n47 0.909422
R420 VSS.n221 VSS.n182 0.841009
R421 VSS.n37 VSS.n0 0.650322
R422 VSS.n37 VSS.n1 0.650322
R423 VSS.n37 VSS.n2 0.650322
R424 VSS.n37 VSS.n3 0.650322
R425 VSS.n37 VSS.n4 0.650322
R426 VSS.n37 VSS.n5 0.650322
R427 VSS.n37 VSS.n6 0.650322
R428 VSS.n37 VSS.n7 0.650322
R429 VSS.n37 VSS.n8 0.650322
R430 VSS.n37 VSS.n9 0.650322
R431 VSS.n37 VSS.n10 0.650322
R432 VSS.n37 VSS.n11 0.650322
R433 VSS.n37 VSS.n12 0.650322
R434 VSS.n37 VSS.n13 0.650322
R435 VSS.n37 VSS.n14 0.650322
R436 VSS.n37 VSS.n15 0.650322
R437 VSS.n37 VSS.n16 0.650322
R438 VSS.n37 VSS.n17 0.650322
R439 VSS.n37 VSS.n18 0.650322
R440 VSS.n37 VSS.n19 0.650322
R441 VSS.n37 VSS.n20 0.650322
R442 VSS.n37 VSS.n21 0.650322
R443 VSS.n37 VSS.n22 0.650322
R444 VSS.n37 VSS.n23 0.650322
R445 VSS.n37 VSS.n24 0.650322
R446 VSS.n37 VSS.n25 0.650322
R447 VSS.n37 VSS.n26 0.650322
R448 VSS.n37 VSS.n27 0.650322
R449 VSS.n37 VSS.n28 0.650322
R450 VSS.n37 VSS.n29 0.650322
R451 VSS.n37 VSS.n30 0.650322
R452 VSS.n37 VSS.n31 0.650322
R453 VSS.n37 VSS.n32 0.650322
R454 VSS.n37 VSS.n33 0.650322
R455 VSS.n37 VSS.n34 0.650322
R456 VSS.n37 VSS.n35 0.650322
R457 VSS.n37 VSS.n36 0.650322
R458 VSS.n264 VSS.n263 0.439009
R459 VSS.n264 VSS.n119 0.4025
R460 VSS.n262 VSS.n261 0.4025
R461 VSS.n257 VSS.n256 0.209825
R462 VSS.n203 VSS.n202 0.209825
R463 VSS.n214 VSS.n213 0.209825
R464 VSS.n132 VSS.n131 0.209825
R465 VSS.n254 VSS.t3 0.200997
R466 VSS.n252 VSS.t6 0.200997
R467 VSS.n250 VSS.t9 0.200997
R468 VSS.n248 VSS.t12 0.200997
R469 VSS.n246 VSS.t18 0.200997
R470 VSS.n244 VSS.t21 0.200997
R471 VSS.n242 VSS.t24 0.200997
R472 VSS.n240 VSS.t27 0.200997
R473 VSS.n110 VSS.t34 0.200997
R474 VSS.n37 VSS.t37 0.200997
R475 VSS.n37 VSS.t40 0.200997
R476 VSS.n37 VSS.t43 0.200997
R477 VSS.n54 VSS.t49 0.200997
R478 VSS.n52 VSS.t52 0.200997
R479 VSS.n109 VSS.t55 0.200997
R480 VSS.n41 VSS.t58 0.200997
R481 VSS.t134 VSS.n201 0.200995
R482 VSS.t131 VSS.n197 0.200995
R483 VSS.t128 VSS.n198 0.200995
R484 VSS.n191 VSS.t125 0.200995
R485 VSS.n187 VSS.t119 0.200995
R486 VSS.t116 VSS.n210 0.200995
R487 VSS.t113 VSS.n209 0.200995
R488 VSS.t110 VSS.n208 0.200995
R489 VSS.t89 VSS.n110 0.200995
R490 VSS.t91 VSS.n37 0.200995
R491 VSS.t93 VSS.n37 0.200995
R492 VSS.t95 VSS.n37 0.200995
R493 VSS.t99 VSS.n54 0.200995
R494 VSS.t101 VSS.n52 0.200995
R495 VSS.t103 VSS.n109 0.200995
R496 VSS.t105 VSS.n41 0.200995
R497 VSS.t46 VSS.t97 0.185126
R498 VSS.n258 VSS.n257 0.16242
R499 VSS.n259 VSS.n258 0.16242
R500 VSS.n124 VSS.n259 0.16242
R501 VSS.n122 VSS.n124 0.16242
R502 VSS.n122 VSS.n123 0.16242
R503 VSS.n129 VSS.n123 0.16242
R504 VSS.n130 VSS.n129 0.16242
R505 VSS.n131 VSS.n130 0.16242
R506 VSS.n213 VSS.n212 0.16242
R507 VSS.n212 VSS.n211 0.16242
R508 VSS.n211 VSS.n185 0.16242
R509 VSS.n186 VSS.n185 0.16242
R510 VSS.n186 VSS.n184 0.16242
R511 VSS.n199 VSS.n184 0.16242
R512 VSS.n200 VSS.n199 0.16242
R513 VSS.n202 VSS.n200 0.16242
R514 VSS.n201 VSS.n47 0.14675
R515 VSS.n208 VSS.n46 0.145358
R516 VSS.n255 VSS.n254 0.144129
R517 VSS.n136 VSS.n111 0.00154752
R518 VSS.n232 VSS.n226 0.117247
R519 VSS.n179 VSS.n178 0.1171
R520 VSS.n254 VSS.n253 0.0952183
R521 VSS.n208 VSS.n188 0.093942
R522 VSS.n201 VSS.n194 0.0935007
R523 VSS.n252 VSS.n251 0.0927738
R524 VSS.n241 VSS.n240 0.0925656
R525 VSS.n197 VSS.n193 0.0917553
R526 VSS.n209 VSS.n189 0.0914976
R527 VSS.n250 VSS.n249 0.0903294
R528 VSS.t15 VSS.n121 0.0903294
R529 VSS.n243 VSS.n242 0.0901212
R530 VSS.t122 VSS.n117 0.0895627
R531 VSS.n210 VSS.n190 0.089375
R532 VSS.n198 VSS.n192 0.088805
R533 VSS.t122 VSS.n219 0.0884223
R534 VSS.n248 VSS.n247 0.0878849
R535 VSS.n246 VSS.n245 0.0878849
R536 VSS.n247 VSS.t15 0.0876767
R537 VSS.n245 VSS.n244 0.0876767
R538 VSS.n219 VSS.n187 0.0871182
R539 VSS.n192 VSS.n191 0.086743
R540 VSS.n190 VSS.n187 0.0861674
R541 VSS.n191 VSS.n117 0.0859778
R542 VSS.n244 VSS.n243 0.0854405
R543 VSS.n249 VSS.n248 0.0852323
R544 VSS.n121 VSS.n246 0.0852323
R545 VSS.t82 VSS.n255 0.0847768
R546 VSS.n210 VSS.n189 0.0840392
R547 VSS.n198 VSS.n193 0.0837839
R548 VSS.t62 VSS.n46 0.0834709
R549 VSS.n242 VSS.n241 0.082996
R550 VSS.t66 VSS.n47 0.0829697
R551 VSS.n251 VSS.n250 0.0827878
R552 VSS.n197 VSS.n194 0.0820417
R553 VSS.n209 VSS.n188 0.0815947
R554 VSS.n226 VSS.n225 0.08146
R555 VSS.n225 VSS.n224 0.08146
R556 VSS.n224 VSS.n223 0.08146
R557 VSS.n223 VSS.n80 0.08146
R558 VSS.n80 VSS.n167 0.08146
R559 VSS.n167 VSS.n181 0.08146
R560 VSS.n181 VSS.n180 0.08146
R561 VSS.n180 VSS.n179 0.08146
R562 VSS.n253 VSS.n252 0.0803434
R563 VSS.t72 VSS.n65 1.0526
R564 VSS.n182 VSS 0.045455
R565 VSS.n263 VSS 0.045455
R566 VSS VSS.n264 0.0445
R567 VSS.n262 VSS 0.0445
R568 VSS.t15 VSS.n122 0.0394177
R569 VSS.n186 VSS.t122 0.0394177
R570 VSS.n260 VSS.n122 0.0389615
R571 VSS.n220 VSS.n186 0.0389615
R572 VSS.t77 VSS.n236 0.031258
R573 VSS.n228 VSS.t32 0.031258
R574 VSS.n232 VSS.n231 0.0291125
R575 VSS.n178 VSS.n177 0.0291125
R576 VSS.n178 VSS.n169 0.0291125
R577 VSS.n233 VSS.n232 0.0291125
R578 VSS.n231 VSS.n227 0.0281144
R579 VSS.n177 VSS.n170 0.0281144
R580 VSS.n172 VSS.n169 0.0281144
R581 VSS.n237 VSS.n233 0.0281144
R582 VSS.n66 VSS.n64 0.0216549
R583 VSS.n174 VSS.n66 0.0216549
R584 VSS.n173 VSS.t61 0.0208704
R585 VSS.n175 VSS.t81 0.0208704
R586 VSS.n235 VSS.n234 0.0202884
R587 VSS.n230 VSS.n229 0.0202884
R588 VSS.n173 VSS.n171 0.0202884
R589 VSS.n176 VSS.n175 0.0202884
R590 VSS.n80 VSS.n168 0.0197308
R591 VSS.t46 VSS.n80 0.0194533
R592 VSS.n66 VSS.n63 0.0135837
R593 VSS.t82 VSS.n118 0.0133922
R594 VSS.t66 VSS.n195 0.0133922
R595 VSS.n218 VSS.t62 0.0133922
R596 VSS.t46 VSS.n79 0.00653296
R597 VSS.n166 VSS.n56 0.0118857
R598 VSS.t78 VSS.n56 0.0161786
R599 VSS.n166 VSS.n151 0.0118857
R600 VSS.n59 VSS.n151 0.0293313
R601 VSS.n52 VSS.n51 0.0145115
R602 VSS.n235 VSS.t78 0.0115582
R603 VSS.n229 VSS.t78 0.0115582
R604 VSS.n48 VSS.t127 19.5212
R605 VSS.n48 VSS.t136 9.76925
R606 VSS.n236 VSS.n234 0.0108877
R607 VSS.n230 VSS.n228 0.0108877
R608 VSS.n64 VSS.n171 0.0108877
R609 VSS.n176 VSS.n174 0.0108877
R610 VSS.n66 VSS.t75 0.0101032
R611 VSS.n66 VSS.t80 0.0101032
R612 VSS.t72 VSS.t78 0.00981217
R613 VSS.n49 VSS.t121 19.5044
R614 VSS.n133 VSS.n126 0.00798582
R615 VSS.n133 VSS.n112 0.0150235
R616 VSS.n127 VSS.n125 0.00798582
R617 VSS.n204 VSS.n113 0.0150226
R618 VSS.n204 VSS.n196 0.00798582
R619 VSS.n215 VSS.n114 0.0150083
R620 VSS.n215 VSS.n207 0.00798582
R621 VSS.n128 VSS.n115 0.0969824
R622 VSS.n128 VSS.n126 0.00756994
R623 VSS.n134 VSS.n112 0.00152956
R624 VSS.n135 VSS.n118 0.00756994
R625 VSS.n135 VSS.n127 0.00756994
R626 VSS.n125 VSS.n111 0.0150055
R627 VSS.n205 VSS.n196 0.00756994
R628 VSS.n205 VSS.n195 0.00756994
R629 VSS.n217 VSS.n207 0.00756994
R630 VSS.n218 VSS.n217 0.00756994
R631 VSS.n112 VSS.n44 1.27435
R632 VSS.n50 VSS.n37 1.09212
R633 VSS.t75 VSS.n65 1.07116
C0 vout2 VDD 11.7272f
C1 VDD vout3 11.7272f
C2 vin1 VDD 26.9799f
C3 VDD vout1 11.7272f
C4 vin4 vin3 0.11002f
C5 vin3 VDD 26.9696f
C6 vin2 VDD 26.9696f
C7 vin1 vout1 16.0649f
C8 vin2 vout2 16.0649f
C9 vin3 vout3 16.0649f
C10 vout4 vin4 16.0649f
C11 vin2 vin1 0.11002f
C12 vout4 VDD 11.7272f
C13 vin4 VDD 26.9799f
C14 vin2 vin3 0.12731f
C15 vout1 VSS 11.99485f
C16 vout2 VSS 11.97725f
C17 vout3 VSS 11.97725f
C18 vout4 VSS 11.99485f
C19 VSS.t58 VSS 7.1315f
C20 VSS.t24 VSS 7.1491f
.ends
