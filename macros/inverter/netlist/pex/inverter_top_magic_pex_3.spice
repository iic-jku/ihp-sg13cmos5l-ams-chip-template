* PEX produced on Sat Aug  1 02:07:38 PM CEST 2026 using /foss/tools/sak/sak-pex.sh with m=3 and s=1 (extresist threshold=10000 mOhm, minres=1000 mOhm, mindelay=1 ps)
* NGSPICE file created from inverter_top_pex.ext - technology: ihp-sg13cmos5l

.subckt inverter_top_pex VDD vin4 vout4 VSS vin3 vout3 vin2 vout2 vout1 vin1
X0 vout4 vin4 VDD VDD sg13_lv_pmos ad=1.14p pd=6.38u as=1.14p ps=6.38u w=6u l=1u
X1 VDD vin2 vout2 VDD sg13_lv_pmos ad=1.14p pd=6.38u as=1.14p ps=6.38u w=6u l=1u
X2 VSS.t128 vin2 vout2 VSS.t48 sg13_lv_nmos ad=0.19p pd=1.38u as=0.19p ps=1.38u w=1u l=1u
X3 vout2 vin2 VSS.t130 VSS.t53 sg13_lv_nmos ad=0.19p pd=1.38u as=0.19p ps=1.38u w=1u l=1u
X4 vout2 vin2 VDD VDD sg13_lv_pmos ad=1.14p pd=6.38u as=1.14p ps=6.38u w=6u l=1u
X5 VSS.t96 vin4 vout4 VSS.t95 sg13_lv_nmos ad=0.19p pd=1.38u as=0.19p ps=1.38u w=1u l=1u
X6 vout1 vin1 VSS.t24 VSS.t25 sg13_lv_nmos ad=0.19p pd=1.38u as=0.19p ps=1.38u w=1u l=1u
X7 VDD vin2 vout2 VDD sg13_lv_pmos ad=1.14p pd=6.38u as=1.14p ps=6.38u w=6u l=1u
X8 vout4 vin4 VSS.t64 VSS.t88 sg13_lv_nmos ad=0.19p pd=1.38u as=0.19p ps=1.38u w=1u l=1u
X9 VDD vin2 vout2 VDD sg13_lv_pmos ad=1.14p pd=6.38u as=1.14p ps=6.38u w=6u l=1u
X10 VSS.t58 vin3 vout3 VSS.t57 sg13_lv_nmos ad=0.19p pd=1.38u as=0.19p ps=1.38u w=1u l=1u
X11 vout4 vin4 VSS.t105 VSS.t106 sg13_lv_nmos ad=0.19p pd=1.38u as=0.19p ps=1.38u w=1u l=1u
X12 VDD vin3 vout3 VDD sg13_lv_pmos ad=1.14p pd=6.38u as=1.14p ps=6.38u w=6u l=1u
X13 VSS.t99 vin4 vout4 VSS.t98 sg13_lv_nmos ad=0.19p pd=1.38u as=0.19p ps=1.38u w=1u l=1u
X14 VDD vin2 vout2 VDD sg13_lv_pmos ad=1.14p pd=6.38u as=1.14p ps=6.38u w=6u l=1u
X15 vout3 vin3 VDD VDD sg13_lv_pmos ad=1.14p pd=6.38u as=1.14p ps=6.38u w=6u l=1u
X16 vout2 vin2 VDD VDD sg13_lv_pmos ad=1.14p pd=6.38u as=1.14p ps=6.38u w=6u l=1u
X17 VSS.t124 vin2 vout2 VSS.t42 sg13_lv_nmos ad=0.19p pd=1.38u as=0.19p ps=1.38u w=1u l=1u
X18 VDD vin3 vout3 VDD sg13_lv_pmos ad=1.14p pd=6.38u as=1.14p ps=6.38u w=6u l=1u
X19 VSS.t72 VSS.t70 VSS.t32 VSS.t71 sg13_lv_nmos ad=0.34p pd=2.68u as=0 ps=0 w=1u l=1u
X20 vout2 vin2 VSS.t126 VSS.t47 sg13_lv_nmos ad=0.19p pd=1.38u as=0.19p ps=1.38u w=1u l=1u
X21 vout1 vin1 VSS.t18 VSS.t19 sg13_lv_nmos ad=0.19p pd=1.38u as=0.19p ps=1.38u w=1u l=1u
X22 VSS.t130 vin2 vout2 VSS.t51 sg13_lv_nmos ad=0.19p pd=1.38u as=0.19p ps=1.38u w=1u l=1u
X23 vout4 vin4 VSS.t102 VSS.t103 sg13_lv_nmos ad=0.19p pd=1.38u as=0.19p ps=1.38u w=1u l=1u
X24 vout1 vin1 VDD VDD sg13_lv_pmos ad=1.14p pd=6.38u as=1.14p ps=6.38u w=6u l=1u
X25 vout1 vin1 VSS.t12 VSS.t13 sg13_lv_nmos ad=0.19p pd=1.38u as=0.19p ps=1.38u w=1u l=1u
X26 VSS.t108 vin4 vout4 VSS.t107 sg13_lv_nmos ad=0.19p pd=1.38u as=0.19p ps=1.38u w=1u l=1u
X27 VDD VDD VDD VDD sg13_lv_pmos ad=1.14p pd=6.38u as=0.56797n ps=1.006m w=6u l=1u
X28 VSS.t18 vin1 vout1 VSS.t17 sg13_lv_nmos ad=0.19p pd=1.38u as=0.19p ps=1.38u w=1u l=1u
X29 vout2 vin2 VDD VDD sg13_lv_pmos ad=1.14p pd=6.38u as=1.14p ps=6.38u w=6u l=1u
X30 VDD vin4 vout4 VDD sg13_lv_pmos ad=1.14p pd=6.38u as=1.14p ps=6.38u w=6u l=1u
X31 vout1 vin1 VSS.t21 VSS.t22 sg13_lv_nmos ad=0.19p pd=1.38u as=0.19p ps=1.38u w=1u l=1u
X32 vout3 vin3 VSS.t55 VSS.t56 sg13_lv_nmos ad=0.19p pd=1.38u as=0.19p ps=1.38u w=1u l=1u
X33 vout4 vin4 VDD VDD sg13_lv_pmos ad=1.14p pd=6.38u as=1.14p ps=6.38u w=6u l=1u
X34 VDD vin3 vout3 VDD sg13_lv_pmos ad=1.14p pd=6.38u as=1.14p ps=6.38u w=6u l=1u
X35 VDD vin4 vout4 VDD sg13_lv_pmos ad=1.14p pd=6.38u as=1.14p ps=6.38u w=6u l=1u
X36 vout3 vin3 VDD VDD sg13_lv_pmos ad=1.14p pd=6.38u as=1.14p ps=6.38u w=6u l=1u
X37 VDD vin3 vout3 VDD sg13_lv_pmos ad=1.14p pd=6.38u as=1.14p ps=6.38u w=6u l=1u
X38 VSS.t69 VSS.t66 VSS.t68 VSS.t67 sg13_lv_nmos ad=0.19p pd=1.38u as=0 ps=0 w=1u l=1u
X39 VDD vin4 vout4 VDD sg13_lv_pmos ad=1.14p pd=6.38u as=1.14p ps=6.38u w=6u l=1u
X40 VDD vin2 vout2 VDD sg13_lv_pmos ad=1.14p pd=6.38u as=1.14p ps=6.38u w=6u l=1u
X41 VSS.t111 vin4 vout4 VSS.t110 sg13_lv_nmos ad=0.19p pd=1.38u as=0.19p ps=1.38u w=1u l=1u
X42 VDD vin3 vout3 VDD sg13_lv_pmos ad=1.14p pd=6.38u as=1.14p ps=6.38u w=6u l=1u
X43 VSS.t12 vin1 vout1 VSS.t11 sg13_lv_nmos ad=0.19p pd=1.38u as=0.19p ps=1.38u w=1u l=1u
X44 VDD vin1 vout1 VDD sg13_lv_pmos ad=1.14p pd=6.38u as=1.14p ps=6.38u w=6u l=1u
X45 vout4 vin4 VSS.t114 VSS.t115 sg13_lv_nmos ad=0.19p pd=1.38u as=0.19p ps=1.38u w=1u l=1u
X46 vout4 vin4 VDD VDD sg13_lv_pmos ad=1.14p pd=6.38u as=1.14p ps=6.38u w=6u l=1u
X47 vout1 vin1 VSS.t15 VSS.t16 sg13_lv_nmos ad=0.19p pd=1.38u as=0.19p ps=1.38u w=1u l=1u
X48 vout1 vin1 VDD VDD sg13_lv_pmos ad=1.14p pd=6.38u as=1.14p ps=6.38u w=6u l=1u
X49 VDD vin1 vout1 VDD sg13_lv_pmos ad=1.14p pd=6.38u as=1.14p ps=6.38u w=6u l=1u
X50 vout3 vin3 VSS.t49 VSS.t50 sg13_lv_nmos ad=0.19p pd=1.38u as=0.19p ps=1.38u w=1u l=1u
X51 VSS.t21 vin1 vout1 VSS.t20 sg13_lv_nmos ad=0.19p pd=1.38u as=0.19p ps=1.38u w=1u l=1u
X52 VDD VDD VDD VDD sg13_lv_pmos ad=2.04p pd=12.68u as=0 ps=0 w=6u l=1u
X53 vout4 vin4 VDD VDD sg13_lv_pmos ad=1.14p pd=6.38u as=1.14p ps=6.38u w=6u l=1u
X54 VDD vin3 vout3 VDD sg13_lv_pmos ad=1.14p pd=6.38u as=1.14p ps=6.38u w=6u l=1u
X55 VDD vin4 vout4 VDD sg13_lv_pmos ad=1.14p pd=6.38u as=1.14p ps=6.38u w=6u l=1u
X56 vout3 vin3 VSS.t43 VSS.t44 sg13_lv_nmos ad=0.19p pd=1.38u as=0.19p ps=1.38u w=1u l=1u
X57 vout3 vin3 VDD VDD sg13_lv_pmos ad=1.14p pd=6.38u as=1.14p ps=6.38u w=6u l=1u
X58 VSS.t49 vin3 vout3 VSS.t48 sg13_lv_nmos ad=0.19p pd=1.38u as=0.19p ps=1.38u w=1u l=1u
X59 VDD VDD VDD VDD sg13_lv_pmos ad=1.14p pd=6.38u as=0 ps=0 w=6u l=1u
X60 vout3 vin3 VSS.t52 VSS.t53 sg13_lv_nmos ad=0.19p pd=1.38u as=0.19p ps=1.38u w=1u l=1u
X61 vout4 vin4 VDD VDD sg13_lv_pmos ad=1.14p pd=6.38u as=1.14p ps=6.38u w=6u l=1u
X62 vout3 vin3 VDD VDD sg13_lv_pmos ad=1.14p pd=6.38u as=1.14p ps=6.38u w=6u l=1u
X63 VDD vin1 vout1 VDD sg13_lv_pmos ad=1.14p pd=6.38u as=1.14p ps=6.38u w=6u l=1u
X64 vout2 vin2 VDD VDD sg13_lv_pmos ad=1.14p pd=6.38u as=1.14p ps=6.38u w=6u l=1u
X65 vout1 vin1 VDD VDD sg13_lv_pmos ad=1.14p pd=6.38u as=1.14p ps=6.38u w=6u l=1u
X66 VDD vin1 vout1 VDD sg13_lv_pmos ad=1.14p pd=6.38u as=1.14p ps=6.38u w=6u l=1u
X67 vout2 vin2 VSS.t120 VSS.t38 sg13_lv_nmos ad=0.19p pd=1.38u as=0.19p ps=1.38u w=1u l=1u
X68 VDD vin1 vout1 VDD sg13_lv_pmos ad=1.14p pd=6.38u as=1.14p ps=6.38u w=6u l=1u
X69 VDD vin3 vout3 VDD sg13_lv_pmos ad=1.14p pd=6.38u as=1.14p ps=6.38u w=6u l=1u
X70 VSS.t43 vin3 vout3 VSS.t42 sg13_lv_nmos ad=0.19p pd=1.38u as=0.19p ps=1.38u w=1u l=1u
X71 vout3 vin3 VSS.t46 VSS.t47 sg13_lv_nmos ad=0.19p pd=1.38u as=0.19p ps=1.38u w=1u l=1u
X72 VSS.t93 vin4 vout4 VSS.t92 sg13_lv_nmos ad=0.19p pd=1.38u as=0.19p ps=1.38u w=1u l=1u
X73 VDD vin4 vout4 VDD sg13_lv_pmos ad=1.14p pd=6.38u as=1.14p ps=6.38u w=6u l=1u
X74 VSS.t52 vin3 vout3 VSS.t51 sg13_lv_nmos ad=0.19p pd=1.38u as=0.19p ps=1.38u w=1u l=1u
X75 vout4 vin4 VSS.t96 VSS.t97 sg13_lv_nmos ad=0.19p pd=1.38u as=0.19p ps=1.38u w=1u l=1u
X76 VDD vin1 vout1 VDD sg13_lv_pmos ad=1.14p pd=6.38u as=1.14p ps=6.38u w=6u l=1u
X77 vout2 vin2 VDD VDD sg13_lv_pmos ad=1.14p pd=6.38u as=1.14p ps=6.38u w=6u l=1u
X78 vout1 vin1 VDD VDD sg13_lv_pmos ad=1.14p pd=6.38u as=1.14p ps=6.38u w=6u l=1u
X79 VSS.t90 vin4 vout4 VSS.t89 sg13_lv_nmos ad=0.19p pd=1.38u as=0.19p ps=1.38u w=1u l=1u
X80 VDD VDD VDD VDD sg13_lv_pmos ad=2.04p pd=12.68u as=0 ps=0 w=6u l=1u
X81 vout2 vin2 VDD VDD sg13_lv_pmos ad=1.14p pd=6.38u as=1.14p ps=6.38u w=6u l=1u
X82 VDD vin2 vout2 VDD sg13_lv_pmos ad=1.14p pd=6.38u as=1.14p ps=6.38u w=6u l=1u
X83 VSS.t120 vin2 vout2 VSS.t36 sg13_lv_nmos ad=0.19p pd=1.38u as=0.19p ps=1.38u w=1u l=1u
X84 VSS.t102 vin4 vout4 VSS.t101 sg13_lv_nmos ad=0.19p pd=1.38u as=0.19p ps=1.38u w=1u l=1u
X85 VDD VDD VDD VDD sg13_lv_pmos ad=2.04p pd=12.68u as=0 ps=0 w=6u l=1u
X86 vout2 vin2 VDD VDD sg13_lv_pmos ad=1.14p pd=6.38u as=1.14p ps=6.38u w=6u l=1u
X87 vout2 vin2 VSS.t122 VSS.t41 sg13_lv_nmos ad=0.19p pd=1.38u as=0.19p ps=1.38u w=1u l=1u
X88 VSS.t126 vin2 vout2 VSS.t45 sg13_lv_nmos ad=0.19p pd=1.38u as=0.19p ps=1.38u w=1u l=1u
X89 vout1 vin1 VDD VDD sg13_lv_pmos ad=1.14p pd=6.38u as=1.14p ps=6.38u w=6u l=1u
X90 vout1 vin1 VSS.t6 VSS.t7 sg13_lv_nmos ad=0.19p pd=1.38u as=0.19p ps=1.38u w=1u l=1u
X91 vout4 vin4 VSS.t99 VSS.t100 sg13_lv_nmos ad=0.19p pd=1.38u as=0.19p ps=1.38u w=1u l=1u
X92 vout3 vin3 VDD VDD sg13_lv_pmos ad=1.14p pd=6.38u as=1.14p ps=6.38u w=6u l=1u
X93 vout4 vin4 VSS.t111 VSS.t112 sg13_lv_nmos ad=0.19p pd=1.38u as=0.19p ps=1.38u w=1u l=1u
X94 VSS.t81 VSS.t79 VSS.t80 VSS.t74 sg13_lv_nmos ad=0.19p pd=1.38u as=0 ps=0 w=1u l=1u
X95 VSS.t105 vin4 vout4 VSS.t104 sg13_lv_nmos ad=0.19p pd=1.38u as=0.19p ps=1.38u w=1u l=1u
X96 VDD vin1 vout1 VDD sg13_lv_pmos ad=1.14p pd=6.38u as=1.14p ps=6.38u w=6u l=1u
X97 VSS.t81 vin2 vout2 VSS.t60 sg13_lv_nmos ad=0.19p pd=1.38u as=0.19p ps=1.38u w=1u l=1u
X98 VDD vin2 vout2 VDD sg13_lv_pmos ad=1.14p pd=6.38u as=1.14p ps=6.38u w=6u l=1u
X99 vout4 vin4 VSS.t108 VSS.t109 sg13_lv_nmos ad=0.19p pd=1.38u as=0.19p ps=1.38u w=1u l=1u
X100 vout4 vin4 VDD VDD sg13_lv_pmos ad=1.14p pd=6.38u as=1.14p ps=6.38u w=6u l=1u
X101 vout2 vin2 VDD VDD sg13_lv_pmos ad=1.14p pd=6.38u as=1.14p ps=6.38u w=6u l=1u
X102 vout2 vin2 VSS.t118 VSS.t35 sg13_lv_nmos ad=0.19p pd=1.38u as=0.19p ps=1.38u w=1u l=1u
X103 VDD vin2 vout2 VDD sg13_lv_pmos ad=1.14p pd=6.38u as=1.14p ps=6.38u w=6u l=1u
X104 VSS.t122 vin2 vout2 VSS.t39 sg13_lv_nmos ad=0.19p pd=1.38u as=0.19p ps=1.38u w=1u l=1u
X105 VDD vin4 vout4 VDD sg13_lv_pmos ad=1.14p pd=6.38u as=1.14p ps=6.38u w=6u l=1u
X106 VDD VDD VDD VDD sg13_lv_pmos ad=2.04p pd=12.68u as=0 ps=0 w=6u l=1u
X107 VSS.t118 vin2 vout2 VSS.t33 sg13_lv_nmos ad=0.19p pd=1.38u as=0.19p ps=1.38u w=1u l=1u
X108 VSS.t6 vin1 vout1 VSS.t5 sg13_lv_nmos ad=0.19p pd=1.38u as=0.19p ps=1.38u w=1u l=1u
X109 vout3 vin3 VDD VDD sg13_lv_pmos ad=1.14p pd=6.38u as=1.14p ps=6.38u w=6u l=1u
X110 vout1 vin1 VSS.t9 VSS.t10 sg13_lv_nmos ad=0.19p pd=1.38u as=0.19p ps=1.38u w=1u l=1u
X111 VSS.t15 vin1 vout1 VSS.t14 sg13_lv_nmos ad=0.19p pd=1.38u as=0.19p ps=1.38u w=1u l=1u
X112 vout3 vin3 VDD VDD sg13_lv_pmos ad=1.14p pd=6.38u as=1.14p ps=6.38u w=6u l=1u
X113 VDD vin3 vout3 VDD sg13_lv_pmos ad=1.14p pd=6.38u as=1.14p ps=6.38u w=6u l=1u
X114 vout3 vin3 VDD VDD sg13_lv_pmos ad=1.14p pd=6.38u as=1.14p ps=6.38u w=6u l=1u
X115 vout3 vin3 VSS.t37 VSS.t38 sg13_lv_nmos ad=0.19p pd=1.38u as=0.19p ps=1.38u w=1u l=1u
X116 VSS.t132 vin2 vout2 VSS.t54 sg13_lv_nmos ad=0.19p pd=1.38u as=0.19p ps=1.38u w=1u l=1u
X117 vout2 vin2 VSS.t134 VSS.t59 sg13_lv_nmos ad=0.19p pd=1.38u as=0.19p ps=1.38u w=1u l=1u
X118 VSS.t69 vin4 vout4 VSS.t116 sg13_lv_nmos ad=0.19p pd=1.38u as=0.19p ps=1.38u w=1u l=1u
X119 vout1 vin1 VDD VDD sg13_lv_pmos ad=1.14p pd=6.38u as=1.14p ps=6.38u w=6u l=1u
X120 VSS.t30 VSS.t85 VSS.t87 VSS.t86 sg13_lv_nmos ad=0.19p pd=1.38u as=0 ps=0 w=1u l=1u
X121 VSS.t30 vin1 vout1 VSS.t29 sg13_lv_nmos ad=0.19p pd=1.38u as=0.19p ps=1.38u w=1u l=1u
X122 vout2 vin2 VSS.t77 VSS.t31 sg13_lv_nmos ad=0.19p pd=1.38u as=0.19p ps=1.38u w=1u l=1u
X123 VSS.t65 VSS.t62 VSS.t64 VSS.t63 sg13_lv_nmos ad=0.34p pd=2.68u as=0 ps=0 w=1u l=1u
X124 vout1 vin1 VSS.t3 VSS.t4 sg13_lv_nmos ad=0.19p pd=1.38u as=0.19p ps=1.38u w=1u l=1u
X125 VSS.t9 vin1 vout1 VSS.t8 sg13_lv_nmos ad=0.19p pd=1.38u as=0.19p ps=1.38u w=1u l=1u
X126 VDD vin3 vout3 VDD sg13_lv_pmos ad=1.14p pd=6.38u as=1.14p ps=6.38u w=6u l=1u
X127 VSS.t3 vin1 vout1 VSS.t2 sg13_lv_nmos ad=0.19p pd=1.38u as=0.19p ps=1.38u w=1u l=1u
X128 vout4 vin4 VDD VDD sg13_lv_pmos ad=1.14p pd=6.38u as=1.14p ps=6.38u w=6u l=1u
X129 vout3 vin3 VDD VDD sg13_lv_pmos ad=1.14p pd=6.38u as=1.14p ps=6.38u w=6u l=1u
X130 VDD vin3 vout3 VDD sg13_lv_pmos ad=1.14p pd=6.38u as=1.14p ps=6.38u w=6u l=1u
X131 VSS.t37 vin3 vout3 VSS.t36 sg13_lv_nmos ad=0.19p pd=1.38u as=0.19p ps=1.38u w=1u l=1u
X132 vout3 vin3 VSS.t40 VSS.t41 sg13_lv_nmos ad=0.19p pd=1.38u as=0.19p ps=1.38u w=1u l=1u
X133 vout1 vin1 VDD VDD sg13_lv_pmos ad=1.14p pd=6.38u as=1.14p ps=6.38u w=6u l=1u
X134 VSS.t134 vin2 vout2 VSS.t57 sg13_lv_nmos ad=0.19p pd=1.38u as=0.19p ps=1.38u w=1u l=1u
X135 VSS.t46 vin3 vout3 VSS.t45 sg13_lv_nmos ad=0.19p pd=1.38u as=0.19p ps=1.38u w=1u l=1u
X136 VDD vin4 vout4 VDD sg13_lv_pmos ad=1.14p pd=6.38u as=1.14p ps=6.38u w=6u l=1u
X137 vout1 vin1 VDD VDD sg13_lv_pmos ad=1.14p pd=6.38u as=1.14p ps=6.38u w=6u l=1u
X138 VDD vin1 vout1 VDD sg13_lv_pmos ad=1.14p pd=6.38u as=1.14p ps=6.38u w=6u l=1u
X139 vout4 vin4 VDD VDD sg13_lv_pmos ad=1.14p pd=6.38u as=1.14p ps=6.38u w=6u l=1u
X140 VSS.t24 vin1 vout1 VSS.t23 sg13_lv_nmos ad=0.19p pd=1.38u as=0.19p ps=1.38u w=1u l=1u
X141 vout1 vin1 VDD VDD sg13_lv_pmos ad=1.14p pd=6.38u as=1.14p ps=6.38u w=6u l=1u
X142 vout1 vin1 VSS.t27 VSS.t28 sg13_lv_nmos ad=0.19p pd=1.38u as=0.19p ps=1.38u w=1u l=1u
X143 vout2 vin2 VDD VDD sg13_lv_pmos ad=1.14p pd=6.38u as=1.14p ps=6.38u w=6u l=1u
X144 vout4 vin4 VSS.t93 VSS.t94 sg13_lv_nmos ad=0.19p pd=1.38u as=0.19p ps=1.38u w=1u l=1u
X145 VSS.t78 VSS.t76 VSS.t77 VSS.t71 sg13_lv_nmos ad=0.34p pd=2.68u as=0 ps=0 w=1u l=1u
X146 VSS.t61 VSS.t73 VSS.t75 VSS.t74 sg13_lv_nmos ad=0.19p pd=1.38u as=0 ps=0 w=1u l=1u
X147 vout4 vin4 VDD VDD sg13_lv_pmos ad=1.14p pd=6.38u as=1.14p ps=6.38u w=6u l=1u
X148 VSS.t61 vin3 vout3 VSS.t60 sg13_lv_nmos ad=0.19p pd=1.38u as=0.19p ps=1.38u w=1u l=1u
X149 VSS.t114 vin4 vout4 VSS.t113 sg13_lv_nmos ad=0.19p pd=1.38u as=0.19p ps=1.38u w=1u l=1u
X150 VDD vin4 vout4 VDD sg13_lv_pmos ad=1.14p pd=6.38u as=1.14p ps=6.38u w=6u l=1u
X151 vout1 vin1 VSS.t1 VSS.t0 sg13_lv_nmos ad=0.19p pd=1.38u as=0.19p ps=1.38u w=1u l=1u
X152 vout3 vin3 VSS.t34 VSS.t35 sg13_lv_nmos ad=0.19p pd=1.38u as=0.19p ps=1.38u w=1u l=1u
X153 VSS.t40 vin3 vout3 VSS.t39 sg13_lv_nmos ad=0.19p pd=1.38u as=0.19p ps=1.38u w=1u l=1u
X154 vout4 vin4 VDD VDD sg13_lv_pmos ad=1.14p pd=6.38u as=1.14p ps=6.38u w=6u l=1u
X155 vout2 vin2 VSS.t132 VSS.t56 sg13_lv_nmos ad=0.19p pd=1.38u as=0.19p ps=1.38u w=1u l=1u
X156 VSS.t34 vin3 vout3 VSS.t33 sg13_lv_nmos ad=0.19p pd=1.38u as=0.19p ps=1.38u w=1u l=1u
X157 VDD vin1 vout1 VDD sg13_lv_pmos ad=1.14p pd=6.38u as=1.14p ps=6.38u w=6u l=1u
X158 vout1 vin1 VDD VDD sg13_lv_pmos ad=1.14p pd=6.38u as=1.14p ps=6.38u w=6u l=1u
X159 VDD vin4 vout4 VDD sg13_lv_pmos ad=1.14p pd=6.38u as=1.14p ps=6.38u w=6u l=1u
X160 VDD vin1 vout1 VDD sg13_lv_pmos ad=1.14p pd=6.38u as=1.14p ps=6.38u w=6u l=1u
X161 VSS.t27 vin1 vout1 VSS.t26 sg13_lv_nmos ad=0.19p pd=1.38u as=0.19p ps=1.38u w=1u l=1u
X162 VDD vin2 vout2 VDD sg13_lv_pmos ad=1.14p pd=6.38u as=1.14p ps=6.38u w=6u l=1u
X163 vout2 vin2 VDD VDD sg13_lv_pmos ad=1.14p pd=6.38u as=1.14p ps=6.38u w=6u l=1u
X164 VDD vin2 vout2 VDD sg13_lv_pmos ad=1.14p pd=6.38u as=1.14p ps=6.38u w=6u l=1u
X165 VSS.t55 vin3 vout3 VSS.t54 sg13_lv_nmos ad=0.19p pd=1.38u as=0.19p ps=1.38u w=1u l=1u
X166 vout3 vin3 VSS.t58 VSS.t59 sg13_lv_nmos ad=0.19p pd=1.38u as=0.19p ps=1.38u w=1u l=1u
X167 VDD VDD VDD VDD sg13_lv_pmos ad=1.14p pd=6.38u as=0 ps=0 w=6u l=1u
X168 VSS.t84 VSS.t82 VSS.t1 VSS.t83 sg13_lv_nmos ad=0.34p pd=2.68u as=0 ps=0 w=1u l=1u
X169 VDD vin4 vout4 VDD sg13_lv_pmos ad=1.14p pd=6.38u as=1.14p ps=6.38u w=6u l=1u
X170 VDD VDD VDD VDD sg13_lv_pmos ad=1.14p pd=6.38u as=0 ps=0 w=6u l=1u
X171 vout2 vin2 VSS.t128 VSS.t50 sg13_lv_nmos ad=0.19p pd=1.38u as=0.19p ps=1.38u w=1u l=1u
X172 vout3 vin3 VDD VDD sg13_lv_pmos ad=1.14p pd=6.38u as=1.14p ps=6.38u w=6u l=1u
X173 vout4 vin4 VSS.t90 VSS.t91 sg13_lv_nmos ad=0.19p pd=1.38u as=0.19p ps=1.38u w=1u l=1u
X174 vout3 vin3 VSS.t32 VSS.t31 sg13_lv_nmos ad=0.19p pd=1.38u as=0.19p ps=1.38u w=1u l=1u
X175 vout2 vin2 VSS.t124 VSS.t44 sg13_lv_nmos ad=0.19p pd=1.38u as=0.19p ps=1.38u w=1u l=1u
R0 VSS.n85 VSS.n107 6777.49
R1 VSS.n46 VSS.n374 6777.49
R2 VSS.n55 VSS.n107 6777.49
R3 VSS.n374 VSS.n373 1580.41
R4 VSS.n372 VSS.n107 1580.41
R5 VSS.n373 VSS.n35 1.53604
R6 VSS.t31 VSS.n122 88.7251
R7 VSS.t60 VSS.n109 88.7251
R8 VSS.n207 VSS.t33 83.1798
R9 VSS.n110 VSS.t59 83.1798
R10 VSS.t35 VSS.n204 77.6345
R11 VSS.n111 VSS.t57 77.6345
R12 VSS.t63 VSS.n86 6.87896
R13 VSS.n82 VSS.t116 11.4002
R14 VSS.t36 VSS.n123 72.0892
R15 VSS.n278 VSS.t56 72.0892
R16 VSS.t116 VSS.n81 68.3206
R17 VSS.t38 VSS.n124 66.5439
R18 VSS.t54 VSS.n112 66.5439
R19 VSS.t115 VSS.n80 64.5255
R20 VSS.n63 VSS.t89 64.5209
R21 VSS.n196 VSS.t39 60.9987
R22 VSS.n113 VSS.t53 60.9987
R23 VSS.t113 VSS.n79 60.7305
R24 VSS.n65 VSS.t91 60.7259
R25 VSS.t29 VSS.n49 68.3172
R26 VSS.t112 VSS.n78 56.9354
R27 VSS.n66 VSS.t92 56.9308
R28 VSS.t41 VSS.n125 55.4534
R29 VSS.t45 VSS.n116 55.4534
R30 VSS.t47 VSS.n128 55.4534
R31 VSS.n265 VSS.t51 55.4534
R32 VSS.t110 VSS.n77 53.1403
R33 VSS.n67 VSS.t94 53.1357
R34 VSS.t42 VSS.n126 49.9081
R35 VSS.n117 VSS.t44 49.9081
R36 VSS.t48 VSS.n129 49.9081
R37 VSS.t50 VSS.n114 49.9081
R38 VSS.t109 VSS.n76 49.3453
R39 VSS.n68 VSS.t95 49.3407
R40 VSS.t107 VSS.n75 45.5502
R41 VSS.t101 VSS.n71 45.5502
R42 VSS.n73 VSS.t103 45.5456
R43 VSS.n69 VSS.t97 45.5456
R44 VSS.n118 VSS.t42 44.3628
R45 VSS.t44 VSS.n127 44.3628
R46 VSS.n115 VSS.t48 44.3628
R47 VSS.n171 VSS.t50 44.3628
R48 VSS.t106 VSS.n74 41.7551
R49 VSS.t100 VSS.n70 41.7551
R50 VSS.n74 VSS.t104 41.7505
R51 VSS.n70 VSS.t98 41.7505
R52 VSS.n241 VSS.t41 38.8175
R53 VSS.n184 VSS.t45 38.8175
R54 VSS.n259 VSS.t47 38.8175
R55 VSS.t51 VSS.n130 38.8175
R56 VSS.t104 VSS.n73 37.9601
R57 VSS.t98 VSS.n69 37.9601
R58 VSS.n75 VSS.t106 37.9555
R59 VSS.n71 VSS.t100 37.9555
R60 VSS.t14 VSS.n39 45.5468
R61 VSS.t103 VSS.n72 34.1682
R62 VSS.t97 VSS.n68 34.165
R63 VSS.n72 VSS.t101 34.1635
R64 VSS.n76 VSS.t107 34.1604
R65 VSS.t13 VSS.n50 41.7518
R66 VSS.t19 VSS.n40 41.7518
R67 VSS.t39 VSS.n119 33.2722
R68 VSS.t53 VSS.n131 33.2722
R69 VSS.t95 VSS.n67 30.3699
R70 VSS.n77 VSS.t109 30.3653
R71 VSS.t17 VSS.n44 37.9567
R72 VSS.n120 VSS.t38 27.7269
R73 VSS.n165 VSS.t54 27.7269
R74 VSS.t94 VSS.n66 26.5749
R75 VSS.n78 VSS.t110 26.5703
R76 VSS.t10 VSS.n54 34.1616
R77 VSS.t16 VSS.n58 34.1642
R78 VSS.t92 VSS.n65 22.7798
R79 VSS.n79 VSS.t112 22.7752
R80 VSS.t8 VSS.n45 30.3673
R81 VSS.t86 VSS.n60 13.7582
R82 VSS.t83 VSS.n48 13.7582
R83 VSS.n53 VSS.t0 68.3166
R84 VSS.n45 VSS.t7 53.1364
R85 VSS.t22 VSS.n41 49.3429
R86 VSS.n230 VSS.t36 22.1816
R87 VSS.t56 VSS.n132 22.1816
R88 VSS.t91 VSS.n63 18.9847
R89 VSS.n80 VSS.t113 18.9801
R90 VSS.t29 VSS.n60 11.3996
R91 VSS.t28 VSS.n49 15.1866
R92 VSS.n52 VSS.n37 0.0109013
R93 VSS.t25 VSS.n51 22.7768
R94 VSS.n57 VSS.n37 0.0109013
R95 VSS.t22 VSS.n42 30.3669
R96 VSS.n41 VSS.n37 0.0108886
R97 VSS.t19 VSS.n59 37.957
R98 VSS.t17 VSS.n40 41.7521
R99 VSS.n44 VSS.n37 0.0109013
R100 VSS.t16 VSS.n44 45.5472
R101 VSS.t14 VSS.n58 34.1655
R102 VSS.n50 VSS.n37 0.0109013
R103 VSS.t11 VSS.n50 41.7521
R104 VSS.t10 VSS.n38 45.5472
R105 VSS.n54 VSS.n37 0.0109013
R106 VSS.t8 VSS.n54 49.3422
R107 VSS.n45 VSS.n37 0.0111485
R108 VSS.t5 VSS.n47 56.9324
R109 VSS.n56 VSS.n37 0.0109013
R110 VSS.t4 VSS.n56 60.7274
R111 VSS.n53 VSS.n37 0.0111485
R112 VSS.t85 VSS.n105 0.008067
R113 VSS.n37 VSS.n105 8.49747
R114 VSS.n380 VSS.n37 17.0005
R115 VSS.n37 VSS.n135 17.0005
R116 VSS.t30 VSS.n379 17.0005
R117 VSS.t30 VSS.n385 17.0005
R118 VSS.n386 VSS.t30 17.0005
R119 VSS.n379 VSS.t87 17.0005
R120 VSS.n385 VSS.t87 17.0005
R121 VSS.n386 VSS.t87 17.0005
R122 VSS.n37 VSS.n61 0.0104944
R123 VSS.n375 VSS.n37 17.0005
R124 VSS.n37 VSS.n378 17.0005
R125 VSS.n37 VSS.n106 17.0005
R126 VSS.n377 VSS.t84 17.0005
R127 VSS.t84 VSS.n143 17.0005
R128 VSS.t84 VSS.n376 17.0005
R129 VSS.n377 VSS.t1 17.0005
R130 VSS.t1 VSS.n143 17.0005
R131 VSS.n376 VSS.t1 17.0005
R132 VSS.n0 VSS.n8 0.650675
R133 VSS.n8 VSS.n288 14.4044
R134 VSS.n0 VSS.n3 0.650675
R135 VSS.n3 VSS.n286 14.4044
R136 VSS.n0 VSS.n285 17.0005
R137 VSS.n34 VSS.t74 6.69134
R138 VSS.n0 VSS.n13 0.650675
R139 VSS.n13 VSS.n150 7.20256
R140 VSS.n0 VSS.n109 8.49992
R141 VSS.n17 VSS.n281 14.4044
R142 VSS.n0 VSS.n110 8.49967
R143 VSS.n0 VSS.n30 0.650675
R144 VSS.n0 VSS.n102 8.49879
R145 VSS.n30 VSS.n280 14.4044
R146 VSS.n0 VSS.n111 8.49901
R147 VSS.n0 VSS.n18 0.650675
R148 VSS.n18 VSS.n279 14.4044
R149 VSS.n19 VSS.n278 7.20256
R150 VSS.n0 VSS.n93 17.0005
R151 VSS.n0 VSS.n24 0.650675
R152 VSS.n24 VSS.n165 7.20256
R153 VSS.n0 VSS.n112 8.49942
R154 VSS.n0 VSS.n20 0.650675
R155 VSS.n20 VSS.n272 14.4044
R156 VSS.n29 VSS.n167 14.4044
R157 VSS.n0 VSS.n29 0.650675
R158 VSS.n0 VSS.n267 17.0005
R159 VSS.n28 VSS.n265 7.20256
R160 VSS.n0 VSS.n28 0.650675
R161 VSS.n0 VSS.n11 0.650675
R162 VSS.n11 VSS.n171 7.20256
R163 VSS.n0 VSS.n114 8.50017
R164 VSS.n0 VSS.n176 17.0005
R165 VSS.n2 VSS.n263 14.4044
R166 VSS.n0 VSS.n262 17.0005
R167 VSS.n0 VSS.n129 8.49917
R168 VSS.n0 VSS.n21 0.650675
R169 VSS.n21 VSS.n260 14.4044
R170 VSS.n0 VSS.n128 8.49774
R171 VSS.n0 VSS.n25 0.650675
R172 VSS.n25 VSS.n258 14.6203
R173 VSS.n0 VSS.n95 17.0005
R174 VSS.n0 VSS.n12 0.650675
R175 VSS.n0 VSS.n96 17.0005
R176 VSS.n12 VSS.n184 7.20256
R177 VSS.n0 VSS.n185 17.0005
R178 VSS.n0 VSS.n116 8.49892
R179 VSS.n0 VSS.n33 0.650675
R180 VSS.n33 VSS.n253 14.4044
R181 VSS.n0 VSS.n252 17.0005
R182 VSS.n0 VSS.n117 8.49867
R183 VSS.n0 VSS.n190 17.0005
R184 VSS.n5 VSS.n250 14.4044
R185 VSS.n0 VSS.n249 17.0005
R186 VSS.n0 VSS.n191 17.0005
R187 VSS.n16 VSS.n244 14.4044
R188 VSS.n0 VSS.n243 17.0005
R189 VSS.n0 VSS.n125 8.49842
R190 VSS.n27 VSS.n240 14.4044
R191 VSS.n0 VSS.n195 17.0005
R192 VSS.n0 VSS.n26 0.650675
R193 VSS.n0 VSS.n239 17.0005
R194 VSS.n26 VSS.n196 7.20256
R195 VSS.n0 VSS.n197 17.0005
R196 VSS.n14 VSS.n234 14.4044
R197 VSS.n0 VSS.n233 17.0005
R198 VSS.n0 VSS.n124 8.49817
R199 VSS.n0 VSS.n120 8.49793
R200 VSS.n0 VSS.n22 0.650675
R201 VSS.n22 VSS.n231 14.4044
R202 VSS.n0 VSS.n88 8.49909
R203 VSS.n32 VSS.n229 14.4044
R204 VSS.n0 VSS.n10 0.650675
R205 VSS.n10 VSS.n204 7.20256
R206 VSS.n0 VSS.n31 0.650675
R207 VSS.n31 VSS.n227 14.4044
R208 VSS.n0 VSS.n23 0.650675
R209 VSS.n0 VSS.n98 8.49879
R210 VSS.n23 VSS.n207 7.20256
R211 VSS.n0 VSS.n121 8.49768
R212 VSS.n0 VSS.n9 0.650675
R213 VSS.n0 VSS.n211 17.0005
R214 VSS.n9 VSS.n226 14.4044
R215 VSS.n0 VSS.n122 8.49743
R216 VSS.n7 VSS.n222 7.20256
R217 VSS.n0 VSS.n6 0.650675
R218 VSS.n0 VSS.n218 17.0005
R219 VSS.n6 VSS.n216 14.4044
R220 VSS.n15 VSS.t71 7.20256
R221 VSS.n0 VSS.n214 17.0005
R222 VSS.n0 VSS.n1 0.650675
R223 VSS.n0 VSS.n35 0.13961
R224 VSS.n0 VSS.n4 0.00994878
R225 VSS.n0 VSS.n134 8.49997
R226 VSS.n0 VSS.n133 8.50037
R227 VSS.n0 VSS.n132 8.5
R228 VSS.n0 VSS.n131 8.49728
R229 VSS.n0 VSS.n113 8.49924
R230 VSS.n0 VSS.n130 8.50042
R231 VSS.n0 VSS.n115 8.49988
R232 VSS.n0 VSS.n127 8.50226
R233 VSS.n0 VSS.n126 8.50013
R234 VSS.n0 VSS.n118 8.50056
R235 VSS.n0 VSS.n119 8.50053
R236 VSS.n0 VSS.n123 8.50032
R237 VSS.n91 VSS.n144 17.0005
R238 VSS.n291 VSS.n144 17.0005
R239 VSS.n255 VSS.n144 17.0005
R240 VSS.n251 VSS.n144 17.0005
R241 VSS.n246 VSS.n144 17.0005
R242 VSS.n242 VSS.n144 17.0005
R243 VSS.n236 VSS.n144 17.0005
R244 VSS.n232 VSS.n144 17.0005
R245 VSS.n224 VSS.n144 17.0005
R246 VSS.n217 VSS.n144 17.0005
R247 VSS.n85 VSS.n334 17.0005
R248 VSS.n85 VSS.n323 17.0005
R249 VSS.n85 VSS.n322 17.0005
R250 VSS.n85 VSS.n311 17.0005
R251 VSS.n85 VSS.n310 17.0005
R252 VSS.n85 VSS.n309 17.0005
R253 VSS.n321 VSS.t69 17.0005
R254 VSS.t69 VSS.n319 17.0005
R255 VSS.t69 VSS.n320 17.0005
R256 VSS.n321 VSS.t68 17.0005
R257 VSS.n319 VSS.t68 17.0005
R258 VSS.n320 VSS.t68 17.0005
R259 VSS.t65 VSS.n332 17.0005
R260 VSS.t65 VSS.n331 17.0005
R261 VSS.n333 VSS.t65 17.0005
R262 VSS.n332 VSS.t64 17.0005
R263 VSS.n331 VSS.t64 17.0005
R264 VSS.n333 VSS.t64 17.0005
R265 VSS.n228 VSS.t35 16.6364
R266 VSS.t57 VSS.n133 16.6364
R267 VSS.t89 VSS.n62 15.1993
R268 VSS.n81 VSS.t115 15.1851
R269 VSS.t5 VSS.n56 22.7764
R270 VSS.t76 VSS.n344 15.0005
R271 VSS.n354 VSS.t70 15.0005
R272 VSS.n367 VSS.t73 15.0005
R273 VSS.n347 VSS.t79 15.0005
R274 VSS.n34 VSS.n283 13.3823
R275 VSS.n174 VSS.n2 14.4051
R276 VSS.n192 VSS.n16 14.4051
R277 VSS.n198 VSS.n14 14.4051
R278 VSS.n1 VSS.n145 14.4051
R279 VSS.n146 VSS.n15 14.4051
R280 VSS.n219 VSS.n7 14.4051
R281 VSS.n228 VSS.n31 7.20324
R282 VSS.n230 VSS.n32 7.20324
R283 VSS.n241 VSS.n27 7.20324
R284 VSS.n259 VSS.n25 7.20324
R285 VSS.n264 VSS.n28 14.4051
R286 VSS.n268 VSS.n29 14.4051
R287 VSS.n277 VSS.n19 14.4051
R288 VSS.n36 VSS.n283 13.3823
R289 VSS.t88 VSS.n62 9.77299
R290 VSS.t4 VSS.n43 18.9814
R291 VSS.t26 VSS.n51 60.7271
R292 VSS.t23 VSS.n42 53.1369
R293 VSS.t20 VSS.n59 45.5468
R294 VSS.t11 VSS.n38 37.9567
R295 VSS.t7 VSS.n47 26.5715
R296 VSS.n46 VSS.t83 13.76
R297 VSS.n43 VSS.t2 64.5232
R298 VSS.n39 VSS.t13 37.9577
R299 VSS.n41 VSS.t20 34.1616
R300 VSS.n57 VSS.t23 26.5715
R301 VSS.n52 VSS.t26 18.9814
R302 VSS.t33 VSS.n121 11.0911
R303 VSS.t59 VSS.n134 11.0911
R304 VSS.n283 VSS.n144 8.5005
R305 VSS.n278 VSS.n144 8.5005
R306 VSS.n265 VSS.n144 8.5005
R307 VSS.n259 VSS.n144 8.5005
R308 VSS.n241 VSS.n144 8.5005
R309 VSS.n230 VSS.n144 8.5005
R310 VSS.n228 VSS.n144 8.5005
R311 VSS.n222 VSS.n144 8.5005
R312 VSS.n150 VSS.n144 8.5005
R313 VSS.n165 VSS.n144 8.5005
R314 VSS.n171 VSS.n144 8.5005
R315 VSS.n184 VSS.n144 8.5005
R316 VSS.n196 VSS.n144 8.5005
R317 VSS.n204 VSS.n144 8.5005
R318 VSS.n207 VSS.n144 8.5005
R319 VSS.n0 VSS.n147 8.4984
R320 VSS.n0 VSS.n149 8.4984
R321 VSS.n0 VSS.n152 8.4984
R322 VSS.n0 VSS.n155 8.4984
R323 VSS.n0 VSS.n157 8.4984
R324 VSS.n0 VSS.n159 8.4984
R325 VSS.n0 VSS.n162 8.4984
R326 VSS.n0 VSS.n164 8.4984
R327 VSS.n0 VSS.n276 8.4984
R328 VSS.n0 VSS.n274 8.4984
R329 VSS.n0 VSS.n271 8.4984
R330 VSS.n0 VSS.n269 8.4984
R331 VSS.n0 VSS.n168 8.4984
R332 VSS.n0 VSS.n170 8.4984
R333 VSS.n0 VSS.n173 8.4984
R334 VSS.n0 VSS.n177 8.4984
R335 VSS.n0 VSS.n180 8.4984
R336 VSS.n0 VSS.n182 8.4984
R337 VSS.n0 VSS.n256 8.4984
R338 VSS.n0 VSS.n187 8.4984
R339 VSS.n0 VSS.n247 8.4984
R340 VSS.n0 VSS.n193 8.4984
R341 VSS.n0 VSS.n237 8.4984
R342 VSS.n0 VSS.n199 8.4984
R343 VSS.n0 VSS.n201 8.4984
R344 VSS.n0 VSS.n203 8.4984
R345 VSS.n0 VSS.n206 8.4984
R346 VSS.n0 VSS.n208 8.4984
R347 VSS.n0 VSS.n225 8.4984
R348 VSS.n0 VSS.n221 8.4984
R349 VSS.n0 VSS.n212 8.4984
R350 VSS.n284 VSS.n144 8.4984
R351 VSS.n148 VSS.n144 8.4984
R352 VSS.n151 VSS.n144 8.4984
R353 VSS.n154 VSS.n144 8.4984
R354 VSS.n156 VSS.n144 8.4984
R355 VSS.n103 VSS.n144 8.4984
R356 VSS.n101 VSS.n144 8.4984
R357 VSS.n161 VSS.n144 8.4984
R358 VSS.n163 VSS.n144 8.4984
R359 VSS.n92 VSS.n144 8.4984
R360 VSS.n275 VSS.n144 8.4984
R361 VSS.n273 VSS.n144 8.4984
R362 VSS.n270 VSS.n144 8.4984
R363 VSS.n266 VSS.n144 8.4984
R364 VSS.n169 VSS.n144 8.4984
R365 VSS.n172 VSS.n144 8.4984
R366 VSS.n175 VSS.n144 8.4984
R367 VSS.n261 VSS.n144 8.4984
R368 VSS.n179 VSS.n144 8.4984
R369 VSS.n181 VSS.n144 8.4984
R370 VSS.n183 VSS.n144 8.4984
R371 VSS.n257 VSS.n144 8.4984
R372 VSS.n254 VSS.n144 8.4984
R373 VSS.n189 VSS.n144 8.4984
R374 VSS.n248 VSS.n144 8.4984
R375 VSS.n245 VSS.n144 8.4984
R376 VSS.n194 VSS.n144 8.4984
R377 VSS.n238 VSS.n144 8.4984
R378 VSS.n235 VSS.n144 8.4984
R379 VSS.n87 VSS.n144 8.4984
R380 VSS.n89 VSS.n144 8.4984
R381 VSS.n202 VSS.n144 8.4984
R382 VSS.n205 VSS.n144 8.4984
R383 VSS.n97 VSS.n144 8.4984
R384 VSS.n99 VSS.n144 8.4984
R385 VSS.n210 VSS.n144 8.4984
R386 VSS.n223 VSS.n144 8.4984
R387 VSS.n220 VSS.n144 8.4984
R388 VSS.n213 VSS.n144 8.4984
R389 VSS.n371 VSS.n8 14.8738
R390 VSS.n82 VSS.t67 6.87897
R391 VSS.n85 VSS.n86 0.00129054
R392 VSS.t2 VSS.n53 15.187
R393 VSS.n351 VSS.t76 7.49606
R394 VSS.t70 VSS.n343 7.49606
R395 VSS.t73 VSS.n366 7.49606
R396 VSS.t79 VSS.n346 7.49606
R397 VSS.n12 VSS.n258 14.6209
R398 VSS.n153 VSS.n109 7.20236
R399 VSS.n158 VSS.n110 7.20236
R400 VSS.n160 VSS.n111 7.20236
R401 VSS.n166 VSS.n112 7.20236
R402 VSS.n178 VSS.n115 7.20236
R403 VSS.n186 VSS.n116 7.20236
R404 VSS.n188 VSS.n117 7.20236
R405 VSS.n200 VSS.n120 7.20236
R406 VSS.n209 VSS.n121 7.20236
R407 VSS.t71 VSS.n216 7.20236
R408 VSS.n145 VSS.n35 14.873
R409 VSS.n286 VSS.t74 7.20236
R410 VSS.n282 VSS.n36 13.8932
R411 VSS.n268 VSS.n130 7.20236
R412 VSS.n263 VSS.n129 7.20236
R413 VSS.n244 VSS.n125 7.20236
R414 VSS.n1 VSS.n146 14.4044
R415 VSS.n6 VSS.n219 14.4051
R416 VSS.n226 VSS.n122 7.20236
R417 VSS.n9 VSS.n209 14.4051
R418 VSS.n23 VSS.n227 14.4051
R419 VSS.n10 VSS.n229 14.4051
R420 VSS.n231 VSS.n123 7.20236
R421 VSS.n22 VSS.n200 14.4051
R422 VSS.n234 VSS.n124 7.20236
R423 VSS.n198 VSS.n119 7.20236
R424 VSS.n26 VSS.n240 14.4051
R425 VSS.n192 VSS.n118 7.20236
R426 VSS.n250 VSS.n126 7.20236
R427 VSS.n5 VSS.n188 14.4051
R428 VSS.n253 VSS.n127 7.20236
R429 VSS.n33 VSS.n186 14.4051
R430 VSS.n260 VSS.n128 7.20236
R431 VSS.n21 VSS.n178 14.4051
R432 VSS.n174 VSS.n114 7.20236
R433 VSS.n11 VSS.n264 14.4051
R434 VSS.n167 VSS.n113 7.20236
R435 VSS.n272 VSS.n131 7.20236
R436 VSS.n20 VSS.n166 14.4051
R437 VSS.n24 VSS.n277 14.4051
R438 VSS.n279 VSS.n132 7.20236
R439 VSS.n18 VSS.n160 14.4051
R440 VSS.n280 VSS.n133 7.20236
R441 VSS.n30 VSS.n158 14.4051
R442 VSS.n281 VSS.n134 7.20236
R443 VSS.n17 VSS.n153 14.4051
R444 VSS.n13 VSS.n282 14.4051
R445 VSS.n288 VSS.n3 14.4051
R446 VSS.n409 VSS.n408 5.97525
R447 VSS.n408 VSS.n138 5.97525
R448 VSS.n336 VSS.n297 5.97525
R449 VSS.n337 VSS.n336 5.97525
R450 VSS.n372 VSS.n0 1.69999
R451 VSS.n222 VSS.t31 5.54579
R452 VSS.n150 VSS.t60 5.54579
R453 VSS.n352 VSS.t77 4.5005
R454 VSS.t32 VSS.n342 4.5005
R455 VSS.n348 VSS.t81 4.5005
R456 VSS.n370 VSS.t61 4.5005
R457 VSS.n215 VSS.n144 4.25219
R458 VSS.n0 VSS.n287 4.25206
R459 VSS.n287 VSS.n144 4.25175
R460 VSS.n0 VSS.n215 4.25169
R461 VSS.t0 VSS.n48 11.3996
R462 VSS.n384 VSS.t85 3.0005
R463 VSS.n404 VSS.t82 3.0005
R464 VSS.n318 VSS.t66 3.0005
R465 VSS.n330 VSS.t62 3.0005
R466 VSS.n350 VSS.n341 3.0005
R467 VSS.n356 VSS.n355 3.0005
R468 VSS.n345 VSS.n290 3.0005
R469 VSS.n369 VSS.n368 3.0005
R470 VSS.n294 VSS.n137 2.98787
R471 VSS.n294 VSS.n338 2.98787
R472 VSS.t28 VSS.n52 64.5225
R473 VSS.t25 VSS.n57 56.9324
R474 VSS.n55 VSS.n37 0.00104471
R475 VSS.n55 VSS.t86 13.761
R476 VSS.n37 VSS.n60 0.00289146
R477 VSS.n37 VSS.n49 0.0109013
R478 VSS.n37 VSS.n51 0.0109013
R479 VSS.n37 VSS.n42 0.0109013
R480 VSS.n37 VSS.n59 0.0109013
R481 VSS.n37 VSS.n40 0.0109013
R482 VSS.n37 VSS.n39 0.0108886
R483 VSS.n37 VSS.n38 0.0109013
R484 VSS.n37 VSS.n47 0.0109013
R485 VSS.n37 VSS.n43 0.0108886
R486 VSS.n48 VSS.n37 0.00289146
R487 VSS.n46 VSS.n37 0.0010491
R488 VSS.n337 VSS.n296 2.71193
R489 VSS.n411 VSS.n136 2.6297
R490 VSS.n58 VSS.n37 0.00957226
R491 VSS.n317 VSS.t114 2.48177
R492 VSS.n315 VSS.t111 2.48177
R493 VSS.n314 VSS.t108 2.48177
R494 VSS.t105 VSS.n298 2.48177
R495 VSS.t99 VSS.n299 2.48177
R496 VSS.n327 VSS.t96 2.48177
R497 VSS.n328 VSS.t93 2.48177
R498 VSS.n329 VSS.t90 2.48177
R499 VSS.n358 VSS.t118 2.48177
R500 VSS.n359 VSS.t120 2.48177
R501 VSS.n360 VSS.t122 2.48177
R502 VSS.n295 VSS.t124 2.48177
R503 VSS.n361 VSS.t128 2.48177
R504 VSS.n362 VSS.t130 2.48177
R505 VSS.n363 VSS.t132 2.48177
R506 VSS.n364 VSS.t134 2.48177
R507 VSS.n405 VSS.t3 2.48177
R508 VSS.n406 VSS.t6 2.48177
R509 VSS.n407 VSS.t9 2.48177
R510 VSS.n142 VSS.t12 2.48177
R511 VSS.t18 VSS.n141 2.48177
R512 VSS.n381 VSS.t21 2.48177
R513 VSS.n382 VSS.t24 2.48177
R514 VSS.n383 VSS.t27 2.48177
R515 VSS.n358 VSS.t34 2.48177
R516 VSS.n359 VSS.t37 2.48177
R517 VSS.n360 VSS.t40 2.48177
R518 VSS.n295 VSS.t43 2.48177
R519 VSS.n361 VSS.t49 2.48177
R520 VSS.n362 VSS.t52 2.48177
R521 VSS.n363 VSS.t55 2.48177
R522 VSS.n364 VSS.t58 2.48177
R523 VSS.n0 VSS.n36 1.20771
R524 VSS.n0 VSS.n34 1.20771
R525 VSS.n0 VSS.n17 0.650675
R526 VSS.n0 VSS.n19 0.650675
R527 VSS.n0 VSS.n2 0.650675
R528 VSS.n0 VSS.n5 0.650675
R529 VSS.n0 VSS.n16 0.650675
R530 VSS.n0 VSS.n27 0.650675
R531 VSS.n0 VSS.n14 0.650675
R532 VSS.n0 VSS.n32 0.650675
R533 VSS.n0 VSS.n7 0.650675
R534 VSS.n0 VSS.n15 0.650675
R535 VSS.t78 VSS.n352 2.2505
R536 VSS.t72 VSS.n342 2.2505
R537 VSS.t80 VSS.n348 2.2505
R538 VSS.t75 VSS.n370 2.2505
R539 VSS.n389 VSS.n37 2.09947
R540 VSS.n391 VSS.n37 2.09947
R541 VSS.n393 VSS.n37 2.09947
R542 VSS.n139 VSS.n37 2.09947
R543 VSS.n395 VSS.n37 2.09947
R544 VSS.n397 VSS.n37 2.09947
R545 VSS.n399 VSS.n37 2.09947
R546 VSS.n401 VSS.n37 2.09947
R547 VSS.n335 VSS.n85 2.09868
R548 VSS.n85 VSS.n307 2.09868
R549 VSS.n85 VSS.n308 2.09868
R550 VSS.n85 VSS.n303 2.09862
R551 VSS.n85 VSS.n108 2.09862
R552 VSS.n85 VSS.n302 2.09857
R553 VSS.n85 VSS.n304 2.09849
R554 VSS.n85 VSS.n306 2.09849
R555 VSS.n373 VSS.n144 1.7005
R556 VSS.n372 VSS.n371 1.53502
R557 VSS.n404 VSS.n143 1.52811
R558 VSS.n319 VSS.n318 1.52811
R559 VSS.n331 VSS.n330 1.52811
R560 VSS.n385 VSS.n384 1.52811
R561 VSS.n332 VSS.n84 1.42216
R562 VSS.n84 VSS.n321 1.37855
R563 VSS.t78 VSS.n349 1.12521
R564 VSS.n349 VSS.t80 1.03559
R565 VSS.n387 VSS.n37 0.96569
R566 VSS.n403 VSS.n37 0.91152
R567 VSS.n85 VSS.n64 0.910334
R568 VSS.n85 VSS.n83 0.909148
R569 VSS.n286 VSS.n144 0.650322
R570 VSS.n282 VSS.n144 0.650322
R571 VSS.n277 VSS.n144 0.650322
R572 VSS.n167 VSS.n144 0.650322
R573 VSS.n268 VSS.n144 0.650322
R574 VSS.n264 VSS.n144 0.650322
R575 VSS.n174 VSS.n144 0.650322
R576 VSS.n263 VSS.n144 0.650322
R577 VSS.n192 VSS.n144 0.650322
R578 VSS.n244 VSS.n144 0.650322
R579 VSS.n240 VSS.n144 0.650322
R580 VSS.n198 VSS.n144 0.650322
R581 VSS.n229 VSS.n144 0.650322
R582 VSS.n227 VSS.n144 0.650322
R583 VSS.n219 VSS.n144 0.650322
R584 VSS.n146 VSS.n144 0.650322
R585 VSS.n288 VSS.n144 0.650322
R586 VSS.n153 VSS.n144 0.650322
R587 VSS.n281 VSS.n144 0.650322
R588 VSS.n158 VSS.n144 0.650322
R589 VSS.n280 VSS.n144 0.650322
R590 VSS.n160 VSS.n144 0.650322
R591 VSS.n279 VSS.n144 0.650322
R592 VSS.n166 VSS.n144 0.650322
R593 VSS.n272 VSS.n144 0.650322
R594 VSS.n178 VSS.n144 0.650322
R595 VSS.n260 VSS.n144 0.650322
R596 VSS.n186 VSS.n144 0.650322
R597 VSS.n253 VSS.n144 0.650322
R598 VSS.n188 VSS.n144 0.650322
R599 VSS.n250 VSS.n144 0.650322
R600 VSS.n234 VSS.n144 0.650322
R601 VSS.n200 VSS.n144 0.650322
R602 VSS.n231 VSS.n144 0.650322
R603 VSS.n209 VSS.n144 0.650322
R604 VSS.n226 VSS.n144 0.650322
R605 VSS.n216 VSS.n144 0.650322
R606 VSS.n145 VSS.n144 0.650322
R607 VSS.n297 VSS.n296 0.632727
R608 VSS.n411 VSS.n410 0.5505
R609 VSS.n258 VSS.n144 0.542397
R610 VSS.n409 VSS.n137 0.2444
R611 VSS.n297 VSS.n137 0.2444
R612 VSS.n338 VSS.n138 0.2444
R613 VSS.n338 VSS.n337 0.2444
R614 VSS.n405 VSS.n404 0.209825
R615 VSS.n318 VSS.n317 0.209825
R616 VSS.n330 VSS.n329 0.209825
R617 VSS.n384 VSS.n383 0.209825
R618 VSS.n402 VSS.t3 0.200997
R619 VSS.n400 VSS.t6 0.200997
R620 VSS.n398 VSS.t9 0.200997
R621 VSS.n396 VSS.t12 0.200997
R622 VSS.n394 VSS.t18 0.200997
R623 VSS.n392 VSS.t21 0.200997
R624 VSS.n390 VSS.t24 0.200997
R625 VSS.n388 VSS.t27 0.200997
R626 VSS.n100 VSS.t34 0.200997
R627 VSS.n90 VSS.t37 0.200997
R628 VSS.n340 VSS.t40 0.200997
R629 VSS.n339 VSS.t43 0.200997
R630 VSS.n293 VSS.t49 0.200997
R631 VSS.n292 VSS.t52 0.200997
R632 VSS.n93 VSS.t55 0.200997
R633 VSS.n104 VSS.t58 0.200997
R634 VSS.t114 VSS.n316 0.200995
R635 VSS.t111 VSS.n312 0.200995
R636 VSS.t108 VSS.n313 0.200995
R637 VSS.n305 VSS.t105 0.200995
R638 VSS.n301 VSS.t99 0.200995
R639 VSS.t96 VSS.n326 0.200995
R640 VSS.t93 VSS.n325 0.200995
R641 VSS.t90 VSS.n324 0.200995
R642 VSS.t118 VSS.n100 0.200995
R643 VSS.t120 VSS.n90 0.200995
R644 VSS.t122 VSS.n340 0.200995
R645 VSS.t124 VSS.n339 0.200995
R646 VSS.t128 VSS.n293 0.200995
R647 VSS.t130 VSS.n292 0.200995
R648 VSS.t132 VSS.n93 0.200995
R649 VSS.t134 VSS.n104 0.200995
R650 VSS.n61 VSS.n376 1.42711
R651 VSS.t46 VSS.t126 0.185126
R652 VSS.n406 VSS.n405 0.16242
R653 VSS.n407 VSS.n406 0.16242
R654 VSS.n142 VSS.n407 0.16242
R655 VSS.n140 VSS.n142 0.16242
R656 VSS.n140 VSS.n141 0.16242
R657 VSS.n381 VSS.n141 0.16242
R658 VSS.n382 VSS.n381 0.16242
R659 VSS.n383 VSS.n382 0.16242
R660 VSS.n329 VSS.n328 0.16242
R661 VSS.n328 VSS.n327 0.16242
R662 VSS.n327 VSS.n299 0.16242
R663 VSS.n300 VSS.n299 0.16242
R664 VSS.n300 VSS.n298 0.16242
R665 VSS.n314 VSS.n298 0.16242
R666 VSS.n315 VSS.n314 0.16242
R667 VSS.n317 VSS.n315 0.16242
R668 VSS.n316 VSS.n83 0.147329
R669 VSS.n324 VSS.n64 0.145358
R670 VSS.n403 VSS.n402 0.144129
R671 VSS.n388 VSS.n387 0.143085
R672 VSS.n371 VSS.n144 0.139317
R673 VSS.n358 VSS.n357 0.117247
R674 VSS.n365 VSS.n364 0.1171
R675 VSS.n402 VSS.n401 0.0952183
R676 VSS.n324 VSS.n302 0.0941991
R677 VSS.n316 VSS.n308 0.0935007
R678 VSS.n400 VSS.n399 0.0927738
R679 VSS.n389 VSS.n388 0.0925656
R680 VSS.n325 VSS.n303 0.0913062
R681 VSS.n312 VSS.n307 0.0910563
R682 VSS.n398 VSS.n397 0.0903294
R683 VSS.t15 VSS.n139 0.0903294
R684 VSS.n391 VSS.n390 0.0901212
R685 VSS.n313 VSS.n306 0.0891801
R686 VSS.n326 VSS.n304 0.0890531
R687 VSS.t102 VSS.n335 0.0889934
R688 VSS.t102 VSS.n108 0.0888618
R689 VSS.n396 VSS.n395 0.0878849
R690 VSS.n394 VSS.n393 0.0878849
R691 VSS.n395 VSS.t15 0.0876767
R692 VSS.n393 VSS.n392 0.0876767
R693 VSS.n305 VSS.n108 0.0866755
R694 VSS.n335 VSS.n301 0.0865401
R695 VSS.n304 VSS.n301 0.0864836
R696 VSS.n306 VSS.n305 0.0863554
R697 VSS.n392 VSS.n391 0.0854405
R698 VSS.n397 VSS.n396 0.0852323
R699 VSS.n139 VSS.n394 0.0852323
R700 VSS.n387 VSS.t85 0.0849321
R701 VSS.t82 VSS.n403 0.0847768
R702 VSS.n313 VSS.n307 0.0844861
R703 VSS.n326 VSS.n303 0.0842311
R704 VSS.t62 VSS.n64 0.0834709
R705 VSS.n390 VSS.n389 0.082996
R706 VSS.n399 VSS.n398 0.0827878
R707 VSS.n410 VSS.n409 0.0827273
R708 VSS.n138 VSS.n136 0.0827273
R709 VSS.t66 VSS.n83 0.0824034
R710 VSS.n312 VSS.n308 0.0820417
R711 VSS.n359 VSS.n358 0.08146
R712 VSS.n360 VSS.n359 0.08146
R713 VSS.n295 VSS.n360 0.08146
R714 VSS.n94 VSS.n295 0.08146
R715 VSS.n361 VSS.n94 0.08146
R716 VSS.n362 VSS.n361 0.08146
R717 VSS.n363 VSS.n362 0.08146
R718 VSS.n364 VSS.n363 0.08146
R719 VSS.n325 VSS.n302 0.0813426
R720 VSS.n401 VSS.n400 0.0803434
R721 VSS.t72 VSS.n4 1.05214
R722 VSS.n4 VSS.t75 1.04028
R723 VSS VSS.n411 0.0445
R724 VSS.n296 VSS 0.0445
R725 VSS.t15 VSS.n140 0.0394177
R726 VSS.n300 VSS.t102 0.0394177
R727 VSS.n408 VSS.n140 0.0389615
R728 VSS.n336 VSS.n300 0.0389615
R729 VSS.t77 VSS.n351 0.031258
R730 VSS.n343 VSS.t32 0.031258
R731 VSS.n357 VSS.n356 0.0291125
R732 VSS.n365 VSS.n290 0.0291125
R733 VSS.n369 VSS.n365 0.0291125
R734 VSS.n357 VSS.n341 0.0291125
R735 VSS.n356 VSS.n342 0.0281144
R736 VSS.n348 VSS.n290 0.0281144
R737 VSS.n370 VSS.n369 0.0281144
R738 VSS.n352 VSS.n341 0.0281144
R739 VSS.n366 VSS.n289 0.0216549
R740 VSS.n346 VSS.n289 0.0216549
R741 VSS.n367 VSS.t61 0.0208704
R742 VSS.t81 VSS.n347 0.0208704
R743 VSS.n350 VSS.n344 0.0202884
R744 VSS.n355 VSS.n354 0.0202884
R745 VSS.n368 VSS.n367 0.0202884
R746 VSS.n347 VSS.n345 0.0202884
R747 VSS.n94 VSS.n294 0.0197308
R748 VSS.t46 VSS.n94 0.0194533
R749 VSS.n289 VSS.n287 0.0162424
R750 VSS.n353 VSS.n215 0.0159649
R751 VSS.t82 VSS.n106 0.0133922
R752 VSS.t66 VSS.n309 0.0133922
R753 VSS.n334 VSS.t62 0.0133922
R754 VSS.n149 VSS.n148 0.0118857
R755 VSS.n151 VSS.n149 0.0118857
R756 VSS.n154 VSS.n152 0.0118857
R757 VSS.n157 VSS.n156 0.0118857
R758 VSS.n161 VSS.n159 0.0118857
R759 VSS.n164 VSS.n163 0.0118857
R760 VSS.n92 VSS.n164 0.0118857
R761 VSS.n276 VSS.n275 0.0118857
R762 VSS.n273 VSS.n271 0.0118857
R763 VSS.n271 VSS.n270 0.0118857
R764 VSS.n266 VSS.n168 0.0118857
R765 VSS.n169 VSS.n168 0.0118857
R766 VSS.n172 VSS.n170 0.0118857
R767 VSS.n175 VSS.n173 0.0118857
R768 VSS.n261 VSS.n177 0.0118857
R769 VSS.n179 VSS.n177 0.0118857
R770 VSS.n181 VSS.n180 0.0118857
R771 VSS.n183 VSS.n182 0.0118857
R772 VSS.n256 VSS.n254 0.0118857
R773 VSS.n189 VSS.n187 0.0118857
R774 VSS.n247 VSS.n245 0.0118857
R775 VSS.n194 VSS.n193 0.0118857
R776 VSS.n237 VSS.n235 0.0118857
R777 VSS.n87 VSS.n199 0.0118857
R778 VSS.n202 VSS.n201 0.0118857
R779 VSS.n205 VSS.n203 0.0118857
R780 VSS.n225 VSS.n223 0.0118857
R781 VSS.n221 VSS.n220 0.0118857
R782 VSS.n213 VSS.n212 0.0118857
R783 VSS.n223 VSS.n221 0.0118857
R784 VSS.n210 VSS.n208 0.0118857
R785 VSS.n99 VSS.n208 0.0118857
R786 VSS.n97 VSS.n206 0.0118857
R787 VSS.n206 VSS.n205 0.0118857
R788 VSS.n203 VSS.n202 0.0118857
R789 VSS.n89 VSS.n201 0.0118857
R790 VSS.n182 VSS.n181 0.0118857
R791 VSS.n180 VSS.n179 0.0118857
R792 VSS.n173 VSS.n172 0.0118857
R793 VSS.n170 VSS.n169 0.0118857
R794 VSS.n270 VSS.n269 0.0118857
R795 VSS.n274 VSS.n273 0.0118857
R796 VSS.n275 VSS.n274 0.0118857
R797 VSS.n163 VSS.n162 0.0118857
R798 VSS.n162 VSS.n161 0.0118857
R799 VSS.n101 VSS.n159 0.0118857
R800 VSS.n103 VSS.n157 0.0118857
R801 VSS.n156 VSS.n155 0.0118857
R802 VSS.n155 VSS.n154 0.0118857
R803 VSS.n152 VSS.n151 0.0118857
R804 VSS.n148 VSS.n147 0.0118857
R805 VSS.n284 VSS.n147 0.0118857
R806 VSS.n353 VSS.n344 0.0115582
R807 VSS.n354 VSS.n353 0.0115582
R808 VSS.n85 VSS.n62 0.00253296
R809 VSS.n85 VSS.n63 0.0112168
R810 VSS.n85 VSS.n65 0.0112168
R811 VSS.n85 VSS.n66 0.0112168
R812 VSS.n85 VSS.n67 0.0112168
R813 VSS.n85 VSS.n68 0.0112168
R814 VSS.n85 VSS.n69 0.0112168
R815 VSS.n85 VSS.n70 0.0112168
R816 VSS.n85 VSS.n71 0.0112168
R817 VSS.n85 VSS.n73 0.0112168
R818 VSS.n85 VSS.n74 0.0112168
R819 VSS.n85 VSS.n75 0.0112168
R820 VSS.n85 VSS.n76 0.0112168
R821 VSS.n85 VSS.n77 0.0112168
R822 VSS.n85 VSS.n78 0.0112168
R823 VSS.n85 VSS.n79 0.0112168
R824 VSS.n85 VSS.n80 0.0112168
R825 VSS.n85 VSS.n81 0.0112168
R826 VSS.n218 VSS.n217 0.0108889
R827 VSS.n224 VSS.n211 0.0108889
R828 VSS.n233 VSS.n232 0.0108889
R829 VSS.n236 VSS.n197 0.0108889
R830 VSS.n243 VSS.n242 0.0108889
R831 VSS.n246 VSS.n191 0.0108889
R832 VSS.n252 VSS.n251 0.0108889
R833 VSS.n255 VSS.n185 0.0108889
R834 VSS.n351 VSS.n350 0.0108877
R835 VSS.n355 VSS.n343 0.0108877
R836 VSS.n368 VSS.n366 0.0108877
R837 VSS.n346 VSS.n345 0.0108877
R838 VSS.t75 VSS.n289 0.0101032
R839 VSS.t80 VSS.n289 0.0101032
R840 VSS.n353 VSS.t78 0.00981217
R841 VSS.n353 VSS.t72 0.00981217
R842 VSS.n85 VSS.n72 0.00963963
R843 VSS.n410 VSS 0.0095
R844 VSS.n136 VSS 0.0095
R845 VSS.n100 VSS.n98 0.0054294
R846 VSS.n104 VSS.n102 0.0054294
R847 VSS.n90 VSS.n88 0.00481859
R848 VSS.n93 VSS.n91 0.00813889
R849 VSS.n385 VSS.n380 0.00798582
R850 VSS.n385 VSS.n135 0.00798582
R851 VSS.n378 VSS.n143 0.00798582
R852 VSS.n375 VSS.n143 0.00798582
R853 VSS.n319 VSS.n311 0.00798582
R854 VSS.n319 VSS.n310 0.00798582
R855 VSS.n331 VSS.n322 0.00798582
R856 VSS.n331 VSS.n323 0.00798582
R857 VSS.n379 VSS.n105 0.0151369
R858 VSS.n104 VSS.n103 0.00772064
R859 VSS.n380 VSS.n379 0.00756994
R860 VSS.n386 VSS.n135 0.00756994
R861 VSS.n377 VSS.n106 0.00756994
R862 VSS.n378 VSS.n377 0.00756994
R863 VSS.n376 VSS.n375 0.00756994
R864 VSS.n321 VSS.n311 0.00756994
R865 VSS.n320 VSS.n310 0.00756994
R866 VSS.n320 VSS.n309 0.00756994
R867 VSS.n332 VSS.n322 0.00756994
R868 VSS.n333 VSS.n323 0.00756994
R869 VSS.n334 VSS.n333 0.00756994
R870 VSS.n61 VSS.n386 1.37836
R871 VSS.n340 VSS.n195 0.00691667
R872 VSS.t46 VSS.n96 0.00691667
R873 VSS.n292 VSS.n267 0.00691667
R874 VSS.n353 VSS.n214 0.00630556
R875 VSS.n291 VSS.n269 0.00619286
R876 VSS.n285 VSS.n284 0.00619286
R877 VSS.n102 VSS.n101 0.0111223
R878 VSS.n100 VSS.n99 0.00772064
R879 VSS.n257 VSS.n185 0.00619286
R880 VSS.n248 VSS.n191 0.00619286
R881 VSS.n239 VSS.n238 0.00619286
R882 VSS.n98 VSS.n97 0.0111223
R883 VSS.t46 VSS.n95 0.00890776
R884 VSS.n211 VSS.n210 0.00619286
R885 VSS.n214 VSS.n213 0.00619286
R886 VSS.n217 VSS.n212 0.00619286
R887 VSS.n220 VSS.n218 0.00619286
R888 VSS.n225 VSS.n224 0.00619286
R889 VSS.n88 VSS.n87 0.0105114
R890 VSS.n232 VSS.n199 0.00619286
R891 VSS.n235 VSS.n233 0.00619286
R892 VSS.n237 VSS.n236 0.00619286
R893 VSS.n238 VSS.n197 0.00619286
R894 VSS.n195 VSS.n194 0.00619286
R895 VSS.n242 VSS.n193 0.00619286
R896 VSS.n245 VSS.n243 0.00619286
R897 VSS.n247 VSS.n246 0.00619286
R898 VSS.n249 VSS.n248 0.00619286
R899 VSS.n190 VSS.n189 0.00619286
R900 VSS.n251 VSS.n187 0.00619286
R901 VSS.n254 VSS.n252 0.00619286
R902 VSS.n256 VSS.n255 0.00619286
R903 VSS.n96 VSS.n257 0.00619286
R904 VSS.n95 VSS.n183 0.00619286
R905 VSS.n262 VSS.n261 0.00619286
R906 VSS.n176 VSS.n175 0.00619286
R907 VSS.n267 VSS.n266 0.00619286
R908 VSS.n91 VSS.n276 0.00619286
R909 VSS.n289 VSS.n285 0.00615278
R910 VSS.n339 VSS.n249 0.00569444
R911 VSS.n339 VSS.n190 0.00569444
R912 VSS.n293 VSS.n262 0.00569444
R913 VSS.n293 VSS.n176 0.00569444
R914 VSS.n349 VSS.n144 0.00467494
R915 VSS.n340 VSS.n239 0.00447222
R916 VSS.n292 VSS.n291 0.00447222
R917 VSS.n85 VSS.n84 0.00421062
R918 VSS.n93 VSS.n92 0.00894286
R919 VSS.n90 VSS.n89 0.00894286
R920 VSS.n85 VSS.n82 0.00482001
R921 VSS.n86 VSS.n374 6777.49
C0 VDD vout3 19.8293f
C1 vin3 vin2 0.25462f
C2 VDD vout4 19.8349f
C3 vin4 vout4 18.7881f
C4 vout2 vin2 18.7881f
C5 VDD vout1 19.8349f
C6 vin1 vout1 18.7881f
C7 vin3 vout3 18.7881f
C8 vin4 VDD 30.3788f
C9 vin1 VDD 30.3788f
C10 vin3 VDD 30.3477f
C11 vin3 vin4 0.22004f
C12 vout2 VDD 19.8293f
C13 VDD vin2 30.3477f
C14 vin1 vin2 0.22004f
C15 vout1 VSS 15.47065f
C16 vout2 VSS 15.45263f
C17 vout3 VSS 15.45263f
C18 vout4 VSS 15.47065f
C19 VSS.t58 VSS 8.57785f
C20 VSS.t24 VSS 8.59555f
.ends
