* PEX produced on Tue Aug 25 09:16:00 AM CEST 2026 using /foss/tools/sak/sak-pex.sh with m=3 and s=1 (extresist threshold=10000 mOhm, minres=1000 mOhm, mindelay=1 ps)
* NGSPICE file created from inverter_top_pex.ext - technology: ihp-sg13cmos5l

.subckt inverter_top_pex VDD vin4 vout4 VSS vin3 vout3 vin2 vout2 vout1 vin1
X0 vout4 vin4 VDD VDD sg13_lv_pmos ad=1.14p pd=6.38u as=1.14p ps=6.38u w=6u l=1u
X1 VDD vin2 vout2 VDD sg13_lv_pmos ad=1.14p pd=6.38u as=1.14p ps=6.38u w=6u l=1u
X2 VSS.t125 vin2 vout2 VSS.t48 sg13_lv_nmos ad=0.19p pd=1.38u as=0.19p ps=1.38u w=1u l=1u
X3 vout2 vin2 VSS.t127 VSS.t53 sg13_lv_nmos ad=0.19p pd=1.38u as=0.19p ps=1.38u w=1u l=1u
X4 vout2 vin2 VDD VDD sg13_lv_pmos ad=1.14p pd=6.38u as=1.14p ps=6.38u w=6u l=1u
X5 VSS.t93 vin4 vout4 VSS.t92 sg13_lv_nmos ad=0.19p pd=1.38u as=0.19p ps=1.38u w=1u l=1u
X6 vout1 vin1 VSS.t24 VSS.t25 sg13_lv_nmos ad=0.19p pd=1.38u as=0.19p ps=1.38u w=1u l=1u
X7 VDD vin2 vout2 VDD sg13_lv_pmos ad=1.14p pd=6.38u as=1.14p ps=6.38u w=6u l=1u
X8 vout4 vin4 VSS.t63 VSS.t85 sg13_lv_nmos ad=0.19p pd=1.38u as=0.19p ps=1.38u w=1u l=1u
X9 VDD vin2 vout2 VDD sg13_lv_pmos ad=1.14p pd=6.38u as=1.14p ps=6.38u w=6u l=1u
X10 VSS.t58 vin3 vout3 VSS.t57 sg13_lv_nmos ad=0.19p pd=1.38u as=0.19p ps=1.38u w=1u l=1u
X11 vout4 vin4 VSS.t102 VSS.t103 sg13_lv_nmos ad=0.19p pd=1.38u as=0.19p ps=1.38u w=1u l=1u
X12 VDD vin3 vout3 VDD sg13_lv_pmos ad=1.14p pd=6.38u as=1.14p ps=6.38u w=6u l=1u
X13 VSS.t96 vin4 vout4 VSS.t95 sg13_lv_nmos ad=0.19p pd=1.38u as=0.19p ps=1.38u w=1u l=1u
X14 VDD vin2 vout2 VDD sg13_lv_pmos ad=1.14p pd=6.38u as=1.14p ps=6.38u w=6u l=1u
X15 vout3 vin3 VDD VDD sg13_lv_pmos ad=1.14p pd=6.38u as=1.14p ps=6.38u w=6u l=1u
X16 vout2 vin2 VDD VDD sg13_lv_pmos ad=1.14p pd=6.38u as=1.14p ps=6.38u w=6u l=1u
X17 VSS.t121 vin2 vout2 VSS.t42 sg13_lv_nmos ad=0.19p pd=1.38u as=0.19p ps=1.38u w=1u l=1u
X18 VDD vin3 vout3 VDD sg13_lv_pmos ad=1.14p pd=6.38u as=1.14p ps=6.38u w=6u l=1u
X19 VSS.t71 VSS.t69 VSS.t32 VSS.t70 sg13_lv_nmos ad=0.34p pd=2.68u as=0 ps=0 w=1u l=1u
X20 vout2 vin2 VSS.t123 VSS.t47 sg13_lv_nmos ad=0.19p pd=1.38u as=0.19p ps=1.38u w=1u l=1u
X21 vout1 vin1 VSS.t18 VSS.t19 sg13_lv_nmos ad=0.19p pd=1.38u as=0.19p ps=1.38u w=1u l=1u
X22 VSS.t127 vin2 vout2 VSS.t51 sg13_lv_nmos ad=0.19p pd=1.38u as=0.19p ps=1.38u w=1u l=1u
X23 vout4 vin4 VSS.t99 VSS.t100 sg13_lv_nmos ad=0.19p pd=1.38u as=0.19p ps=1.38u w=1u l=1u
X24 vout1 vin1 VDD VDD sg13_lv_pmos ad=1.14p pd=6.38u as=1.14p ps=6.38u w=6u l=1u
X25 vout1 vin1 VSS.t12 VSS.t13 sg13_lv_nmos ad=0.19p pd=1.38u as=0.19p ps=1.38u w=1u l=1u
X26 VSS.t105 vin4 vout4 VSS.t104 sg13_lv_nmos ad=0.19p pd=1.38u as=0.19p ps=1.38u w=1u l=1u
X27 VDD VDD VDD VDD sg13_lv_pmos ad=1.14p pd=6.38u as=0.56797n ps=1.006m w=6u l=1u
X28 VSS.t18 vin1 vout1 VSS.t17 sg13_lv_nmos ad=0.19p pd=1.38u as=0.19p ps=1.38u w=1u l=1u
X29 vout2 vin2 VDD VDD sg13_lv_pmos ad=1.14p pd=6.38u as=1.14p ps=6.38u w=6u l=1u
X30 VDD vin4 vout4 VDD sg13_lv_pmos ad=1.14p pd=6.38u as=1.14p ps=6.38u w=6u l=1u
X31 vout1 vin1 VSS.t21 VSS.t22 sg13_lv_nmos ad=0.19p pd=1.38u as=0.19p ps=1.38u w=1u l=1u
X32 vout3 vin3 VSS.t55 VSS.t56 sg13_lv_nmos ad=0.19p pd=1.38u as=0.19p ps=1.38u w=1u l=1u
X33 vout4 vin4 VDD VDD sg13_lv_pmos ad=1.14p pd=6.38u as=1.14p ps=6.38u w=6u l=1u
X34 VDD vin3 vout3 VDD sg13_lv_pmos ad=1.14p pd=6.38u as=1.14p ps=6.38u w=6u l=1u
X35 VDD vin4 vout4 VDD sg13_lv_pmos ad=1.14p pd=6.38u as=1.14p ps=6.38u w=6u l=1u
X36 vout3 vin3 VDD VDD sg13_lv_pmos ad=1.14p pd=6.38u as=1.14p ps=6.38u w=6u l=1u
X37 VDD vin3 vout3 VDD sg13_lv_pmos ad=1.14p pd=6.38u as=1.14p ps=6.38u w=6u l=1u
X38 VSS.t68 VSS.t65 VSS.t67 VSS.t66 sg13_lv_nmos ad=0.19p pd=1.38u as=0 ps=0 w=1u l=1u
X39 VDD vin4 vout4 VDD sg13_lv_pmos ad=1.14p pd=6.38u as=1.14p ps=6.38u w=6u l=1u
X40 VDD vin2 vout2 VDD sg13_lv_pmos ad=1.14p pd=6.38u as=1.14p ps=6.38u w=6u l=1u
X41 VSS.t108 vin4 vout4 VSS.t107 sg13_lv_nmos ad=0.19p pd=1.38u as=0.19p ps=1.38u w=1u l=1u
X42 VDD vin3 vout3 VDD sg13_lv_pmos ad=1.14p pd=6.38u as=1.14p ps=6.38u w=6u l=1u
X43 VSS.t12 vin1 vout1 VSS.t11 sg13_lv_nmos ad=0.19p pd=1.38u as=0.19p ps=1.38u w=1u l=1u
X44 VDD vin1 vout1 VDD sg13_lv_pmos ad=1.14p pd=6.38u as=1.14p ps=6.38u w=6u l=1u
X45 vout4 vin4 VSS.t111 VSS.t112 sg13_lv_nmos ad=0.19p pd=1.38u as=0.19p ps=1.38u w=1u l=1u
X46 vout4 vin4 VDD VDD sg13_lv_pmos ad=1.14p pd=6.38u as=1.14p ps=6.38u w=6u l=1u
X47 vout1 vin1 VSS.t15 VSS.t16 sg13_lv_nmos ad=0.19p pd=1.38u as=0.19p ps=1.38u w=1u l=1u
X48 vout1 vin1 VDD VDD sg13_lv_pmos ad=1.14p pd=6.38u as=1.14p ps=6.38u w=6u l=1u
X49 VDD vin1 vout1 VDD sg13_lv_pmos ad=1.14p pd=6.38u as=1.14p ps=6.38u w=6u l=1u
X50 vout3 vin3 VSS.t49 VSS.t50 sg13_lv_nmos ad=0.19p pd=1.38u as=0.19p ps=1.38u w=1u l=1u
X51 VSS.t21 vin1 vout1 VSS.t20 sg13_lv_nmos ad=0.19p pd=1.38u as=0.19p ps=1.38u w=1u l=1u
X52 VDD VDD VDD VDD sg13_lv_pmos ad=2.04p pd=12.68u as=0 ps=0 w=6u l=1u
X53 vout4 vin4 VDD VDD sg13_lv_pmos ad=1.14p pd=6.38u as=1.14p ps=6.38u w=6u l=1u
X54 VDD vin3 vout3 VDD sg13_lv_pmos ad=1.14p pd=6.38u as=1.14p ps=6.38u w=6u l=1u
X55 VDD vin4 vout4 VDD sg13_lv_pmos ad=1.14p pd=6.38u as=1.14p ps=6.38u w=6u l=1u
X56 vout3 vin3 VSS.t43 VSS.t44 sg13_lv_nmos ad=0.19p pd=1.38u as=0.19p ps=1.38u w=1u l=1u
X57 vout3 vin3 VDD VDD sg13_lv_pmos ad=1.14p pd=6.38u as=1.14p ps=6.38u w=6u l=1u
X58 VSS.t49 vin3 vout3 VSS.t48 sg13_lv_nmos ad=0.19p pd=1.38u as=0.19p ps=1.38u w=1u l=1u
X59 VDD VDD VDD VDD sg13_lv_pmos ad=1.14p pd=6.38u as=0 ps=0 w=6u l=1u
X60 vout3 vin3 VSS.t52 VSS.t53 sg13_lv_nmos ad=0.19p pd=1.38u as=0.19p ps=1.38u w=1u l=1u
X61 vout4 vin4 VDD VDD sg13_lv_pmos ad=1.14p pd=6.38u as=1.14p ps=6.38u w=6u l=1u
X62 vout3 vin3 VDD VDD sg13_lv_pmos ad=1.14p pd=6.38u as=1.14p ps=6.38u w=6u l=1u
X63 VDD vin1 vout1 VDD sg13_lv_pmos ad=1.14p pd=6.38u as=1.14p ps=6.38u w=6u l=1u
X64 vout2 vin2 VDD VDD sg13_lv_pmos ad=1.14p pd=6.38u as=1.14p ps=6.38u w=6u l=1u
X65 vout1 vin1 VDD VDD sg13_lv_pmos ad=1.14p pd=6.38u as=1.14p ps=6.38u w=6u l=1u
X66 VDD vin1 vout1 VDD sg13_lv_pmos ad=1.14p pd=6.38u as=1.14p ps=6.38u w=6u l=1u
X67 vout2 vin2 VSS.t117 VSS.t38 sg13_lv_nmos ad=0.19p pd=1.38u as=0.19p ps=1.38u w=1u l=1u
X68 VDD vin1 vout1 VDD sg13_lv_pmos ad=1.14p pd=6.38u as=1.14p ps=6.38u w=6u l=1u
X69 VDD vin3 vout3 VDD sg13_lv_pmos ad=1.14p pd=6.38u as=1.14p ps=6.38u w=6u l=1u
X70 VSS.t43 vin3 vout3 VSS.t42 sg13_lv_nmos ad=0.19p pd=1.38u as=0.19p ps=1.38u w=1u l=1u
X71 vout3 vin3 VSS.t46 VSS.t47 sg13_lv_nmos ad=0.19p pd=1.38u as=0.19p ps=1.38u w=1u l=1u
X72 VSS.t90 vin4 vout4 VSS.t89 sg13_lv_nmos ad=0.19p pd=1.38u as=0.19p ps=1.38u w=1u l=1u
X73 VDD vin4 vout4 VDD sg13_lv_pmos ad=1.14p pd=6.38u as=1.14p ps=6.38u w=6u l=1u
X74 VSS.t52 vin3 vout3 VSS.t51 sg13_lv_nmos ad=0.19p pd=1.38u as=0.19p ps=1.38u w=1u l=1u
X75 vout4 vin4 VSS.t93 VSS.t94 sg13_lv_nmos ad=0.19p pd=1.38u as=0.19p ps=1.38u w=1u l=1u
X76 VDD vin1 vout1 VDD sg13_lv_pmos ad=1.14p pd=6.38u as=1.14p ps=6.38u w=6u l=1u
X77 vout2 vin2 VDD VDD sg13_lv_pmos ad=1.14p pd=6.38u as=1.14p ps=6.38u w=6u l=1u
X78 vout1 vin1 VDD VDD sg13_lv_pmos ad=1.14p pd=6.38u as=1.14p ps=6.38u w=6u l=1u
X79 VSS.t87 vin4 vout4 VSS.t86 sg13_lv_nmos ad=0.19p pd=1.38u as=0.19p ps=1.38u w=1u l=1u
X80 VDD VDD VDD VDD sg13_lv_pmos ad=2.04p pd=12.68u as=0 ps=0 w=6u l=1u
X81 vout2 vin2 VDD VDD sg13_lv_pmos ad=1.14p pd=6.38u as=1.14p ps=6.38u w=6u l=1u
X82 VDD vin2 vout2 VDD sg13_lv_pmos ad=1.14p pd=6.38u as=1.14p ps=6.38u w=6u l=1u
X83 VSS.t117 vin2 vout2 VSS.t36 sg13_lv_nmos ad=0.19p pd=1.38u as=0.19p ps=1.38u w=1u l=1u
X84 VSS.t99 vin4 vout4 VSS.t98 sg13_lv_nmos ad=0.19p pd=1.38u as=0.19p ps=1.38u w=1u l=1u
X85 VDD VDD VDD VDD sg13_lv_pmos ad=2.04p pd=12.68u as=0 ps=0 w=6u l=1u
X86 vout2 vin2 VDD VDD sg13_lv_pmos ad=1.14p pd=6.38u as=1.14p ps=6.38u w=6u l=1u
X87 vout2 vin2 VSS.t119 VSS.t41 sg13_lv_nmos ad=0.19p pd=1.38u as=0.19p ps=1.38u w=1u l=1u
X88 VSS.t123 vin2 vout2 VSS.t45 sg13_lv_nmos ad=0.19p pd=1.38u as=0.19p ps=1.38u w=1u l=1u
X89 vout1 vin1 VDD VDD sg13_lv_pmos ad=1.14p pd=6.38u as=1.14p ps=6.38u w=6u l=1u
X90 vout1 vin1 VSS.t6 VSS.t7 sg13_lv_nmos ad=0.19p pd=1.38u as=0.19p ps=1.38u w=1u l=1u
X91 vout4 vin4 VSS.t96 VSS.t97 sg13_lv_nmos ad=0.19p pd=1.38u as=0.19p ps=1.38u w=1u l=1u
X92 vout3 vin3 VDD VDD sg13_lv_pmos ad=1.14p pd=6.38u as=1.14p ps=6.38u w=6u l=1u
X93 vout4 vin4 VSS.t108 VSS.t109 sg13_lv_nmos ad=0.19p pd=1.38u as=0.19p ps=1.38u w=1u l=1u
X94 VSS.t58 VSS.t77 VSS.t58 VSS.t73 sg13_lv_nmos ad=0.19p pd=1.38u as=0 ps=0 w=1u l=1u
X95 VSS.t102 vin4 vout4 VSS.t101 sg13_lv_nmos ad=0.19p pd=1.38u as=0.19p ps=1.38u w=1u l=1u
X96 VDD vin1 vout1 VDD sg13_lv_pmos ad=1.14p pd=6.38u as=1.14p ps=6.38u w=6u l=1u
X97 VSS.t58 vin2 vout2 VSS.t60 sg13_lv_nmos ad=0.19p pd=1.38u as=0.19p ps=1.38u w=1u l=1u
X98 VDD vin2 vout2 VDD sg13_lv_pmos ad=1.14p pd=6.38u as=1.14p ps=6.38u w=6u l=1u
X99 vout4 vin4 VSS.t105 VSS.t106 sg13_lv_nmos ad=0.19p pd=1.38u as=0.19p ps=1.38u w=1u l=1u
X100 vout4 vin4 VDD VDD sg13_lv_pmos ad=1.14p pd=6.38u as=1.14p ps=6.38u w=6u l=1u
X101 vout2 vin2 VDD VDD sg13_lv_pmos ad=1.14p pd=6.38u as=1.14p ps=6.38u w=6u l=1u
X102 vout2 vin2 VSS.t115 VSS.t35 sg13_lv_nmos ad=0.19p pd=1.38u as=0.19p ps=1.38u w=1u l=1u
X103 VDD vin2 vout2 VDD sg13_lv_pmos ad=1.14p pd=6.38u as=1.14p ps=6.38u w=6u l=1u
X104 VSS.t119 vin2 vout2 VSS.t39 sg13_lv_nmos ad=0.19p pd=1.38u as=0.19p ps=1.38u w=1u l=1u
X105 VDD vin4 vout4 VDD sg13_lv_pmos ad=1.14p pd=6.38u as=1.14p ps=6.38u w=6u l=1u
X106 VDD VDD VDD VDD sg13_lv_pmos ad=2.04p pd=12.68u as=0 ps=0 w=6u l=1u
X107 VSS.t115 vin2 vout2 VSS.t33 sg13_lv_nmos ad=0.19p pd=1.38u as=0.19p ps=1.38u w=1u l=1u
X108 VSS.t6 vin1 vout1 VSS.t5 sg13_lv_nmos ad=0.19p pd=1.38u as=0.19p ps=1.38u w=1u l=1u
X109 vout3 vin3 VDD VDD sg13_lv_pmos ad=1.14p pd=6.38u as=1.14p ps=6.38u w=6u l=1u
X110 vout1 vin1 VSS.t9 VSS.t10 sg13_lv_nmos ad=0.19p pd=1.38u as=0.19p ps=1.38u w=1u l=1u
X111 VSS.t15 vin1 vout1 VSS.t14 sg13_lv_nmos ad=0.19p pd=1.38u as=0.19p ps=1.38u w=1u l=1u
X112 vout3 vin3 VDD VDD sg13_lv_pmos ad=1.14p pd=6.38u as=1.14p ps=6.38u w=6u l=1u
X113 VDD vin3 vout3 VDD sg13_lv_pmos ad=1.14p pd=6.38u as=1.14p ps=6.38u w=6u l=1u
X114 vout3 vin3 VDD VDD sg13_lv_pmos ad=1.14p pd=6.38u as=1.14p ps=6.38u w=6u l=1u
X115 vout3 vin3 VSS.t37 VSS.t38 sg13_lv_nmos ad=0.19p pd=1.38u as=0.19p ps=1.38u w=1u l=1u
X116 VSS.t129 vin2 vout2 VSS.t54 sg13_lv_nmos ad=0.19p pd=1.38u as=0.19p ps=1.38u w=1u l=1u
X117 vout2 vin2 VSS.t131 VSS.t59 sg13_lv_nmos ad=0.19p pd=1.38u as=0.19p ps=1.38u w=1u l=1u
X118 VSS.t68 vin4 vout4 VSS.t113 sg13_lv_nmos ad=0.19p pd=1.38u as=0.19p ps=1.38u w=1u l=1u
X119 vout1 vin1 VDD VDD sg13_lv_pmos ad=1.14p pd=6.38u as=1.14p ps=6.38u w=6u l=1u
X120 VSS.t30 VSS.t82 VSS.t84 VSS.t83 sg13_lv_nmos ad=0.19p pd=1.38u as=0 ps=0 w=1u l=1u
X121 VSS.t30 vin1 vout1 VSS.t29 sg13_lv_nmos ad=0.19p pd=1.38u as=0.19p ps=1.38u w=1u l=1u
X122 vout2 vin2 VSS.t75 VSS.t31 sg13_lv_nmos ad=0.19p pd=1.38u as=0.19p ps=1.38u w=1u l=1u
X123 VSS.t64 VSS.t61 VSS.t63 VSS.t62 sg13_lv_nmos ad=0.34p pd=2.68u as=0 ps=0 w=1u l=1u
X124 vout1 vin1 VSS.t3 VSS.t4 sg13_lv_nmos ad=0.19p pd=1.38u as=0.19p ps=1.38u w=1u l=1u
X125 VSS.t9 vin1 vout1 VSS.t8 sg13_lv_nmos ad=0.19p pd=1.38u as=0.19p ps=1.38u w=1u l=1u
X126 VDD vin3 vout3 VDD sg13_lv_pmos ad=1.14p pd=6.38u as=1.14p ps=6.38u w=6u l=1u
X127 VSS.t3 vin1 vout1 VSS.t2 sg13_lv_nmos ad=0.19p pd=1.38u as=0.19p ps=1.38u w=1u l=1u
X128 vout4 vin4 VDD VDD sg13_lv_pmos ad=1.14p pd=6.38u as=1.14p ps=6.38u w=6u l=1u
X129 vout3 vin3 VDD VDD sg13_lv_pmos ad=1.14p pd=6.38u as=1.14p ps=6.38u w=6u l=1u
X130 VDD vin3 vout3 VDD sg13_lv_pmos ad=1.14p pd=6.38u as=1.14p ps=6.38u w=6u l=1u
X131 VSS.t37 vin3 vout3 VSS.t36 sg13_lv_nmos ad=0.19p pd=1.38u as=0.19p ps=1.38u w=1u l=1u
X132 vout3 vin3 VSS.t40 VSS.t41 sg13_lv_nmos ad=0.19p pd=1.38u as=0.19p ps=1.38u w=1u l=1u
X133 vout1 vin1 VDD VDD sg13_lv_pmos ad=1.14p pd=6.38u as=1.14p ps=6.38u w=6u l=1u
X134 VSS.t131 vin2 vout2 VSS.t57 sg13_lv_nmos ad=0.19p pd=1.38u as=0.19p ps=1.38u w=1u l=1u
X135 VSS.t46 vin3 vout3 VSS.t45 sg13_lv_nmos ad=0.19p pd=1.38u as=0.19p ps=1.38u w=1u l=1u
X136 VDD vin4 vout4 VDD sg13_lv_pmos ad=1.14p pd=6.38u as=1.14p ps=6.38u w=6u l=1u
X137 vout1 vin1 VDD VDD sg13_lv_pmos ad=1.14p pd=6.38u as=1.14p ps=6.38u w=6u l=1u
X138 VDD vin1 vout1 VDD sg13_lv_pmos ad=1.14p pd=6.38u as=1.14p ps=6.38u w=6u l=1u
X139 vout4 vin4 VDD VDD sg13_lv_pmos ad=1.14p pd=6.38u as=1.14p ps=6.38u w=6u l=1u
X140 VSS.t24 vin1 vout1 VSS.t23 sg13_lv_nmos ad=0.19p pd=1.38u as=0.19p ps=1.38u w=1u l=1u
X141 vout1 vin1 VDD VDD sg13_lv_pmos ad=1.14p pd=6.38u as=1.14p ps=6.38u w=6u l=1u
X142 vout1 vin1 VSS.t27 VSS.t28 sg13_lv_nmos ad=0.19p pd=1.38u as=0.19p ps=1.38u w=1u l=1u
X143 vout2 vin2 VDD VDD sg13_lv_pmos ad=1.14p pd=6.38u as=1.14p ps=6.38u w=6u l=1u
X144 vout4 vin4 VSS.t90 VSS.t91 sg13_lv_nmos ad=0.19p pd=1.38u as=0.19p ps=1.38u w=1u l=1u
X145 VSS.t76 VSS.t74 VSS.t75 VSS.t70 sg13_lv_nmos ad=0.34p pd=2.68u as=0 ps=0 w=1u l=1u
X146 VSS.t58 VSS.t72 VSS.t58 VSS.t73 sg13_lv_nmos ad=0.19p pd=1.38u as=0 ps=0 w=1u l=1u
X147 vout4 vin4 VDD VDD sg13_lv_pmos ad=1.14p pd=6.38u as=1.14p ps=6.38u w=6u l=1u
X148 VSS.t58 vin3 vout3 VSS.t60 sg13_lv_nmos ad=0.19p pd=1.38u as=0.19p ps=1.38u w=1u l=1u
X149 VSS.t111 vin4 vout4 VSS.t110 sg13_lv_nmos ad=0.19p pd=1.38u as=0.19p ps=1.38u w=1u l=1u
X150 VDD vin4 vout4 VDD sg13_lv_pmos ad=1.14p pd=6.38u as=1.14p ps=6.38u w=6u l=1u
X151 vout1 vin1 VSS.t1 VSS.t0 sg13_lv_nmos ad=0.19p pd=1.38u as=0.19p ps=1.38u w=1u l=1u
X152 vout3 vin3 VSS.t34 VSS.t35 sg13_lv_nmos ad=0.19p pd=1.38u as=0.19p ps=1.38u w=1u l=1u
X153 VSS.t40 vin3 vout3 VSS.t39 sg13_lv_nmos ad=0.19p pd=1.38u as=0.19p ps=1.38u w=1u l=1u
X154 vout4 vin4 VDD VDD sg13_lv_pmos ad=1.14p pd=6.38u as=1.14p ps=6.38u w=6u l=1u
X155 vout2 vin2 VSS.t129 VSS.t56 sg13_lv_nmos ad=0.19p pd=1.38u as=0.19p ps=1.38u w=1u l=1u
X156 VSS.t34 vin3 vout3 VSS.t33 sg13_lv_nmos ad=0.19p pd=1.38u as=0.19p ps=1.38u w=1u l=1u
X157 VDD vin1 vout1 VDD sg13_lv_pmos ad=1.14p pd=6.38u as=1.14p ps=6.38u w=6u l=1u
X158 vout1 vin1 VDD VDD sg13_lv_pmos ad=1.14p pd=6.38u as=1.14p ps=6.38u w=6u l=1u
X159 VDD vin4 vout4 VDD sg13_lv_pmos ad=1.14p pd=6.38u as=1.14p ps=6.38u w=6u l=1u
X160 VDD vin1 vout1 VDD sg13_lv_pmos ad=1.14p pd=6.38u as=1.14p ps=6.38u w=6u l=1u
X161 VSS.t27 vin1 vout1 VSS.t26 sg13_lv_nmos ad=0.19p pd=1.38u as=0.19p ps=1.38u w=1u l=1u
X162 VDD vin2 vout2 VDD sg13_lv_pmos ad=1.14p pd=6.38u as=1.14p ps=6.38u w=6u l=1u
X163 vout2 vin2 VDD VDD sg13_lv_pmos ad=1.14p pd=6.38u as=1.14p ps=6.38u w=6u l=1u
X164 VDD vin2 vout2 VDD sg13_lv_pmos ad=1.14p pd=6.38u as=1.14p ps=6.38u w=6u l=1u
X165 VSS.t55 vin3 vout3 VSS.t54 sg13_lv_nmos ad=0.19p pd=1.38u as=0.19p ps=1.38u w=1u l=1u
X166 vout3 vin3 VSS.t58 VSS.t59 sg13_lv_nmos ad=0.19p pd=1.38u as=0.19p ps=1.38u w=1u l=1u
X167 VDD VDD VDD VDD sg13_lv_pmos ad=1.14p pd=6.38u as=0 ps=0 w=6u l=1u
X168 VSS.t81 VSS.t79 VSS.t1 VSS.t80 sg13_lv_nmos ad=0.34p pd=2.68u as=0 ps=0 w=1u l=1u
X169 VDD vin4 vout4 VDD sg13_lv_pmos ad=1.14p pd=6.38u as=1.14p ps=6.38u w=6u l=1u
X170 VDD VDD VDD VDD sg13_lv_pmos ad=1.14p pd=6.38u as=0 ps=0 w=6u l=1u
X171 vout2 vin2 VSS.t125 VSS.t50 sg13_lv_nmos ad=0.19p pd=1.38u as=0.19p ps=1.38u w=1u l=1u
X172 vout3 vin3 VDD VDD sg13_lv_pmos ad=1.14p pd=6.38u as=1.14p ps=6.38u w=6u l=1u
X173 vout4 vin4 VSS.t87 VSS.t88 sg13_lv_nmos ad=0.19p pd=1.38u as=0.19p ps=1.38u w=1u l=1u
X174 vout3 vin3 VSS.t32 VSS.t31 sg13_lv_nmos ad=0.19p pd=1.38u as=0.19p ps=1.38u w=1u l=1u
X175 vout2 vin2 VSS.t121 VSS.t44 sg13_lv_nmos ad=0.19p pd=1.38u as=0.19p ps=1.38u w=1u l=1u
R0 VSS.n65 VSS.n167 6777.49
R1 VSS.n300 VSS.n65 6777.49
R2 VSS.n300 VSS.n299 1580.41
R3 VSS.n288 VSS.n167 1580.41
R4 VSS.t31 VSS.n151 88.7251
R5 VSS.n116 VSS.t60 88.7251
R6 VSS.t33 VSS.n152 83.1798
R7 VSS.t59 VSS.n135 83.1798
R8 VSS.n74 VSS.t35 77.6345
R9 VSS.n136 VSS.t57 77.6345
R10 VSS.t66 VSS.n65 6.87897
R11 VSS.t36 VSS.n75 72.0892
R12 VSS.n137 VSS.t56 72.0892
R13 VSS.n64 VSS.t112 15.1947
R14 VSS.n124 VSS.t85 9.77299
R15 VSS.t38 VSS.n153 66.5439
R16 VSS.n138 VSS.t54 66.5439
R17 VSS.t112 VSS.n63 64.5255
R18 VSS.n47 VSS.t86 64.5209
R19 VSS.t39 VSS.n154 60.9987
R20 VSS.n139 VSS.t53 60.9987
R21 VSS.t110 VSS.n62 60.7305
R22 VSS.n48 VSS.t88 60.7259
R23 VSS.t109 VSS.n61 56.9354
R24 VSS.n49 VSS.t89 56.9308
R25 VSS.t28 VSS.n2 12.2979
R26 VSS.t41 VSS.n155 55.4534
R27 VSS.t45 VSS.n143 55.4534
R28 VSS.t47 VSS.n158 55.4534
R29 VSS.n140 VSS.t51 55.4534
R30 VSS.t107 VSS.n60 53.1403
R31 VSS.n50 VSS.t91 53.1357
R32 VSS.t26 VSS.n2 14.4654
R33 VSS.t42 VSS.n156 49.9081
R34 VSS.n144 VSS.t44 49.9081
R35 VSS.t48 VSS.n159 49.9081
R36 VSS.n141 VSS.t50 49.9081
R37 VSS.t106 VSS.n59 49.3453
R38 VSS.n51 VSS.t92 49.3407
R39 VSS.t104 VSS.n58 45.5502
R40 VSS.t98 VSS.n54 45.5502
R41 VSS.n56 VSS.t100 45.5456
R42 VSS.n52 VSS.t94 45.5456
R43 VSS.n145 VSS.t42 44.3628
R44 VSS.t44 VSS.n157 44.3628
R45 VSS.n142 VSS.t48 44.3628
R46 VSS.t50 VSS.n160 44.3628
R47 VSS.t103 VSS.n57 41.7551
R48 VSS.t97 VSS.n53 41.7551
R49 VSS.n57 VSS.t101 41.7505
R50 VSS.n53 VSS.t95 41.7505
R51 VSS.t22 VSS.n2 18.7989
R52 VSS.n146 VSS.t41 38.8175
R53 VSS.n78 VSS.t45 38.8175
R54 VSS.n107 VSS.t47 38.8175
R55 VSS.t51 VSS.n161 38.8175
R56 VSS.t101 VSS.n56 37.9601
R57 VSS.t95 VSS.n52 37.9601
R58 VSS.n58 VSS.t103 37.9555
R59 VSS.n54 VSS.t97 37.9555
R60 VSS.t20 VSS.n2 19.5211
R61 VSS.t100 VSS.n55 34.1682
R62 VSS.t94 VSS.n51 34.165
R63 VSS.n55 VSS.t98 34.1635
R64 VSS.n59 VSS.t104 34.1604
R65 VSS.n147 VSS.t39 33.2722
R66 VSS.t53 VSS.n162 33.2722
R67 VSS.t92 VSS.n50 30.3699
R68 VSS.n60 VSS.t106 30.3653
R69 VSS.n97 VSS.t38 27.7269
R70 VSS.t54 VSS.n163 27.7269
R71 VSS.t91 VSS.n49 26.5749
R72 VSS.n61 VSS.t107 26.5703
R73 VSS.t16 VSS.n2 19.5603
R74 VSS.t89 VSS.n48 22.7798
R75 VSS.n62 VSS.t109 22.7752
R76 VSS.t80 VSS.n2 6.87995
R77 VSS.t7 VSS.n2 17.716
R78 VSS.t23 VSS.n2 17.7157
R79 VSS.n95 VSS.t36 22.1816
R80 VSS.t56 VSS.n164 22.1816
R81 VSS.t88 VSS.n47 18.9847
R82 VSS.n63 VSS.t110 18.9801
R83 VSS.t25 VSS.n2 16.2709
R84 VSS.t19 VSS.n2 19.8822
R85 VSS.n2 VSS.t14 19.5028
R86 VSS.t11 VSS.n2 19.8821
R87 VSS.t10 VSS.n2 19.5214
R88 VSS.n2 VSS.t8 18.7988
R89 VSS.n2 VSS.t5 16.2707
R90 VSS.t82 VSS.n166 0.008067
R91 VSS.n2 VSS.n166 8.49747
R92 VSS.n2 VSS.n176 17.0005
R93 VSS.n41 VSS.n2 1.27435
R94 VSS.t30 VSS.n177 17.0005
R95 VSS.t30 VSS.n182 17.0005
R96 VSS.n183 VSS.t30 17.0005
R97 VSS.n177 VSS.t84 17.0005
R98 VSS.n182 VSS.t84 17.0005
R99 VSS.n183 VSS.t84 17.0005
R100 VSS.n2 VSS.n0 0.931665
R101 VSS.n0 VSS.t79 0.00253412
R102 VSS.t81 VSS.t79 17.0005
R103 VSS.t81 VSS.n175 17.0005
R104 VSS.n184 VSS.t81 17.0005
R105 VSS.t79 VSS.t1 17.0005
R106 VSS.t1 VSS.n175 17.0005
R107 VSS.n184 VSS.t1 17.0005
R108 VSS.t58 VSS.n39 1.20771
R109 VSS.t58 VSS.n19 0.650675
R110 VSS.n19 VSS.t73 7.20256
R111 VSS.n35 VSS.n90 14.4044
R112 VSS.n23 VSS.n89 7.20256
R113 VSS.t58 VSS.n20 0.650675
R114 VSS.n20 VSS.n115 14.4044
R115 VSS.n18 VSS.n88 7.20256
R116 VSS.t58 VSS.n9 0.650675
R117 VSS.n9 VSS.n114 14.4044
R118 VSS.t58 VSS.n165 8.50002
R119 VSS.t58 VSS.n14 0.650675
R120 VSS.n14 VSS.n113 14.4044
R121 VSS.t58 VSS.n137 8.49929
R122 VSS.t58 VSS.n11 0.650675
R123 VSS.t58 VSS.n128 8.49909
R124 VSS.n11 VSS.n112 14.4044
R125 VSS.t58 VSS.n28 0.650675
R126 VSS.t58 VSS.n162 8.50029
R127 VSS.n32 VSS.n111 14.4044
R128 VSS.t58 VSS.n122 8.4994
R129 VSS.t58 VSS.n32 0.650675
R130 VSS.t58 VSS.n161 8.50032
R131 VSS.t58 VSS.n140 8.49999
R132 VSS.n29 VSS.n110 14.4044
R133 VSS.t58 VSS.n29 0.650675
R134 VSS.t58 VSS.n141 8.50244
R135 VSS.t58 VSS.n36 0.650675
R136 VSS.n46 VSS.n45 0.00619286
R137 VSS.n36 VSS.n81 14.4044
R138 VSS.t58 VSS.n46 8.4984
R139 VSS.t58 VSS.n191 17.0005
R140 VSS.n34 VSS.n79 14.4044
R141 VSS.t58 VSS.n158 8.49911
R142 VSS.n27 VSS.n106 14.6203
R143 VSS.t58 VSS.n16 0.650675
R144 VSS.n16 VSS.n78 7.20256
R145 VSS.n30 VSS.n105 14.4044
R146 VSS.t58 VSS.n192 17.0005
R147 VSS.t58 VSS.n30 0.650675
R148 VSS.t58 VSS.n157 8.49982
R149 VSS.t58 VSS.n33 0.650675
R150 VSS.n33 VSS.n77 14.4044
R151 VSS.t58 VSS.n43 17.0005
R152 VSS.t58 VSS.n156 8.49993
R153 VSS.t58 VSS.n145 8.49772
R154 VSS.n12 VSS.n101 14.4044
R155 VSS.n10 VSS.n76 14.4044
R156 VSS.t58 VSS.n120 8.4994
R157 VSS.t58 VSS.n154 8.50034
R158 VSS.n8 VSS.n98 14.4044
R159 VSS.n22 VSS.n97 7.20256
R160 VSS.t58 VSS.n125 17.0005
R161 VSS.t58 VSS.n15 0.650675
R162 VSS.n15 VSS.n75 7.20256
R163 VSS.n25 VSS.n94 14.4044
R164 VSS.t58 VSS.n13 0.650675
R165 VSS.n13 VSS.n74 7.20256
R166 VSS.t58 VSS.n31 0.650675
R167 VSS.t58 VSS.n152 8.49983
R168 VSS.t58 VSS.n149 8.49932
R169 VSS.n37 VSS.n71 14.4044
R170 VSS.t58 VSS.n151 8.49784
R171 VSS.n24 VSS.n69 14.4044
R172 VSS.t58 VSS.n26 0.650675
R173 VSS.n26 VSS.t70 7.20256
R174 VSS.t58 VSS.n21 0.650675
R175 VSS.n21 VSS.n66 14.4044
R176 VSS.t58 VSS.n17 0.650675
R177 VSS.n92 VSS.n17 14.8732
R178 VSS.t58 VSS.n135 8.49609
R179 VSS.t58 VSS.n136 8.49634
R180 VSS.t58 VSS.n164 8.49882
R181 VSS.t58 VSS.n163 8.49857
R182 VSS.t58 VSS.n138 8.49907
R183 VSS.t58 VSS.n139 8.49957
R184 VSS.t58 VSS.n160 8.49832
R185 VSS.t58 VSS.n159 8.49807
R186 VSS.t58 VSS.n142 8.49658
R187 VSS.t58 VSS.n143 8.49923
R188 VSS.t58 VSS.n144 8.50007
R189 VSS.t58 VSS.n155 8.49782
R190 VSS.t58 VSS.n146 8.49683
R191 VSS.t58 VSS.n147 8.49747
R192 VSS.t58 VSS.n153 8.49758
R193 VSS.t58 VSS.n148 8.49708
R194 VSS.t58 VSS.n150 8.49733
R195 VSS.n7 VSS.t58 0.432305
R196 VSS.n119 VSS.n278 17.0005
R197 VSS.n119 VSS.n276 17.0005
R198 VSS.n119 VSS.n44 17.0005
R199 VSS.n119 VSS.n127 17.0005
R200 VSS.n134 VSS.n204 0.0111223
R201 VSS.n119 VSS.n134 8.49879
R202 VSS.n290 VSS.n119 17.0005
R203 VSS.n214 VSS.n65 17.0005
R204 VSS.n218 VSS.n65 17.0005
R205 VSS.n233 VSS.n65 17.0005
R206 VSS.n232 VSS.n65 17.0005
R207 VSS.n235 VSS.t68 17.0005
R208 VSS.t68 VSS.n219 17.0005
R209 VSS.t68 VSS.n234 17.0005
R210 VSS.n235 VSS.t67 17.0005
R211 VSS.n219 VSS.t67 17.0005
R212 VSS.n234 VSS.t67 17.0005
R213 VSS.n236 VSS.t64 17.0005
R214 VSS.n238 VSS.t64 17.0005
R215 VSS.n237 VSS.t64 17.0005
R216 VSS.t63 VSS.n236 17.0005
R217 VSS.n238 VSS.t63 17.0005
R218 VSS.t63 VSS.n237 17.0005
R219 VSS.t35 VSS.n148 16.6364
R220 VSS.t57 VSS.n165 16.6364
R221 VSS.t86 VSS.n124 15.1993
R222 VSS.t74 VSS.n255 15.0005
R223 VSS.n292 VSS.t69 15.0005
R224 VSS.n102 VSS.n12 14.4051
R225 VSS.n100 VSS.n10 14.4051
R226 VSS.n99 VSS.n8 14.4051
R227 VSS.n93 VSS.n37 14.4051
R228 VSS.n72 VSS.n31 14.4051
R229 VSS.n95 VSS.n25 7.20324
R230 VSS.n96 VSS.n22 14.4051
R231 VSS.n104 VSS.n30 14.4051
R232 VSS.n107 VSS.n27 7.20324
R233 VSS.n109 VSS.n29 14.4051
R234 VSS.n82 VSS.n32 14.4051
R235 VSS.n83 VSS.n28 14.4051
R236 VSS.n116 VSS.n20 7.20324
R237 VSS.n117 VSS.n35 14.4051
R238 VSS.n289 VSS.n38 13.3823
R239 VSS.n124 VSS.n65 0.00253296
R240 VSS.t17 VSS.n2 19.8814
R241 VSS.t2 VSS.n2 12.2982
R242 VSS.t4 VSS.n2 14.4652
R243 VSS.t13 VSS.n2 19.8815
R244 VSS.n2 VSS.t29 9.77047
R245 VSS.t83 VSS.n2 6.87971
R246 VSS.n149 VSS.t33 11.0911
R247 VSS.n88 VSS.t59 11.0911
R248 VSS.n288 VSS.t58 1.70006
R249 VSS.n119 VSS.n289 8.5005
R250 VSS.n119 VSS.n116 8.5005
R251 VSS.n119 VSS.n107 8.5005
R252 VSS.n119 VSS.n97 8.5005
R253 VSS.n119 VSS.n95 8.5005
R254 VSS.n119 VSS.n89 8.5005
R255 VSS.n119 VSS.n88 8.5005
R256 VSS.n119 VSS.n78 8.5005
R257 VSS.n119 VSS.n75 8.5005
R258 VSS.n119 VSS.n74 8.5005
R259 VSS.t58 VSS.n185 8.4984
R260 VSS.t58 VSS.n186 8.4984
R261 VSS.t58 VSS.n187 8.4984
R262 VSS.t58 VSS.n188 8.4984
R263 VSS.t58 VSS.n189 8.4984
R264 VSS.t58 VSS.n190 8.4984
R265 VSS.t58 VSS.n208 8.4984
R266 VSS.t46 VSS.n4 0.00738772
R267 VSS.n3 VSS.t46 0.00474254
R268 VSS.t58 VSS.n3 0.586794
R269 VSS.t58 VSS.n207 8.4984
R270 VSS.t58 VSS.n42 8.4984
R271 VSS.t58 VSS.n193 8.4984
R272 VSS.t58 VSS.n194 8.4984
R273 VSS.t58 VSS.n195 8.4984
R274 VSS.t58 VSS.n196 8.4984
R275 VSS.t58 VSS.n197 8.4984
R276 VSS.t58 VSS.n198 8.4984
R277 VSS.t58 VSS.n126 8.4984
R278 VSS.t58 VSS.n206 8.4984
R279 VSS.t58 VSS.n205 8.4984
R280 VSS.t58 VSS.n204 8.4984
R281 VSS.t58 VSS.n132 8.4984
R282 VSS.t58 VSS.n203 8.4984
R283 VSS.t58 VSS.n202 8.4984
R284 VSS.t58 VSS.n201 8.4984
R285 VSS.t58 VSS.n200 8.4984
R286 VSS.t58 VSS.n199 8.4984
R287 VSS.n119 VSS.n7 0.408308
R288 VSS.n119 VSS.n287 8.4984
R289 VSS.n119 VSS.n286 8.4984
R290 VSS.n119 VSS.n285 8.4984
R291 VSS.n119 VSS.n284 8.4984
R292 VSS.n119 VSS.n283 8.4984
R293 VSS.n119 VSS.n282 8.4984
R294 VSS.n119 VSS.n281 8.4984
R295 VSS.n119 VSS.n280 8.4984
R296 VSS.n119 VSS.n279 8.4984
R297 VSS.n119 VSS.n4 2.42327
R298 VSS.n119 VSS.n277 8.4984
R299 VSS.n119 VSS.n275 8.4984
R300 VSS.n119 VSS.n274 8.4984
R301 VSS.n119 VSS.n273 8.4984
R302 VSS.n119 VSS.n272 8.4984
R303 VSS.n119 VSS.n271 8.4984
R304 VSS.n119 VSS.n270 8.4984
R305 VSS.n119 VSS.n269 8.4984
R306 VSS.n119 VSS.n268 8.4984
R307 VSS.n119 VSS.n267 8.4984
R308 VSS.n119 VSS.n266 8.4984
R309 VSS.n119 VSS.n265 8.4984
R310 VSS.n119 VSS.n264 8.4984
R311 VSS.n119 VSS.n263 8.4984
R312 VSS.n119 VSS.n262 8.4984
R313 VSS.n119 VSS.n261 8.4984
R314 VSS.n119 VSS.n260 8.4984
R315 VSS.n119 VSS.n259 8.4984
R316 VSS.n91 VSS.n39 14.3619
R317 VSS.n65 VSS.t62 6.87872
R318 VSS.n257 VSS.t74 7.49606
R319 VSS.t69 VSS.n254 7.49606
R320 VSS.t72 VSS.t58 4.99463
R321 VSS.t77 VSS.t58 4.99463
R322 VSS.n106 VSS.n16 14.6209
R323 VSS.n87 VSS.n135 7.20236
R324 VSS.n86 VSS.n136 7.20236
R325 VSS.n85 VSS.n137 7.20236
R326 VSS.n84 VSS.n138 7.20236
R327 VSS.n80 VSS.n142 7.20236
R328 VSS.n73 VSS.n148 7.20236
R329 VSS.n70 VSS.n150 7.20236
R330 VSS.n68 VSS.t70 7.20236
R331 VSS.n118 VSS.n38 13.8932
R332 VSS.n114 VSS.n165 7.20236
R333 VSS.n113 VSS.n164 7.20236
R334 VSS.n112 VSS.n163 7.20236
R335 VSS.n109 VSS.n160 7.20236
R336 VSS.n108 VSS.n36 14.4051
R337 VSS.n104 VSS.n157 7.20236
R338 VSS.n103 VSS.n33 14.4051
R339 VSS.n101 VSS.n155 7.20236
R340 VSS.n98 VSS.n153 7.20236
R341 VSS.n66 VSS.n17 14.4051
R342 VSS.n68 VSS.n21 14.4051
R343 VSS.n69 VSS.n26 14.4051
R344 VSS.n70 VSS.n24 14.4051
R345 VSS.n71 VSS.n151 7.20236
R346 VSS.n93 VSS.n149 7.20236
R347 VSS.n72 VSS.n152 7.20236
R348 VSS.n73 VSS.n31 14.4044
R349 VSS.n94 VSS.n13 14.4051
R350 VSS.n96 VSS.n15 14.4051
R351 VSS.n99 VSS.n147 7.20236
R352 VSS.n76 VSS.n154 7.20236
R353 VSS.n100 VSS.n146 7.20236
R354 VSS.n102 VSS.n145 7.20236
R355 VSS.n77 VSS.n156 7.20236
R356 VSS.n103 VSS.n144 7.20236
R357 VSS.n105 VSS.n143 7.20236
R358 VSS.n79 VSS.n158 7.20236
R359 VSS.n80 VSS.n34 14.4051
R360 VSS.n81 VSS.n159 7.20236
R361 VSS.n108 VSS.n141 7.20236
R362 VSS.n110 VSS.n140 7.20236
R363 VSS.n82 VSS.n161 7.20236
R364 VSS.n111 VSS.n139 7.20236
R365 VSS.n83 VSS.n162 7.20236
R366 VSS.n84 VSS.n28 14.4044
R367 VSS.n85 VSS.n11 14.4051
R368 VSS.n86 VSS.n14 14.4051
R369 VSS.n87 VSS.n9 14.4051
R370 VSS.n115 VSS.n18 14.4051
R371 VSS.n117 VSS.n23 14.4051
R372 VSS.n90 VSS.t73 7.20236
R373 VSS.n118 VSS.n19 14.4051
R374 VSS.n2 VSS.n167 6777.49
R375 VSS.n150 VSS.t31 5.54579
R376 VSS.t60 VSS.n89 5.54579
R377 VSS.n258 VSS.t75 4.5005
R378 VSS.t32 VSS.n253 4.5005
R379 VSS.n119 VSS.n67 4.25219
R380 VSS.t58 VSS.n67 4.25169
R381 VSS.n299 VSS.t58 1.69985
R382 VSS.t0 VSS.n2 9.76977
R383 VSS.n319 VSS.n170 3.77525
R384 VSS.n320 VSS.n319 3.77525
R385 VSS.n250 VSS.n249 3.77525
R386 VSS.n249 VSS.n210 3.77525
R387 VSS.n181 VSS.t82 3.0005
R388 VSS.n315 VSS.t79 3.0005
R389 VSS.t65 VSS.n231 3.0005
R390 VSS.t61 VSS.n239 3.0005
R391 VSS.n256 VSS.n252 3.0005
R392 VSS.n294 VSS.n293 3.0005
R393 VSS.n230 VSS.t111 2.48177
R394 VSS.t108 VSS.n221 2.48177
R395 VSS.t105 VSS.n222 2.48177
R396 VSS.t102 VSS.n211 2.48177
R397 VSS.t96 VSS.n212 2.48177
R398 VSS.n215 VSS.t93 2.48177
R399 VSS.n216 VSS.t90 2.48177
R400 VSS.n217 VSS.t87 2.48177
R401 VSS.n296 VSS.t115 2.48177
R402 VSS.n297 VSS.t117 2.48177
R403 VSS.n298 VSS.t119 2.48177
R404 VSS.n6 VSS.t121 2.48177
R405 VSS.t58 VSS.t125 2.48177
R406 VSS.t58 VSS.t127 2.48177
R407 VSS.t58 VSS.t129 2.48177
R408 VSS.t58 VSS.t131 0.156657
R409 VSS.n316 VSS.t3 2.48177
R410 VSS.n317 VSS.t6 2.48177
R411 VSS.n318 VSS.t9 2.48177
R412 VSS.n174 VSS.t12 2.48177
R413 VSS.t18 VSS.n173 2.48177
R414 VSS.n178 VSS.t21 2.48177
R415 VSS.n179 VSS.t24 2.48177
R416 VSS.n180 VSS.t27 2.48177
R417 VSS.n296 VSS.t34 2.48177
R418 VSS.n297 VSS.t37 2.48177
R419 VSS.n298 VSS.t40 2.48177
R420 VSS.n6 VSS.t43 2.48177
R421 VSS.t58 VSS.t49 2.48177
R422 VSS.t58 VSS.t52 2.48177
R423 VSS.t58 VSS.t55 2.48177
R424 VSS.n210 VSS.n209 2.4377
R425 VSS.t58 VSS.n38 1.20771
R426 VSS.n39 VSS.n289 13.3823
R427 VSS.t58 VSS.n35 0.650675
R428 VSS.t58 VSS.n23 0.650675
R429 VSS.t58 VSS.n18 0.650675
R430 VSS.t58 VSS.n34 0.650675
R431 VSS.t58 VSS.n27 0.650675
R432 VSS.t58 VSS.n12 0.650675
R433 VSS.t58 VSS.n10 0.650675
R434 VSS.t58 VSS.n8 0.650675
R435 VSS.t58 VSS.n22 0.650675
R436 VSS.t58 VSS.n25 0.650675
R437 VSS.t58 VSS.n37 0.650675
R438 VSS.t58 VSS.n24 0.650675
R439 VSS.t76 VSS.n258 2.2505
R440 VSS.t71 VSS.n253 2.2505
R441 VSS.n303 VSS.n2 2.09947
R442 VSS.n305 VSS.n2 2.09947
R443 VSS.n307 VSS.n2 2.09947
R444 VSS.n171 VSS.n2 2.09947
R445 VSS.n309 VSS.n2 2.09947
R446 VSS.n311 VSS.n2 2.09947
R447 VSS.n313 VSS.n2 2.09947
R448 VSS.n314 VSS.n1 0.165903
R449 VSS.n242 VSS.n65 2.0987
R450 VSS.n244 VSS.n65 2.09868
R451 VSS.n224 VSS.n65 2.09868
R452 VSS.n228 VSS.n65 2.09868
R453 VSS.n248 VSS.n65 2.09866
R454 VSS.n65 VSS.n168 2.09862
R455 VSS.n246 VSS.n65 2.09859
R456 VSS.n226 VSS.n65 2.09849
R457 VSS.n5 VSS.n251 1.88787
R458 VSS.n5 VSS.n169 1.88787
R459 VSS.n41 VSS.n183 0.00152956
R460 VSS.n91 VSS.n288 1.53502
R461 VSS.n299 VSS.n92 1.53502
R462 VSS.n315 VSS.n175 1.52811
R463 VSS.n231 VSS.n219 1.52811
R464 VSS.n239 VSS.n238 1.52811
R465 VSS.n182 VSS.n181 1.52811
R466 VSS.n131 VSS.n65 1.31087
R467 VSS.n65 VSS.n130 1.27641
R468 VSS.n320 VSS.n169 1.1929
R469 VSS.n210 VSS.n169 1.1929
R470 VSS.n251 VSS.n170 1.1929
R471 VSS.n251 VSS.n250 1.1929
R472 VSS.n119 VSS.t76 1.12521
R473 VSS.n301 VSS.n2 0.96569
R474 VSS.n240 VSS.n65 0.910334
R475 VSS.n220 VSS.n65 0.909085
R476 VSS.n119 VSS.n118 0.650322
R477 VSS.n119 VSS.n117 0.650322
R478 VSS.n119 VSS.n115 0.650322
R479 VSS.n119 VSS.n114 0.650322
R480 VSS.n119 VSS.n113 0.650322
R481 VSS.n119 VSS.n112 0.650322
R482 VSS.n119 VSS.n111 0.650322
R483 VSS.n119 VSS.n110 0.650322
R484 VSS.n119 VSS.n109 0.650322
R485 VSS.n119 VSS.n108 0.650322
R486 VSS.n119 VSS.n105 0.650322
R487 VSS.n119 VSS.n104 0.650322
R488 VSS.n119 VSS.n103 0.650322
R489 VSS.n119 VSS.n102 0.650322
R490 VSS.n119 VSS.n101 0.650322
R491 VSS.n119 VSS.n100 0.650322
R492 VSS.n119 VSS.n99 0.650322
R493 VSS.n119 VSS.n98 0.650322
R494 VSS.n119 VSS.n96 0.650322
R495 VSS.n119 VSS.n94 0.650322
R496 VSS.n119 VSS.n93 0.650322
R497 VSS.n119 VSS.n90 0.650322
R498 VSS.n119 VSS.n87 0.650322
R499 VSS.n119 VSS.n86 0.650322
R500 VSS.n119 VSS.n85 0.650322
R501 VSS.n119 VSS.n84 0.650322
R502 VSS.n119 VSS.n83 0.650322
R503 VSS.n119 VSS.n82 0.650322
R504 VSS.n119 VSS.n81 0.650322
R505 VSS.n119 VSS.n80 0.650322
R506 VSS.n119 VSS.n79 0.650322
R507 VSS.n119 VSS.n77 0.650322
R508 VSS.n119 VSS.n76 0.650322
R509 VSS.n119 VSS.n73 0.650322
R510 VSS.n119 VSS.n72 0.650322
R511 VSS.n119 VSS.n71 0.650322
R512 VSS.n119 VSS.n70 0.650322
R513 VSS.n119 VSS.n69 0.650322
R514 VSS.n119 VSS.n68 0.650322
R515 VSS.n119 VSS.n66 0.650322
R516 VSS.n119 VSS.n106 0.542397
R517 VSS VSS.n320 0.3585
R518 VSS.n170 VSS 0.3585
R519 VSS.n250 VSS.n209 0.3585
R520 VSS.n316 VSS.n315 0.209825
R521 VSS.n231 VSS.n230 0.209825
R522 VSS.n239 VSS.n217 0.209825
R523 VSS.n181 VSS.n180 0.209825
R524 VSS.n314 VSS.t6 0.200997
R525 VSS.n312 VSS.t9 0.200997
R526 VSS.n310 VSS.t12 0.200997
R527 VSS.n308 VSS.t18 0.200997
R528 VSS.n306 VSS.t21 0.200997
R529 VSS.n304 VSS.t24 0.200997
R530 VSS.n302 VSS.t27 0.200997
R531 VSS.n133 VSS.t34 0.200997
R532 VSS.n127 VSS.t37 0.200997
R533 VSS.n121 VSS.t40 0.200997
R534 VSS.n44 VSS.t43 0.200997
R535 VSS.n45 VSS.t49 0.200997
R536 VSS.n123 VSS.t52 0.200997
R537 VSS.n129 VSS.t55 0.200997
R538 VSS.t111 VSS.n229 0.200995
R539 VSS.n227 VSS.t108 0.200995
R540 VSS.n225 VSS.t105 0.200995
R541 VSS.n223 VSS.t102 0.200995
R542 VSS.n247 VSS.t96 0.200995
R543 VSS.n245 VSS.t93 0.200995
R544 VSS.n243 VSS.t90 0.200995
R545 VSS.n241 VSS.t87 0.200995
R546 VSS.n133 VSS.t115 0.200995
R547 VSS.n127 VSS.t117 0.200995
R548 VSS.t119 VSS.n121 0.200995
R549 VSS.n44 VSS.t121 0.200995
R550 VSS.t125 VSS.n45 0.200995
R551 VSS.t127 VSS.n123 0.200995
R552 VSS.t129 VSS.n129 0.200995
R553 VSS.t46 VSS.t123 0.185126
R554 VSS.n317 VSS.n316 0.16242
R555 VSS.n318 VSS.n317 0.16242
R556 VSS.n174 VSS.n318 0.16242
R557 VSS.n172 VSS.n174 0.16242
R558 VSS.n172 VSS.n173 0.16242
R559 VSS.n178 VSS.n173 0.16242
R560 VSS.n179 VSS.n178 0.16242
R561 VSS.n180 VSS.n179 0.16242
R562 VSS.n217 VSS.n216 0.16242
R563 VSS.n216 VSS.n215 0.16242
R564 VSS.n215 VSS.n212 0.16242
R565 VSS.n213 VSS.n212 0.16242
R566 VSS.n213 VSS.n211 0.16242
R567 VSS.n222 VSS.n211 0.16242
R568 VSS.n222 VSS.n221 0.16242
R569 VSS.n230 VSS.n221 0.16242
R570 VSS.n229 VSS.n220 0.147795
R571 VSS.n241 VSS.n240 0.145358
R572 VSS.n2 VSS.n1 0.129982
R573 VSS.n302 VSS.n301 0.143085
R574 VSS.n119 VSS.n92 0.139317
R575 VSS.n40 VSS.n2 1.31753
R576 VSS.n296 VSS.n295 0.117247
R577 VSS.t3 VSS.n1 0.207317
R578 VSS.n229 VSS.n228 0.0942639
R579 VSS.n242 VSS.n241 0.0939981
R580 VSS.n314 VSS.n313 0.0927738
R581 VSS.n303 VSS.n302 0.0925656
R582 VSS.n244 VSS.n243 0.0918194
R583 VSS.n227 VSS.n226 0.0914366
R584 VSS.n312 VSS.n311 0.0903294
R585 VSS.t15 VSS.n171 0.0903294
R586 VSS.n305 VSS.n304 0.0901212
R587 VSS.t99 VSS.n248 0.0893736
R588 VSS.n246 VSS.n245 0.0892445
R589 VSS.t99 VSS.n168 0.0888618
R590 VSS.n225 VSS.n224 0.0886118
R591 VSS.n310 VSS.n309 0.0878849
R592 VSS.n308 VSS.n307 0.0878849
R593 VSS.n309 VSS.t15 0.0876767
R594 VSS.n307 VSS.n306 0.0876767
R595 VSS.n224 VSS.n223 0.0869305
R596 VSS.n223 VSS.n168 0.0866755
R597 VSS.n247 VSS.n246 0.0862916
R598 VSS.n248 VSS.n247 0.0861688
R599 VSS.n306 VSS.n305 0.0854405
R600 VSS.n311 VSS.n310 0.0852323
R601 VSS.n171 VSS.n308 0.0852323
R602 VSS.n301 VSS.t82 0.0849321
R603 VSS.n226 VSS.n225 0.0841033
R604 VSS.n245 VSS.n244 0.083723
R605 VSS.n240 VSS.t61 0.0834709
R606 VSS.n304 VSS.n303 0.082996
R607 VSS.n313 VSS.n312 0.0827878
R608 VSS.t65 VSS.n220 0.0819405
R609 VSS.n243 VSS.n242 0.0815366
R610 VSS.n297 VSS.n296 0.08146
R611 VSS.n298 VSS.n297 0.08146
R612 VSS.n6 VSS.n298 0.08146
R613 VSS.t58 VSS.n6 0.08146
R614 VSS.n228 VSS.n227 0.0812785
R615 VSS.t71 VSS.t58 1.05148
R616 VSS.n209 VSS 0.0445
R617 VSS.t15 VSS.n172 0.0394177
R618 VSS.n213 VSS.t99 0.0394177
R619 VSS.n319 VSS.n172 0.0389615
R620 VSS.n249 VSS.n213 0.0389615
R621 VSS.t75 VSS.n257 0.031258
R622 VSS.n254 VSS.t32 0.031258
R623 VSS.n295 VSS.n294 0.0291125
R624 VSS.n295 VSS.n252 0.0291125
R625 VSS.n294 VSS.n253 0.0281144
R626 VSS.n258 VSS.n252 0.0281144
R627 VSS.n256 VSS.n255 0.0202884
R628 VSS.n293 VSS.n292 0.0202884
R629 VSS.t58 VSS.n5 0.0197308
R630 VSS.n291 VSS.n67 0.0159649
R631 VSS.n232 VSS.t65 0.0133922
R632 VSS.t61 VSS.n214 0.0133922
R633 VSS.n287 VSS.n185 0.0118857
R634 VSS.n286 VSS.n186 0.0118857
R635 VSS.n285 VSS.n186 0.0118857
R636 VSS.n284 VSS.n187 0.0118857
R637 VSS.n283 VSS.n188 0.0118857
R638 VSS.n282 VSS.n188 0.0118857
R639 VSS.n281 VSS.n190 0.0118857
R640 VSS.n280 VSS.n190 0.0118857
R641 VSS.n4 VSS.n208 0.0283655
R642 VSS.n277 VSS.n3 0.062614
R643 VSS.n275 VSS.n207 0.0118857
R644 VSS.n273 VSS.n194 0.0118857
R645 VSS.n272 VSS.n194 0.0118857
R646 VSS.n270 VSS.n196 0.0118857
R647 VSS.n269 VSS.n196 0.0118857
R648 VSS.n268 VSS.n197 0.0118857
R649 VSS.n266 VSS.n126 0.0118857
R650 VSS.n265 VSS.n206 0.0118857
R651 VSS.n264 VSS.n204 0.0118857
R652 VSS.n263 VSS.n132 0.0118857
R653 VSS.n262 VSS.n203 0.0118857
R654 VSS.n261 VSS.n202 0.0118857
R655 VSS.n260 VSS.n200 0.0118857
R656 VSS.n259 VSS.n200 0.0118857
R657 VSS.n259 VSS.n199 0.0118857
R658 VSS.n260 VSS.n201 0.0118857
R659 VSS.n261 VSS.n201 0.0118857
R660 VSS.n262 VSS.n202 0.0118857
R661 VSS.n263 VSS.n203 0.0118857
R662 VSS.n264 VSS.n205 0.0118857
R663 VSS.n265 VSS.n205 0.0118857
R664 VSS.n266 VSS.n206 0.0118857
R665 VSS.n267 VSS.n198 0.0118857
R666 VSS.n268 VSS.n198 0.0118857
R667 VSS.n269 VSS.n197 0.0118857
R668 VSS.n271 VSS.n195 0.0118857
R669 VSS.n272 VSS.n195 0.0118857
R670 VSS.n273 VSS.n193 0.0118857
R671 VSS.n274 VSS.n193 0.0118857
R672 VSS.n275 VSS.n42 0.0118857
R673 VSS.n281 VSS.n189 0.0118857
R674 VSS.n282 VSS.n189 0.0118857
R675 VSS.n285 VSS.n187 0.0118857
R676 VSS.n286 VSS.n185 0.0118857
R677 VSS.n129 VSS.n7 0.130549
R678 VSS.n291 VSS.n255 0.0115582
R679 VSS.n292 VSS.n291 0.0115582
R680 VSS.n65 VSS.n47 0.0112168
R681 VSS.n65 VSS.n48 0.0112168
R682 VSS.n65 VSS.n49 0.0112168
R683 VSS.n65 VSS.n50 0.0112168
R684 VSS.n65 VSS.n51 0.0112168
R685 VSS.n65 VSS.n52 0.0112168
R686 VSS.n65 VSS.n53 0.0112168
R687 VSS.n65 VSS.n54 0.0112168
R688 VSS.n65 VSS.n56 0.0112168
R689 VSS.n65 VSS.n57 0.0112168
R690 VSS.n65 VSS.n58 0.0112168
R691 VSS.n65 VSS.n59 0.0112168
R692 VSS.n65 VSS.n60 0.0112168
R693 VSS.n65 VSS.n61 0.0112168
R694 VSS.n65 VSS.n62 0.0112168
R695 VSS.n65 VSS.n63 0.0112168
R696 VSS.n64 VSS.t113 9.76925
R697 VSS.n119 VSS.n91 0.143492
R698 VSS.n276 VSS.n192 0.0108889
R699 VSS.n278 VSS.n191 0.0108889
R700 VSS.n257 VSS.n256 0.0108877
R701 VSS.n293 VSS.n254 0.0108877
R702 VSS.n291 VSS.t76 0.00981217
R703 VSS.n291 VSS.t71 0.00981217
R704 VSS.n65 VSS.n55 0.00963963
R705 VSS.n134 VSS.n133 0.0054294
R706 VSS.n127 VSS.n125 0.00813889
R707 VSS.n129 VSS.n128 0.00481859
R708 VSS.n182 VSS.n176 0.00798582
R709 VSS.n0 VSS.n175 0.034931
R710 VSS.n40 VSS.n175 0.0150055
R711 VSS.n219 VSS.n130 0.0150226
R712 VSS.n233 VSS.n219 0.00798582
R713 VSS.n238 VSS.n131 0.0150083
R714 VSS.n238 VSS.n218 0.00798582
R715 VSS.n177 VSS.n166 0.0151369
R716 VSS.n46 VSS.n279 0.0118857
R717 VSS.n44 VSS.n43 0.0108889
R718 VSS.n133 VSS.n132 0.00772064
R719 VSS.n177 VSS.n176 0.00756994
R720 VSS.n41 VSS.n182 0.0150235
R721 VSS.n40 VSS.n184 0.00154752
R722 VSS.n235 VSS.n130 0.00153042
R723 VSS.n234 VSS.n233 0.00756994
R724 VSS.n234 VSS.n232 0.00756994
R725 VSS.n236 VSS.n131 0.00154475
R726 VSS.n237 VSS.n218 0.00756994
R727 VSS.n237 VSS.n214 0.00756994
R728 VSS.n121 VSS.n120 0.00420773
R729 VSS.n123 VSS.n122 0.00420773
R730 VSS.n291 VSS.n290 0.00630556
R731 VSS.n44 VSS.n42 0.00619286
R732 VSS.n290 VSS.n199 0.00619286
R733 VSS.n274 VSS.n43 0.00619286
R734 VSS.n271 VSS.n120 0.00990059
R735 VSS.n267 VSS.n125 0.00619286
R736 VSS.n276 VSS.n207 0.00619286
R737 VSS.n277 VSS.n192 0.00619286
R738 VSS.n278 VSS.n208 0.00619286
R739 VSS.n279 VSS.n191 0.00619286
R740 VSS.n280 VSS.n45 0.00619286
R741 VSS.n283 VSS.n122 0.00990059
R742 VSS.n287 VSS.n128 0.0105114
R743 VSS.n284 VSS.n123 0.0101651
R744 VSS.n270 VSS.n121 0.0101651
R745 VSS.n127 VSS.n126 0.00894286
R746 VSS.n65 VSS.n64 0.00767282
R747 VSS.n300 VSS.n2 6777.49
C0 vin3 vout3 16.0649f
C1 vin2 vin1 0.11002f
C2 VDD vout4 11.7328f
C3 vout1 VDD 11.7328f
C4 vin3 VDD 26.9696f
C5 vout2 VDD 11.7272f
C6 vin3 vin2 0.12731f
C7 vin4 vout4 16.0649f
C8 vout3 VDD 11.7272f
C9 vin2 vout2 16.0649f
C10 vin3 vin4 0.11002f
C11 vin1 vout1 16.0649f
C12 vin2 VDD 26.9696f
C13 vin4 VDD 27.0009f
C14 vin1 VDD 27.0009f
C15 vout1 VSS 11.99485f
C16 vout2 VSS 11.97725f
C17 vout3 VSS 11.97725f
C18 vout4 VSS 11.99485f
C19 VSS.t58 VSS 7.1315f
C20 VSS.t24 VSS 7.1491f
.ends
