* Extracted by KLayout with SG13CMOS5L LVS runset on : 03/11/2026 19:36

.SUBCKT vco_core VSS rf_n rf_p vdd_core vtune
X$1 VSS rf_p vtune rf_n vco_var
M$1 VSS rf_p rf_n VSS sg13_lv_nmos L=0.13u W=20u AS=4.1p AD=4.1p PS=26.1u
+ PD=26.1u rfmode=0
M$11 VSS rf_n rf_p VSS sg13_lv_nmos L=0.13u W=20u AS=4.1p AD=4.1p PS=26.1u
+ PD=26.1u rfmode=0
C$21 VSS vdd_core cap_cmomf w=19u l=26u A=0p P=0u m=2
C$22 vdd_core VSS cap_cmomf w=19u l=26u A=0p P=0u m=2
C$25 VSS vdd_core cap_cmomf w=25.5u l=19u A=0p P=0u m=1
C$26 vdd_core VSS cap_cmomf w=25.5u l=19u A=0p P=0u m=1
.ENDS vco_core

.SUBCKT vco_var VSS rf_p vtune rf_n
C$1 rf_p vtune rf_n VSS sg13_hv_svaricap w=3.74u l=0.3u Nx=8
C$2 rf_p vtune rf_n VSS sg13_hv_svaricap w=3.74u l=0.3u Nx=8
C$3 rf_p vtune rf_n VSS sg13_hv_svaricap w=3.74u l=0.3u Nx=8
.ENDS vco_var
