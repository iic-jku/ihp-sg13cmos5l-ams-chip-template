* Extracted by KLayout with SG13CMOS5L LVS runset on : 07/11/2026 12:30

.SUBCKT vco_top VDD VSS di_en ibias_100u rf_out_n rf_out_p vdd_core vtune
X$1 VSS vdd_core \$35 vtune \$36 vco_core
X$3 VSS rf_out_n \$21 rf_out_p VDD \$35 \$29 \$36 vco_buf
X$4 \$21 VSS \$29 di_en ibias_100u VDD vco_bias
L$1 \$35 \$36 VSS inductor w=3.999u s=4u d=50.004u nr_r=2
.ENDS vco_top

.SUBCKT vco_bias vbn_buf VSS vbg_buf di_en ibias_100u VDD
M$1 VSS vbn_buf VSS VSS sg13_lv_nmos L=10u W=80u AS=17.6p AD=17.6p PS=100.4u
+ PD=100.4u rfmode=0
M$11 VSS \$28 \$29 VSS sg13_lv_nmos L=0.13u W=0.5u AS=0.17p AD=0.17p PS=1.68u
+ PD=1.68u rfmode=0
M$12 VSS VSS VSS VSS sg13_lv_nmos L=0.5u W=5u AS=1.7p AD=1.7p PS=11.36u
+ PD=11.36u rfmode=0
M$13 VSS ibias_100u \$25 VSS sg13_lv_nmos L=0.5u W=2.5u AS=0.85p AD=0.85p
+ PS=5.68u PD=5.68u rfmode=0
M$14 VSS \$28 vbn_buf VSS sg13_lv_nmos L=0.13u W=1u AS=0.34p AD=0.34p PS=2.68u
+ PD=2.68u rfmode=0
M$15 VSS \$24 \$24 VSS sg13_lv_nmos L=0.5u W=2.5u AS=0.85p AD=0.85p PS=5.68u
+ PD=5.68u rfmode=0
M$16 VSS vbg_buf VSS VSS sg13_lv_nmos L=10u W=80u AS=17.6p AD=17.6p PS=100.4u
+ PD=100.4u rfmode=0
M$22 VSS \$28 ibias_100u VSS sg13_lv_nmos L=0.13u W=1u AS=0.34p AD=0.34p
+ PS=2.68u PD=2.68u rfmode=0
M$23 VSS di_en \$28 VSS sg13_lv_nmos L=0.13u W=0.5u AS=0.17p AD=0.17p PS=1.68u
+ PD=1.68u rfmode=0
M$24 VSS ibias_100u ibias_100u VSS sg13_lv_nmos L=0.5u W=2.5u AS=0.85p AD=0.85p
+ PS=5.68u PD=5.68u rfmode=0
M$30 VDD \$25 \$25 VDD sg13_lv_pmos L=0.5u W=5u AS=1.7p AD=1.7p PS=10.68u
+ PD=10.68u rfmode=0
M$31 VDD VDD VDD VDD sg13_lv_pmos L=0.5u W=15u AS=5.1p AD=5.1p PS=32.04u
+ PD=32.04u rfmode=0
M$34 VDD VDD VDD VDD sg13_lv_pmos L=0.13u W=1u AS=0.34p AD=0.34p PS=2.68u
+ PD=2.68u rfmode=0
M$35 VDD \$29 \$25 VDD sg13_lv_pmos L=0.13u W=1u AS=0.34p AD=0.34p PS=2.68u
+ PD=2.68u rfmode=0
M$36 VDD \$25 \$44 VDD sg13_lv_pmos L=0.5u W=5u AS=1.7p AD=1.7p PS=10.68u
+ PD=10.68u rfmode=0
M$37 VDD di_en \$28 VDD sg13_lv_pmos L=0.13u W=1u AS=0.34p AD=0.34p PS=2.68u
+ PD=2.68u rfmode=0
M$38 VDD \$28 \$29 VDD sg13_lv_pmos L=0.13u W=1u AS=0.34p AD=0.34p PS=2.68u
+ PD=2.68u rfmode=0
R$39 \$24 \$44 VSS rppd w=0.5u l=8.5u ps=0u b=0 m=1
R$40 vbn_buf ibias_100u VSS rhigh w=0.5u l=32u ps=0u b=0 m=1
R$41 vbg_buf \$44 VSS rhigh w=0.5u l=32u ps=0u b=0 m=1
C$42 VSS vbg_buf cap_cmomf w=20.55u l=20.7u A=0p P=0u m=1
C$43 VSS vbg_buf cap_cmomf w=8.58u l=14.8u A=0p P=0u m=1
.ENDS vco_bias

.SUBCKT vco_buf VSS rf_out_n vbn_buf rf_out_p VDD rf_p vbg_buf rf_n
M$1 VSS vbn_buf \$5 VSS sg13_lv_nmos L=0.5u W=150u AS=29.25p AD=29.25p
+ PS=166.7u PD=166.7u rfmode=0
M$31 \$5 \$17 rf_out_n VSS sg13_lv_nmos L=0.13u W=24u AS=4.86p AD=4.86p
+ PS=30.86u PD=30.86u rfmode=0
M$43 \$5 \$19 rf_out_p VSS sg13_lv_nmos L=0.13u W=24u AS=4.86p AD=4.86p
+ PS=30.86u PD=30.86u rfmode=0
R$55 rf_out_n VDD VSS rppd w=10u l=1.65u ps=0u b=0 m=1
R$56 rf_out_p VDD VSS rppd w=10u l=1.65u ps=0u b=0 m=1
R$57 \$17 vbg_buf VSS rhigh w=0.5u l=8u ps=0u b=0 m=1
R$58 \$19 vbg_buf VSS rhigh w=0.5u l=8u ps=0u b=0 m=1
C$59 rf_p \$17 cap_cmomf w=10u l=18.6u A=0p P=0u m=1
C$60 \$19 rf_n cap_cmomf w=10u l=18.6u A=0p P=0u m=1
.ENDS vco_buf

.SUBCKT vco_core VSS vdd_core rf_p vtune rf_n
X$1 VSS rf_p vtune rf_n vco_var
M$1 VSS rf_p rf_n VSS sg13_lv_nmos L=0.13u W=20u AS=4.1p AD=4.1p PS=26.1u
+ PD=26.1u rfmode=0
M$11 VSS rf_n rf_p VSS sg13_lv_nmos L=0.13u W=20u AS=4.1p AD=4.1p PS=26.1u
+ PD=26.1u rfmode=0
C$21 VSS vdd_core cap_cmomf w=19u l=26u A=0p P=0u m=2
C$22 vdd_core VSS cap_cmomf w=19u l=26u A=0p P=0u m=2
C$25 VSS vdd_core cap_cmomf w=25.5u l=19u A=0p P=0u m=1
C$26 vdd_core VSS cap_cmomf w=25.5u l=19u A=0p P=0u m=1
.ENDS vco_core

.SUBCKT vco_var VSS rf_p vtune rf_n
C$1 rf_p vtune rf_n VSS sg13_hv_svaricap w=3.74u l=0.3u Nx=8
C$2 rf_p vtune rf_n VSS sg13_hv_svaricap w=3.74u l=0.3u Nx=8
C$3 rf_p vtune rf_n VSS sg13_hv_svaricap w=3.74u l=0.3u Nx=8
.ENDS vco_var
