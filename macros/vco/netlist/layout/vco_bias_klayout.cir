* Extracted by KLayout with SG13CMOS5L LVS runset on : 07/11/2026 21:41

.SUBCKT vco_bias VDD VSS di_en en_b vbg_buf vbn_buf
M$1 VSS vbn_buf VSS VSS sg13_lv_nmos L=10u W=80u AS=17.6p AD=17.6p PS=100.4u
+ PD=100.4u rfmode=0
M$11 VSS en_b \$29 VSS sg13_lv_nmos L=0.13u W=0.5u AS=0.17p AD=0.17p PS=1.68u
+ PD=1.68u rfmode=0
M$12 VSS VSS VSS VSS sg13_lv_nmos L=0.5u W=5u AS=1.7p AD=1.7p PS=11.36u
+ PD=11.36u rfmode=0
M$13 VSS \$23 \$31 VSS sg13_lv_nmos L=0.5u W=2.5u AS=0.85p AD=0.85p PS=5.68u
+ PD=5.68u rfmode=0
M$14 VSS en_b vbn_buf VSS sg13_lv_nmos L=0.13u W=1u AS=0.34p AD=0.34p PS=2.68u
+ PD=2.68u rfmode=0
M$15 VSS \$24 \$24 VSS sg13_lv_nmos L=0.5u W=2.5u AS=0.85p AD=0.85p PS=5.68u
+ PD=5.68u rfmode=0
M$16 VSS vbg_buf VSS VSS sg13_lv_nmos L=10u W=80u AS=17.6p AD=17.6p PS=100.4u
+ PD=100.4u rfmode=0
M$22 VSS en_b \$23 VSS sg13_lv_nmos L=0.13u W=1u AS=0.34p AD=0.34p PS=2.68u
+ PD=2.68u rfmode=0
M$23 VSS di_en en_b VSS sg13_lv_nmos L=0.13u W=0.5u AS=0.17p AD=0.17p PS=1.68u
+ PD=1.68u rfmode=0
M$24 VSS \$23 \$23 VSS sg13_lv_nmos L=0.5u W=2.5u AS=0.85p AD=0.85p PS=5.68u
+ PD=5.68u rfmode=0
M$30 VDD VDD VDD VDD sg13_lv_pmos L=0.5u W=10u AS=3.4p AD=3.4p PS=21.36u
+ PD=21.36u rfmode=0
M$31 VDD \$31 \$31 VDD sg13_lv_pmos L=0.5u W=5u AS=1.7p AD=1.7p PS=10.68u
+ PD=10.68u rfmode=0
M$32 VDD en_b \$29 VDD sg13_lv_pmos L=0.13u W=1u AS=0.34p AD=0.34p PS=2.68u
+ PD=2.68u rfmode=0
M$33 VDD \$31 \$49 VDD sg13_lv_pmos L=0.5u W=5u AS=1.7p AD=1.7p PS=10.68u
+ PD=10.68u rfmode=0
M$34 VDD di_en en_b VDD sg13_lv_pmos L=0.13u W=1u AS=0.34p AD=0.34p PS=2.68u
+ PD=2.68u rfmode=0
M$35 VDD en_b \$48 VDD sg13_lv_pmos L=0.13u W=2u AS=0.68p AD=0.68p PS=4.68u
+ PD=4.68u rfmode=0
M$36 VDD \$29 \$31 VDD sg13_lv_pmos L=0.13u W=1u AS=0.34p AD=0.34p PS=2.68u
+ PD=2.68u rfmode=0
M$37 VDD VDD VDD VDD sg13_lv_pmos L=0.13u W=1u AS=0.34p AD=0.34p PS=2.68u
+ PD=2.68u rfmode=0
R$39 \$24 \$49 VSS rppd w=0.5u l=8.5u ps=0u b=0 m=1
R$40 \$23 \$48 VSS rppd w=0.5u l=13.1u ps=0u b=0 m=1
R$41 vbn_buf \$23 VSS rhigh w=0.5u l=32u ps=0u b=0 m=1
R$42 vbg_buf \$49 VSS rhigh w=0.5u l=32u ps=0u b=0 m=1
C$43 VSS vbg_buf cap_cmomf w=8.58u l=14.8u A=0p P=0u m=1
C$44 VSS vbg_buf cap_cmomf w=20.55u l=18.7u A=0p P=0u m=1
.ENDS vco_bias
