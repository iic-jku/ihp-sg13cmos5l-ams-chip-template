* PEX produced on Tue Nov  3 11:30:13 PM CET 2026 using /foss/tools/sak/sak-pex.sh with m=3 and s=1 (extresist threshold=1000 mOhm, minres=100 mOhm, mindelay=0 ps)
* NGSPICE file created from vco_top_pex.ext - technology: ihp-sg13cmos5l

.subckt vco_top_pex ibias_100u di_en VDD VSS vdd_core vtune rf_out_p rf_out_n
X0 VSS.t157 vdd_core.t3 vdd_core.t6 VSS.t156 sg13_lv_nmos ad=0.38p pd=2.38u as=0.38p ps=2.38u w=2u l=0.13u
X1 a_11798_1860.t11 vco_bias_0.vbn_buf.t2 VSS.t84 VSS.t85 sg13_lv_nmos ad=0.95p pd=5.38u as=0.95p ps=5.38u w=5u l=0.5u
X2 rf_out_n.t5 a_9400_4880# a_11798_1860.t20 VSS.t107 sg13_lv_nmos ad=0.38p pd=2.38u as=0.38p ps=2.38u w=2u l=0.13u
X3 rf_out_n.t1 a_9400_4880# a_11798_1860.t18 VSS.t103 sg13_lv_nmos ad=0.38p pd=2.38u as=0.38p ps=2.38u w=2u l=0.13u
X4 VSS.t42 vco_bias_0.vbg_buf VSS.t41 VSS.t0 sg13_lv_nmos ad=2.72p pd=16.68u as=0 ps=0 w=8u l=10u
X5 VSS.t141 vdd_core.t0 vdd_core.t9 VSS.t140 sg13_lv_nmos ad=0.38p pd=2.38u as=0.38p ps=2.38u w=2u l=0.13u
X6 a_11798_1860.t12 vco_bias_0.vbn_buf.t2 VSS.t87 VSS.t88 sg13_lv_nmos ad=0.95p pd=5.38u as=0.95p ps=5.38u w=5u l=0.5u
X7 VSS.t10 vco_bias_0.vbn_buf.t3 VSS.t8 VSS.t9 sg13_lv_nmos ad=1.52p pd=8.38u as=0 ps=0 w=8u l=10u
X8 a_11798_1860.t23 a_14668_3324# rf_out_p.t1 VSS.t117 sg13_lv_nmos ad=0.38p pd=2.38u as=0.38p ps=2.38u w=2u l=0.13u
X9 a_11798_1860.t1 vco_bias_0.vbn_buf.t2 VSS.t58 VSS.t61 sg13_lv_nmos ad=0.95p pd=5.38u as=0.95p ps=5.38u w=5u l=0.5u
X10 VSS.t68 vco_bias_0.vbn_buf.t2 a_11798_1860.t4 VSS.t67 sg13_lv_nmos ad=0.95p pd=5.38u as=0.95p ps=5.38u w=5u l=0.5u
X11 a_11798_1860.t2 vco_bias_0.vbn_buf.t2 VSS.t60 VSS.t59 sg13_lv_nmos ad=0.95p pd=5.38u as=0.95p ps=5.38u w=5u l=0.5u
X12 vdd_core.t2 vdd_core.t0 VSS.t135 VSS.t136 sg13_lv_nmos ad=0.38p pd=2.38u as=0.38p ps=2.38u w=2u l=0.13u
X13 VSS.t71 vco_bias_0.vbn_buf.t2 a_11798_1860.t5 VSS.t70 sg13_lv_nmos ad=0.95p pd=5.38u as=0.95p ps=5.38u w=5u l=0.5u
X14 vdd_core.t13 vdd_core.t0 VSS.t130 VSS.t129 sg13_lv_nmos ad=0.38p pd=2.38u as=0.68p ps=4.68u w=2u l=0.13u
X15 VSS.t151 vdd_core.t3 vdd_core.t17 VSS.t150 sg13_lv_nmos ad=0.38p pd=2.38u as=0.38p ps=2.38u w=2u l=0.13u
X16 a_11798_1860.t9 vco_bias_0.vbn_buf.t2 VSS.t54 VSS.t81 sg13_lv_nmos ad=0.95p pd=5.38u as=0.95p ps=5.38u w=5u l=0.5u
X17 a_11798_1860.t26 a_14668_3324# rf_out_p.t6 VSS.t123 sg13_lv_nmos ad=0.38p pd=2.38u as=0.38p ps=2.38u w=2u l=0.13u
X18 rf_out_p.t5 a_14668_3324# a_11798_1860.t24 VSS.t120 sg13_lv_nmos ad=0.38p pd=2.38u as=0.38p ps=2.38u w=2u l=0.13u
X19 ibias_100u.t2 ibias_100u.t1 VSS.t18 VSS.t11 sg13_lv_nmos ad=0.85p pd=5.68u as=0.85p ps=5.68u w=2.5u l=0.5u
X20 vco_bias_0.vbn_buf.t0 a_1254_3500.t2 VSS.t17 VSS.t13 sg13_lv_nmos ad=0.34p pd=2.68u as=0.34p ps=2.68u w=1u l=0.13u
X21 VSS.t132 vdd_core.t0 vdd_core.t13 VSS.t131 sg13_lv_nmos ad=0.38p pd=2.38u as=0.38p ps=2.38u w=2u l=0.13u
X22 a_11798_1860.t16 a_9400_4880# rf_out_n.t0 VSS.t98 sg13_lv_nmos ad=0.38p pd=2.38u as=0.38p ps=2.38u w=2u l=0.13u
X23 VSS.t44 vco_bias_0.vbg_buf VSS.t42 VSS.t3 sg13_lv_nmos ad=1.52p pd=8.38u as=0 ps=0 w=8u l=10u
X24 VSS.t64 vco_bias_0.vbn_buf.t2 a_11798_1860.t2 VSS.t63 sg13_lv_nmos ad=0.95p pd=5.38u as=0.95p ps=5.38u w=5u l=0.5u
X25 a_11798_1860.t21 a_9400_4880# rf_out_n.t5 VSS.t108 sg13_lv_nmos ad=0.68p pd=4.68u as=0.38p ps=2.38u w=2u l=0.13u
X26 a_1474_1770.t1 a_5428_3064.t2 VSS.t111 rppd l=8.5u w=0.5u
X27 VSS.t54 vco_bias_0.vbn_buf.t2 a_11798_1860.t8 VSS.t53 sg13_lv_nmos ad=0.95p pd=5.38u as=0.95p ps=5.38u w=5u l=0.5u
X28 a_11798_1860.t6 vco_bias_0.vbn_buf.t2 VSS.t71 VSS.t72 sg13_lv_nmos ad=0.95p pd=5.38u as=0.95p ps=5.38u w=5u l=0.5u
X29 a_11798_1860.t19 a_9400_4880# rf_out_n.t1 VSS.t104 sg13_lv_nmos ad=0.38p pd=2.38u as=0.38p ps=2.38u w=2u l=0.13u
X30 a_11798_1860.t17 a_9400_4880# rf_out_n.t3 VSS.t100 sg13_lv_nmos ad=0.38p pd=2.38u as=0.38p ps=2.38u w=2u l=0.13u
X31 vco_bias_0.vbg_buf a_14668_3324# VSS.t114 rhigh l=8u w=0.5u
X32 vdd_core.t8 vdd_core.t3 VSS.t157 VSS.t158 sg13_lv_nmos ad=0.38p pd=2.38u as=0.38p ps=2.38u w=2u l=0.13u
X33 VSS.t24 vco_bias_0.vbn_buf.t4 VSS.t22 VSS.t23 sg13_lv_nmos ad=1.52p pd=8.38u as=0 ps=0 w=8u l=10u
X34 VSS.t28 vco_bias_0.vbn_buf.t4 VSS.t26 VSS.t27 sg13_lv_nmos ad=1.52p pd=8.38u as=0 ps=0 w=8u l=10u
X35 vdd_core.t10 vdd_core.t0 VSS.t141 VSS.t142 sg13_lv_nmos ad=0.38p pd=2.38u as=0.38p ps=2.38u w=2u l=0.13u
X36 rf_out_p.t2 a_14668_3324# a_11798_1860.t23 VSS.t118 sg13_lv_nmos ad=0.38p pd=2.38u as=0.38p ps=2.38u w=2u l=0.13u
X37 a_1254_3500.t1 di_en.t0 VSS.t128 VSS.t15 sg13_lv_nmos ad=0.17p pd=1.68u as=0.17p ps=1.68u w=0.5u l=0.13u
X38 VSS.t38 vco_bias_0.vbg_buf VSS.t36 VSS.t7 sg13_lv_nmos ad=1.52p pd=8.38u as=0 ps=0 w=8u l=10u
X39 a_11798_1860.t3 vco_bias_0.vbn_buf.t2 VSS.t64 VSS.t65 sg13_lv_nmos ad=0.95p pd=5.38u as=0.95p ps=5.38u w=5u l=0.5u
X40 VSS.t74 vco_bias_0.vbn_buf.t2 a_11798_1860.t6 VSS.t73 sg13_lv_nmos ad=0.95p pd=5.38u as=0.95p ps=5.38u w=5u l=0.5u
N41 vdd_core.t26 vtune.t0 sg13_hv_svaricap l=0.3u w=30.08u
X42 a_11798_1860.t28 a_14668_3324# rf_out_p.t4 VSS.t127 sg13_lv_nmos ad=0.68p pd=4.68u as=0.38p ps=2.38u w=2u l=0.13u
X43 rf_out_p.t3 a_14668_3324# a_11798_1860.t26 VSS.t124 sg13_lv_nmos ad=0.38p pd=2.38u as=0.38p ps=2.38u w=2u l=0.13u
X44 a_11798_1860.t25 a_14668_3324# rf_out_p.t5 VSS.t121 sg13_lv_nmos ad=0.38p pd=2.38u as=0.38p ps=2.38u w=2u l=0.13u
X45 VSS.t138 vdd_core.t0 vdd_core.t2 VSS.t137 sg13_lv_nmos ad=0.38p pd=2.38u as=0.38p ps=2.38u w=2u l=0.13u
X46 VSS.t36 vco_bias_0.vbg_buf VSS.t34 VSS.t5 sg13_lv_nmos ad=1.52p pd=8.38u as=0 ps=0 w=8u l=10u
X47 vdd_core.t5 vdd_core.t3 VSS.t151 VSS.t152 sg13_lv_nmos ad=0.38p pd=2.38u as=0.38p ps=2.38u w=2u l=0.13u
X48 rf_out_n.t3 a_9400_4880# a_11798_1860.t16 VSS.t99 sg13_lv_nmos ad=0.38p pd=2.38u as=0.38p ps=2.38u w=2u l=0.13u
X49 vdd_core.t4 vdd_core.t3 VSS.t146 VSS.t145 sg13_lv_nmos ad=0.38p pd=2.38u as=0.68p ps=4.68u w=2u l=0.13u
X50 a_1474_1770.t0 a_2654_5520.t4 VDD.t3 VDD.t2 sg13_lv_pmos ad=1.7p pd=10.68u as=1.7p ps=10.68u w=5u l=0.5u
N51 vdd_core.t22 vtune.t6 sg13_hv_svaricap l=0.3u w=30.08u
X52 VSS.t90 vco_bias_0.vbn_buf.t2 a_11798_1860.t12 VSS.t89 sg13_lv_nmos ad=0.95p pd=5.38u as=0.95p ps=5.38u w=5u l=0.5u
X53 a_11798_1860.t10 vco_bias_0.vbn_buf.t2 VSS.t80 VSS.t79 sg13_lv_nmos ad=0.95p pd=5.38u as=0.95p ps=5.38u w=5u l=0.5u
X54 a_11798_1860.t0 vco_bias_0.vbn_buf.t2 VSS.t56 VSS.t55 sg13_lv_nmos ad=0.95p pd=5.38u as=1.7p ps=10.68u w=5u l=0.5u
X55 vdd_core.t1 vdd_core.t0 VSS.t132 VSS.t133 sg13_lv_nmos ad=0.38p pd=2.38u as=0.38p ps=2.38u w=2u l=0.13u
X56 VDD.t8 rf_out_n.t6 VSS.t109 rppd l=1.65u w=10u
X57 VSS.t4 vco_bias_0.vbn_buf.t3 VSS.t2 VSS.t3 sg13_lv_nmos ad=1.52p pd=8.38u as=0 ps=0 w=8u l=10u
X58 VSS.t148 vdd_core.t3 vdd_core.t4 VSS.t147 sg13_lv_nmos ad=0.38p pd=2.38u as=0.38p ps=2.38u w=2u l=0.13u
X59 VSS.t52 vco_bias_0.vbn_buf.t2 a_11798_1860.t3 VSS.t51 sg13_lv_nmos ad=0.95p pd=5.38u as=0.95p ps=5.38u w=5u l=0.5u
X60 VSS.t8 vco_bias_0.vbn_buf.t3 VSS.t6 VSS.t7 sg13_lv_nmos ad=1.52p pd=8.38u as=0 ps=0 w=8u l=10u
X61 rf_out_n.t2 a_9400_4880# a_11798_1860.t19 VSS.t105 sg13_lv_nmos ad=0.38p pd=2.38u as=0.38p ps=2.38u w=2u l=0.13u
X62 rf_out_n.t4 a_9400_4880# a_11798_1860.t17 VSS.t101 sg13_lv_nmos ad=0.38p pd=2.38u as=0.38p ps=2.38u w=2u l=0.13u
X63 VSS.t26 vco_bias_0.vbn_buf.t4 VSS.t24 VSS.t25 sg13_lv_nmos ad=1.52p pd=8.38u as=0 ps=0 w=8u l=10u
X64 VSS.t40 vco_bias_0.vbg_buf VSS.t38 VSS.t9 sg13_lv_nmos ad=1.52p pd=8.38u as=0 ps=0 w=8u l=10u
X65 a_11798_1860.t24 a_14668_3324# rf_out_p.t2 VSS.t119 sg13_lv_nmos ad=0.38p pd=2.38u as=0.38p ps=2.38u w=2u l=0.13u
X66 rf_out_p.t1 a_14668_3324# a_11798_1860.t22 VSS.t116 sg13_lv_nmos ad=0.38p pd=2.38u as=0.68p ps=4.68u w=2u l=0.13u
X67 ibias_100u.t0 a_1254_3500.t3 VSS.t14 VSS.t13 sg13_lv_nmos ad=0.34p pd=2.68u as=0.34p ps=2.68u w=1u l=0.13u
X68 VSS.t48 vco_bias_0.vbg_buf VSS.t46 VSS.t7 sg13_lv_nmos ad=1.52p pd=8.38u as=0 ps=0 w=8u l=10u
X69 VSS.t80 vco_bias_0.vbn_buf.t2 a_11798_1860.t9 VSS.t82 sg13_lv_nmos ad=0.95p pd=5.38u as=0.95p ps=5.38u w=5u l=0.5u
X70 VSS.t58 vco_bias_0.vbn_buf.t2 a_11798_1860.t0 VSS.t57 sg13_lv_nmos ad=0.95p pd=5.38u as=0.95p ps=5.38u w=5u l=0.5u
N71 vdd_core.t24 vtune.t3 sg13_hv_svaricap l=0.3u w=30.08u
X72 a_11798_1860.t13 vco_bias_0.vbn_buf.t2 VSS.t90 VSS.t91 sg13_lv_nmos ad=0.95p pd=5.38u as=0.95p ps=5.38u w=5u l=0.5u
X73 a_2654_5520.t3 a_1954_3500.t2 VDD.t1 VDD.t0 sg13_lv_pmos ad=0.34p pd=2.68u as=0.34p ps=2.68u w=1u l=0.13u
X74 a_11798_1860.t14 vco_bias_0.vbn_buf.t2 VSS.t93 VSS.t94 sg13_lv_nmos ad=0.95p pd=5.38u as=0.95p ps=5.38u w=5u l=0.5u
X75 VSS.t160 vdd_core.t3 vdd_core.t8 VSS.t159 sg13_lv_nmos ad=0.68p pd=4.68u as=0.38p ps=2.38u w=2u l=0.13u
X76 VSS.t144 vdd_core.t0 vdd_core.t10 VSS.t143 sg13_lv_nmos ad=0.68p pd=4.68u as=0.38p ps=2.38u w=2u l=0.13u
X77 a_1954_3500.t0 a_1254_3500.t4 VSS.t16 VSS.t15 sg13_lv_nmos ad=0.17p pd=1.68u as=0.17p ps=1.68u w=0.5u l=0.13u
X78 a_11798_1860.t27 a_14668_3324# rf_out_p.t3 VSS.t125 sg13_lv_nmos ad=0.38p pd=2.38u as=0.38p ps=2.38u w=2u l=0.13u
X79 vco_bias_0.vbg_buf a_9400_4880# VSS.t110 rhigh l=8u w=0.5u
X80 VSS.t46 vco_bias_0.vbg_buf VSS.t44 VSS.t5 sg13_lv_nmos ad=1.52p pd=8.38u as=0 ps=0 w=8u l=10u
X81 a_1254_3500.t0 di_en.t1 VDD.t11 VDD.t10 sg13_lv_pmos ad=0.34p pd=2.68u as=0.34p ps=2.68u w=1u l=0.13u
X82 VSS.t6 vco_bias_0.vbn_buf.t3 VSS.t4 VSS.t5 sg13_lv_nmos ad=1.52p pd=8.38u as=0 ps=0 w=8u l=10u
X83 a_11798_1860.t4 vco_bias_0.vbn_buf.t2 VSS.t52 VSS.t66 sg13_lv_nmos ad=0.95p pd=5.38u as=0.95p ps=5.38u w=5u l=0.5u
X84 a_1474_1770.t2 vco_bias_0.vbg_buf VSS.t112 rhigh l=32u w=0.5u
X85 a_5428_3064.t1 a_5428_3064.t0 VSS.t12 VSS.t11 sg13_lv_nmos ad=0.85p pd=5.68u as=0.85p ps=5.68u w=2.5u l=0.5u
X86 VSS.t76 vco_bias_0.vbn_buf.t2 a_11798_1860.t7 VSS.t78 sg13_lv_nmos ad=0.95p pd=5.38u as=0.95p ps=5.38u w=5u l=0.5u
X87 VSS.t154 vdd_core.t3 vdd_core.t5 VSS.t153 sg13_lv_nmos ad=0.38p pd=2.38u as=0.38p ps=2.38u w=2u l=0.13u
X88 VSS.t93 vco_bias_0.vbn_buf.t2 a_11798_1860.t13 VSS.t92 sg13_lv_nmos ad=0.95p pd=5.38u as=0.95p ps=5.38u w=5u l=0.5u
X89 a_11798_1860.t20 a_9400_4880# rf_out_n.t2 VSS.t106 sg13_lv_nmos ad=0.38p pd=2.38u as=0.38p ps=2.38u w=2u l=0.13u
X90 a_11798_1860.t18 a_9400_4880# rf_out_n.t4 VSS.t102 sg13_lv_nmos ad=0.38p pd=2.38u as=0.38p ps=2.38u w=2u l=0.13u
X91 VSS.t96 vco_bias_0.vbn_buf.t2 a_11798_1860.t14 VSS.t95 sg13_lv_nmos ad=1.7p pd=10.68u as=0.95p ps=5.38u w=5u l=0.5u
X92 VSS.t22 vco_bias_0.vbn_buf.t4 VSS.t21 VSS.t20 sg13_lv_nmos ad=2.72p pd=16.68u as=0 ps=0 w=8u l=10u
X93 VSS.t32 vco_bias_0.vbg_buf VSS.t31 VSS.t0 sg13_lv_nmos ad=2.72p pd=16.68u as=0 ps=0 w=8u l=10u
X94 a_2654_5520.t0 ibias_100u.t4 VSS.t19 VSS.t11 sg13_lv_nmos ad=0.85p pd=5.68u as=0.85p ps=5.68u w=2.5u l=0.5u
X95 VSS.t50 vco_bias_0.vbg_buf VSS.t48 VSS.t9 sg13_lv_nmos ad=1.52p pd=8.38u as=0 ps=0 w=8u l=10u
X96 VSS.t135 vdd_core.t0 vdd_core.t1 VSS.t134 sg13_lv_nmos ad=0.38p pd=2.38u as=0.38p ps=2.38u w=2u l=0.13u
X97 vdd_core.t6 vdd_core.t3 VSS.t154 VSS.t155 sg13_lv_nmos ad=0.38p pd=2.38u as=0.38p ps=2.38u w=2u l=0.13u
X98 ibias_100u.t3 vco_bias_0.vbn_buf.t1 VSS.t113 rhigh l=32u w=0.5u
X99 vdd_core.t9 vdd_core.t0 VSS.t138 VSS.t139 sg13_lv_nmos ad=0.38p pd=2.38u as=0.38p ps=2.38u w=2u l=0.13u
X100 vdd_core.t17 vdd_core.t3 VSS.t148 VSS.t149 sg13_lv_nmos ad=0.38p pd=2.38u as=0.38p ps=2.38u w=2u l=0.13u
N101 vdd_core.t23 vtune.t6 sg13_hv_svaricap l=0.3u w=30.08u
X102 a_11798_1860.t7 vco_bias_0.vbn_buf.t2 VSS.t74 VSS.t77 sg13_lv_nmos ad=0.95p pd=5.38u as=0.95p ps=5.38u w=5u l=0.5u
X103 VSS.t30 vco_bias_0.vbn_buf.t4 VSS.t28 VSS.t29 sg13_lv_nmos ad=1.52p pd=8.38u as=0 ps=0 w=8u l=10u
X104 VSS.t84 vco_bias_0.vbn_buf.t2 a_11798_1860.t10 VSS.t83 sg13_lv_nmos ad=0.95p pd=5.38u as=0.95p ps=5.38u w=5u l=0.5u
X105 a_11798_1860.t8 vco_bias_0.vbn_buf.t2 VSS.t76 VSS.t75 sg13_lv_nmos ad=0.95p pd=5.38u as=0.95p ps=5.38u w=5u l=0.5u
X106 VSS.t87 vco_bias_0.vbn_buf.t2 a_11798_1860.t11 VSS.t86 sg13_lv_nmos ad=0.95p pd=5.38u as=0.95p ps=5.38u w=5u l=0.5u
X107 rf_out_p.t4 a_14668_3324# a_11798_1860.t27 VSS.t126 sg13_lv_nmos ad=0.38p pd=2.38u as=0.38p ps=2.38u w=2u l=0.13u
X108 a_2654_5520.t2 a_2654_5520.t1 VDD.t7 VDD.t6 sg13_lv_pmos ad=1.7p pd=10.68u as=1.7p ps=10.68u w=5u l=0.5u
X109 rf_out_p.t6 a_14668_3324# a_11798_1860.t25 VSS.t122 sg13_lv_nmos ad=0.38p pd=2.38u as=0.38p ps=2.38u w=2u l=0.13u
N110 vdd_core.t25 vtune.t3 sg13_hv_svaricap l=0.3u w=30.08u
N111 vdd_core.t27 vtune.t0 sg13_hv_svaricap l=0.3u w=30.08u
X112 rf_out_n.t0 a_9400_4880# a_11798_1860.t15 VSS.t97 sg13_lv_nmos ad=0.38p pd=2.38u as=0.68p ps=4.68u w=2u l=0.13u
X113 VSS.t2 vco_bias_0.vbn_buf.t3 VSS.t1 VSS.t0 sg13_lv_nmos ad=2.72p pd=16.68u as=0 ps=0 w=8u l=10u
X114 VSS.t60 vco_bias_0.vbn_buf.t2 a_11798_1860.t1 VSS.t62 sg13_lv_nmos ad=0.95p pd=5.38u as=0.95p ps=5.38u w=5u l=0.5u
X115 VSS.t34 vco_bias_0.vbg_buf VSS.t32 VSS.t3 sg13_lv_nmos ad=1.52p pd=8.38u as=0 ps=0 w=8u l=10u
X116 a_11798_1860.t5 vco_bias_0.vbn_buf.t2 VSS.t68 VSS.t69 sg13_lv_nmos ad=0.95p pd=5.38u as=0.95p ps=5.38u w=5u l=0.5u
X117 VDD.t9 rf_out_p.t0 VSS.t115 rppd l=1.65u w=10u
X118 a_1954_3500.t1 a_1254_3500.t5 VDD.t5 VDD.t4 sg13_lv_pmos ad=0.34p pd=2.68u as=0.34p ps=2.68u w=1u l=0.13u
R0 ibias_100u.n3 ibias_100u.t3 54.3738
R1 ibias_100u.n0 ibias_100u.t4 34.6784
R2 ibias_100u.n1 ibias_100u.t1 34.2252
R3 ibias_100u.n2 ibias_100u.t0 20.5585
R4 ibias_100u.n0 ibias_100u.t2 14.6093
R5 ibias_100u.n3 ibias_100u.n2 1.7473
R6 ibias_100u ibias_100u.n3 1.2149
R7 ibias_100u.n2 ibias_100u.n1 0.5351
R8 ibias_100u.n1 ibias_100u.n0 0.3173
R9 rf_out_p rf_out_p.n2 7.11117
R10 rf_out_p.n0 rf_out_p.t1 4.77599
R11 rf_out_p.n1 rf_out_p.t4 4.72949
R12 rf_out_p.n1 rf_out_p.t3 4.72949
R13 rf_out_p.n0 rf_out_p.t6 4.72949
R14 rf_out_p.n0 rf_out_p.t5 4.72949
R15 rf_out_p.n0 rf_out_p.t2 4.72949
R16 rf_out_p.n2 rf_out_p.t0 2.40801
R17 rf_out_p.n2 rf_out_p.n1 0.685593
R18 rf_out_p.n1 rf_out_p.n0 0.186531
R19 rf_out_n rf_out_n.n2 7.11117
R20 rf_out_n.n0 rf_out_n.t5 4.77599
R21 rf_out_n.n0 rf_out_n.t2 4.72949
R22 rf_out_n.n0 rf_out_n.t1 4.72949
R23 rf_out_n.n1 rf_out_n.t4 4.72949
R24 rf_out_n.n1 rf_out_n.t3 4.72949
R25 rf_out_n.n1 rf_out_n.t0 4.72949
R26 rf_out_n.n2 rf_out_n.t6 2.40801
R27 rf_out_n.n2 rf_out_n.n1 0.685593
R28 rf_out_n.n1 rf_out_n.n0 0.186531
R29 di_en.n0 di_en.t1 26.3252
R30 di_en.n0 di_en.t0 24.5065
R31 di_en di_en.n0 10.1632
R32 vdd_core.n87 vdd_core.n86 6.52948
R33 vdd_core.n46 vdd_core.n45 6.52948
R34 vdd_core.n102 vdd_core.n101 6.47038
R35 vdd_core.n169 vdd_core.n168 6.47038
R36 vdd_core.n235 vdd_core.n234 6.05177
R37 vdd_core.n212 vdd_core.n24 6.00132
R38 vdd_core.n3 vdd_core.t10 4.76919
R39 vdd_core.n0 vdd_core.t4 4.76919
R40 vdd_core.n107 vdd_core.t13 4.74635
R41 vdd_core.n126 vdd_core.t8 4.74635
R42 vdd_core.n4 vdd_core.t9 4.72949
R43 vdd_core.n110 vdd_core.t2 4.72949
R44 vdd_core.n111 vdd_core.t1 4.72949
R45 vdd_core.n125 vdd_core.t6 4.72949
R46 vdd_core.n121 vdd_core.t5 4.72949
R47 vdd_core.n1 vdd_core.t17 4.72949
R48 vdd_core.n113 vdd_core.t3 4.17215
R49 vdd_core.n128 vdd_core.t0 4.00826
R50 vdd_core.n108 vdd_core.t22 3.71265
R51 vdd_core.n123 vdd_core.t23 3.6936
R52 vdd_core.n143 vdd_core.n142 3.55422
R53 vdd_core.n108 vdd_core.t24 3.41873
R54 vdd_core.n109 vdd_core.t26 3.41873
R55 vdd_core.n123 vdd_core.t25 3.39968
R56 vdd_core.n124 vdd_core.t27 3.39968
R57 vdd_core.n147 vdd_core.n117 3.34302
R58 vdd_core.n136 vdd_core.n115 3.13182
R59 vdd_core.n134 vdd_core.n120 2.4579
R60 vdd_core.n141 vdd_core.n140 2.3523
R61 vdd_core.n145 vdd_core.n116 2.3523
R62 vdd_core.n4 vdd_core.n3 0.0338961
R63 vdd_core.n1 vdd_core.n0 0.0338961
R64 vdd_core.n148 vdd_core.n114 2.2467
R65 vdd_core.n138 vdd_core.n137 2.2467
R66 vdd_core.n7 vdd_core.n115 0.0886235
R67 vdd_core.n130 vdd_core.n129 1.94587
R68 vdd_core.n149 vdd_core.n148 1.86783
R69 vdd_core.n133 vdd_core.n132 1.79979
R70 vdd_core.n142 vdd_core.n135 1.72436
R71 vdd_core.n144 vdd_core.n143 1.72436
R72 vdd_core.n147 vdd_core.n146 1.64893
R73 vdd_core.n139 vdd_core.n117 1.64893
R74 vdd_core.n136 vdd_core.n8 0.134007
R75 vdd_core.n129 vdd_core.n118 1.44601
R76 vdd_core.n131 vdd_core.n119 1.16033
R77 vdd_core.n2 vdd_core.n107 1.12056
R78 vdd_core.n127 vdd_core.n126 1.12056
R79 vdd_core vdd_core.n248 0.9603
R80 vdd_core.n150 vdd_core.n149 0.917955
R81 vdd_core.n129 vdd_core.n128 0.833239
R82 vdd_core.n2 vdd_core.n112 0.741487
R83 vdd_core.n127 vdd_core.n122 0.741487
R84 vdd_core.n150 vdd_core.n79 0.56175
R85 vdd_core.n248 vdd_core.n247 0.5505
R86 vdd_core.n14 vdd_core.n9 0.5505
R87 vdd_core.n217 vdd_core.n216 0.5505
R88 vdd_core.n219 vdd_core.n218 0.5505
R89 vdd_core.n221 vdd_core.n220 0.5505
R90 vdd_core.n225 vdd_core.n181 0.5505
R91 vdd_core.n230 vdd_core.n229 0.5505
R92 vdd_core.n232 vdd_core.n231 0.5505
R93 vdd_core.n178 vdd_core.n26 0.5505
R94 vdd_core.n175 vdd_core.n174 0.5505
R95 vdd_core.n173 vdd_core.n172 0.5505
R96 vdd_core.n60 vdd_core.n37 0.5505
R97 vdd_core.n166 vdd_core.n165 0.5505
R98 vdd_core.n164 vdd_core.n47 0.5505
R99 vdd_core.n163 vdd_core.n162 0.5505
R100 vdd_core.n155 vdd_core.n63 0.5505
R101 vdd_core.n152 vdd_core.n151 0.5505
R102 vdd_core.n150 vdd_core.n106 0.5505
R103 vdd_core.n246 vdd_core.n11 0.446709
R104 vdd_core.n246 vdd_core.n245 0.445751
R105 vdd_core.n97 vdd_core.n84 0.4405
R106 vdd_core.n89 vdd_core.n88 0.4405
R107 vdd_core.n50 vdd_core.n43 0.4405
R108 vdd_core.n49 vdd_core.n48 0.4405
R109 vdd_core.n192 vdd_core.n190 0.4405
R110 vdd_core.n191 vdd_core.n183 0.4405
R111 vdd_core.n101 vdd_core.n84 0.4405
R112 vdd_core.n88 vdd_core.n87 0.4405
R113 vdd_core.n168 vdd_core.n43 0.4405
R114 vdd_core.n48 vdd_core.n46 0.4405
R115 vdd_core.n190 vdd_core.n189 0.4405
R116 vdd_core.n184 vdd_core.n183 0.4405
R117 vdd_core.n131 vdd_core.n130 0.421631
R118 vdd_core.n95 vdd_core.n94 0.3635
R119 vdd_core.n94 vdd_core.n81 0.3635
R120 vdd_core.n77 vdd_core.n75 0.3635
R121 vdd_core.n75 vdd_core.n73 0.3635
R122 vdd_core.n69 vdd_core.n67 0.3635
R123 vdd_core.n67 vdd_core.n65 0.3635
R124 vdd_core.n92 vdd_core.n91 0.3635
R125 vdd_core.n91 vdd_core.n80 0.3635
R126 vdd_core.n76 vdd_core.n74 0.3635
R127 vdd_core.n74 vdd_core.n72 0.3635
R128 vdd_core.n68 vdd_core.n66 0.3635
R129 vdd_core.n66 vdd_core.n64 0.3635
R130 vdd_core.n58 vdd_core.n54 0.3635
R131 vdd_core.n58 vdd_core.n57 0.3635
R132 vdd_core.n42 vdd_core.n35 0.3635
R133 vdd_core.n35 vdd_core.n33 0.3635
R134 vdd_core.n29 vdd_core.n27 0.3635
R135 vdd_core.n27 vdd_core.n5 0.421153
R136 vdd_core.n56 vdd_core.n53 0.3635
R137 vdd_core.n56 vdd_core.n55 0.3635
R138 vdd_core.n44 vdd_core.n34 0.3635
R139 vdd_core.n34 vdd_core.n32 0.3635
R140 vdd_core.n198 vdd_core.n196 0.3635
R141 vdd_core.n200 vdd_core.n198 0.3635
R142 vdd_core.n211 vdd_core.n210 0.3635
R143 vdd_core.n210 vdd_core.n209 0.3635
R144 vdd_core.n207 vdd_core.n206 0.3635
R145 vdd_core.n206 vdd_core.n205 0.3635
R146 vdd_core.n185 vdd_core.n184 0.3635
R147 vdd_core.n197 vdd_core.n195 0.3635
R148 vdd_core.n199 vdd_core.n197 0.3635
R149 vdd_core.n237 vdd_core.n236 0.3635
R150 vdd_core.n238 vdd_core.n237 0.3635
R151 vdd_core.n241 vdd_core.n240 0.3635
R152 vdd_core.n242 vdd_core.n241 0.3635
R153 vdd_core.n158 vdd_core.n64 0.345639
R154 vdd_core.n2 vdd_core.n109 0.33314
R155 vdd_core.n160 vdd_core.n159 0.299759
R156 vdd_core.n109 vdd_core.n108 0.29442
R157 vdd_core.n124 vdd_core.n123 0.29442
R158 vdd_core.n187 vdd_core.n24 0.276447
R159 vdd_core.n189 vdd_core.n188 0.276447
R160 vdd_core.n194 vdd_core.n192 0.276447
R161 vdd_core.n196 vdd_core.n194 0.276447
R162 vdd_core.n202 vdd_core.n200 0.276447
R163 vdd_core.n209 vdd_core.n208 0.276447
R164 vdd_core.n208 vdd_core.n207 0.276447
R165 vdd_core.n205 vdd_core.n204 0.276447
R166 vdd_core.n203 vdd_core.n11 0.276447
R167 vdd_core.n234 vdd_core.n23 0.276447
R168 vdd_core.n193 vdd_core.n191 0.276447
R169 vdd_core.n195 vdd_core.n193 0.276447
R170 vdd_core.n201 vdd_core.n199 0.276447
R171 vdd_core.n239 vdd_core.n238 0.276447
R172 vdd_core.n240 vdd_core.n239 0.276447
R173 vdd_core.n243 vdd_core.n242 0.276447
R174 vdd_core.n245 vdd_core.n244 0.276447
R175 vdd_core.n97 vdd_core.n96 0.276188
R176 vdd_core.n96 vdd_core.n95 0.276188
R177 vdd_core.n104 vdd_core.n81 0.276188
R178 vdd_core.n73 vdd_core.n71 0.276188
R179 vdd_core.n71 vdd_core.n69 0.276188
R180 vdd_core.n160 vdd_core.n65 0.276188
R181 vdd_core.n90 vdd_core.n89 0.276188
R182 vdd_core.n92 vdd_core.n90 0.276188
R183 vdd_core.n83 vdd_core.n80 0.276188
R184 vdd_core.n72 vdd_core.n70 0.276188
R185 vdd_core.n70 vdd_core.n68 0.276188
R186 vdd_core.n52 vdd_core.n50 0.276188
R187 vdd_core.n54 vdd_core.n52 0.276188
R188 vdd_core.n57 vdd_core.n39 0.276188
R189 vdd_core.n33 vdd_core.n31 0.276188
R190 vdd_core.n31 vdd_core.n29 0.276188
R191 vdd_core.n51 vdd_core.n49 0.276188
R192 vdd_core.n53 vdd_core.n51 0.276188
R193 vdd_core.n55 vdd_core.n38 0.276188
R194 vdd_core.n32 vdd_core.n30 0.276188
R195 vdd_core.n30 vdd_core.n28 0.276188
R196 vdd_core.n144 vdd_core.n118 0.264545
R197 vdd_core.n102 vdd_core.n77 0.2645
R198 vdd_core.n86 vdd_core.n76 0.2645
R199 vdd_core.n169 vdd_core.n42 0.2645
R200 vdd_core.n45 vdd_core.n44 0.2645
R201 vdd_core.n212 vdd_core.n211 0.2645
R202 vdd_core.n236 vdd_core.n235 0.2645
R203 vdd_core.n8 vdd_core.n138 0.449962
R204 vdd_core.n119 vdd_core.n118 0.249794
R205 vdd_core.n188 vdd_core.n187 0.199447
R206 vdd_core.n213 vdd_core.n202 0.199447
R207 vdd_core.n204 vdd_core.n203 0.199447
R208 vdd_core.n185 vdd_core.n23 0.199447
R209 vdd_core.n201 vdd_core.n22 0.199447
R210 vdd_core.n244 vdd_core.n243 0.199447
R211 vdd_core.n104 vdd_core.n103 0.199188
R212 vdd_core.n85 vdd_core.n83 0.199188
R213 vdd_core.n170 vdd_core.n39 0.199188
R214 vdd_core.n41 vdd_core.n38 0.199188
R215 vdd_core.n133 vdd_core.n130 0.195018
R216 vdd_core.n127 vdd_core.n124 0.175092
R217 vdd_core.n146 vdd_core.n114 0.1061
R218 vdd_core.n139 vdd_core.n138 0.1061
R219 vdd_core.n140 vdd_core.n135 0.1061
R220 vdd_core.n134 vdd_core.n133 0.1061
R221 vdd_core.n145 vdd_core.n144 0.1061
R222 vdd_core.n113 vdd_core.n2 0.102521
R223 vdd_core.n231 vdd_core.n180 0.1019
R224 vdd_core.n96 vdd_core.n79 0.101071
R225 vdd_core.n94 vdd_core.n82 0.101071
R226 vdd_core.n105 vdd_core.n104 0.101071
R227 vdd_core.n103 vdd_core.n78 0.101071
R228 vdd_core.n153 vdd_core.n75 0.101071
R229 vdd_core.n155 vdd_core.n71 0.101071
R230 vdd_core.n157 vdd_core.n67 0.101071
R231 vdd_core.n161 vdd_core.n160 0.101071
R232 vdd_core.n90 vdd_core.n79 0.101071
R233 vdd_core.n91 vdd_core.n82 0.101071
R234 vdd_core.n105 vdd_core.n83 0.101071
R235 vdd_core.n85 vdd_core.n78 0.101071
R236 vdd_core.n153 vdd_core.n74 0.101071
R237 vdd_core.n155 vdd_core.n70 0.101071
R238 vdd_core.n157 vdd_core.n66 0.101071
R239 vdd_core.n61 vdd_core.n52 0.101071
R240 vdd_core.n59 vdd_core.n58 0.101071
R241 vdd_core.n172 vdd_core.n39 0.101071
R242 vdd_core.n171 vdd_core.n170 0.101071
R243 vdd_core.n175 vdd_core.n35 0.101071
R244 vdd_core.n177 vdd_core.n31 0.101071
R245 vdd_core.n179 vdd_core.n27 0.101071
R246 vdd_core.n61 vdd_core.n51 0.101071
R247 vdd_core.n59 vdd_core.n56 0.101071
R248 vdd_core.n172 vdd_core.n38 0.101071
R249 vdd_core.n171 vdd_core.n41 0.101071
R250 vdd_core.n175 vdd_core.n34 0.101071
R251 vdd_core.n177 vdd_core.n30 0.101071
R252 vdd_core.n179 vdd_core.n6 0.00761283
R253 vdd_core.n187 vdd_core.n25 0.101071
R254 vdd_core.n188 vdd_core.n186 0.101071
R255 vdd_core.n226 vdd_core.n194 0.101071
R256 vdd_core.n223 vdd_core.n198 0.101071
R257 vdd_core.n215 vdd_core.n202 0.101071
R258 vdd_core.n214 vdd_core.n213 0.101071
R259 vdd_core.n210 vdd_core.n20 0.101071
R260 vdd_core.n208 vdd_core.n18 0.101071
R261 vdd_core.n206 vdd_core.n16 0.101071
R262 vdd_core.n204 vdd_core.n13 0.101071
R263 vdd_core.n203 vdd_core.n12 0.101071
R264 vdd_core.n25 vdd_core.n23 0.101071
R265 vdd_core.n186 vdd_core.n185 0.101071
R266 vdd_core.n226 vdd_core.n193 0.101071
R267 vdd_core.n223 vdd_core.n197 0.101071
R268 vdd_core.n215 vdd_core.n201 0.101071
R269 vdd_core.n214 vdd_core.n22 0.101071
R270 vdd_core.n237 vdd_core.n20 0.101071
R271 vdd_core.n239 vdd_core.n18 0.101071
R272 vdd_core.n241 vdd_core.n16 0.101071
R273 vdd_core.n243 vdd_core.n13 0.101071
R274 vdd_core.n244 vdd_core.n12 0.101071
R275 vdd_core.n128 vdd_core.n127 0.0955821
R276 vdd_core.n7 vdd_core.n8 0.872565
R277 vdd_core.n7 vdd_core.n114 0.433741
R278 vdd_core.n140 vdd_core.n139 0.0759286
R279 vdd_core.n135 vdd_core.n134 0.0759286
R280 vdd_core.n146 vdd_core.n145 0.0759286
R281 vdd_core.n100 vdd_core.n87 0.0759286
R282 vdd_core.n101 vdd_core.n100 0.0759286
R283 vdd_core.n162 vdd_core.n65 0.0759286
R284 vdd_core.n156 vdd_core.n69 0.0759286
R285 vdd_core.n154 vdd_core.n73 0.0759286
R286 vdd_core.n152 vdd_core.n77 0.0759286
R287 vdd_core.n106 vdd_core.n81 0.0759286
R288 vdd_core.n95 vdd_core.n93 0.0759286
R289 vdd_core.n98 vdd_core.n97 0.0759286
R290 vdd_core.n99 vdd_core.n84 0.0759286
R291 vdd_core.n162 vdd_core.n64 0.0759286
R292 vdd_core.n156 vdd_core.n68 0.0759286
R293 vdd_core.n154 vdd_core.n72 0.0759286
R294 vdd_core.n152 vdd_core.n76 0.0759286
R295 vdd_core.n106 vdd_core.n80 0.0759286
R296 vdd_core.n93 vdd_core.n92 0.0759286
R297 vdd_core.n99 vdd_core.n88 0.0759286
R298 vdd_core.n98 vdd_core.n89 0.0759286
R299 vdd_core.n167 vdd_core.n46 0.0759286
R300 vdd_core.n168 vdd_core.n167 0.0759286
R301 vdd_core.n178 vdd_core.n29 0.0759286
R302 vdd_core.n176 vdd_core.n33 0.0759286
R303 vdd_core.n42 vdd_core.n36 0.0759286
R304 vdd_core.n57 vdd_core.n40 0.0759286
R305 vdd_core.n60 vdd_core.n54 0.0759286
R306 vdd_core.n62 vdd_core.n50 0.0759286
R307 vdd_core.n166 vdd_core.n43 0.0759286
R308 vdd_core.n6 vdd_core.n28 0.439821
R309 vdd_core.n178 vdd_core.n28 0.0759286
R310 vdd_core.n176 vdd_core.n32 0.0759286
R311 vdd_core.n44 vdd_core.n36 0.0759286
R312 vdd_core.n55 vdd_core.n40 0.0759286
R313 vdd_core.n60 vdd_core.n53 0.0759286
R314 vdd_core.n166 vdd_core.n48 0.0759286
R315 vdd_core.n62 vdd_core.n49 0.0759286
R316 vdd_core.n234 vdd_core.n233 0.0759286
R317 vdd_core.n233 vdd_core.n24 0.0759286
R318 vdd_core.n11 vdd_core.n10 0.0759286
R319 vdd_core.n205 vdd_core.n15 0.0759286
R320 vdd_core.n207 vdd_core.n17 0.0759286
R321 vdd_core.n209 vdd_core.n19 0.0759286
R322 vdd_core.n211 vdd_core.n21 0.0759286
R323 vdd_core.n222 vdd_core.n200 0.0759286
R324 vdd_core.n224 vdd_core.n196 0.0759286
R325 vdd_core.n227 vdd_core.n192 0.0759286
R326 vdd_core.n228 vdd_core.n190 0.0759286
R327 vdd_core.n189 vdd_core.n182 0.0759286
R328 vdd_core.n245 vdd_core.n10 0.0759286
R329 vdd_core.n242 vdd_core.n15 0.0759286
R330 vdd_core.n240 vdd_core.n17 0.0759286
R331 vdd_core.n238 vdd_core.n19 0.0759286
R332 vdd_core.n236 vdd_core.n21 0.0759286
R333 vdd_core.n222 vdd_core.n199 0.0759286
R334 vdd_core.n224 vdd_core.n195 0.0759286
R335 vdd_core.n184 vdd_core.n182 0.0759286
R336 vdd_core.n228 vdd_core.n183 0.0759286
R337 vdd_core.n227 vdd_core.n191 0.0759286
R338 vdd_core.n167 vdd_core.n47 0.0738333
R339 vdd_core.n148 vdd_core.n115 0.0621
R340 vdd_core.n137 vdd_core.n136 0.0621
R341 vdd_core.n141 vdd_core.n117 0.0621
R342 vdd_core.n142 vdd_core.n120 0.0621
R343 vdd_core.n143 vdd_core.n119 0.0621
R344 vdd_core.n147 vdd_core.n116 0.0621
R345 vdd_core.n132 vdd_core.n131 0.0383489
R346 vdd_core.n5 vdd_core.n6 0.0351511
R347 vdd_core.n179 vdd_core.n178 0.0371667
R348 vdd_core.n178 vdd_core.n177 0.0371667
R349 vdd_core.n177 vdd_core.n176 0.0371667
R350 vdd_core.n176 vdd_core.n175 0.0371667
R351 vdd_core.n175 vdd_core.n36 0.0371667
R352 vdd_core.n171 vdd_core.n36 0.0371667
R353 vdd_core.n172 vdd_core.n171 0.0371667
R354 vdd_core.n172 vdd_core.n40 0.0371667
R355 vdd_core.n59 vdd_core.n40 0.0371667
R356 vdd_core.n60 vdd_core.n59 0.0371667
R357 vdd_core.n61 vdd_core.n60 0.0371667
R358 vdd_core.n62 vdd_core.n61 0.0371667
R359 vdd_core.n166 vdd_core.n62 0.0371667
R360 vdd_core.n167 vdd_core.n166 0.0371667
R361 vdd_core.n159 vdd_core.n47 0.0371667
R362 vdd_core.n162 vdd_core.n161 0.0371667
R363 vdd_core.n162 vdd_core.n157 0.0371667
R364 vdd_core.n157 vdd_core.n156 0.0371667
R365 vdd_core.n156 vdd_core.n155 0.0371667
R366 vdd_core.n155 vdd_core.n154 0.0371667
R367 vdd_core.n154 vdd_core.n153 0.0371667
R368 vdd_core.n153 vdd_core.n152 0.0371667
R369 vdd_core.n152 vdd_core.n78 0.0371667
R370 vdd_core.n105 vdd_core.n78 0.0371667
R371 vdd_core.n106 vdd_core.n105 0.0371667
R372 vdd_core.n106 vdd_core.n82 0.0371667
R373 vdd_core.n93 vdd_core.n82 0.0371667
R374 vdd_core.n93 vdd_core.n79 0.0371667
R375 vdd_core.n98 vdd_core.n79 0.0371667
R376 vdd_core.n99 vdd_core.n98 0.0371667
R377 vdd_core.n100 vdd_core.n99 0.0371667
R378 vdd_core.n12 vdd_core.n10 0.0371667
R379 vdd_core.n13 vdd_core.n12 0.0371667
R380 vdd_core.n16 vdd_core.n15 0.0371667
R381 vdd_core.n17 vdd_core.n16 0.0371667
R382 vdd_core.n19 vdd_core.n18 0.0371667
R383 vdd_core.n20 vdd_core.n19 0.0371667
R384 vdd_core.n214 vdd_core.n21 0.0371667
R385 vdd_core.n215 vdd_core.n214 0.0371667
R386 vdd_core.n223 vdd_core.n222 0.0371667
R387 vdd_core.n224 vdd_core.n223 0.0371667
R388 vdd_core.n227 vdd_core.n226 0.0371667
R389 vdd_core.n228 vdd_core.n227 0.0371667
R390 vdd_core.n186 vdd_core.n182 0.0371667
R391 vdd_core.n186 vdd_core.n25 0.0371667
R392 vdd_core.n148 vdd_core.n147 0.0319286
R393 vdd_core.n137 vdd_core.n117 0.0319286
R394 vdd_core.n142 vdd_core.n141 0.0319286
R395 vdd_core.n132 vdd_core.n120 0.0319286
R396 vdd_core.n143 vdd_core.n116 0.0319286
R397 vdd_core.n111 vdd_core.n107 0.0310403
R398 vdd_core.n126 vdd_core.n125 0.0310403
R399 vdd_core.n3 vdd_core.n2 0.59294
R400 vdd_core.n247 vdd_core.n10 0.028
R401 vdd_core.n15 vdd_core.n14 0.028
R402 vdd_core.n216 vdd_core.n18 0.028
R403 vdd_core.n218 vdd_core.n21 0.028
R404 vdd_core.n222 vdd_core.n221 0.028
R405 vdd_core.n226 vdd_core.n225 0.028
R406 vdd_core.n229 vdd_core.n182 0.028
R407 vdd_core.n233 vdd_core.n232 0.028
R408 vdd_core.n159 vdd_core.n158 0.0261384
R409 vdd_core.n125 vdd_core.n122 0.0260771
R410 vdd_core.n112 vdd_core.n111 0.0257351
R411 vdd_core.n112 vdd_core.n110 0.0233414
R412 vdd_core.n248 vdd_core.n9 0.023
R413 vdd_core.n217 vdd_core.n9 0.023
R414 vdd_core.n219 vdd_core.n217 0.023
R415 vdd_core.n220 vdd_core.n219 0.023
R416 vdd_core.n220 vdd_core.n181 0.023
R417 vdd_core.n230 vdd_core.n181 0.023
R418 vdd_core.n231 vdd_core.n230 0.023
R419 vdd_core.n180 vdd_core.n26 0.023
R420 vdd_core.n174 vdd_core.n26 0.023
R421 vdd_core.n174 vdd_core.n173 0.023
R422 vdd_core.n173 vdd_core.n37 0.023
R423 vdd_core.n165 vdd_core.n37 0.023
R424 vdd_core.n165 vdd_core.n164 0.023
R425 vdd_core.n164 vdd_core.n163 0.023
R426 vdd_core.n163 vdd_core.n63 0.023
R427 vdd_core.n151 vdd_core.n63 0.023
R428 vdd_core.n122 vdd_core.n121 0.0229994
R429 vdd_core.n110 vdd_core.n4 0.022386
R430 vdd_core.n121 vdd_core.n1 0.022386
R431 vdd_core.n127 vdd_core.n0 0.59294
R432 vdd_core.n213 vdd_core.n212 0.0124467
R433 vdd_core.n235 vdd_core.n22 0.0124467
R434 vdd_core.n103 vdd_core.n102 0.0121878
R435 vdd_core.n86 vdd_core.n85 0.0121878
R436 vdd_core.n170 vdd_core.n169 0.0121878
R437 vdd_core.n45 vdd_core.n41 0.0121878
R438 vdd_core.n151 vdd_core.n150 0.01175
R439 vdd_core.n247 vdd_core.n246 0.0113759
R440 vdd_core.n14 vdd_core.n13 0.00966667
R441 vdd_core.n216 vdd_core.n17 0.00966667
R442 vdd_core.n218 vdd_core.n20 0.00966667
R443 vdd_core.n221 vdd_core.n215 0.00966667
R444 vdd_core.n225 vdd_core.n224 0.00966667
R445 vdd_core.n229 vdd_core.n228 0.00966667
R446 vdd_core.n232 vdd_core.n25 0.00966667
R447 vdd_core.n161 vdd_core.n158 0.00944821
R448 vdd_core.n113 vdd_core.n149 1.16529
R449 vdd_core.n5 vdd_core.n180 0.578991
R450 VDD VDD.n9 17.9801
R451 VDD VDD.n8 17.071
R452 VDD.n7 VDD.t10 17.0005
R453 VDD.n5 VDD.t4 17.0005
R454 VDD.n3 VDD.t0 17.0005
R455 VDD.n1 VDD.t6 11.3356
R456 VDD.n0 VDD.t2 11.3356
R457 VDD.n7 VDD.t11 6.19097
R458 VDD.n5 VDD.t5 6.19097
R459 VDD.n3 VDD.t1 6.19097
R460 VDD.n9 VDD.t9 4.22454
R461 VDD.n1 VDD.t7 2.44281
R462 VDD.n0 VDD.t3 2.44203
R463 VDD.n2 VDD.n0 1.42463
R464 VDD.n4 VDD.n2 0.851625
R465 VDD.n8 VDD.n7 0.751488
R466 VDD.n6 VDD.n5 0.751488
R467 VDD.n4 VDD.n3 0.751488
R468 VDD.n9 VDD.t8 0.517741
R469 VDD.n8 VDD.n6 0.370375
R470 VDD.n6 VDD.n4 0.370375
R471 VDD.n2 VDD.n1 0.143127
R472 vtune vtune.n1 16.693
R473 vtune.n0 vtune.t0 16.1774
R474 vtune.n0 vtune.t3 14.7078
R475 vtune.n1 vtune.t6 14.7078
R476 vtune.n1 vtune.n0 1.4701
R477 VSS.n225 VSS.n224 4127.1
R478 VSS.n3 VSS.t15 1963.69
R479 VSS.n443 VSS.t114 1390.68
R480 VSS.t110 VSS.t111 804.431
R481 VSS.n205 VSS.n3 712.367
R482 VSS.n204 VSS.t109 552.61
R483 VSS.t111 VSS.n203 547.362
R484 VSS.t114 VSS.t115 374.546
R485 VSS.n203 VSS.t113 287.356
R486 VSS.n446 VSS.n445 278.832
R487 VSS.t109 VSS.n134 254.446
R488 VSS.n204 VSS.t110 168.756
R489 VSS.t113 VSS.t112 141.554
R490 VSS.n202 VSS.n188 141.554
R491 VSS.t115 VSS.n442 132.113
R492 VSS.n203 VSS.n202 71.2493
R493 VSS.t11 VSS.t13 70.7775
R494 VSS.n192 VSS.n188 47.1851
R495 VSS.n215 VSS.n214 40.7645
R496 VSS.n3 VSS.n10 11.591
R497 VSS.n3 VSS.t9 7.16425
R498 VSS.n129 VSS.t63 35.0371
R499 VSS.n136 VSS.t61 33.2884
R500 VSS.n192 VSS.t11 33.0298
R501 VSS.t62 VSS.n136 29.7909
R502 VSS.t55 VSS.n134 28.8551
R503 VSS.t59 VSS.n129 28.0421
R504 VSS.n135 VSS.t57 27.4296
R505 VSS.n141 VSS.t98 26.6691
R506 VSS.t100 VSS.n125 26.6691
R507 VSS.n143 VSS.t102 26.6691
R508 VSS.t7 VSS.n3 11.5002
R509 VSS.t57 VSS.n131 23.9329
R510 VSS.t13 VSS.t15 23.5928
R511 VSS.t97 VSS.n128 22.6205
R512 VSS.n224 VSS.n148 22.5291
R513 VSS.n3 VSS.t3 11.4999
R514 VSS.n137 VSS.t59 20.4345
R515 VSS.n142 VSS.t66 20.1113
R516 VSS.t108 VSS.t72 19.8391
R517 VSS.t116 VSS.t53 19.8391
R518 VSS.t69 VSS.n122 19.5029
R519 VSS.t82 VSS.n164 19.5029
R520 VSS.t88 VSS.n106 19.3829
R521 VSS.n137 VSS.t62 18.6866
R522 VSS.t92 VSS.n437 18.4749
R523 VSS.n183 VSS.t77 18.1579
R524 VSS.n220 VSS.t78 18.1579
R525 VSS.t99 VSS.n125 17.9253
R526 VSS.n143 VSS.t101 17.9253
R527 VSS.n193 VSS.t16 17.4597
R528 VSS.n191 VSS.t128 17.4597
R529 VSS.n208 VSS.n2 17.0261
R530 VSS.n447 VSS.n446 17.0005
R531 VSS.n447 VSS.n70 17.0005
R532 VSS.n447 VSS.n82 17.0005
R533 VSS.n447 VSS.n72 17.0005
R534 VSS.n447 VSS.n78 17.0005
R535 VSS.n447 VSS.n15 17.0005
R536 VSS.n444 VSS.n443 17.0005
R537 VSS.n444 VSS.n84 17.0005
R538 VSS.n444 VSS.n97 17.0005
R539 VSS.n444 VSS.n87 17.0005
R540 VSS.n444 VSS.n92 17.0005
R541 VSS.n445 VSS.n444 17.0005
R542 VSS.n228 VSS.n227 17.0005
R543 VSS.n227 VSS.n109 17.0005
R544 VSS.n227 VSS.n166 17.0005
R545 VSS.n227 VSS.n177 17.0005
R546 VSS.n227 VSS.n226 17.0005
R547 VSS.n227 VSS.n111 17.0005
R548 VSS.n227 VSS.n164 17.0005
R549 VSS.n227 VSS.n178 17.0005
R550 VSS.n227 VSS.n223 17.0005
R551 VSS.n227 VSS.n112 17.0005
R552 VSS.n227 VSS.n222 17.0005
R553 VSS.n227 VSS.n179 17.0005
R554 VSS.n227 VSS.n159 17.0005
R555 VSS.n227 VSS.n180 17.0005
R556 VSS.n227 VSS.n221 17.0005
R557 VSS.n227 VSS.n181 17.0005
R558 VSS.n227 VSS.n220 17.0005
R559 VSS.n227 VSS.n183 17.0005
R560 VSS.n227 VSS.n219 17.0005
R561 VSS.n227 VSS.n185 17.0005
R562 VSS.n227 VSS.n218 17.0005
R563 VSS.n227 VSS.n119 17.0005
R564 VSS.n227 VSS.n217 17.0005
R565 VSS.n227 VSS.n186 17.0005
R566 VSS.n227 VSS.n149 17.0005
R567 VSS.n227 VSS.n187 17.0005
R568 VSS.n227 VSS.n216 17.0005
R569 VSS.n227 VSS.n122 17.0005
R570 VSS.n227 VSS.n148 17.0005
R571 VSS.n227 VSS.n205 17.0005
R572 VSS.n227 VSS.n65 17.0005
R573 VSS.n442 VSS.n441 17.0005
R574 VSS.n441 VSS.n107 17.0005
R575 VSS.n441 VSS.n228 17.0005
R576 VSS.n441 VSS.n109 17.0005
R577 VSS.n441 VSS.n166 17.0005
R578 VSS.n441 VSS.n111 17.0005
R579 VSS.n441 VSS.n164 17.0005
R580 VSS.n441 VSS.n112 17.0005
R581 VSS.n441 VSS.n159 17.0005
R582 VSS.n441 VSS.n116 17.0005
R583 VSS.n441 VSS.n154 17.0005
R584 VSS.n441 VSS.n119 17.0005
R585 VSS.n441 VSS.n149 17.0005
R586 VSS.n441 VSS.n122 17.0005
R587 VSS.n441 VSS.n148 17.0005
R588 VSS.n441 VSS.n123 17.0005
R589 VSS.n441 VSS.n143 17.0005
R590 VSS.n441 VSS.n124 17.0005
R591 VSS.n441 VSS.n142 17.0005
R592 VSS.n441 VSS.n125 17.0005
R593 VSS.n441 VSS.n141 17.0005
R594 VSS.n441 VSS.n134 17.0005
R595 VSS.n192 VSS.n191 17.0005
R596 VSS.n193 VSS.n192 17.0005
R597 VSS.n195 VSS.n188 17.0005
R598 VSS.n199 VSS.n188 17.0005
R599 VSS.t79 VSS.n111 16.8129
R600 VSS.t94 VSS.n101 16.7178
R601 VSS.n437 VSS.t91 16.659
R602 VSS.n106 VSS.t89 15.751
R603 VSS.t61 VSS.n131 15.1883
R604 VSS.n442 VSS.t95 14.9823
R605 VSS.n438 VSS.t94 14.901
R606 VSS.n141 VSS.t65 14.865
R607 VSS.n436 VSS.t127 14.2208
R608 VSS.t73 VSS.n185 14.1229
R609 VSS.n221 VSS.t75 14.1229
R610 VSS.n9 VSS.n15 100.391
R611 VSS.t126 VSS.n107 13.8474
R612 VSS.t103 VSS.n122 13.7866
R613 VSS.t105 VSS.n149 13.7866
R614 VSS.t107 VSS.n119 13.7866
R615 VSS.t117 VSS.n159 13.7866
R616 VSS.t119 VSS.n112 13.7866
R617 VSS.n164 VSS.t121 13.7866
R618 VSS.n182 VSS.n115 13.6726
R619 VSS.n184 VSS.n153 13.6726
R620 VSS.t63 VSS.n128 13.4403
R621 VSS.t89 VSS.n103 13.0858
R622 VSS.n3 VSS.n204 9.17847
R623 VSS.n224 VSS.n215 12.4359
R624 VSS.n16 VSS.n9 2.22315
R625 VSS.n12 VSS.t124 12.2584
R626 VSS.t91 VSS.n103 12.1771
R627 VSS.t101 VSS.n124 11.8046
R628 VSS.n135 VSS.t55 11.6916
R629 VSS.n202 VSS.n190 11.3338
R630 VSS.n202 VSS.n189 11.3338
R631 VSS.n202 VSS.n201 11.3338
R632 VSS.t98 VSS.n127 10.9917
R633 VSS.n127 VSS.t51 10.5545
R634 VSS.t83 VSS.n109 10.4424
R635 VSS.t106 VSS.t70 10.4242
R636 VSS.t118 VSS.t81 10.4242
R637 VSS.n438 VSS.t92 10.3618
R638 VSS.n10 VSS.n9 0.0727097
R639 VSS.t70 VSS.n149 10.0879
R640 VSS.t81 VSS.n112 10.0879
R641 VSS.n460 VSS.n459 9.75612
R642 VSS.t23 VSS.n9 4.9844
R643 VSS.t66 VSS.n124 9.61869
R644 VSS.n436 VSS.t88 9.4531
R645 VSS.n177 VSS.t123 9.3074
R646 VSS.n228 VSS.t125 9.3074
R647 VSS.t51 VSS.t99 9.1815
R648 VSS.n148 VSS.t103 9.07918
R649 VSS.n187 VSS.t105 9.07918
R650 VSS.n217 VSS.t107 9.07918
R651 VSS.n179 VSS.t117 9.07918
R652 VSS.n223 VSS.t119 9.07918
R653 VSS.t121 VSS.n111 9.07918
R654 VSS.n219 VSS.t73 8.74293
R655 VSS.t75 VSS.n181 8.74293
R656 VSS.n101 VSS.t95 8.54511
R657 VSS.n214 VSS.n2 0.356909
R658 VSS.n2 VSS.n0 0.00777774
R659 VSS.n24 VSS.n25 0.00173273
R660 VSS.n25 VSS.n26 0.00172462
R661 VSS.n26 VSS.n27 0.00170812
R662 VSS.n27 VSS.n28 0.00166658
R663 VSS.n28 VSS.n19 0.00149997
R664 VSS.n214 VSS.n23 1.00005
R665 VSS.n5 VSS.n4 0.68236
R666 VSS.n39 VSS.n4 0.0103686
R667 VSS.n32 VSS.n39 0.00166658
R668 VSS.n31 VSS.n12 3.40102
R669 VSS.n8 VSS.n12 0.771407
R670 VSS.n45 VSS.n12 1.70056
R671 VSS.n44 VSS.n45 0.00172462
R672 VSS.n46 VSS.n44 0.00170812
R673 VSS.n35 VSS.n46 0.00166658
R674 VSS.n37 VSS.n35 0.00149997
R675 VSS.n168 VSS.n167 8.5005
R676 VSS.n208 VSS.n1 0.824581
R677 VSS.n1 VSS.n0 0.284196
R678 VSS.n209 VSS.n24 8.48544
R679 VSS.n210 VSS.n25 8.48544
R680 VSS.n211 VSS.n26 8.48544
R681 VSS.n212 VSS.n27 8.48544
R682 VSS.n213 VSS.n28 8.48544
R683 VSS.n20 VSS.n19 3.35165
R684 VSS.n22 VSS.n29 1.90938
R685 VSS.n175 VSS.n39 8.48544
R686 VSS.n32 VSS.n40 8.48544
R687 VSS.n34 VSS.n40 0.219757
R688 VSS.n30 VSS.n41 8.48544
R689 VSS.n42 VSS.n174 8.48544
R690 VSS.n174 VSS.n7 0.556401
R691 VSS.n7 VSS.n6 0.844206
R692 VSS.n172 VSS.n171 8.48544
R693 VSS.n44 VSS.n43 8.48544
R694 VSS.n46 VSS.n170 8.48544
R695 VSS.n169 VSS.n35 8.48544
R696 VSS.n37 VSS.n38 3.35165
R697 VSS.n461 VSS.n460 8.10482
R698 VSS.n459 VSS.n49 7.76695
R699 VSS.t86 VSS.n107 7.71842
R700 VSS.n145 VSS.n47 7.56743
R701 VSS.n432 VSS.n431 7.56743
R702 VSS.n224 VSS.t67 7.43274
R703 VSS.n3 VSS.t5 5.92136
R704 VSS.t129 VSS.n15 6.90359
R705 VSS.n78 VSS.t131 6.90359
R706 VSS.n78 VSS.t133 6.90359
R707 VSS.t134 VSS.n72 6.90359
R708 VSS.t136 VSS.n72 6.90359
R709 VSS.n82 VSS.t137 6.90359
R710 VSS.n82 VSS.t139 6.90359
R711 VSS.t142 VSS.n70 6.90359
R712 VSS.n446 VSS.t143 6.90359
R713 VSS.n445 VSS.t145 6.90359
R714 VSS.n92 VSS.t147 6.90359
R715 VSS.t150 VSS.n87 6.90359
R716 VSS.t152 VSS.n87 6.90359
R717 VSS.n97 VSS.t153 6.90359
R718 VSS.n97 VSS.t155 6.90359
R719 VSS.t156 VSS.n84 6.90359
R720 VSS.t158 VSS.n84 6.90359
R721 VSS.n443 VSS.t159 6.90359
R722 VSS.n108 VSS.t126 6.89806
R723 VSS.n184 VSS.n154 6.83654
R724 VSS.n178 VSS.n160 6.83654
R725 VSS.n222 VSS.n113 6.83654
R726 VSS.n180 VSS.n158 6.83654
R727 VSS.n220 VSS.n117 6.83654
R728 VSS.n218 VSS.n118 6.83654
R729 VSS.n186 VSS.n150 6.83654
R730 VSS.n216 VSS.n121 6.83654
R731 VSS.n187 VSS.n121 6.83654
R732 VSS.n217 VSS.n150 6.83654
R733 VSS.n185 VSS.n118 6.83654
R734 VSS.n219 VSS.n153 6.83654
R735 VSS.n183 VSS.n117 6.83654
R736 VSS.n182 VSS.n116 6.83654
R737 VSS.n181 VSS.n115 6.83654
R738 VSS.n221 VSS.n158 6.83654
R739 VSS.n179 VSS.n113 6.83654
R740 VSS.n223 VSS.n160 6.83654
R741 VSS.n447 VSS.n83 6.69018
R742 VSS.n447 VSS.n71 6.69018
R743 VSS.n447 VSS.n79 6.69018
R744 VSS.n447 VSS.n74 6.69018
R745 VSS.n447 VSS.n75 6.69018
R746 VSS.n444 VSS.n98 6.69018
R747 VSS.n444 VSS.n86 6.69018
R748 VSS.n444 VSS.n93 6.69018
R749 VSS.n444 VSS.n89 6.69018
R750 VSS.n444 VSS.n91 6.69018
R751 VSS.t85 VSS.n108 6.67106
R752 VSS.n362 VSS.n361 6.61367
R753 VSS.n287 VSS.n264 6.51503
R754 VSS.n263 VSS.n254 6.5067
R755 VSS.n253 VSS.n244 6.5067
R756 VSS.n396 VSS.n395 6.34066
R757 VSS.n199 VSS.t17 6.19054
R758 VSS.n195 VSS.t14 6.19054
R759 VSS.t123 VSS.n166 6.12943
R760 VSS.n341 VSS.n340 6.09818
R761 VSS.n243 VSS.n231 6.04071
R762 VSS.n75 VSS.t129 5.92367
R763 VSS.t131 VSS.n75 5.92367
R764 VSS.t133 VSS.n74 5.92367
R765 VSS.n74 VSS.t134 5.92367
R766 VSS.n79 VSS.t136 5.92367
R767 VSS.t137 VSS.n79 5.92367
R768 VSS.t139 VSS.n71 5.92367
R769 VSS.t140 VSS.n71 5.92367
R770 VSS.n83 VSS.t142 5.92367
R771 VSS.t143 VSS.n83 5.92367
R772 VSS.n91 VSS.t145 5.92367
R773 VSS.t147 VSS.n91 5.92367
R774 VSS.t149 VSS.n89 5.92367
R775 VSS.n89 VSS.t150 5.92367
R776 VSS.n93 VSS.t152 5.92367
R777 VSS.t153 VSS.n93 5.92367
R778 VSS.t155 VSS.n86 5.92367
R779 VSS.n86 VSS.t156 5.92367
R780 VSS.n98 VSS.t158 5.92367
R781 VSS.t159 VSS.n98 5.92367
R782 VSS.t20 VSS.n9 4.16182
R783 VSS.n9 VSS.t29 4.16042
R784 VSS.n441 VSS.n437 5.84696
R785 VSS.n441 VSS.n106 5.84696
R786 VSS.n441 VSS.n108 5.84696
R787 VSS.n441 VSS.n165 5.84696
R788 VSS.n38 VSS.n168 5.89051
R789 VSS.n225 VSS.t79 5.71671
R790 VSS.n0 VSS.n24 0.00682271
R791 VSS.n214 VSS.n18 5.66778
R792 VSS.n23 VSS.n29 0.0075735
R793 VSS.n4 VSS.n12 0.627003
R794 VSS.n33 VSS.n31 0.00229996
R795 VSS.n6 VSS.n8 0.00908117
R796 VSS.n13 VSS.n6 0.00199982
R797 VSS.n36 VSS.n12 5.66778
R798 VSS.n11 VSS.n9 1.33838
R799 VSS.n454 VSS.n11 0.607945
R800 VSS.n447 VSS.n68 5.65086
R801 VSS.n448 VSS.n447 5.65086
R802 VSS.n447 VSS.n81 5.65086
R803 VSS.n447 VSS.n73 5.65086
R804 VSS.n444 VSS.n100 5.65086
R805 VSS.n444 VSS.n85 5.65086
R806 VSS.n444 VSS.n96 5.65086
R807 VSS.n444 VSS.n90 5.65086
R808 VSS.n20 VSS.n22 0.405112
R809 VSS.n22 VSS.n21 2.04601
R810 VSS.n34 VSS.n33 3.35165
R811 VSS.n13 VSS.n173 5.64018
R812 VSS.n177 VSS.n165 5.30908
R813 VSS.n226 VSS.n165 5.30908
R814 VSS.n10 VSS.t25 3.85593
R815 VSS.n227 VSS.n182 5.08323
R816 VSS.n227 VSS.n184 5.08323
R817 VSS.n441 VSS.n160 5.08323
R818 VSS.n441 VSS.n113 5.08323
R819 VSS.n441 VSS.n158 5.08323
R820 VSS.n441 VSS.n115 5.08323
R821 VSS.n441 VSS.n117 5.08323
R822 VSS.n441 VSS.n153 5.08323
R823 VSS.n441 VSS.n118 5.08323
R824 VSS.n441 VSS.n150 5.08323
R825 VSS.n441 VSS.n121 5.08323
R826 VSS.n166 VSS.t83 4.99445
R827 VSS.t125 VSS.t85 4.76745
R828 VSS.t77 VSS.n154 4.70796
R829 VSS.t78 VSS.n116 4.70796
R830 VSS.n459 VSS.n458 4.67815
R831 VSS.n206 VSS.t140 4.60256
R832 VSS.n167 VSS.t149 4.60256
R833 VSS.n441 VSS.n127 4.53583
R834 VSS.n441 VSS.n129 4.53583
R835 VSS.n441 VSS.n136 4.53583
R836 VSS.n206 VSS.n29 8.50469
R837 VSS.t27 VSS.n16 6.64571
R838 VSS.n14 VSS.n9 0.207283
R839 VSS.n458 VSS.n17 0.239711
R840 VSS.n447 VSS.n77 4.22744
R841 VSS.n444 VSS.n88 4.22744
R842 VSS.n429 VSS.n428 3.93263
R843 VSS.n454 VSS.n453 3.89224
R844 VSS.n453 VSS.n65 3.88607
R845 VSS.n452 VSS.n451 3.57733
R846 VSS.n394 VSS.n393 3.57193
R847 VSS.n273 VSS.t148 3.45423
R848 VSS.n94 VSS.t151 3.45423
R849 VSS.n95 VSS.t154 3.45423
R850 VSS.n99 VSS.t157 3.45423
R851 VSS.n76 VSS.t132 3.45423
R852 VSS.n80 VSS.t135 3.45423
R853 VSS.n69 VSS.t138 3.45423
R854 VSS.n449 VSS.t141 3.45423
R855 VSS.n267 VSS.t146 3.45313
R856 VSS.n393 VSS.t160 3.45313
R857 VSS.n66 VSS.t130 3.45313
R858 VSS.n268 VSS.t144 3.45313
R859 VSS.n441 VSS.n440 3.38758
R860 VSS.n441 VSS.n105 3.38758
R861 VSS.n441 VSS.n435 3.38758
R862 VSS.n441 VSS.n110 3.38758
R863 VSS.n441 VSS.n163 3.38758
R864 VSS.n441 VSS.n114 3.38758
R865 VSS.n441 VSS.n152 3.38758
R866 VSS.n441 VSS.n120 3.38758
R867 VSS.n441 VSS.n147 3.38758
R868 VSS.n441 VSS.n126 3.38758
R869 VSS.n441 VSS.n140 3.38758
R870 VSS.n441 VSS.n133 3.38758
R871 VSS.n275 VSS.n274 3.3755
R872 VSS.n272 VSS.n271 3.3755
R873 VSS.n270 VSS.n266 3.3755
R874 VSS.n269 VSS.n67 3.3755
R875 VSS.n451 VSS.n450 3.3755
R876 VSS.n214 VSS.n205 3.3055
R877 VSS.n201 VSS.t12 3.22826
R878 VSS.n189 VSS.t19 3.22826
R879 VSS.n190 VSS.t18 3.22826
R880 VSS.t65 VSS.t97 3.06083
R881 VSS.n142 VSS.t100 3.06083
R882 VSS.t102 VSS.n123 3.06083
R883 VSS.n441 VSS.n102 2.81806
R884 VSS.n441 VSS.n157 2.81806
R885 VSS.n441 VSS.n130 2.81806
R886 VSS.n11 VSS.t27 5.379
R887 VSS.n225 VSS.t122 2.69048
R888 VSS.n440 VSS.t96 2.40098
R889 VSS.n133 VSS.t56 2.40093
R890 VSS.n138 VSS.t60 2.3605
R891 VSS.n132 VSS.t58 2.36048
R892 VSS.n144 VSS.t52 2.36044
R893 VSS.n139 VSS.t64 2.36035
R894 VSS.n162 VSS.t80 2.36035
R895 VSS.n439 VSS.t93 2.36029
R896 VSS.n155 VSS.t74 2.36029
R897 VSS.n161 VSS.t54 2.36021
R898 VSS.n104 VSS.t90 2.36021
R899 VSS.n151 VSS.t71 2.36019
R900 VSS.n156 VSS.t76 2.36006
R901 VSS.n434 VSS.t87 2.35987
R902 VSS.n146 VSS.t68 2.3598
R903 VSS.n433 VSS.t84 2.35938
R904 VSS.n216 VSS.t104 2.35423
R905 VSS.n186 VSS.t106 2.35423
R906 VSS.n218 VSS.t108 2.35423
R907 VSS.n180 VSS.t116 2.35423
R908 VSS.n222 VSS.t118 2.35423
R909 VSS.n178 VSS.t120 2.35423
R910 VSS.n206 VSS.n70 2.30153
R911 VSS.n167 VSS.n92 2.30153
R912 VSS.n441 VSS.n101 2.28106
R913 VSS.n441 VSS.n438 2.28106
R914 VSS.n441 VSS.n103 2.28106
R915 VSS.n441 VSS.n436 2.28106
R916 VSS.n56 VSS.t48 2.21158
R917 VSS.n455 VSS.t8 2.2109
R918 VSS.n458 VSS.t41 2.21089
R919 VSS.n51 VSS.t46 2.21087
R920 VSS.n63 VSS.t4 2.21078
R921 VSS.n62 VSS.t2 2.21074
R922 VSS.n456 VSS.t10 2.21056
R923 VSS.n53 VSS.t42 2.21032
R924 VSS.n57 VSS.t50 2.20995
R925 VSS.n54 VSS.t44 2.20978
R926 VSS.n60 VSS.t6 2.2097
R927 VSS.n49 VSS.t1 2.20953
R928 VSS.n455 VSS.t28 2.20272
R929 VSS.n54 VSS.t34 2.20272
R930 VSS.n49 VSS.t21 2.20266
R931 VSS.n456 VSS.t30 2.20264
R932 VSS.n62 VSS.t22 2.20211
R933 VSS.n57 VSS.t40 2.20189
R934 VSS.n51 VSS.t36 2.20186
R935 VSS.n53 VSS.t32 2.20165
R936 VSS.n56 VSS.t38 2.20164
R937 VSS.n63 VSS.t24 2.20139
R938 VSS.n458 VSS.t31 2.20137
R939 VSS.n60 VSS.t26 2.20109
R940 VSS.n16 VSS.n454 2.3888
R941 VSS.t124 VSS.n109 1.58948
R942 VSS.n228 VSS.n12 1.58948
R943 VSS.t127 VSS.t86 1.58948
R944 VSS.n416 VSS.n415 1.30527
R945 VSS.n441 VSS.n128 1.30348
R946 VSS.n441 VSS.n137 1.30348
R947 VSS.n441 VSS.n131 1.30348
R948 VSS.n441 VSS.n135 1.30348
R949 VSS.t104 VSS.t69 1.00924
R950 VSS.t120 VSS.t82 1.00924
R951 VSS.n207 VSS.n176 0.882565
R952 VSS.n406 VSS.n405 0.812182
R953 VSS.t72 VSS.n119 0.672995
R954 VSS.t53 VSS.n159 0.672995
R955 VSS.n201 VSS.n200 0.513002
R956 VSS.n194 VSS.n193 0.479883
R957 VSS.n191 VSS.n48 0.479883
R958 VSS.n326 VSS.n310 0.4405
R959 VSS.n256 VSS.n255 0.4405
R960 VSS.n246 VSS.n245 0.4405
R961 VSS.n236 VSS.n235 0.4405
R962 VSS.n286 VSS.n285 0.4405
R963 VSS.n310 VSS.n309 0.4405
R964 VSS.n255 VSS.n254 0.4405
R965 VSS.n245 VSS.n244 0.4405
R966 VSS.n235 VSS.n234 0.4405
R967 VSS.n287 VSS.n286 0.4405
R968 VSS.n224 VSS.n123 0.43769
R969 VSS.n351 VSS.n350 0.424088
R970 VSS.n290 VSS.n288 0.422335
R971 VSS.n200 VSS.n199 0.411981
R972 VSS.n196 VSS.n195 0.411981
R973 VSS.n197 VSS.n196 0.370375
R974 VSS.n196 VSS.n194 0.370375
R975 VSS.n194 VSS.n48 0.370375
R976 VSS.n298 VSS.n297 0.367167
R977 VSS.n313 VSS.n312 0.367167
R978 VSS.n315 VSS.n314 0.367167
R979 VSS.n320 VSS.n316 0.367167
R980 VSS.n331 VSS.n330 0.367167
R981 VSS.n333 VSS.n332 0.367167
R982 VSS.n337 VSS.n229 0.367167
R983 VSS.n430 VSS.n429 0.367167
R984 VSS.n325 VSS.n324 0.3635
R985 VSS.n324 VSS.n323 0.3635
R986 VSS.n343 VSS.n342 0.3635
R987 VSS.n344 VSS.n343 0.3635
R988 VSS.n347 VSS.n346 0.3635
R989 VSS.n348 VSS.n347 0.3635
R990 VSS.n260 VSS.n259 0.3635
R991 VSS.n259 VSS.n258 0.3635
R992 VSS.n250 VSS.n249 0.3635
R993 VSS.n249 VSS.n248 0.3635
R994 VSS.n240 VSS.n239 0.3635
R995 VSS.n239 VSS.n238 0.3635
R996 VSS.n282 VSS.n281 0.3635
R997 VSS.n283 VSS.n282 0.3635
R998 VSS.n295 VSS.n294 0.3635
R999 VSS.n357 VSS.n354 0.3635
R1000 VSS.n355 VSS.n354 0.3635
R1001 VSS.n294 VSS.n293 0.3635
R1002 VSS.n291 VSS.n290 0.3635
R1003 VSS.n362 VSS.n356 0.338523
R1004 VSS.n270 VSS.n269 0.337235
R1005 VSS.n271 VSS.n270 0.337235
R1006 VSS.n227 VSS.n215 0.334254
R1007 VSS.n200 VSS.n198 0.3195
R1008 VSS.n198 VSS.n197 0.3195
R1009 VSS.n416 VSS.n243 0.31812
R1010 VSS.n396 VSS.n263 0.31812
R1011 VSS.n406 VSS.n253 0.31812
R1012 VSS.n395 VSS.n264 0.31812
R1013 VSS.n389 VSS.n388 0.288357
R1014 VSS.n461 VSS.n47 0.27725
R1015 VSS.n340 VSS.n339 0.276447
R1016 VSS.n309 VSS.n308 0.276447
R1017 VSS.n327 VSS.n326 0.276447
R1018 VSS.n327 VSS.n325 0.276447
R1019 VSS.n323 VSS.n322 0.276447
R1020 VSS.n345 VSS.n344 0.276447
R1021 VSS.n346 VSS.n345 0.276447
R1022 VSS.n349 VSS.n348 0.276447
R1023 VSS.n241 VSS.n240 0.276447
R1024 VSS.n238 VSS.n237 0.276447
R1025 VSS.n237 VSS.n236 0.276447
R1026 VSS.n234 VSS.n233 0.276447
R1027 VSS.n232 VSS.n231 0.276447
R1028 VSS.n261 VSS.n260 0.276188
R1029 VSS.n258 VSS.n257 0.276188
R1030 VSS.n257 VSS.n256 0.276188
R1031 VSS.n251 VSS.n250 0.276188
R1032 VSS.n248 VSS.n247 0.276188
R1033 VSS.n247 VSS.n246 0.276188
R1034 VSS.n281 VSS.n276 0.276188
R1035 VSS.n284 VSS.n283 0.276188
R1036 VSS.n285 VSS.n284 0.276188
R1037 VSS.n359 VSS.n357 0.276188
R1038 VSS.n356 VSS.n355 0.276188
R1039 VSS.n293 VSS.n292 0.276188
R1040 VSS.n292 VSS.n291 0.276188
R1041 VSS.n363 VSS.n352 0.2755
R1042 VSS.n368 VSS.n367 0.2755
R1043 VSS.n370 VSS.n369 0.2755
R1044 VSS.n374 VSS.n289 0.2755
R1045 VSS.n379 VSS.n378 0.2755
R1046 VSS.n381 VSS.n380 0.2755
R1047 VSS.n383 VSS.n278 0.2755
R1048 VSS.n388 VSS.n387 0.2755
R1049 VSS.n350 VSS.n349 0.271823
R1050 VSS.n342 VSS.n341 0.2645
R1051 VSS.n361 VSS.n295 0.2645
R1052 VSS.n17 VSS.n53 0.225229
R1053 VSS.n14 VSS.n49 0.239732
R1054 VSS.n460 VSS.n48 0.248
R1055 VSS.n55 VSS.n53 0.243424
R1056 VSS.n64 VSS.n62 0.243424
R1057 VSS.n51 VSS.n50 0.24245
R1058 VSS.n60 VSS.n59 0.24245
R1059 VSS.n269 VSS.n268 0.241827
R1060 VSS.n271 VSS.n267 0.241827
R1061 VSS.n54 VSS.n52 0.240796
R1062 VSS.n63 VSS.n61 0.240796
R1063 VSS.n58 VSS.n56 0.239822
R1064 VSS.n457 VSS.n455 0.239822
R1065 VSS.n14 VSS.n62 0.225219
R1066 VSS.n56 VSS.n50 0.227974
R1067 VSS.n455 VSS.n59 0.227974
R1068 VSS.n226 VSS.n225 0.227498
R1069 VSS.n55 VSS.n54 0.227001
R1070 VSS.n64 VSS.n63 0.227001
R1071 VSS.n227 VSS.n176 0.22697
R1072 VSS.n58 VSS.n57 0.225646
R1073 VSS.n457 VSS.n456 0.225646
R1074 VSS.n52 VSS.n51 0.224672
R1075 VSS.n61 VSS.n60 0.224672
R1076 VSS.n9 VSS.n59 0.218846
R1077 VSS.n9 VSS.n64 0.218846
R1078 VSS.n3 VSS.n50 0.218846
R1079 VSS.n3 VSS.n55 0.218846
R1080 VSS.n9 VSS.n457 0.208386
R1081 VSS.n9 VSS.n61 0.208386
R1082 VSS.n3 VSS.n58 0.208386
R1083 VSS.n3 VSS.n52 0.208386
R1084 VSS.n339 VSS.n308 0.199447
R1085 VSS.n322 VSS.n307 0.199447
R1086 VSS.n242 VSS.n241 0.199447
R1087 VSS.n233 VSS.n232 0.199447
R1088 VSS.n262 VSS.n261 0.199188
R1089 VSS.n252 VSS.n251 0.199188
R1090 VSS.n276 VSS.n265 0.199188
R1091 VSS.n360 VSS.n359 0.199188
R1092 VSS.n352 VSS.n351 0.165999
R1093 VSS.n391 VSS.n275 0.161968
R1094 VSS.n34 VSS.n41 0.220165
R1095 VSS.n173 VSS.n172 0.157715
R1096 VSS.n20 VSS.n213 0.219757
R1097 VSS.n7 VSS.n173 0.59104
R1098 VSS.n38 VSS.n169 0.219757
R1099 VSS.n198 VSS.n189 0.143127
R1100 VSS.n197 VSS.n190 0.143127
R1101 VSS.n209 VSS.n1 0.85819
R1102 VSS.n210 VSS.n209 0.126053
R1103 VSS.n211 VSS.n210 0.126053
R1104 VSS.n212 VSS.n211 0.126053
R1105 VSS.n213 VSS.n212 0.126053
R1106 VSS.n5 VSS.n175 0.628068
R1107 VSS.n175 VSS.n40 0.126053
R1108 VSS.n174 VSS.n41 0.126053
R1109 VSS.n172 VSS.n43 0.126053
R1110 VSS.n170 VSS.n43 0.126053
R1111 VSS.n170 VSS.n169 0.126053
R1112 VSS.n431 VSS.n430 0.12605
R1113 VSS.n176 VSS.n5 1.44521
R1114 VSS.n451 VSS.n67 0.121601
R1115 VSS.n266 VSS.n67 0.121601
R1116 VSS.n272 VSS.n266 0.121601
R1117 VSS.n275 VSS.n272 0.121601
R1118 VSS.n208 VSS.n207 0.11325
R1119 VSS.n397 VSS.n396 0.102006
R1120 VSS.n407 VSS.n406 0.102006
R1121 VSS.n417 VSS.n416 0.102006
R1122 VSS.n339 VSS.n338 0.101071
R1123 VSS.n336 VSS.n308 0.101071
R1124 VSS.n328 VSS.n327 0.101071
R1125 VSS.n324 VSS.n317 0.101071
R1126 VSS.n322 VSS.n321 0.101071
R1127 VSS.n319 VSS.n307 0.101071
R1128 VSS.n343 VSS.n305 0.101071
R1129 VSS.n345 VSS.n303 0.101071
R1130 VSS.n347 VSS.n301 0.101071
R1131 VSS.n349 VSS.n299 0.101071
R1132 VSS.n397 VSS.n262 0.101071
R1133 VSS.n398 VSS.n261 0.101071
R1134 VSS.n400 VSS.n259 0.101071
R1135 VSS.n402 VSS.n257 0.101071
R1136 VSS.n407 VSS.n252 0.101071
R1137 VSS.n408 VSS.n251 0.101071
R1138 VSS.n410 VSS.n249 0.101071
R1139 VSS.n412 VSS.n247 0.101071
R1140 VSS.n417 VSS.n242 0.101071
R1141 VSS.n418 VSS.n241 0.101071
R1142 VSS.n420 VSS.n239 0.101071
R1143 VSS.n422 VSS.n237 0.101071
R1144 VSS.n426 VSS.n233 0.101071
R1145 VSS.n427 VSS.n232 0.101071
R1146 VSS.n392 VSS.n265 0.101071
R1147 VSS.n390 VSS.n276 0.101071
R1148 VSS.n282 VSS.n280 0.101071
R1149 VSS.n386 VSS.n284 0.101071
R1150 VSS.n360 VSS.n296 0.101071
R1151 VSS.n359 VSS.n358 0.101071
R1152 VSS.n366 VSS.n354 0.101071
R1153 VSS.n364 VSS.n356 0.101071
R1154 VSS.n372 VSS.n294 0.101071
R1155 VSS.n375 VSS.n292 0.101071
R1156 VSS.n377 VSS.n290 0.101071
R1157 VSS.n428 VSS.n427 0.0885
R1158 VSS.n427 VSS.n426 0.0885
R1159 VSS.n426 VSS.n425 0.0885
R1160 VSS.n425 VSS.n424 0.0885
R1161 VSS.n424 VSS.n423 0.0885
R1162 VSS.n423 VSS.n422 0.0885
R1163 VSS.n422 VSS.n421 0.0885
R1164 VSS.n421 VSS.n420 0.0885
R1165 VSS.n420 VSS.n419 0.0885
R1166 VSS.n419 VSS.n418 0.0885
R1167 VSS.n418 VSS.n417 0.0885
R1168 VSS.n415 VSS.n414 0.0885
R1169 VSS.n414 VSS.n413 0.0885
R1170 VSS.n413 VSS.n412 0.0885
R1171 VSS.n412 VSS.n411 0.0885
R1172 VSS.n411 VSS.n410 0.0885
R1173 VSS.n410 VSS.n409 0.0885
R1174 VSS.n409 VSS.n408 0.0885
R1175 VSS.n408 VSS.n407 0.0885
R1176 VSS.n405 VSS.n404 0.0885
R1177 VSS.n404 VSS.n403 0.0885
R1178 VSS.n403 VSS.n402 0.0885
R1179 VSS.n402 VSS.n401 0.0885
R1180 VSS.n401 VSS.n400 0.0885
R1181 VSS.n400 VSS.n399 0.0885
R1182 VSS.n399 VSS.n398 0.0885
R1183 VSS.n398 VSS.n397 0.0885
R1184 VSS.n452 VSS.n66 0.0846837
R1185 VSS.n76 VSS.n73 0.0779076
R1186 VSS.n81 VSS.n80 0.0779076
R1187 VSS.n448 VSS.n69 0.0779076
R1188 VSS.n96 VSS.n94 0.0779076
R1189 VSS.n95 VSS.n85 0.0779076
R1190 VSS.n100 VSS.n99 0.0779076
R1191 VSS.n340 VSS.n230 0.0759286
R1192 VSS.n348 VSS.n300 0.0759286
R1193 VSS.n346 VSS.n302 0.0759286
R1194 VSS.n344 VSS.n304 0.0759286
R1195 VSS.n342 VSS.n306 0.0759286
R1196 VSS.n323 VSS.n318 0.0759286
R1197 VSS.n329 VSS.n325 0.0759286
R1198 VSS.n326 VSS.n311 0.0759286
R1199 VSS.n334 VSS.n310 0.0759286
R1200 VSS.n335 VSS.n309 0.0759286
R1201 VSS.n405 VSS.n254 0.0759286
R1202 VSS.n404 VSS.n255 0.0759286
R1203 VSS.n403 VSS.n256 0.0759286
R1204 VSS.n401 VSS.n258 0.0759286
R1205 VSS.n399 VSS.n260 0.0759286
R1206 VSS.n415 VSS.n244 0.0759286
R1207 VSS.n414 VSS.n245 0.0759286
R1208 VSS.n413 VSS.n246 0.0759286
R1209 VSS.n411 VSS.n248 0.0759286
R1210 VSS.n409 VSS.n250 0.0759286
R1211 VSS.n428 VSS.n231 0.0759286
R1212 VSS.n425 VSS.n234 0.0759286
R1213 VSS.n424 VSS.n235 0.0759286
R1214 VSS.n423 VSS.n236 0.0759286
R1215 VSS.n421 VSS.n238 0.0759286
R1216 VSS.n419 VSS.n240 0.0759286
R1217 VSS.n385 VSS.n285 0.0759286
R1218 VSS.n384 VSS.n286 0.0759286
R1219 VSS.n382 VSS.n287 0.0759286
R1220 VSS.n283 VSS.n279 0.0759286
R1221 VSS.n281 VSS.n277 0.0759286
R1222 VSS.n365 VSS.n355 0.0759286
R1223 VSS.n357 VSS.n353 0.0759286
R1224 VSS.n376 VSS.n291 0.0759286
R1225 VSS.n373 VSS.n293 0.0759286
R1226 VSS.n371 VSS.n295 0.0759286
R1227 VSS.n77 VSS.n66 0.0594056
R1228 VSS.n273 VSS.n88 0.0594056
R1229 VSS.n450 VSS.n68 0.058826
R1230 VSS.n77 VSS.n76 0.0586497
R1231 VSS.n94 VSS.n88 0.0586497
R1232 VSS.n274 VSS.n90 0.0584906
R1233 VSS.n453 VSS.n452 0.0566224
R1234 VSS.n431 VSS.n47 0.0545
R1235 VSS.n140 VSS.n138 0.0539757
R1236 VSS.n156 VSS.n114 0.0529665
R1237 VSS.n382 VSS.n381 0.0528809
R1238 VSS.n105 VSS.n104 0.0527701
R1239 VSS.n440 VSS.n439 0.0519573
R1240 VSS.n429 VSS.n230 0.0518333
R1241 VSS.n155 VSS.n152 0.0517609
R1242 VSS.n139 VSS.n126 0.0509482
R1243 VSS.n133 VSS.n132 0.0507518
R1244 VSS.n163 VSS.n161 0.049939
R1245 VSS.n435 VSS.n434 0.0497426
R1246 VSS.n132 VSS.n130 0.0490925
R1247 VSS.n151 VSS.n120 0.0487334
R1248 VSS.n157 VSS.n155 0.0480833
R1249 VSS.n439 VSS.n102 0.0474161
R1250 VSS.n381 VSS.n288 0.0473412
R1251 VSS.n104 VSS.n102 0.0470742
R1252 VSS.n162 VSS.n110 0.0469115
R1253 VSS.n157 VSS.n156 0.0464069
R1254 VSS.n395 VSS.n394 0.046273
R1255 VSS.n147 VSS.n146 0.0457059
R1256 VSS.n138 VSS.n130 0.0453978
R1257 VSS.n146 VSS.n120 0.0448931
R1258 VSS.n435 VSS.n433 0.0438839
R1259 VSS.n163 VSS.n162 0.0436875
R1260 VSS.n144 VSS.n126 0.0426784
R1261 VSS.n152 VSS.n151 0.0418656
R1262 VSS.n434 VSS.n105 0.0408564
R1263 VSS.n161 VSS.n114 0.04066
R1264 VSS.n147 VSS.n145 0.0398472
R1265 VSS.n267 VSS.n90 0.0397443
R1266 VSS.n140 VSS.n139 0.0396508
R1267 VSS.n80 VSS.n73 0.039409
R1268 VSS.n81 VSS.n69 0.039409
R1269 VSS.n449 VSS.n448 0.039409
R1270 VSS.n268 VSS.n68 0.039409
R1271 VSS.n96 VSS.n95 0.039409
R1272 VSS.n99 VSS.n85 0.039409
R1273 VSS.n393 VSS.n100 0.039409
R1274 VSS.n432 VSS.n110 0.0386417
R1275 VSS.n350 VSS.n298 0.0302645
R1276 VSS.n338 VSS.n230 0.0298333
R1277 VSS.n336 VSS.n335 0.0298333
R1278 VSS.n335 VSS.n334 0.0298333
R1279 VSS.n328 VSS.n311 0.0298333
R1280 VSS.n329 VSS.n328 0.0298333
R1281 VSS.n318 VSS.n317 0.0298333
R1282 VSS.n321 VSS.n318 0.0298333
R1283 VSS.n319 VSS.n306 0.0298333
R1284 VSS.n306 VSS.n305 0.0298333
R1285 VSS.n304 VSS.n303 0.0298333
R1286 VSS.n303 VSS.n302 0.0298333
R1287 VSS.n301 VSS.n300 0.0298333
R1288 VSS.n300 VSS.n299 0.0298333
R1289 VSS.n337 VSS.n336 0.0225
R1290 VSS.n333 VSS.n311 0.0225
R1291 VSS.n330 VSS.n317 0.0225
R1292 VSS.n320 VSS.n319 0.0225
R1293 VSS.n314 VSS.n304 0.0225
R1294 VSS.n312 VSS.n301 0.0225
R1295 VSS.n365 VSS.n364 0.0214524
R1296 VSS.n366 VSS.n365 0.0214524
R1297 VSS.n358 VSS.n353 0.0214524
R1298 VSS.n358 VSS.n296 0.0214524
R1299 VSS.n372 VSS.n371 0.0214524
R1300 VSS.n373 VSS.n372 0.0214524
R1301 VSS.n376 VSS.n375 0.0214524
R1302 VSS.n377 VSS.n376 0.0214524
R1303 VSS.n385 VSS.n384 0.0214524
R1304 VSS.n386 VSS.n385 0.0214524
R1305 VSS.n280 VSS.n279 0.0214524
R1306 VSS.n280 VSS.n277 0.0214524
R1307 VSS.n450 VSS.n449 0.0195816
R1308 VSS.n274 VSS.n273 0.0195816
R1309 VSS VSS.n461 0.0185
R1310 VSS.n430 VSS.n229 0.0185
R1311 VSS.n332 VSS.n229 0.0185
R1312 VSS.n332 VSS.n331 0.0185
R1313 VSS.n331 VSS.n316 0.0185
R1314 VSS.n316 VSS.n315 0.0185
R1315 VSS.n315 VSS.n313 0.0185
R1316 VSS.n313 VSS.n297 0.0185
R1317 VSS.n351 VSS.n297 0.0185
R1318 VSS.n378 VSS.n288 0.0159153
R1319 VSS.n363 VSS.n362 0.0156425
R1320 VSS.n391 VSS.n390 0.0143286
R1321 VSS.n368 VSS.n352 0.0133571
R1322 VSS.n369 VSS.n368 0.0133571
R1323 VSS.n369 VSS.n289 0.0133571
R1324 VSS.n379 VSS.n289 0.0133571
R1325 VSS.n380 VSS.n379 0.0133571
R1326 VSS.n380 VSS.n278 0.0133571
R1327 VSS.n388 VSS.n278 0.0133571
R1328 VSS.n341 VSS.n307 0.0124467
R1329 VSS.n243 VSS.n242 0.0124467
R1330 VSS.n263 VSS.n262 0.0121878
R1331 VSS.n253 VSS.n252 0.0121878
R1332 VSS.n265 VSS.n264 0.0121878
R1333 VSS.n361 VSS.n360 0.0121878
R1334 VSS.n364 VSS.n363 0.0109762
R1335 VSS.n367 VSS.n366 0.0109762
R1336 VSS.n367 VSS.n353 0.0109762
R1337 VSS.n370 VSS.n296 0.0109762
R1338 VSS.n371 VSS.n370 0.0109762
R1339 VSS.n374 VSS.n373 0.0109762
R1340 VSS.n375 VSS.n374 0.0109762
R1341 VSS.n378 VSS.n377 0.0109762
R1342 VSS.n383 VSS.n382 0.0109762
R1343 VSS.n384 VSS.n383 0.0109762
R1344 VSS.n387 VSS.n386 0.0109762
R1345 VSS.n387 VSS.n279 0.0109762
R1346 VSS.n389 VSS.n277 0.0109762
R1347 VSS.n390 VSS.n389 0.0109762
R1348 VSS.n145 VSS.n144 0.0085734
R1349 VSS.n433 VSS.n432 0.0085734
R1350 VSS.n338 VSS.n337 0.00783333
R1351 VSS.n334 VSS.n333 0.00783333
R1352 VSS.n330 VSS.n329 0.00783333
R1353 VSS.n321 VSS.n320 0.00783333
R1354 VSS.n314 VSS.n305 0.00783333
R1355 VSS.n312 VSS.n302 0.00783333
R1356 VSS.n299 VSS.n298 0.00783333
R1357 VSS.n392 VSS.n391 0.00762381
R1358 VSS.n207 VSS.n65 0.00691667
R1359 VSS.n8 VSS.n42 0.0102097
R1360 VSS.n394 VSS.n392 0.00594762
R1361 VSS.n21 VSS.n18 0.00566656
R1362 VSS.n23 VSS.n21 0.00423062
R1363 VSS.n171 VSS.n45 0.00439839
R1364 VSS.n31 VSS.n30 0.00169993
R1365 VSS.n171 VSS.n13 0.00166667
R1366 VSS.n168 VSS.n36 0.00166667
R1367 VSS.n30 VSS.n42 0.0015
R1368 VSS.n33 VSS.n32 0.00199997
R1369 VSS.n37 VSS.n36 0.00183332
R1370 VSS.n19 VSS.n18 0.00183332
R1371 VSS.t0 VSS.n3 7.16512
R1372 VSS.n3 VSS.n17 0.221582
R1373 a_11798_1860.n0 a_11798_1860.n4 9.42143
R1374 a_11798_1860.n1 a_11798_1860.n12 9.42143
R1375 a_11798_1860.n1 a_11798_1860.n5 9.42143
R1376 a_11798_1860.n1 a_11798_1860.n6 9.42143
R1377 a_11798_1860.n2 a_11798_1860.n9 9.42143
R1378 a_11798_1860.n2 a_11798_1860.n7 9.42143
R1379 a_11798_1860.n4 a_11798_1860.t15 3.60374
R1380 a_11798_1860.n5 a_11798_1860.t21 3.60255
R1381 a_11798_1860.n6 a_11798_1860.t22 3.60255
R1382 a_11798_1860.n7 a_11798_1860.t28 3.60255
R1383 a_11798_1860.n4 a_11798_1860.t16 3.45423
R1384 a_11798_1860.n13 a_11798_1860.t17 3.45423
R1385 a_11798_1860.n11 a_11798_1860.t19 3.45423
R1386 a_11798_1860.n5 a_11798_1860.t20 3.45423
R1387 a_11798_1860.n12 a_11798_1860.t18 3.45423
R1388 a_11798_1860.n6 a_11798_1860.t23 3.45423
R1389 a_11798_1860.n10 a_11798_1860.t24 3.45423
R1390 a_11798_1860.n8 a_11798_1860.t26 3.45423
R1391 a_11798_1860.n7 a_11798_1860.t27 3.45423
R1392 a_11798_1860.n9 a_11798_1860.t25 3.45423
R1393 a_11798_1860.t14 a_11798_1860.n3 2.61386
R1394 a_11798_1860.n0 a_11798_1860.t0 2.61061
R1395 a_11798_1860.n1 a_11798_1860.t4 2.5622
R1396 a_11798_1860.n2 a_11798_1860.t11 2.56207
R1397 a_11798_1860.n2 a_11798_1860.t10 2.56174
R1398 a_11798_1860.n1 a_11798_1860.t7 2.56174
R1399 a_11798_1860.n0 a_11798_1860.t3 2.56174
R1400 a_11798_1860.n0 a_11798_1860.t2 2.56174
R1401 a_11798_1860.n0 a_11798_1860.t1 2.56174
R1402 a_11798_1860.n3 a_11798_1860.t13 2.56173
R1403 a_11798_1860.n1 a_11798_1860.t6 2.56155
R1404 a_11798_1860.n1 a_11798_1860.t5 2.56155
R1405 a_11798_1860.n1 a_11798_1860.t8 2.56147
R1406 a_11798_1860.n1 a_11798_1860.t9 2.5613
R1407 a_11798_1860.n3 a_11798_1860.t12 2.56128
R1408 a_11798_1860.n2 a_11798_1860.n1 0.245563
R1409 a_11798_1860.n8 a_11798_1860.n7 0.225083
R1410 a_11798_1860.n6 a_11798_1860.n10 0.225083
R1411 a_11798_1860.n11 a_11798_1860.n5 0.225083
R1412 a_11798_1860.n4 a_11798_1860.n13 0.225083
R1413 a_11798_1860.n1 a_11798_1860.n0 0.196551
R1414 a_11798_1860.n13 a_11798_1860.n12 0.1875
R1415 a_11798_1860.n12 a_11798_1860.n11 0.1875
R1416 a_11798_1860.n10 a_11798_1860.n9 0.1875
R1417 a_11798_1860.n9 a_11798_1860.n8 0.1875
R1418 a_11798_1860.n3 a_11798_1860.n2 0.147538
R1419 a_5428_3064.n0 a_5428_3064.t2 36.3628
R1420 a_5428_3064.n0 a_5428_3064.t0 35.246
R1421 a_5428_3064.t1 a_5428_3064.n0 15.3137
R1422 a_1474_1770.n0 a_1474_1770.t2 60.5214
R1423 a_1474_1770.n0 a_1474_1770.t1 33.8343
R1424 a_1474_1770.n1 a_1474_1770.n0 12.0028
R1425 a_1474_1770.t0 a_1474_1770.n1 2.87353
R1426 a_1474_1770.t0 a_1474_1770.n1 2.86853
R1427 a_1954_3500.n0 a_1954_3500.t2 44.3673
R1428 a_1954_3500.n0 a_1954_3500.t0 27.0418
R1429 a_1954_3500.t1 a_1954_3500.n0 12.2034
R1430 a_1254_3500.n0 a_1254_3500.t2 36.0512
R1431 a_1254_3500.n0 a_1254_3500.t3 33.7412
R1432 a_1254_3500.n3 a_1254_3500.t1 26.8072
R1433 a_1254_3500.n1 a_1254_3500.t5 26.0905
R1434 a_1254_3500.n1 a_1254_3500.t4 24.7412
R1435 a_1254_3500.t0 a_1254_3500.n3 12.4381
R1436 a_1254_3500.n3 a_1254_3500.n2 9.512
R1437 a_1254_3500.n2 a_1254_3500.n1 9.0005
R1438 a_1254_3500.n2 a_1254_3500.n0 0.7705
R1439 a_2654_5520.n1 a_2654_5520.t4 36.3944
R1440 a_2654_5520.n0 a_2654_5520.t1 34.4012
R1441 a_2654_5520.n0 a_2654_5520.t3 22.0391
R1442 a_2654_5520.n2 a_2654_5520.n1 9.0005
R1443 a_2654_5520.n2 a_2654_5520.t0 5.84394
R1444 a_2654_5520.t2 a_2654_5520.n2 4.67685
R1445 a_2654_5520.n1 a_2654_5520.n0 0.3173
R1446 vco_bias_0.vbn_buf.n3 vco_bias_0.vbn_buf.t1 55.3125
R1447 vco_bias_0.vbn_buf.n1 vco_bias_0.vbn_buf.t4 34.2391
R1448 vco_bias_0.vbn_buf.n1 vco_bias_0.vbn_buf.t3 28.5544
R1449 vco_bias_0.vbn_buf.n2 vco_bias_0.vbn_buf.n1 23.0981
R1450 vco_bias_0.vbn_buf.n0 vco_bias_0.vbn_buf.t2 21.7736
R1451 vco_bias_0.vbn_buf.n2 vco_bias_0.vbn_buf.t0 21.4968
R1452 vco_bias_0.vbn_buf vco_bias_0.vbn_buf.n0 20.8275
R1453 vco_bias_0.vbn_buf.n3 vco_bias_0.vbn_buf.n2 3.1069
R1454 vco_bias_0.vbn_buf vco_bias_0.vbn_buf.n3 1.2149
R1455 vco_bias_0.vbn_buf.n0 vco_bias_0.vbn_buf 0.1105
C0 a_9400_4880# rf_out_n 0.74832f
C1 a_10100_4160# a_9400_4880# 0.15006f
C2 a_19100_4966# vco_bias_0.vbg_buf 0.03283f
C3 a_10100_4160# rf_out_n 0.47919f
C4 vco_bias_0.vbn_buf di_en 0.04954f
C5 a_14668_3324# rf_out_p 0.74832f
C6 VDD di_en 0.23778f
C7 vco_bias_0.vbn_buf rf_out_p 0.18271f
C8 vdd_core a_9400_4966# 0.0801f
C9 VDD rf_out_p 0.45091f
C10 vco_bias_0.vbn_buf a_1160_2070# 0.03589f
C11 a_16500_4160# rf_out_p 0.47919f
C12 vco_bias_0.vbn_buf a_6760_4930# 0.04276f
C13 vdd_core a_14668_3324# 0.15264p
C14 vco_bias_0.vbn_buf vdd_core 0.29548f
C15 vco_bias_0.vbn_buf a_14668_3324# 0.05139f
C16 VDD vdd_core 1.71236f
C17 VDD a_14668_3324# 1.26121f
C18 a_16500_4160# a_14668_3324# 0.15006f
C19 VDD vco_bias_0.vbn_buf 0.42369f
C20 a_1560_1770# a_1160_2070# 0.60592f
C21 VDD a_16500_4160# 0.32132f
C22 a_1560_1770# vco_bias_0.vbn_buf 0.01263f
C23 vtune rf_out_p 0.03176f
C24 di_en vco_bias_0.vbg_buf 0.06389f
C25 VDD a_1560_1770# 0.02705f
C26 a_9400_4966# vco_bias_0.vbg_buf 0.05066f
C27 vtune vdd_core 13.5146f
C28 vtune a_14668_3324# 0.19347f
C29 rf_out_n rf_out_p 0.0144f
C30 a_6760_4930# vco_bias_0.vbg_buf 0.01207f
C31 a_9400_4966# a_9400_4880# 0.04847f
C32 vtune vco_bias_0.vbn_buf 0.09134f
C33 vdd_core vco_bias_0.vbg_buf 3.7479f
C34 a_14668_3324# vco_bias_0.vbg_buf 0.04106f
C35 vtune VDD 0.34468f
C36 vdd_core a_9400_4880# 0.15264p
C37 a_14668_3324# a_9400_4880# 0.09717f
C38 vco_bias_0.vbn_buf vco_bias_0.vbg_buf 7.0653f
C39 vco_bias_0.vbn_buf a_9400_4880# 0.06406f
C40 VDD vco_bias_0.vbg_buf 0.71134f
C41 di_en ibias_100u 0.20785f
C42 VDD a_9400_4880# 1.3464f
C43 vco_bias_0.vbn_buf rf_out_n 0.21187f
C44 vdd_core a_19100_4966# 0.08348f
C45 vco_bias_0.vbn_buf a_10100_4160# 0.01643f
C46 VDD rf_out_n 0.46478f
C47 a_19100_4966# a_14668_3324# 0.04847f
C48 a_1160_2070# ibias_100u 0.03793f
C49 VDD a_10100_4160# 0.35416f
C50 a_1560_1770# vco_bias_0.vbg_buf 0.03564f
C51 vco_bias_0.vbn_buf ibias_100u 0.0424f
C52 VDD ibias_100u 0.19675f
C53 vtune vco_bias_0.vbg_buf 0.07434f
C54 vtune a_9400_4880# 0.20309f
C55 vtune rf_out_n 0.03176f
C56 a_9400_4880# vco_bias_0.vbg_buf 0.0829f
C57 ibias_100u VSS 3.04847f
C58 rf_out_p VSS 4.45776f
C59 rf_out_n VSS 4.43878f
C60 di_en VSS 1.43665f
C61 vdd_core VSS 3.7827p
C62 VDD VSS 45.77975f
C63 vtune VSS 4.05654f
C64 vco_bias_0.vbn_buf VSS 0.1252p
C65 vco_bias_0.vbn_buf.n0 VSS 0.11278f
C66 vco_bias_0.vbn_buf.n1 VSS 0.23315f
C67 vco_bias_0.vbn_buf.t0 VSS 0.10315f
C68 vco_bias_0.vbn_buf.n2 VSS 0.21656f
C69 vco_bias_0.vbn_buf.t1 VSS 2.00251f
C70 vco_bias_0.vbn_buf.n3 VSS 0.12052f
C71 a_2654_5520.t0 VSS 0.38842f
C72 a_2654_5520.t3 VSS 0.43521f
C73 a_2654_5520.n0 VSS 0.8291f
C74 a_2654_5520.n1 VSS 0.87471f
C75 a_2654_5520.n2 VSS 0.68233f
C76 a_2654_5520.t2 VSS 0.82453f
C77 a_1254_3500.t1 VSS 0.06686f
C78 a_1254_3500.n0 VSS 0.92133f
C79 a_1254_3500.n1 VSS 0.49535f
C80 a_1254_3500.n2 VSS 0.24439f
C81 a_1254_3500.n3 VSS 0.45099f
C82 a_1254_3500.t0 VSS 0.14271f
C83 a_1954_3500.t0 VSS 0.08774f
C84 a_1954_3500.n0 VSS 1.17442f
C85 a_1954_3500.t1 VSS 0.1847f
C86 a_1474_1770.t1 VSS 0.64325f
C87 a_1474_1770.t2 VSS 2.31521f
C88 a_1474_1770.n0 VSS 2.68115f
C89 a_1474_1770.n1 VSS 0.51269f
C90 a_1474_1770.t0 VSS 0.67253f
C91 a_5428_3064.t2 VSS 0.65938f
C92 a_5428_3064.n0 VSS 1.39401f
C93 a_5428_3064.t1 VSS 0.65316f
C94 a_11798_1860.n0 VSS 2.0034f
C95 a_11798_1860.n1 VSS 3.45055f
C96 a_11798_1860.n2 VSS 1.4077f
C97 a_11798_1860.n3 VSS 1.32658f
C98 a_11798_1860.n4 VSS 0.13903f
C99 a_11798_1860.n5 VSS 0.13903f
C100 a_11798_1860.n6 VSS 0.13903f
C101 a_11798_1860.n7 VSS 0.13903f
C102 a_11798_1860.t28 VSS 0.0653f
C103 a_11798_1860.t25 VSS 0.06988f
C104 a_11798_1860.t26 VSS 0.06988f
C105 a_11798_1860.t27 VSS 0.06988f
C106 a_11798_1860.n8 VSS 0.07805f
C107 a_11798_1860.n9 VSS 0.08168f
C108 a_11798_1860.t23 VSS 4.48405f
C109 a_11798_1860.t24 VSS 0.06988f
C110 a_11798_1860.n10 VSS 0.07805f
C111 a_11798_1860.t22 VSS 0.0653f
C112 a_11798_1860.t21 VSS 0.0653f
C113 a_11798_1860.t18 VSS 0.06988f
C114 a_11798_1860.t19 VSS 0.06988f
C115 a_11798_1860.t20 VSS 4.34857f
C116 a_11798_1860.n11 VSS 0.07805f
C117 a_11798_1860.n12 VSS 0.08168f
C118 a_11798_1860.t16 VSS 0.06988f
C119 a_11798_1860.t17 VSS 0.06988f
C120 a_11798_1860.n13 VSS 0.07805f
C121 a_11798_1860.t15 VSS 0.0653f
C122 a_11798_1860.t0 VSS 0.21056f
C123 a_11798_1860.t1 VSS 0.20486f
C124 a_11798_1860.t2 VSS 0.20486f
C125 a_11798_1860.t3 VSS 0.20486f
C126 a_11798_1860.t4 VSS 0.20486f
C127 a_11798_1860.t5 VSS 0.20486f
C128 a_11798_1860.t6 VSS 0.20486f
C129 a_11798_1860.t7 VSS 0.20486f
C130 a_11798_1860.t8 VSS 0.20486f
C131 a_11798_1860.t9 VSS 0.20486f
C132 a_11798_1860.t10 VSS 0.20486f
C133 a_11798_1860.t11 VSS 1.03486f
C134 a_11798_1860.t12 VSS 0.20486f
C135 a_11798_1860.t13 VSS 0.20486f
C136 a_11798_1860.t14 VSS 0.21053f
C137 VSS.t31 VSS 0.97007f
C138 VSS.t41 VSS 54.7625f
C139 VSS.t36 VSS 0.28406f
C140 VSS.t46 VSS 0.26528f
C141 VSS.t32 VSS 0.97007f
C142 VSS.t42 VSS 54.7625f
C143 VSS.t44 VSS 0.26528f
C144 VSS.t38 VSS 0.28406f
C145 VSS.t22 VSS 3.70285f
C146 VSS.t24 VSS 3.70285f
C147 VSS.t141 VSS 0.53956f
C148 VSS.t157 VSS 0.37416f
C149 VSS.t19 VSS 0.13353f
C150 VSS.t18 VSS 0.13227f
C151 VSS.t12 VSS 0.19817f
C152 VSS.t16 VSS 0.03718f
C153 VSS.t128 VSS 0.0352f
C154 VSS.t14 VSS 0.06319f
C155 VSS.t17 VSS 0.07707f
C156 VSS.t84 VSS 0.83f
C157 VSS.t8 VSS 3.69775f
C158 VSS.t10 VSS 3.69775f
C159 vtune.t0 VSS 7.20321f
C160 vtune.t3 VSS 7.18915f
C161 vtune.n0 VSS 0.40877f
C162 vtune.t6 VSS 8.74735f
C163 vtune.n1 VSS 1.10946f
C164 VDD.t2 VSS 0.26329f
C165 VDD.t3 VSS 0.36993f
C166 VDD.n0 VSS 0.14737f
C167 VDD.t6 VSS 0.26329f
C168 VDD.t7 VSS 0.35485f
C169 VDD.n1 VSS 0.0543f
C170 VDD.n2 VSS 0.16397f
C171 VDD.t1 VSS 0.20608f
C172 VDD.t0 VSS 0.09246f
C173 VDD.n3 VSS 0.0679f
C174 VDD.n4 VSS 0.12395f
C175 VDD.t5 VSS 0.05569f
C176 VDD.t4 VSS 0.09246f
C177 VDD.n5 VSS 0.0679f
C178 VDD.n6 VSS 0.09558f
C179 VDD.t11 VSS 0.05549f
C180 VDD.t10 VSS 0.09246f
C181 VDD.n7 VSS 0.0679f
C182 VDD.n8 VSS 0.21904f
C183 VDD.t9 VSS 1.35256f
C184 VDD.t8 VSS 0.88196f
C185 VDD.n9 VSS 1.23582f
C186 vdd_core.n0 VSS 0.08489f
C187 vdd_core.n1 VSS 0.11397f
C188 vdd_core.n2 VSS 0.92962f
C189 vdd_core.n3 VSS 0.08489f
C190 vdd_core.n4 VSS 0.11397f
C191 vdd_core.n5 VSS 1.95769f
C192 vdd_core.n6 VSS 0.39987f
C193 vdd_core.n7 VSS 0.4866f
C194 vdd_core.n8 VSS 0.53833f
C195 vdd_core.n9 VSS 0.33042f
C196 vdd_core.n10 VSS 0.10119f
C197 vdd_core.n11 VSS 0.22701f
C198 vdd_core.n12 VSS 0.11657f
C199 vdd_core.n13 VSS 0.07526f
C200 vdd_core.n14 VSS 0.05507f
C201 vdd_core.n15 VSS 0.10119f
C202 vdd_core.n16 VSS 0.11657f
C203 vdd_core.n17 VSS 0.07366f
C204 vdd_core.n18 VSS 0.1028f
C205 vdd_core.n19 VSS 0.11496f
C206 vdd_core.n20 VSS 0.07526f
C207 vdd_core.n21 VSS 0.10119f
C208 vdd_core.n22 VSS 0.12107f
C209 vdd_core.n23 VSS 0.25789f
C210 vdd_core.n24 VSS 5.62227f
C211 vdd_core.n25 VSS 0.07526f
C212 vdd_core.n26 VSS 0.33042f
C213 vdd_core.n27 VSS 0.39243f
C214 vdd_core.n28 VSS 0.29485f
C215 vdd_core.n29 VSS 0.22665f
C216 vdd_core.n30 VSS 0.3785f
C217 vdd_core.n31 VSS 0.3785f
C218 vdd_core.n32 VSS 0.22943f
C219 vdd_core.n33 VSS 0.22943f
C220 vdd_core.n34 VSS 0.34712f
C221 vdd_core.n35 VSS 0.34712f
C222 vdd_core.n36 VSS 0.11496f
C223 vdd_core.n37 VSS 0.33042f
C224 vdd_core.n38 VSS 0.34853f
C225 vdd_core.n39 VSS 0.34853f
C226 vdd_core.n40 VSS 0.11496f
C227 vdd_core.n41 VSS 0.16256f
C228 vdd_core.n42 VSS 0.20951f
C229 vdd_core.n43 VSS 0.30872f
C230 vdd_core.n44 VSS 0.20951f
C231 vdd_core.n45 VSS 12.3819f
C232 vdd_core.n46 VSS 5.36468f
C233 vdd_core.n47 VSS 0.16521f
C234 vdd_core.n48 VSS 0.30872f
C235 vdd_core.n49 VSS 0.24518f
C236 vdd_core.n50 VSS 0.24518f
C237 vdd_core.n51 VSS 0.3785f
C238 vdd_core.n52 VSS 0.3785f
C239 vdd_core.n53 VSS 0.22481f
C240 vdd_core.n54 VSS 0.22481f
C241 vdd_core.n55 VSS 0.22204f
C242 vdd_core.n56 VSS 0.34712f
C243 vdd_core.n57 VSS 0.22204f
C244 vdd_core.n58 VSS 0.34712f
C245 vdd_core.n59 VSS 0.11657f
C246 vdd_core.n60 VSS 0.11496f
C247 vdd_core.n61 VSS 0.11657f
C248 vdd_core.n62 VSS 0.11496f
C249 vdd_core.n63 VSS 0.33042f
C250 vdd_core.n64 VSS 0.31388f
C251 vdd_core.n65 VSS 0.22019f
C252 vdd_core.n66 VSS 0.34712f
C253 vdd_core.n67 VSS 0.34712f
C254 vdd_core.n68 VSS 0.22665f
C255 vdd_core.n69 VSS 0.22665f
C256 vdd_core.n70 VSS 0.3785f
C257 vdd_core.n71 VSS 0.3785f
C258 vdd_core.n72 VSS 0.22943f
C259 vdd_core.n73 VSS 0.22943f
C260 vdd_core.n74 VSS 0.34712f
C261 vdd_core.n75 VSS 0.34712f
C262 vdd_core.n76 VSS 0.20951f
C263 vdd_core.n77 VSS 0.20951f
C264 vdd_core.n78 VSS 0.11657f
C265 vdd_core.n79 VSS 0.12595f
C266 vdd_core.n80 VSS 0.22204f
C267 vdd_core.n81 VSS 0.22204f
C268 vdd_core.n82 VSS 0.11657f
C269 vdd_core.n83 VSS 0.34853f
C270 vdd_core.n84 VSS 0.30872f
C271 vdd_core.n85 VSS 0.16256f
C272 vdd_core.n86 VSS 12.3819f
C273 vdd_core.n87 VSS 5.36468f
C274 vdd_core.n88 VSS 0.30872f
C275 vdd_core.n89 VSS 0.24518f
C276 vdd_core.n90 VSS 0.3785f
C277 vdd_core.n91 VSS 0.34712f
C278 vdd_core.n92 VSS 0.22481f
C279 vdd_core.n93 VSS 0.11496f
C280 vdd_core.n94 VSS 0.34712f
C281 vdd_core.n95 VSS 0.22481f
C282 vdd_core.n96 VSS 0.3785f
C283 vdd_core.n97 VSS 0.24518f
C284 vdd_core.n98 VSS 0.11496f
C285 vdd_core.n99 VSS 0.11496f
C286 vdd_core.n100 VSS 0.11496f
C287 vdd_core.n101 VSS 5.40921f
C288 vdd_core.n102 VSS 12.3374f
C289 vdd_core.n103 VSS 0.16256f
C290 vdd_core.n104 VSS 0.34853f
C291 vdd_core.n105 VSS 0.11657f
C292 vdd_core.n106 VSS 0.11496f
C293 vdd_core.t13 VSS 0.04267f
C294 vdd_core.n107 VSS 0.07706f
C295 vdd_core.n108 VSS 12.3733f
C296 vdd_core.n109 VSS 1.14331f
C297 vdd_core.t9 VSS 0.58207f
C298 vdd_core.t10 VSS 0.04306f
C299 vdd_core.t2 VSS 0.04251f
C300 vdd_core.n110 VSS 0.06801f
C301 vdd_core.t1 VSS 0.04251f
C302 vdd_core.n111 VSS 0.0819f
C303 vdd_core.n112 VSS 0.01811f
C304 vdd_core.n113 VSS 23.9141f
C305 vdd_core.n114 VSS 0.14402f
C306 vdd_core.n115 VSS 0.19348f
C307 vdd_core.n116 VSS 0.0963f
C308 vdd_core.n117 VSS 0.08404f
C309 vdd_core.n118 VSS 1.39257f
C310 vdd_core.n119 VSS 0.55371f
C311 vdd_core.n120 VSS 0.10048f
C312 vdd_core.t5 VSS 0.04251f
C313 vdd_core.t17 VSS 0.04251f
C314 vdd_core.t4 VSS 0.04306f
C315 vdd_core.n121 VSS 0.06855f
C316 vdd_core.n122 VSS 0.018f
C317 vdd_core.n123 VSS 12.3287f
C318 vdd_core.n124 VSS 0.8829f
C319 vdd_core.t8 VSS 0.04267f
C320 vdd_core.t6 VSS 0.41667f
C321 vdd_core.n125 VSS 0.08148f
C322 vdd_core.n126 VSS 0.07706f
C323 vdd_core.n127 VSS 0.63638f
C324 vdd_core.n128 VSS 13.199f
C325 vdd_core.n129 VSS 22.4533f
C326 vdd_core.n130 VSS 1.93428f
C327 vdd_core.n131 VSS 0.35282f
C328 vdd_core.n132 VSS 0.07099f
C329 vdd_core.n133 VSS 0.06782f
C330 vdd_core.n134 VSS 0.03007f
C331 vdd_core.n135 VSS 0.0388f
C332 vdd_core.n136 VSS 0.15414f
C333 vdd_core.n137 VSS 0.09211f
C334 vdd_core.n138 VSS 0.13611f
C335 vdd_core.n139 VSS 0.03726f
C336 vdd_core.n140 VSS 0.02897f
C337 vdd_core.n141 VSS 0.0963f
C338 vdd_core.n142 VSS 0.08779f
C339 vdd_core.n143 VSS 0.08779f
C340 vdd_core.n144 VSS 0.08705f
C341 vdd_core.n145 VSS 0.02897f
C342 vdd_core.n146 VSS 0.03726f
C343 vdd_core.n147 VSS 0.08404f
C344 vdd_core.n148 VSS 4.24297f
C345 vdd_core.n149 VSS 48.8273f
C346 vdd_core.n150 VSS 9.33546f
C347 vdd_core.n151 VSS 0.24782f
C348 vdd_core.n152 VSS 0.11496f
C349 vdd_core.n153 VSS 0.11657f
C350 vdd_core.n154 VSS 0.11496f
C351 vdd_core.n155 VSS 0.11657f
C352 vdd_core.n156 VSS 0.11496f
C353 vdd_core.n157 VSS 0.11657f
C354 vdd_core.n158 VSS 0.3719f
C355 vdd_core.n159 VSS 0.59057f
C356 vdd_core.n160 VSS 0.46559f
C357 vdd_core.n161 VSS 0.11657f
C358 vdd_core.n162 VSS 0.11496f
C359 vdd_core.n163 VSS 0.33042f
C360 vdd_core.n164 VSS 0.33042f
C361 vdd_core.n165 VSS 0.33042f
C362 vdd_core.n166 VSS 0.11496f
C363 vdd_core.n167 VSS 0.17003f
C364 vdd_core.n168 VSS 5.40921f
C365 vdd_core.n169 VSS 12.3374f
C366 vdd_core.n170 VSS 0.16256f
C367 vdd_core.n171 VSS 0.11657f
C368 vdd_core.n172 VSS 0.11657f
C369 vdd_core.n173 VSS 0.33042f
C370 vdd_core.n174 VSS 0.33042f
C371 vdd_core.n175 VSS 0.11657f
C372 vdd_core.n176 VSS 0.11496f
C373 vdd_core.n177 VSS 0.11657f
C374 vdd_core.n178 VSS 0.11496f
C375 vdd_core.n179 VSS 0.11657f
C376 vdd_core.n180 VSS 1.03552f
C377 vdd_core.n181 VSS 0.33042f
C378 vdd_core.n182 VSS 0.10119f
C379 vdd_core.n183 VSS 0.2268f
C380 vdd_core.n184 VSS 0.19835f
C381 vdd_core.n185 VSS 0.22734f
C382 vdd_core.n186 VSS 0.11657f
C383 vdd_core.n187 VSS 0.25789f
C384 vdd_core.n188 VSS 0.24841f
C385 vdd_core.n189 VSS 0.17727f
C386 vdd_core.n190 VSS 0.2268f
C387 vdd_core.n191 VSS 0.18048f
C388 vdd_core.n192 VSS 0.18048f
C389 vdd_core.n193 VSS 0.27775f
C390 vdd_core.n194 VSS 0.27775f
C391 vdd_core.n195 VSS 0.16546f
C392 vdd_core.n196 VSS 0.16546f
C393 vdd_core.n197 VSS 0.25484f
C394 vdd_core.n198 VSS 0.25484f
C395 vdd_core.n199 VSS 0.16344f
C396 vdd_core.n200 VSS 0.16344f
C397 vdd_core.n201 VSS 0.25578f
C398 vdd_core.n202 VSS 0.25578f
C399 vdd_core.n203 VSS 0.25262f
C400 vdd_core.n204 VSS 0.25368f
C401 vdd_core.n205 VSS 0.16209f
C402 vdd_core.n206 VSS 0.25484f
C403 vdd_core.n207 VSS 0.16681f
C404 vdd_core.n208 VSS 0.27775f
C405 vdd_core.n209 VSS 0.16884f
C406 vdd_core.n210 VSS 0.25484f
C407 vdd_core.n211 VSS 0.15421f
C408 vdd_core.n212 VSS 11.6259f
C409 vdd_core.n213 VSS 0.12107f
C410 vdd_core.n214 VSS 0.11657f
C411 vdd_core.n215 VSS 0.07526f
C412 vdd_core.n216 VSS 0.05507f
C413 vdd_core.n217 VSS 0.33042f
C414 vdd_core.n218 VSS 0.05507f
C415 vdd_core.n219 VSS 0.33042f
C416 vdd_core.n220 VSS 0.33042f
C417 vdd_core.n221 VSS 0.05507f
C418 vdd_core.n222 VSS 0.10119f
C419 vdd_core.n223 VSS 0.11657f
C420 vdd_core.n224 VSS 0.07366f
C421 vdd_core.n225 VSS 0.05507f
C422 vdd_core.n226 VSS 0.1028f
C423 vdd_core.n227 VSS 0.11496f
C424 vdd_core.n228 VSS 0.07366f
C425 vdd_core.n229 VSS 0.05507f
C426 vdd_core.n230 VSS 0.33042f
C427 vdd_core.n231 VSS 0.94332f
C428 vdd_core.n232 VSS 0.05507f
C429 vdd_core.n233 VSS 0.12873f
C430 vdd_core.n234 VSS 5.57947f
C431 vdd_core.n235 VSS 11.6687f
C432 vdd_core.n236 VSS 0.15421f
C433 vdd_core.n237 VSS 0.25484f
C434 vdd_core.n238 VSS 0.16884f
C435 vdd_core.n239 VSS 0.27775f
C436 vdd_core.n240 VSS 0.16681f
C437 vdd_core.n241 VSS 0.25484f
C438 vdd_core.n242 VSS 0.16209f
C439 vdd_core.n243 VSS 0.25368f
C440 vdd_core.n244 VSS 0.25262f
C441 vdd_core.n245 VSS 0.22543f
C442 vdd_core.n246 VSS 1.19425f
C443 vdd_core.n247 VSS 0.0669f
C444 vdd_core.n248 VSS 1.58456f
C445 di_en.n0 VSS 0.49428f
C446 rf_out_n.n0 VSS 0.67025f
C447 rf_out_n.n1 VSS 0.83016f
C448 rf_out_n.t6 VSS 1.71803f
C449 rf_out_n.t5 VSS 4.12113f
C450 rf_out_n.t2 VSS 0.3714f
C451 rf_out_n.t1 VSS 0.10612f
C452 rf_out_n.t4 VSS 0.10612f
C453 rf_out_n.t3 VSS 0.10612f
C454 rf_out_n.t0 VSS 0.10612f
C455 rf_out_n.n2 VSS 0.81115f
C456 rf_out_p.n0 VSS 0.91627f
C457 rf_out_p.n1 VSS 0.57093f
C458 rf_out_p.t0 VSS 1.7222f
C459 rf_out_p.t1 VSS 4.23688f
C460 rf_out_p.t2 VSS 0.38925f
C461 rf_out_p.t5 VSS 0.10519f
C462 rf_out_p.t6 VSS 0.10519f
C463 rf_out_p.t3 VSS 0.10519f
C464 rf_out_p.t4 VSS 0.10519f
C465 rf_out_p.n2 VSS 0.804f
C466 ibias_100u.t2 VSS 0.41391f
C467 ibias_100u.n0 VSS 0.34372f
C468 ibias_100u.n1 VSS 0.21893f
C469 ibias_100u.t0 VSS 0.19392f
C470 ibias_100u.n2 VSS 0.32183f
C471 ibias_100u.t3 VSS 2.0985f
C472 ibias_100u.n3 VSS 0.61912f
.ends
