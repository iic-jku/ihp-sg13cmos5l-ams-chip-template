* PEX produced on Fri Nov  6 09:39:25 AM CET 2026 using /foss/tools/sak/sak-pex.sh with m=3 and s=1 (extresist threshold=1000 mOhm, minres=100 mOhm, mindelay=0 ps)
* NGSPICE file created from vco_top_pex.ext - technology: ihp-sg13cmos5l

.subckt vco_top_pex ibias_100u di_en VDD VSS vdd_core vtune rf_out_p rf_out_n
X0 VSS.t157 vdd_core.t4 vdd_core.t12 VSS.t156 sg13_lv_nmos ad=0.38p pd=2.38u as=0.38p ps=2.38u w=2u l=0.13u
X1 a_11798_1860.t11 vco_bias_0.vbn_buf.t2 VSS.t84 VSS.t85 sg13_lv_nmos ad=0.95p pd=5.38u as=0.95p ps=5.38u w=5u l=0.5u
X2 rf_out_n.t5 a_9400_4880# a_11798_1860.t20 VSS.t107 sg13_lv_nmos ad=0.38p pd=2.38u as=0.38p ps=2.38u w=2u l=0.13u
X3 rf_out_n.t1 a_9400_4880# a_11798_1860.t18 VSS.t103 sg13_lv_nmos ad=0.38p pd=2.38u as=0.38p ps=2.38u w=2u l=0.13u
X4 VSS.t42 vco_bias_0.vbg_buf VSS.t41 VSS.t0 sg13_lv_nmos ad=2.72p pd=16.68u as=0 ps=0 w=8u l=10u
X5 VSS.t141 vdd_core.t0 vdd_core.t15 VSS.t140 sg13_lv_nmos ad=0.38p pd=2.38u as=0.38p ps=2.38u w=2u l=0.13u
X6 a_11798_1860.t12 vco_bias_0.vbn_buf.t2 VSS.t87 VSS.t88 sg13_lv_nmos ad=0.95p pd=5.38u as=0.95p ps=5.38u w=5u l=0.5u
X7 VSS.t10 vco_bias_0.vbn_buf.t3 VSS.t8 VSS.t9 sg13_lv_nmos ad=1.52p pd=8.38u as=0 ps=0 w=8u l=10u
X8 a_11798_1860.t23 a_14668_3324# rf_out_p.t1 VSS.t117 sg13_lv_nmos ad=0.38p pd=2.38u as=0.38p ps=2.38u w=2u l=0.13u
X9 a_11798_1860.t1 vco_bias_0.vbn_buf.t2 VSS.t56 VSS.t55 sg13_lv_nmos ad=0.95p pd=5.38u as=0.95p ps=5.38u w=5u l=0.5u
X10 VSS.t68 vco_bias_0.vbn_buf.t2 a_11798_1860.t4 VSS.t67 sg13_lv_nmos ad=0.95p pd=5.38u as=0.95p ps=5.38u w=5u l=0.5u
X11 a_11798_1860.t2 vco_bias_0.vbn_buf.t2 VSS.t59 VSS.t60 sg13_lv_nmos ad=0.95p pd=5.38u as=0.95p ps=5.38u w=5u l=0.5u
X12 vdd_core.t2 vdd_core.t0 VSS.t135 VSS.t136 sg13_lv_nmos ad=0.38p pd=2.38u as=0.38p ps=2.38u w=2u l=0.13u
X13 VSS.t71 vco_bias_0.vbn_buf.t2 a_11798_1860.t5 VSS.t72 sg13_lv_nmos ad=0.95p pd=5.38u as=0.95p ps=5.38u w=5u l=0.5u
X14 vdd_core.t3 vdd_core.t0 VSS.t130 VSS.t129 sg13_lv_nmos ad=0.38p pd=2.38u as=0.68p ps=4.68u w=2u l=0.13u
X15 VSS.t151 vdd_core.t4 vdd_core.t8 VSS.t150 sg13_lv_nmos ad=0.38p pd=2.38u as=0.38p ps=2.38u w=2u l=0.13u
X16 a_11798_1860.t9 vco_bias_0.vbn_buf.t2 VSS.t52 VSS.t81 sg13_lv_nmos ad=0.95p pd=5.38u as=0.95p ps=5.38u w=5u l=0.5u
X17 a_11798_1860.t26 a_14668_3324# rf_out_p.t6 VSS.t123 sg13_lv_nmos ad=0.38p pd=2.38u as=0.38p ps=2.38u w=2u l=0.13u
X18 rf_out_p.t5 a_14668_3324# a_11798_1860.t24 VSS.t120 sg13_lv_nmos ad=0.38p pd=2.38u as=0.38p ps=2.38u w=2u l=0.13u
X19 ibias_100u.t2 ibias_100u.t1 VSS.t18 VSS.t11 sg13_lv_nmos ad=0.85p pd=5.68u as=0.85p ps=5.68u w=2.5u l=0.5u
X20 vco_bias_0.vbn_buf.t0 a_1254_3500.t2 VSS.t17 VSS.t13 sg13_lv_nmos ad=0.34p pd=2.68u as=0.34p ps=2.68u w=1u l=0.13u
X21 VSS.t132 vdd_core.t0 vdd_core.t3 VSS.t131 sg13_lv_nmos ad=0.38p pd=2.38u as=0.38p ps=2.38u w=2u l=0.13u
X22 a_11798_1860.t16 a_9400_4880# rf_out_n.t0 VSS.t98 sg13_lv_nmos ad=0.38p pd=2.38u as=0.38p ps=2.38u w=2u l=0.13u
X23 VSS.t44 vco_bias_0.vbg_buf VSS.t42 VSS.t3 sg13_lv_nmos ad=1.52p pd=8.38u as=0 ps=0 w=8u l=10u
X24 VSS.t62 vco_bias_0.vbn_buf.t2 a_11798_1860.t2 VSS.t61 sg13_lv_nmos ad=0.95p pd=5.38u as=0.95p ps=5.38u w=5u l=0.5u
X25 a_11798_1860.t21 a_9400_4880# rf_out_n.t5 VSS.t108 sg13_lv_nmos ad=0.68p pd=4.68u as=0.38p ps=2.38u w=2u l=0.13u
X26 a_1474_1770.t1 a_5428_3064.t2 VSS.t111 rppd l=8.5u w=0.5u
X27 VSS.t52 vco_bias_0.vbn_buf.t2 a_11798_1860.t8 VSS.t51 sg13_lv_nmos ad=0.95p pd=5.38u as=0.95p ps=5.38u w=5u l=0.5u
X28 a_11798_1860.t6 vco_bias_0.vbn_buf.t2 VSS.t71 VSS.t70 sg13_lv_nmos ad=0.95p pd=5.38u as=0.95p ps=5.38u w=5u l=0.5u
X29 a_11798_1860.t19 a_9400_4880# rf_out_n.t1 VSS.t104 sg13_lv_nmos ad=0.38p pd=2.38u as=0.38p ps=2.38u w=2u l=0.13u
X30 a_11798_1860.t17 a_9400_4880# rf_out_n.t3 VSS.t100 sg13_lv_nmos ad=0.38p pd=2.38u as=0.38p ps=2.38u w=2u l=0.13u
X31 vco_bias_0.vbg_buf a_14668_3324# VSS.t114 rhigh l=8u w=0.5u
X32 vdd_core.t5 vdd_core.t4 VSS.t157 VSS.t158 sg13_lv_nmos ad=0.38p pd=2.38u as=0.38p ps=2.38u w=2u l=0.13u
X33 VSS.t24 vco_bias_0.vbn_buf.t4 VSS.t22 VSS.t23 sg13_lv_nmos ad=1.52p pd=8.38u as=0 ps=0 w=8u l=10u
X34 VSS.t28 vco_bias_0.vbn_buf.t4 VSS.t26 VSS.t27 sg13_lv_nmos ad=1.52p pd=8.38u as=0 ps=0 w=8u l=10u
X35 vdd_core.t14 vdd_core.t0 VSS.t141 VSS.t142 sg13_lv_nmos ad=0.38p pd=2.38u as=0.38p ps=2.38u w=2u l=0.13u
X36 rf_out_p.t2 a_14668_3324# a_11798_1860.t23 VSS.t118 sg13_lv_nmos ad=0.38p pd=2.38u as=0.38p ps=2.38u w=2u l=0.13u
X37 a_1254_3500.t1 di_en.t0 VSS.t128 VSS.t15 sg13_lv_nmos ad=0.17p pd=1.68u as=0.17p ps=1.68u w=0.5u l=0.13u
X38 VSS.t38 vco_bias_0.vbg_buf VSS.t36 VSS.t7 sg13_lv_nmos ad=1.52p pd=8.38u as=0 ps=0 w=8u l=10u
X39 a_11798_1860.t3 vco_bias_0.vbn_buf.t2 VSS.t62 VSS.t63 sg13_lv_nmos ad=0.95p pd=5.38u as=0.95p ps=5.38u w=5u l=0.5u
X40 VSS.t74 vco_bias_0.vbn_buf.t2 a_11798_1860.t6 VSS.t73 sg13_lv_nmos ad=0.95p pd=5.38u as=0.95p ps=5.38u w=5u l=0.5u
N41 vdd_core.t26 vtune.t0 sg13_hv_svaricap l=0.3u w=30.08u
X42 a_11798_1860.t28 a_14668_3324# rf_out_p.t4 VSS.t127 sg13_lv_nmos ad=0.68p pd=4.68u as=0.38p ps=2.38u w=2u l=0.13u
X43 rf_out_p.t3 a_14668_3324# a_11798_1860.t26 VSS.t124 sg13_lv_nmos ad=0.38p pd=2.38u as=0.38p ps=2.38u w=2u l=0.13u
X44 a_11798_1860.t25 a_14668_3324# rf_out_p.t5 VSS.t121 sg13_lv_nmos ad=0.38p pd=2.38u as=0.38p ps=2.38u w=2u l=0.13u
X45 VSS.t138 vdd_core.t0 vdd_core.t2 VSS.t137 sg13_lv_nmos ad=0.38p pd=2.38u as=0.38p ps=2.38u w=2u l=0.13u
X46 VSS.t36 vco_bias_0.vbg_buf VSS.t34 VSS.t5 sg13_lv_nmos ad=1.52p pd=8.38u as=0 ps=0 w=8u l=10u
X47 vdd_core.t9 vdd_core.t4 VSS.t151 VSS.t152 sg13_lv_nmos ad=0.38p pd=2.38u as=0.38p ps=2.38u w=2u l=0.13u
X48 rf_out_n.t3 a_9400_4880# a_11798_1860.t16 VSS.t99 sg13_lv_nmos ad=0.38p pd=2.38u as=0.38p ps=2.38u w=2u l=0.13u
X49 vdd_core.t10 vdd_core.t4 VSS.t146 VSS.t145 sg13_lv_nmos ad=0.38p pd=2.38u as=0.68p ps=4.68u w=2u l=0.13u
X50 a_1474_1770.t0 a_2654_5520.t4 VDD.t3 VDD.t2 sg13_lv_pmos ad=1.7p pd=10.68u as=1.7p ps=10.68u w=5u l=0.5u
N51 vdd_core.t22 vtune.t6 sg13_hv_svaricap l=0.3u w=30.08u
X52 VSS.t90 vco_bias_0.vbn_buf.t2 a_11798_1860.t12 VSS.t89 sg13_lv_nmos ad=0.95p pd=5.38u as=0.95p ps=5.38u w=5u l=0.5u
X53 a_11798_1860.t10 vco_bias_0.vbn_buf.t2 VSS.t80 VSS.t79 sg13_lv_nmos ad=0.95p pd=5.38u as=0.95p ps=5.38u w=5u l=0.5u
X54 a_11798_1860.t0 vco_bias_0.vbn_buf.t2 VSS.t54 VSS.t53 sg13_lv_nmos ad=0.95p pd=5.38u as=1.7p ps=10.68u w=5u l=0.5u
X55 vdd_core.t1 vdd_core.t0 VSS.t132 VSS.t133 sg13_lv_nmos ad=0.38p pd=2.38u as=0.38p ps=2.38u w=2u l=0.13u
X56 VDD.t8 rf_out_n.t6 VSS.t109 rppd l=1.65u w=10u
X57 VSS.t4 vco_bias_0.vbn_buf.t3 VSS.t2 VSS.t3 sg13_lv_nmos ad=1.52p pd=8.38u as=0 ps=0 w=8u l=10u
X58 VSS.t148 vdd_core.t4 vdd_core.t10 VSS.t147 sg13_lv_nmos ad=0.38p pd=2.38u as=0.38p ps=2.38u w=2u l=0.13u
X59 VSS.t65 vco_bias_0.vbn_buf.t2 a_11798_1860.t3 VSS.t64 sg13_lv_nmos ad=0.95p pd=5.38u as=0.95p ps=5.38u w=5u l=0.5u
X60 VSS.t8 vco_bias_0.vbn_buf.t3 VSS.t6 VSS.t7 sg13_lv_nmos ad=1.52p pd=8.38u as=0 ps=0 w=8u l=10u
X61 rf_out_n.t2 a_9400_4880# a_11798_1860.t19 VSS.t105 sg13_lv_nmos ad=0.38p pd=2.38u as=0.38p ps=2.38u w=2u l=0.13u
X62 rf_out_n.t4 a_9400_4880# a_11798_1860.t17 VSS.t101 sg13_lv_nmos ad=0.38p pd=2.38u as=0.38p ps=2.38u w=2u l=0.13u
X63 VSS.t26 vco_bias_0.vbn_buf.t4 VSS.t24 VSS.t25 sg13_lv_nmos ad=1.52p pd=8.38u as=0 ps=0 w=8u l=10u
X64 VSS.t40 vco_bias_0.vbg_buf VSS.t38 VSS.t9 sg13_lv_nmos ad=1.52p pd=8.38u as=0 ps=0 w=8u l=10u
X65 a_11798_1860.t24 a_14668_3324# rf_out_p.t2 VSS.t119 sg13_lv_nmos ad=0.38p pd=2.38u as=0.38p ps=2.38u w=2u l=0.13u
X66 rf_out_p.t1 a_14668_3324# a_11798_1860.t22 VSS.t116 sg13_lv_nmos ad=0.38p pd=2.38u as=0.68p ps=4.68u w=2u l=0.13u
X67 ibias_100u.t0 a_1254_3500.t3 VSS.t14 VSS.t13 sg13_lv_nmos ad=0.34p pd=2.68u as=0.34p ps=2.68u w=1u l=0.13u
X68 VSS.t48 vco_bias_0.vbg_buf VSS.t46 VSS.t7 sg13_lv_nmos ad=1.52p pd=8.38u as=0 ps=0 w=8u l=10u
X69 VSS.t80 vco_bias_0.vbn_buf.t2 a_11798_1860.t9 VSS.t82 sg13_lv_nmos ad=0.95p pd=5.38u as=0.95p ps=5.38u w=5u l=0.5u
X70 VSS.t56 vco_bias_0.vbn_buf.t2 a_11798_1860.t0 VSS.t57 sg13_lv_nmos ad=0.95p pd=5.38u as=0.95p ps=5.38u w=5u l=0.5u
N71 vdd_core.t24 vtune.t3 sg13_hv_svaricap l=0.3u w=30.08u
X72 a_11798_1860.t13 vco_bias_0.vbn_buf.t2 VSS.t90 VSS.t91 sg13_lv_nmos ad=0.95p pd=5.38u as=0.95p ps=5.38u w=5u l=0.5u
X73 a_2654_5520.t3 a_1954_3500.t2 VDD.t1 VDD.t0 sg13_lv_pmos ad=0.34p pd=2.68u as=0.34p ps=2.68u w=1u l=0.13u
X74 a_11798_1860.t14 vco_bias_0.vbn_buf.t2 VSS.t93 VSS.t94 sg13_lv_nmos ad=0.95p pd=5.38u as=0.95p ps=5.38u w=5u l=0.5u
X75 VSS.t160 vdd_core.t4 vdd_core.t5 VSS.t159 sg13_lv_nmos ad=0.68p pd=4.68u as=0.38p ps=2.38u w=2u l=0.13u
X76 VSS.t144 vdd_core.t0 vdd_core.t14 VSS.t143 sg13_lv_nmos ad=0.68p pd=4.68u as=0.38p ps=2.38u w=2u l=0.13u
X77 a_1954_3500.t0 a_1254_3500.t4 VSS.t16 VSS.t15 sg13_lv_nmos ad=0.17p pd=1.68u as=0.17p ps=1.68u w=0.5u l=0.13u
X78 a_11798_1860.t27 a_14668_3324# rf_out_p.t3 VSS.t125 sg13_lv_nmos ad=0.38p pd=2.38u as=0.38p ps=2.38u w=2u l=0.13u
X79 vco_bias_0.vbg_buf a_9400_4880# VSS.t110 rhigh l=8u w=0.5u
X80 VSS.t46 vco_bias_0.vbg_buf VSS.t44 VSS.t5 sg13_lv_nmos ad=1.52p pd=8.38u as=0 ps=0 w=8u l=10u
X81 a_1254_3500.t0 di_en.t1 VDD.t11 VDD.t10 sg13_lv_pmos ad=0.34p pd=2.68u as=0.34p ps=2.68u w=1u l=0.13u
X82 VSS.t6 vco_bias_0.vbn_buf.t3 VSS.t4 VSS.t5 sg13_lv_nmos ad=1.52p pd=8.38u as=0 ps=0 w=8u l=10u
X83 a_11798_1860.t4 vco_bias_0.vbn_buf.t2 VSS.t65 VSS.t66 sg13_lv_nmos ad=0.95p pd=5.38u as=0.95p ps=5.38u w=5u l=0.5u
X84 a_1474_1770.t2 vco_bias_0.vbg_buf VSS.t112 rhigh l=32u w=0.5u
X85 a_5428_3064.t1 a_5428_3064.t0 VSS.t12 VSS.t11 sg13_lv_nmos ad=0.85p pd=5.68u as=0.85p ps=5.68u w=2.5u l=0.5u
X86 VSS.t76 vco_bias_0.vbn_buf.t2 a_11798_1860.t7 VSS.t78 sg13_lv_nmos ad=0.95p pd=5.38u as=0.95p ps=5.38u w=5u l=0.5u
X87 VSS.t154 vdd_core.t4 vdd_core.t9 VSS.t153 sg13_lv_nmos ad=0.38p pd=2.38u as=0.38p ps=2.38u w=2u l=0.13u
X88 VSS.t93 vco_bias_0.vbn_buf.t2 a_11798_1860.t13 VSS.t92 sg13_lv_nmos ad=0.95p pd=5.38u as=0.95p ps=5.38u w=5u l=0.5u
X89 a_11798_1860.t20 a_9400_4880# rf_out_n.t2 VSS.t106 sg13_lv_nmos ad=0.38p pd=2.38u as=0.38p ps=2.38u w=2u l=0.13u
X90 a_11798_1860.t18 a_9400_4880# rf_out_n.t4 VSS.t102 sg13_lv_nmos ad=0.38p pd=2.38u as=0.38p ps=2.38u w=2u l=0.13u
X91 VSS.t96 vco_bias_0.vbn_buf.t2 a_11798_1860.t14 VSS.t95 sg13_lv_nmos ad=1.7p pd=10.68u as=0.95p ps=5.38u w=5u l=0.5u
X92 VSS.t22 vco_bias_0.vbn_buf.t4 VSS.t21 VSS.t20 sg13_lv_nmos ad=2.72p pd=16.68u as=0 ps=0 w=8u l=10u
X93 VSS.t32 vco_bias_0.vbg_buf VSS.t31 VSS.t0 sg13_lv_nmos ad=2.72p pd=16.68u as=0 ps=0 w=8u l=10u
X94 a_2654_5520.t0 ibias_100u.t4 VSS.t19 VSS.t11 sg13_lv_nmos ad=0.85p pd=5.68u as=0.85p ps=5.68u w=2.5u l=0.5u
X95 VSS.t50 vco_bias_0.vbg_buf VSS.t48 VSS.t9 sg13_lv_nmos ad=1.52p pd=8.38u as=0 ps=0 w=8u l=10u
X96 VSS.t135 vdd_core.t0 vdd_core.t1 VSS.t134 sg13_lv_nmos ad=0.38p pd=2.38u as=0.38p ps=2.38u w=2u l=0.13u
X97 vdd_core.t12 vdd_core.t4 VSS.t154 VSS.t155 sg13_lv_nmos ad=0.38p pd=2.38u as=0.38p ps=2.38u w=2u l=0.13u
X98 ibias_100u.t3 vco_bias_0.vbn_buf.t1 VSS.t113 rhigh l=32u w=0.5u
X99 vdd_core.t15 vdd_core.t0 VSS.t138 VSS.t139 sg13_lv_nmos ad=0.38p pd=2.38u as=0.38p ps=2.38u w=2u l=0.13u
X100 vdd_core.t8 vdd_core.t4 VSS.t148 VSS.t149 sg13_lv_nmos ad=0.38p pd=2.38u as=0.38p ps=2.38u w=2u l=0.13u
N101 vdd_core.t23 vtune.t6 sg13_hv_svaricap l=0.3u w=30.08u
X102 a_11798_1860.t7 vco_bias_0.vbn_buf.t2 VSS.t74 VSS.t77 sg13_lv_nmos ad=0.95p pd=5.38u as=0.95p ps=5.38u w=5u l=0.5u
X103 VSS.t30 vco_bias_0.vbn_buf.t4 VSS.t28 VSS.t29 sg13_lv_nmos ad=1.52p pd=8.38u as=0 ps=0 w=8u l=10u
X104 VSS.t84 vco_bias_0.vbn_buf.t2 a_11798_1860.t10 VSS.t83 sg13_lv_nmos ad=0.95p pd=5.38u as=0.95p ps=5.38u w=5u l=0.5u
X105 a_11798_1860.t8 vco_bias_0.vbn_buf.t2 VSS.t76 VSS.t75 sg13_lv_nmos ad=0.95p pd=5.38u as=0.95p ps=5.38u w=5u l=0.5u
X106 VSS.t87 vco_bias_0.vbn_buf.t2 a_11798_1860.t11 VSS.t86 sg13_lv_nmos ad=0.95p pd=5.38u as=0.95p ps=5.38u w=5u l=0.5u
X107 rf_out_p.t4 a_14668_3324# a_11798_1860.t27 VSS.t126 sg13_lv_nmos ad=0.38p pd=2.38u as=0.38p ps=2.38u w=2u l=0.13u
X108 a_2654_5520.t2 a_2654_5520.t1 VDD.t7 VDD.t6 sg13_lv_pmos ad=1.7p pd=10.68u as=1.7p ps=10.68u w=5u l=0.5u
X109 rf_out_p.t6 a_14668_3324# a_11798_1860.t25 VSS.t122 sg13_lv_nmos ad=0.38p pd=2.38u as=0.38p ps=2.38u w=2u l=0.13u
N110 vdd_core.t25 vtune.t3 sg13_hv_svaricap l=0.3u w=30.08u
N111 vdd_core.t27 vtune.t0 sg13_hv_svaricap l=0.3u w=30.08u
X112 rf_out_n.t0 a_9400_4880# a_11798_1860.t15 VSS.t97 sg13_lv_nmos ad=0.38p pd=2.38u as=0.68p ps=4.68u w=2u l=0.13u
X113 VSS.t2 vco_bias_0.vbn_buf.t3 VSS.t1 VSS.t0 sg13_lv_nmos ad=2.72p pd=16.68u as=0 ps=0 w=8u l=10u
X114 VSS.t59 vco_bias_0.vbn_buf.t2 a_11798_1860.t1 VSS.t58 sg13_lv_nmos ad=0.95p pd=5.38u as=0.95p ps=5.38u w=5u l=0.5u
X115 VSS.t34 vco_bias_0.vbg_buf VSS.t32 VSS.t3 sg13_lv_nmos ad=1.52p pd=8.38u as=0 ps=0 w=8u l=10u
X116 a_11798_1860.t5 vco_bias_0.vbn_buf.t2 VSS.t68 VSS.t69 sg13_lv_nmos ad=0.95p pd=5.38u as=0.95p ps=5.38u w=5u l=0.5u
X117 VDD.t9 rf_out_p.t0 VSS.t115 rppd l=1.65u w=10u
X118 a_1954_3500.t1 a_1254_3500.t5 VDD.t5 VDD.t4 sg13_lv_pmos ad=0.34p pd=2.68u as=0.34p ps=2.68u w=1u l=0.13u
R0 ibias_100u.n3 ibias_100u.t3 54.3738
R1 ibias_100u.n0 ibias_100u.t4 34.6784
R2 ibias_100u.n1 ibias_100u.t1 34.2252
R3 ibias_100u.n2 ibias_100u.t0 20.5585
R4 ibias_100u.n0 ibias_100u.t2 14.6093
R5 ibias_100u.n3 ibias_100u.n2 1.7473
R6 ibias_100u ibias_100u.n3 1.2149
R7 ibias_100u.n2 ibias_100u.n1 0.5351
R8 ibias_100u.n1 ibias_100u.n0 0.3173
R9 rf_out_p rf_out_p.n2 7.11117
R10 rf_out_p.n0 rf_out_p.t1 4.77599
R11 rf_out_p.n1 rf_out_p.t4 4.72949
R12 rf_out_p.n1 rf_out_p.t3 4.72949
R13 rf_out_p.n0 rf_out_p.t6 4.72949
R14 rf_out_p.n0 rf_out_p.t5 4.72949
R15 rf_out_p.n0 rf_out_p.t2 4.72949
R16 rf_out_p.n2 rf_out_p.t0 2.40801
R17 rf_out_p.n2 rf_out_p.n1 0.685593
R18 rf_out_p.n1 rf_out_p.n0 0.186531
R19 rf_out_n rf_out_n.n2 7.11117
R20 rf_out_n.n0 rf_out_n.t5 4.77599
R21 rf_out_n.n0 rf_out_n.t2 4.72949
R22 rf_out_n.n0 rf_out_n.t1 4.72949
R23 rf_out_n.n1 rf_out_n.t4 4.72949
R24 rf_out_n.n1 rf_out_n.t3 4.72949
R25 rf_out_n.n1 rf_out_n.t0 4.72949
R26 rf_out_n.n2 rf_out_n.t6 2.40801
R27 rf_out_n.n2 rf_out_n.n1 0.685593
R28 rf_out_n.n1 rf_out_n.n0 0.186531
R29 di_en.n0 di_en.t1 26.3252
R30 di_en.n0 di_en.t0 24.5065
R31 di_en di_en.n0 10.1632
R32 vdd_core.n87 vdd_core.n86 6.52948
R33 vdd_core.n46 vdd_core.n45 6.52948
R34 vdd_core.n102 vdd_core.n101 6.47038
R35 vdd_core.n169 vdd_core.n168 6.47038
R36 vdd_core.n235 vdd_core.n234 6.05177
R37 vdd_core.n212 vdd_core.n24 6.00132
R38 vdd_core.n3 vdd_core.t14 4.76919
R39 vdd_core.n0 vdd_core.t10 4.76919
R40 vdd_core.n107 vdd_core.t3 4.74635
R41 vdd_core.n126 vdd_core.t5 4.74635
R42 vdd_core.n4 vdd_core.t15 4.72949
R43 vdd_core.n110 vdd_core.t2 4.72949
R44 vdd_core.n111 vdd_core.t1 4.72949
R45 vdd_core.n125 vdd_core.t12 4.72949
R46 vdd_core.n121 vdd_core.t9 4.72949
R47 vdd_core.n1 vdd_core.t8 4.72949
R48 vdd_core.n113 vdd_core.t4 4.17215
R49 vdd_core.n128 vdd_core.t0 4.00826
R50 vdd_core.n108 vdd_core.t22 3.71265
R51 vdd_core.n123 vdd_core.t23 3.6936
R52 vdd_core.n143 vdd_core.n142 3.55422
R53 vdd_core.n108 vdd_core.t24 3.41873
R54 vdd_core.n109 vdd_core.t26 3.41873
R55 vdd_core.n123 vdd_core.t25 3.39968
R56 vdd_core.n124 vdd_core.t27 3.39968
R57 vdd_core.n147 vdd_core.n117 3.34302
R58 vdd_core.n136 vdd_core.n115 3.13182
R59 vdd_core.n134 vdd_core.n120 2.4579
R60 vdd_core.n141 vdd_core.n140 2.3523
R61 vdd_core.n145 vdd_core.n116 2.3523
R62 vdd_core.n4 vdd_core.n3 0.0338961
R63 vdd_core.n1 vdd_core.n0 0.0338961
R64 vdd_core.n148 vdd_core.n114 2.2467
R65 vdd_core.n138 vdd_core.n137 2.2467
R66 vdd_core.n7 vdd_core.n115 0.0886235
R67 vdd_core.n130 vdd_core.n129 1.94587
R68 vdd_core.n149 vdd_core.n148 1.86783
R69 vdd_core.n133 vdd_core.n132 1.79979
R70 vdd_core.n142 vdd_core.n135 1.72436
R71 vdd_core.n144 vdd_core.n143 1.72436
R72 vdd_core.n147 vdd_core.n146 1.64893
R73 vdd_core.n139 vdd_core.n117 1.64893
R74 vdd_core.n136 vdd_core.n8 0.134007
R75 vdd_core.n129 vdd_core.n118 1.44601
R76 vdd_core.n131 vdd_core.n119 1.16033
R77 vdd_core.n2 vdd_core.n107 1.12056
R78 vdd_core.n127 vdd_core.n126 1.12056
R79 vdd_core vdd_core.n248 0.9603
R80 vdd_core.n150 vdd_core.n149 0.917955
R81 vdd_core.n129 vdd_core.n128 0.833239
R82 vdd_core.n2 vdd_core.n112 0.741487
R83 vdd_core.n127 vdd_core.n122 0.741487
R84 vdd_core.n150 vdd_core.n79 0.56175
R85 vdd_core.n248 vdd_core.n247 0.5505
R86 vdd_core.n14 vdd_core.n9 0.5505
R87 vdd_core.n217 vdd_core.n216 0.5505
R88 vdd_core.n219 vdd_core.n218 0.5505
R89 vdd_core.n221 vdd_core.n220 0.5505
R90 vdd_core.n225 vdd_core.n181 0.5505
R91 vdd_core.n230 vdd_core.n229 0.5505
R92 vdd_core.n232 vdd_core.n231 0.5505
R93 vdd_core.n178 vdd_core.n26 0.5505
R94 vdd_core.n175 vdd_core.n174 0.5505
R95 vdd_core.n173 vdd_core.n172 0.5505
R96 vdd_core.n60 vdd_core.n37 0.5505
R97 vdd_core.n166 vdd_core.n165 0.5505
R98 vdd_core.n164 vdd_core.n47 0.5505
R99 vdd_core.n163 vdd_core.n162 0.5505
R100 vdd_core.n155 vdd_core.n63 0.5505
R101 vdd_core.n152 vdd_core.n151 0.5505
R102 vdd_core.n150 vdd_core.n106 0.5505
R103 vdd_core.n246 vdd_core.n11 0.446709
R104 vdd_core.n246 vdd_core.n245 0.445751
R105 vdd_core.n97 vdd_core.n84 0.4405
R106 vdd_core.n89 vdd_core.n88 0.4405
R107 vdd_core.n50 vdd_core.n43 0.4405
R108 vdd_core.n49 vdd_core.n48 0.4405
R109 vdd_core.n192 vdd_core.n190 0.4405
R110 vdd_core.n191 vdd_core.n183 0.4405
R111 vdd_core.n101 vdd_core.n84 0.4405
R112 vdd_core.n88 vdd_core.n87 0.4405
R113 vdd_core.n168 vdd_core.n43 0.4405
R114 vdd_core.n48 vdd_core.n46 0.4405
R115 vdd_core.n190 vdd_core.n189 0.4405
R116 vdd_core.n184 vdd_core.n183 0.4405
R117 vdd_core.n131 vdd_core.n130 0.421631
R118 vdd_core.n95 vdd_core.n94 0.3635
R119 vdd_core.n94 vdd_core.n81 0.3635
R120 vdd_core.n77 vdd_core.n75 0.3635
R121 vdd_core.n75 vdd_core.n73 0.3635
R122 vdd_core.n69 vdd_core.n67 0.3635
R123 vdd_core.n67 vdd_core.n65 0.3635
R124 vdd_core.n92 vdd_core.n91 0.3635
R125 vdd_core.n91 vdd_core.n80 0.3635
R126 vdd_core.n76 vdd_core.n74 0.3635
R127 vdd_core.n74 vdd_core.n72 0.3635
R128 vdd_core.n68 vdd_core.n66 0.3635
R129 vdd_core.n66 vdd_core.n64 0.3635
R130 vdd_core.n58 vdd_core.n54 0.3635
R131 vdd_core.n58 vdd_core.n57 0.3635
R132 vdd_core.n42 vdd_core.n35 0.3635
R133 vdd_core.n35 vdd_core.n33 0.3635
R134 vdd_core.n29 vdd_core.n27 0.3635
R135 vdd_core.n27 vdd_core.n5 0.421153
R136 vdd_core.n56 vdd_core.n53 0.3635
R137 vdd_core.n56 vdd_core.n55 0.3635
R138 vdd_core.n44 vdd_core.n34 0.3635
R139 vdd_core.n34 vdd_core.n32 0.3635
R140 vdd_core.n198 vdd_core.n196 0.3635
R141 vdd_core.n200 vdd_core.n198 0.3635
R142 vdd_core.n211 vdd_core.n210 0.3635
R143 vdd_core.n210 vdd_core.n209 0.3635
R144 vdd_core.n207 vdd_core.n206 0.3635
R145 vdd_core.n206 vdd_core.n205 0.3635
R146 vdd_core.n185 vdd_core.n184 0.3635
R147 vdd_core.n197 vdd_core.n195 0.3635
R148 vdd_core.n199 vdd_core.n197 0.3635
R149 vdd_core.n237 vdd_core.n236 0.3635
R150 vdd_core.n238 vdd_core.n237 0.3635
R151 vdd_core.n241 vdd_core.n240 0.3635
R152 vdd_core.n242 vdd_core.n241 0.3635
R153 vdd_core.n158 vdd_core.n64 0.345639
R154 vdd_core.n2 vdd_core.n109 0.33314
R155 vdd_core.n160 vdd_core.n159 0.299759
R156 vdd_core.n109 vdd_core.n108 0.29442
R157 vdd_core.n124 vdd_core.n123 0.29442
R158 vdd_core.n187 vdd_core.n24 0.276447
R159 vdd_core.n189 vdd_core.n188 0.276447
R160 vdd_core.n194 vdd_core.n192 0.276447
R161 vdd_core.n196 vdd_core.n194 0.276447
R162 vdd_core.n202 vdd_core.n200 0.276447
R163 vdd_core.n209 vdd_core.n208 0.276447
R164 vdd_core.n208 vdd_core.n207 0.276447
R165 vdd_core.n205 vdd_core.n204 0.276447
R166 vdd_core.n203 vdd_core.n11 0.276447
R167 vdd_core.n234 vdd_core.n23 0.276447
R168 vdd_core.n193 vdd_core.n191 0.276447
R169 vdd_core.n195 vdd_core.n193 0.276447
R170 vdd_core.n201 vdd_core.n199 0.276447
R171 vdd_core.n239 vdd_core.n238 0.276447
R172 vdd_core.n240 vdd_core.n239 0.276447
R173 vdd_core.n243 vdd_core.n242 0.276447
R174 vdd_core.n245 vdd_core.n244 0.276447
R175 vdd_core.n97 vdd_core.n96 0.276188
R176 vdd_core.n96 vdd_core.n95 0.276188
R177 vdd_core.n104 vdd_core.n81 0.276188
R178 vdd_core.n73 vdd_core.n71 0.276188
R179 vdd_core.n71 vdd_core.n69 0.276188
R180 vdd_core.n160 vdd_core.n65 0.276188
R181 vdd_core.n90 vdd_core.n89 0.276188
R182 vdd_core.n92 vdd_core.n90 0.276188
R183 vdd_core.n83 vdd_core.n80 0.276188
R184 vdd_core.n72 vdd_core.n70 0.276188
R185 vdd_core.n70 vdd_core.n68 0.276188
R186 vdd_core.n52 vdd_core.n50 0.276188
R187 vdd_core.n54 vdd_core.n52 0.276188
R188 vdd_core.n57 vdd_core.n39 0.276188
R189 vdd_core.n33 vdd_core.n31 0.276188
R190 vdd_core.n31 vdd_core.n29 0.276188
R191 vdd_core.n51 vdd_core.n49 0.276188
R192 vdd_core.n53 vdd_core.n51 0.276188
R193 vdd_core.n55 vdd_core.n38 0.276188
R194 vdd_core.n32 vdd_core.n30 0.276188
R195 vdd_core.n30 vdd_core.n28 0.276188
R196 vdd_core.n144 vdd_core.n118 0.264545
R197 vdd_core.n102 vdd_core.n77 0.2645
R198 vdd_core.n86 vdd_core.n76 0.2645
R199 vdd_core.n169 vdd_core.n42 0.2645
R200 vdd_core.n45 vdd_core.n44 0.2645
R201 vdd_core.n212 vdd_core.n211 0.2645
R202 vdd_core.n236 vdd_core.n235 0.2645
R203 vdd_core.n8 vdd_core.n138 0.449962
R204 vdd_core.n119 vdd_core.n118 0.249794
R205 vdd_core.n188 vdd_core.n187 0.199447
R206 vdd_core.n213 vdd_core.n202 0.199447
R207 vdd_core.n204 vdd_core.n203 0.199447
R208 vdd_core.n185 vdd_core.n23 0.199447
R209 vdd_core.n201 vdd_core.n22 0.199447
R210 vdd_core.n244 vdd_core.n243 0.199447
R211 vdd_core.n104 vdd_core.n103 0.199188
R212 vdd_core.n85 vdd_core.n83 0.199188
R213 vdd_core.n170 vdd_core.n39 0.199188
R214 vdd_core.n41 vdd_core.n38 0.199188
R215 vdd_core.n133 vdd_core.n130 0.195018
R216 vdd_core.n127 vdd_core.n124 0.175092
R217 vdd_core.n146 vdd_core.n114 0.1061
R218 vdd_core.n139 vdd_core.n138 0.1061
R219 vdd_core.n140 vdd_core.n135 0.1061
R220 vdd_core.n134 vdd_core.n133 0.1061
R221 vdd_core.n145 vdd_core.n144 0.1061
R222 vdd_core.n113 vdd_core.n2 0.102521
R223 vdd_core.n231 vdd_core.n180 0.1019
R224 vdd_core.n96 vdd_core.n79 0.101071
R225 vdd_core.n94 vdd_core.n82 0.101071
R226 vdd_core.n105 vdd_core.n104 0.101071
R227 vdd_core.n103 vdd_core.n78 0.101071
R228 vdd_core.n153 vdd_core.n75 0.101071
R229 vdd_core.n155 vdd_core.n71 0.101071
R230 vdd_core.n157 vdd_core.n67 0.101071
R231 vdd_core.n161 vdd_core.n160 0.101071
R232 vdd_core.n90 vdd_core.n79 0.101071
R233 vdd_core.n91 vdd_core.n82 0.101071
R234 vdd_core.n105 vdd_core.n83 0.101071
R235 vdd_core.n85 vdd_core.n78 0.101071
R236 vdd_core.n153 vdd_core.n74 0.101071
R237 vdd_core.n155 vdd_core.n70 0.101071
R238 vdd_core.n157 vdd_core.n66 0.101071
R239 vdd_core.n61 vdd_core.n52 0.101071
R240 vdd_core.n59 vdd_core.n58 0.101071
R241 vdd_core.n172 vdd_core.n39 0.101071
R242 vdd_core.n171 vdd_core.n170 0.101071
R243 vdd_core.n175 vdd_core.n35 0.101071
R244 vdd_core.n177 vdd_core.n31 0.101071
R245 vdd_core.n179 vdd_core.n27 0.101071
R246 vdd_core.n61 vdd_core.n51 0.101071
R247 vdd_core.n59 vdd_core.n56 0.101071
R248 vdd_core.n172 vdd_core.n38 0.101071
R249 vdd_core.n171 vdd_core.n41 0.101071
R250 vdd_core.n175 vdd_core.n34 0.101071
R251 vdd_core.n177 vdd_core.n30 0.101071
R252 vdd_core.n179 vdd_core.n6 0.00761283
R253 vdd_core.n187 vdd_core.n25 0.101071
R254 vdd_core.n188 vdd_core.n186 0.101071
R255 vdd_core.n226 vdd_core.n194 0.101071
R256 vdd_core.n223 vdd_core.n198 0.101071
R257 vdd_core.n215 vdd_core.n202 0.101071
R258 vdd_core.n214 vdd_core.n213 0.101071
R259 vdd_core.n210 vdd_core.n20 0.101071
R260 vdd_core.n208 vdd_core.n18 0.101071
R261 vdd_core.n206 vdd_core.n16 0.101071
R262 vdd_core.n204 vdd_core.n13 0.101071
R263 vdd_core.n203 vdd_core.n12 0.101071
R264 vdd_core.n25 vdd_core.n23 0.101071
R265 vdd_core.n186 vdd_core.n185 0.101071
R266 vdd_core.n226 vdd_core.n193 0.101071
R267 vdd_core.n223 vdd_core.n197 0.101071
R268 vdd_core.n215 vdd_core.n201 0.101071
R269 vdd_core.n214 vdd_core.n22 0.101071
R270 vdd_core.n237 vdd_core.n20 0.101071
R271 vdd_core.n239 vdd_core.n18 0.101071
R272 vdd_core.n241 vdd_core.n16 0.101071
R273 vdd_core.n243 vdd_core.n13 0.101071
R274 vdd_core.n244 vdd_core.n12 0.101071
R275 vdd_core.n128 vdd_core.n127 0.0955821
R276 vdd_core.n7 vdd_core.n8 0.872565
R277 vdd_core.n7 vdd_core.n114 0.433741
R278 vdd_core.n140 vdd_core.n139 0.0759286
R279 vdd_core.n135 vdd_core.n134 0.0759286
R280 vdd_core.n146 vdd_core.n145 0.0759286
R281 vdd_core.n100 vdd_core.n87 0.0759286
R282 vdd_core.n101 vdd_core.n100 0.0759286
R283 vdd_core.n162 vdd_core.n65 0.0759286
R284 vdd_core.n156 vdd_core.n69 0.0759286
R285 vdd_core.n154 vdd_core.n73 0.0759286
R286 vdd_core.n152 vdd_core.n77 0.0759286
R287 vdd_core.n106 vdd_core.n81 0.0759286
R288 vdd_core.n95 vdd_core.n93 0.0759286
R289 vdd_core.n98 vdd_core.n97 0.0759286
R290 vdd_core.n99 vdd_core.n84 0.0759286
R291 vdd_core.n162 vdd_core.n64 0.0759286
R292 vdd_core.n156 vdd_core.n68 0.0759286
R293 vdd_core.n154 vdd_core.n72 0.0759286
R294 vdd_core.n152 vdd_core.n76 0.0759286
R295 vdd_core.n106 vdd_core.n80 0.0759286
R296 vdd_core.n93 vdd_core.n92 0.0759286
R297 vdd_core.n99 vdd_core.n88 0.0759286
R298 vdd_core.n98 vdd_core.n89 0.0759286
R299 vdd_core.n167 vdd_core.n46 0.0759286
R300 vdd_core.n168 vdd_core.n167 0.0759286
R301 vdd_core.n178 vdd_core.n29 0.0759286
R302 vdd_core.n176 vdd_core.n33 0.0759286
R303 vdd_core.n42 vdd_core.n36 0.0759286
R304 vdd_core.n57 vdd_core.n40 0.0759286
R305 vdd_core.n60 vdd_core.n54 0.0759286
R306 vdd_core.n62 vdd_core.n50 0.0759286
R307 vdd_core.n166 vdd_core.n43 0.0759286
R308 vdd_core.n6 vdd_core.n28 0.439821
R309 vdd_core.n178 vdd_core.n28 0.0759286
R310 vdd_core.n176 vdd_core.n32 0.0759286
R311 vdd_core.n44 vdd_core.n36 0.0759286
R312 vdd_core.n55 vdd_core.n40 0.0759286
R313 vdd_core.n60 vdd_core.n53 0.0759286
R314 vdd_core.n166 vdd_core.n48 0.0759286
R315 vdd_core.n62 vdd_core.n49 0.0759286
R316 vdd_core.n234 vdd_core.n233 0.0759286
R317 vdd_core.n233 vdd_core.n24 0.0759286
R318 vdd_core.n11 vdd_core.n10 0.0759286
R319 vdd_core.n205 vdd_core.n15 0.0759286
R320 vdd_core.n207 vdd_core.n17 0.0759286
R321 vdd_core.n209 vdd_core.n19 0.0759286
R322 vdd_core.n211 vdd_core.n21 0.0759286
R323 vdd_core.n222 vdd_core.n200 0.0759286
R324 vdd_core.n224 vdd_core.n196 0.0759286
R325 vdd_core.n227 vdd_core.n192 0.0759286
R326 vdd_core.n228 vdd_core.n190 0.0759286
R327 vdd_core.n189 vdd_core.n182 0.0759286
R328 vdd_core.n245 vdd_core.n10 0.0759286
R329 vdd_core.n242 vdd_core.n15 0.0759286
R330 vdd_core.n240 vdd_core.n17 0.0759286
R331 vdd_core.n238 vdd_core.n19 0.0759286
R332 vdd_core.n236 vdd_core.n21 0.0759286
R333 vdd_core.n222 vdd_core.n199 0.0759286
R334 vdd_core.n224 vdd_core.n195 0.0759286
R335 vdd_core.n184 vdd_core.n182 0.0759286
R336 vdd_core.n228 vdd_core.n183 0.0759286
R337 vdd_core.n227 vdd_core.n191 0.0759286
R338 vdd_core.n167 vdd_core.n47 0.0738333
R339 vdd_core.n148 vdd_core.n115 0.0621
R340 vdd_core.n137 vdd_core.n136 0.0621
R341 vdd_core.n141 vdd_core.n117 0.0621
R342 vdd_core.n142 vdd_core.n120 0.0621
R343 vdd_core.n143 vdd_core.n119 0.0621
R344 vdd_core.n147 vdd_core.n116 0.0621
R345 vdd_core.n132 vdd_core.n131 0.0383489
R346 vdd_core.n5 vdd_core.n6 0.0351511
R347 vdd_core.n179 vdd_core.n178 0.0371667
R348 vdd_core.n178 vdd_core.n177 0.0371667
R349 vdd_core.n177 vdd_core.n176 0.0371667
R350 vdd_core.n176 vdd_core.n175 0.0371667
R351 vdd_core.n175 vdd_core.n36 0.0371667
R352 vdd_core.n171 vdd_core.n36 0.0371667
R353 vdd_core.n172 vdd_core.n171 0.0371667
R354 vdd_core.n172 vdd_core.n40 0.0371667
R355 vdd_core.n59 vdd_core.n40 0.0371667
R356 vdd_core.n60 vdd_core.n59 0.0371667
R357 vdd_core.n61 vdd_core.n60 0.0371667
R358 vdd_core.n62 vdd_core.n61 0.0371667
R359 vdd_core.n166 vdd_core.n62 0.0371667
R360 vdd_core.n167 vdd_core.n166 0.0371667
R361 vdd_core.n159 vdd_core.n47 0.0371667
R362 vdd_core.n162 vdd_core.n161 0.0371667
R363 vdd_core.n162 vdd_core.n157 0.0371667
R364 vdd_core.n157 vdd_core.n156 0.0371667
R365 vdd_core.n156 vdd_core.n155 0.0371667
R366 vdd_core.n155 vdd_core.n154 0.0371667
R367 vdd_core.n154 vdd_core.n153 0.0371667
R368 vdd_core.n153 vdd_core.n152 0.0371667
R369 vdd_core.n152 vdd_core.n78 0.0371667
R370 vdd_core.n105 vdd_core.n78 0.0371667
R371 vdd_core.n106 vdd_core.n105 0.0371667
R372 vdd_core.n106 vdd_core.n82 0.0371667
R373 vdd_core.n93 vdd_core.n82 0.0371667
R374 vdd_core.n93 vdd_core.n79 0.0371667
R375 vdd_core.n98 vdd_core.n79 0.0371667
R376 vdd_core.n99 vdd_core.n98 0.0371667
R377 vdd_core.n100 vdd_core.n99 0.0371667
R378 vdd_core.n12 vdd_core.n10 0.0371667
R379 vdd_core.n13 vdd_core.n12 0.0371667
R380 vdd_core.n16 vdd_core.n15 0.0371667
R381 vdd_core.n17 vdd_core.n16 0.0371667
R382 vdd_core.n19 vdd_core.n18 0.0371667
R383 vdd_core.n20 vdd_core.n19 0.0371667
R384 vdd_core.n214 vdd_core.n21 0.0371667
R385 vdd_core.n215 vdd_core.n214 0.0371667
R386 vdd_core.n223 vdd_core.n222 0.0371667
R387 vdd_core.n224 vdd_core.n223 0.0371667
R388 vdd_core.n227 vdd_core.n226 0.0371667
R389 vdd_core.n228 vdd_core.n227 0.0371667
R390 vdd_core.n186 vdd_core.n182 0.0371667
R391 vdd_core.n186 vdd_core.n25 0.0371667
R392 vdd_core.n148 vdd_core.n147 0.0319286
R393 vdd_core.n137 vdd_core.n117 0.0319286
R394 vdd_core.n142 vdd_core.n141 0.0319286
R395 vdd_core.n132 vdd_core.n120 0.0319286
R396 vdd_core.n143 vdd_core.n116 0.0319286
R397 vdd_core.n111 vdd_core.n107 0.0310403
R398 vdd_core.n126 vdd_core.n125 0.0310403
R399 vdd_core.n3 vdd_core.n2 0.59294
R400 vdd_core.n247 vdd_core.n10 0.028
R401 vdd_core.n15 vdd_core.n14 0.028
R402 vdd_core.n216 vdd_core.n18 0.028
R403 vdd_core.n218 vdd_core.n21 0.028
R404 vdd_core.n222 vdd_core.n221 0.028
R405 vdd_core.n226 vdd_core.n225 0.028
R406 vdd_core.n229 vdd_core.n182 0.028
R407 vdd_core.n233 vdd_core.n232 0.028
R408 vdd_core.n159 vdd_core.n158 0.0261384
R409 vdd_core.n125 vdd_core.n122 0.0260771
R410 vdd_core.n112 vdd_core.n111 0.0257351
R411 vdd_core.n112 vdd_core.n110 0.0233414
R412 vdd_core.n248 vdd_core.n9 0.023
R413 vdd_core.n217 vdd_core.n9 0.023
R414 vdd_core.n219 vdd_core.n217 0.023
R415 vdd_core.n220 vdd_core.n219 0.023
R416 vdd_core.n220 vdd_core.n181 0.023
R417 vdd_core.n230 vdd_core.n181 0.023
R418 vdd_core.n231 vdd_core.n230 0.023
R419 vdd_core.n180 vdd_core.n26 0.023
R420 vdd_core.n174 vdd_core.n26 0.023
R421 vdd_core.n174 vdd_core.n173 0.023
R422 vdd_core.n173 vdd_core.n37 0.023
R423 vdd_core.n165 vdd_core.n37 0.023
R424 vdd_core.n165 vdd_core.n164 0.023
R425 vdd_core.n164 vdd_core.n163 0.023
R426 vdd_core.n163 vdd_core.n63 0.023
R427 vdd_core.n151 vdd_core.n63 0.023
R428 vdd_core.n122 vdd_core.n121 0.0229994
R429 vdd_core.n110 vdd_core.n4 0.022386
R430 vdd_core.n121 vdd_core.n1 0.022386
R431 vdd_core.n127 vdd_core.n0 0.59294
R432 vdd_core.n213 vdd_core.n212 0.0124467
R433 vdd_core.n235 vdd_core.n22 0.0124467
R434 vdd_core.n103 vdd_core.n102 0.0121878
R435 vdd_core.n86 vdd_core.n85 0.0121878
R436 vdd_core.n170 vdd_core.n169 0.0121878
R437 vdd_core.n45 vdd_core.n41 0.0121878
R438 vdd_core.n151 vdd_core.n150 0.01175
R439 vdd_core.n247 vdd_core.n246 0.0113759
R440 vdd_core.n14 vdd_core.n13 0.00966667
R441 vdd_core.n216 vdd_core.n17 0.00966667
R442 vdd_core.n218 vdd_core.n20 0.00966667
R443 vdd_core.n221 vdd_core.n215 0.00966667
R444 vdd_core.n225 vdd_core.n224 0.00966667
R445 vdd_core.n229 vdd_core.n228 0.00966667
R446 vdd_core.n232 vdd_core.n25 0.00966667
R447 vdd_core.n161 vdd_core.n158 0.00944821
R448 vdd_core.n113 vdd_core.n149 1.16529
R449 vdd_core.n5 vdd_core.n180 0.578991
R450 VDD VDD.n9 17.9801
R451 VDD VDD.n8 17.071
R452 VDD.n7 VDD.t10 17.0005
R453 VDD.n5 VDD.t4 17.0005
R454 VDD.n3 VDD.t0 17.0005
R455 VDD.n1 VDD.t6 11.3356
R456 VDD.n0 VDD.t2 11.3356
R457 VDD.n7 VDD.t11 6.19097
R458 VDD.n5 VDD.t5 6.19097
R459 VDD.n3 VDD.t1 6.19097
R460 VDD.n9 VDD.t9 4.22454
R461 VDD.n1 VDD.t7 2.44327
R462 VDD.n0 VDD.t3 2.44261
R463 VDD.n2 VDD.n0 1.42463
R464 VDD.n4 VDD.n2 0.851625
R465 VDD.n8 VDD.n7 0.751488
R466 VDD.n6 VDD.n5 0.751488
R467 VDD.n4 VDD.n3 0.751488
R468 VDD.n9 VDD.t8 0.517741
R469 VDD.n8 VDD.n6 0.370375
R470 VDD.n6 VDD.n4 0.370375
R471 VDD.n2 VDD.n1 0.143127
R472 vtune vtune.n1 16.693
R473 vtune.n0 vtune.t0 16.1774
R474 vtune.n0 vtune.t3 14.7078
R475 vtune.n1 vtune.t6 14.7078
R476 vtune.n1 vtune.n0 1.4701
R477 VSS.n308 VSS.n307 4127.1
R478 VSS.n0 VSS.t15 1963.69
R479 VSS.t0 VSS.n0 7.16668
R480 VSS.n526 VSS.t114 1390.68
R481 VSS.t110 VSS.t111 804.431
R482 VSS.n264 VSS.n0 712.366
R483 VSS.n263 VSS.t109 552.61
R484 VSS.t111 VSS.n262 547.362
R485 VSS.t114 VSS.t115 374.546
R486 VSS.n262 VSS.t113 287.356
R487 VSS.n529 VSS.n528 278.832
R488 VSS.t109 VSS.n180 254.446
R489 VSS.n263 VSS.t110 168.756
R490 VSS.t113 VSS.t112 141.554
R491 VSS.n261 VSS.n247 141.554
R492 VSS.t115 VSS.n525 132.113
R493 VSS.n121 VSS.n2 100.389
R494 VSS.n262 VSS.n261 71.2493
R495 VSS.t11 VSS.t13 70.7775
R496 VSS.n251 VSS.n247 47.1851
R497 VSS.n297 VSS.n296 40.7645
R498 VSS.n0 VSS.t9 7.16457
R499 VSS.n546 VSS.n0 7.44475
R500 VSS.n175 VSS.t61 35.0371
R501 VSS.n182 VSS.t55 33.2884
R502 VSS.n251 VSS.t11 33.0298
R503 VSS.t58 VSS.n182 29.7909
R504 VSS.t53 VSS.n180 28.8551
R505 VSS.t60 VSS.n175 28.0421
R506 VSS.n181 VSS.t57 27.4296
R507 VSS.n187 VSS.t98 26.6691
R508 VSS.t100 VSS.n171 26.6691
R509 VSS.n189 VSS.t102 26.6691
R510 VSS.t3 VSS.n0 11.5004
R511 VSS.t57 VSS.n177 23.9329
R512 VSS.t13 VSS.t15 23.5928
R513 VSS.t97 VSS.n174 22.6205
R514 VSS.n307 VSS.n194 22.5291
R515 VSS.n0 VSS.t7 11.5043
R516 VSS.n183 VSS.t60 20.4345
R517 VSS.n188 VSS.t66 20.1113
R518 VSS.t108 VSS.t70 19.8391
R519 VSS.t116 VSS.t51 19.8391
R520 VSS.t69 VSS.n168 19.5029
R521 VSS.t82 VSS.n211 19.5029
R522 VSS.t88 VSS.n153 19.3829
R523 VSS.n183 VSS.t58 18.6866
R524 VSS.t92 VSS.n520 18.4749
R525 VSS.t77 VSS.n243 18.1579
R526 VSS.n303 VSS.t78 18.1579
R527 VSS.t99 VSS.n171 17.9253
R528 VSS.n189 VSS.t101 17.9253
R529 VSS.n252 VSS.t16 17.4597
R530 VSS.n250 VSS.t128 17.4597
R531 VSS.n235 VSS.n63 17.0036
R532 VSS.n530 VSS.n529 17.0005
R533 VSS.n530 VSS.n116 17.0005
R534 VSS.n530 VSS.n129 17.0005
R535 VSS.n530 VSS.n118 17.0005
R536 VSS.n530 VSS.n125 17.0005
R537 VSS.n530 VSS.n121 17.0005
R538 VSS.n527 VSS.n526 17.0005
R539 VSS.n527 VSS.n131 17.0005
R540 VSS.n527 VSS.n144 17.0005
R541 VSS.n527 VSS.n134 17.0005
R542 VSS.n527 VSS.n139 17.0005
R543 VSS.n528 VSS.n527 17.0005
R544 VSS.n311 VSS.n310 17.0005
R545 VSS.n310 VSS.n156 17.0005
R546 VSS.n310 VSS.n213 17.0005
R547 VSS.n310 VSS.n237 17.0005
R548 VSS.n310 VSS.n309 17.0005
R549 VSS.n310 VSS.n158 17.0005
R550 VSS.n310 VSS.n211 17.0005
R551 VSS.n310 VSS.n238 17.0005
R552 VSS.n310 VSS.n306 17.0005
R553 VSS.n310 VSS.n159 17.0005
R554 VSS.n310 VSS.n305 17.0005
R555 VSS.n310 VSS.n239 17.0005
R556 VSS.n310 VSS.n205 17.0005
R557 VSS.n310 VSS.n240 17.0005
R558 VSS.n310 VSS.n304 17.0005
R559 VSS.n310 VSS.n241 17.0005
R560 VSS.n310 VSS.n303 17.0005
R561 VSS.n310 VSS.n243 17.0005
R562 VSS.n310 VSS.n302 17.0005
R563 VSS.n310 VSS.n244 17.0005
R564 VSS.n310 VSS.n300 17.0005
R565 VSS.n310 VSS.n164 17.0005
R566 VSS.n310 VSS.n299 17.0005
R567 VSS.n310 VSS.n245 17.0005
R568 VSS.n310 VSS.n195 17.0005
R569 VSS.n310 VSS.n246 17.0005
R570 VSS.n310 VSS.n298 17.0005
R571 VSS.n310 VSS.n168 17.0005
R572 VSS.n310 VSS.n194 17.0005
R573 VSS.n310 VSS.n264 17.0005
R574 VSS.n310 VSS.n111 17.0005
R575 VSS.n525 VSS.n524 17.0005
R576 VSS.n524 VSS.n154 17.0005
R577 VSS.n524 VSS.n311 17.0005
R578 VSS.n524 VSS.n156 17.0005
R579 VSS.n524 VSS.n213 17.0005
R580 VSS.n524 VSS.n158 17.0005
R581 VSS.n524 VSS.n211 17.0005
R582 VSS.n524 VSS.n159 17.0005
R583 VSS.n524 VSS.n205 17.0005
R584 VSS.n524 VSS.n162 17.0005
R585 VSS.n524 VSS.n199 17.0005
R586 VSS.n524 VSS.n164 17.0005
R587 VSS.n524 VSS.n195 17.0005
R588 VSS.n524 VSS.n168 17.0005
R589 VSS.n524 VSS.n194 17.0005
R590 VSS.n524 VSS.n169 17.0005
R591 VSS.n524 VSS.n189 17.0005
R592 VSS.n524 VSS.n170 17.0005
R593 VSS.n524 VSS.n188 17.0005
R594 VSS.n524 VSS.n171 17.0005
R595 VSS.n524 VSS.n187 17.0005
R596 VSS.n524 VSS.n180 17.0005
R597 VSS.n251 VSS.n250 17.0005
R598 VSS.n252 VSS.n251 17.0005
R599 VSS.n254 VSS.n247 17.0005
R600 VSS.n258 VSS.n247 17.0005
R601 VSS.t79 VSS.n158 16.8129
R602 VSS.t94 VSS.n148 16.7178
R603 VSS.n520 VSS.t91 16.659
R604 VSS.n153 VSS.t89 15.751
R605 VSS.t55 VSS.n177 15.1883
R606 VSS.n525 VSS.t95 14.9823
R607 VSS.n521 VSS.t94 14.901
R608 VSS.n187 VSS.t63 14.865
R609 VSS.n519 VSS.t127 14.2208
R610 VSS.n244 VSS.t73 14.1229
R611 VSS.n304 VSS.t75 14.1229
R612 VSS.n3 VSS.n2 0.00237165
R613 VSS.n546 VSS.n1 13.8998
R614 VSS.t126 VSS.n154 13.8474
R615 VSS.t103 VSS.n168 13.7866
R616 VSS.t105 VSS.n195 13.7866
R617 VSS.t107 VSS.n164 13.7866
R618 VSS.t117 VSS.n205 13.7866
R619 VSS.t119 VSS.n159 13.7866
R620 VSS.n211 VSS.t121 13.7866
R621 VSS.n242 VSS.n161 13.6726
R622 VSS.n301 VSS.n163 13.6726
R623 VSS.t61 VSS.n174 13.4403
R624 VSS.t89 VSS.n150 13.0858
R625 VSS.n0 VSS.n263 9.17871
R626 VSS.n307 VSS.n297 12.4359
R627 VSS.n107 VSS.n3 12.414
R628 VSS.n38 VSS.t124 12.2584
R629 VSS.t91 VSS.n150 12.1771
R630 VSS.t101 VSS.n170 11.8046
R631 VSS.n181 VSS.t53 11.6916
R632 VSS.n261 VSS.n249 11.3338
R633 VSS.n261 VSS.n248 11.3338
R634 VSS.n261 VSS.n260 11.3338
R635 VSS.t98 VSS.n173 10.9917
R636 VSS.n173 VSS.t64 10.5545
R637 VSS.t83 VSS.n156 10.4424
R638 VSS.t106 VSS.t72 10.4242
R639 VSS.t118 VSS.t81 10.4242
R640 VSS.n521 VSS.t92 10.3618
R641 VSS.n6 VSS.t23 4.98427
R642 VSS.t72 VSS.n195 10.0879
R643 VSS.t81 VSS.n159 10.0879
R644 VSS.n549 VSS.n548 9.75612
R645 VSS.n6 VSS.n2 0.00127616
R646 VSS.t66 VSS.n170 9.61869
R647 VSS.n519 VSS.t88 9.4531
R648 VSS.n237 VSS.t123 9.3074
R649 VSS.n311 VSS.t125 9.3074
R650 VSS.t5 VSS.n0 5.92136
R651 VSS.t64 VSS.t99 9.1815
R652 VSS.n194 VSS.t103 9.07918
R653 VSS.n246 VSS.t105 9.07918
R654 VSS.n299 VSS.t107 9.07918
R655 VSS.n239 VSS.t117 9.07918
R656 VSS.n306 VSS.t119 9.07918
R657 VSS.t121 VSS.n158 9.07918
R658 VSS.t73 VSS.n199 8.74293
R659 VSS.t75 VSS.n241 8.74293
R660 VSS.n148 VSS.t95 8.54511
R661 VSS.n8 VSS.n7 5.64743
R662 VSS.n296 VSS.n8 0.850044
R663 VSS.n19 VSS.n20 0.0017399
R664 VSS.n20 VSS.n21 0.00173723
R665 VSS.n21 VSS.n22 0.00173273
R666 VSS.n22 VSS.n23 0.00172462
R667 VSS.n23 VSS.n24 0.00170812
R668 VSS.n24 VSS.n25 0.00166658
R669 VSS.n296 VSS.n26 4.251
R670 VSS.n296 VSS.n27 4.251
R671 VSS.n27 VSS.n14 0.00149997
R672 VSS.n29 VSS.n28 0.00216799
R673 VSS.n28 VSS.n30 0.00172462
R674 VSS.n30 VSS.n31 0.00170812
R675 VSS.n31 VSS.n32 0.00166658
R676 VSS.n32 VSS.n17 0.00149997
R677 VSS.n296 VSS.n33 3.40102
R678 VSS.n296 VSS.n35 3.40102
R679 VSS.n63 VSS.n38 2.12569
R680 VSS.n65 VSS.n63 0.00170812
R681 VSS.n41 VSS.n65 0.00166658
R682 VSS.n40 VSS.n38 3.40102
R683 VSS.n67 VSS.n68 0.00216959
R684 VSS.n69 VSS.n67 0.00170812
R685 VSS.n44 VSS.n69 0.00166658
R686 VSS.n43 VSS.n38 3.40102
R687 VSS.n48 VSS.n38 4.251
R688 VSS.n47 VSS.n38 2.83417
R689 VSS.n53 VSS.n47 0.00166658
R690 VSS.n52 VSS.n38 3.40102
R691 VSS.n56 VSS.n38 4.251
R692 VSS.n75 VSS.n38 2.83417
R693 VSS.n59 VSS.n75 0.00166658
R694 VSS.n61 VSS.n59 0.00149997
R695 VSS.n268 VSS.n267 8.5005
R696 VSS.n2 VSS.n89 8.5005
R697 VSS.n2 VSS.n541 8.5005
R698 VSS.n2 VSS.n90 8.5005
R699 VSS.n2 VSS.n102 8.5005
R700 VSS.n2 VSS.n91 8.5005
R701 VSS.n2 VSS.n101 8.5005
R702 VSS.n2 VSS.n92 8.5005
R703 VSS.n2 VSS.n100 8.5005
R704 VSS.n2 VSS.n93 8.5005
R705 VSS.n2 VSS.n99 8.5005
R706 VSS.n218 VSS.n217 8.5005
R707 VSS.n275 VSS.n19 8.48544
R708 VSS.n276 VSS.n20 8.48544
R709 VSS.n277 VSS.n21 8.48544
R710 VSS.n278 VSS.n22 8.48544
R711 VSS.n279 VSS.n23 8.48544
R712 VSS.n280 VSS.n24 8.48544
R713 VSS.n281 VSS.n25 8.48544
R714 VSS.n281 VSS.n10 0.188868
R715 VSS.n10 VSS.n9 4.21231
R716 VSS.n10 VSS.n12 0.251683
R717 VSS.n12 VSS.n11 4.21231
R718 VSS.n15 VSS.n14 3.35165
R719 VSS.n284 VSS.n28 8.48544
R720 VSS.n285 VSS.n30 8.48544
R721 VSS.n286 VSS.n31 8.48544
R722 VSS.n287 VSS.n32 8.48544
R723 VSS.n18 VSS.n17 3.35165
R724 VSS.n289 VSS.n34 8.48544
R725 VSS.n292 VSS.n36 8.48544
R726 VSS.n65 VSS.n64 8.48544
R727 VSS.n41 VSS.n234 8.48544
R728 VSS.n234 VSS.n37 0.219757
R729 VSS.n39 VSS.n233 8.48544
R730 VSS.n67 VSS.n66 8.48544
R731 VSS.n69 VSS.n230 8.48544
R732 VSS.n229 VSS.n44 8.48544
R733 VSS.n46 VSS.n229 0.219757
R734 VSS.n228 VSS.n71 8.48544
R735 VSS.n70 VSS.n214 8.48544
R736 VSS.n50 VSS.n214 0.188868
R737 VSS.n50 VSS.n49 4.21231
R738 VSS.n53 VSS.n72 8.48544
R739 VSS.n55 VSS.n72 0.219757
R740 VSS.n51 VSS.n73 8.48544
R741 VSS.n226 VSS.n225 8.48544
R742 VSS.n58 VSS.n226 0.188868
R743 VSS.n57 VSS.n58 4.21231
R744 VSS.n224 VSS.n59 8.48544
R745 VSS.n61 VSS.n62 3.35165
R746 VSS.n550 VSS.n549 8.10482
R747 VSS.n548 VSS.n78 7.76695
R748 VSS.t86 VSS.n154 7.71842
R749 VSS.n191 VSS.n76 7.56743
R750 VSS.n515 VSS.n514 7.56743
R751 VSS.n537 VSS.n1 7.53653
R752 VSS.n307 VSS.t67 7.43274
R753 VSS.n537 VSS.n99 7.03894
R754 VSS.n538 VSS.n93 7.03894
R755 VSS.n104 VSS.n100 7.03894
R756 VSS.n110 VSS.n92 7.03894
R757 VSS.n105 VSS.n101 7.03894
R758 VSS.n109 VSS.n91 7.03894
R759 VSS.n106 VSS.n102 7.03894
R760 VSS.n541 VSS.n540 7.03894
R761 VSS.n103 VSS.n89 7.03894
R762 VSS.t129 VSS.n121 6.90359
R763 VSS.n125 VSS.t131 6.90359
R764 VSS.n125 VSS.t133 6.90359
R765 VSS.t134 VSS.n118 6.90359
R766 VSS.t136 VSS.n118 6.90359
R767 VSS.n129 VSS.t137 6.90359
R768 VSS.n129 VSS.t139 6.90359
R769 VSS.t142 VSS.n116 6.90359
R770 VSS.n529 VSS.t143 6.90359
R771 VSS.n528 VSS.t145 6.90359
R772 VSS.n139 VSS.t147 6.90359
R773 VSS.t150 VSS.n134 6.90359
R774 VSS.t152 VSS.n134 6.90359
R775 VSS.n144 VSS.t153 6.90359
R776 VSS.n144 VSS.t155 6.90359
R777 VSS.t156 VSS.n131 6.90359
R778 VSS.t158 VSS.n131 6.90359
R779 VSS.n526 VSS.t159 6.90359
R780 VSS.n155 VSS.t126 6.89806
R781 VSS.n238 VSS.n207 6.83654
R782 VSS.n239 VSS.n206 6.83654
R783 VSS.n240 VSS.n204 6.83654
R784 VSS.n243 VSS.n200 6.83654
R785 VSS.n302 VSS.n163 6.83654
R786 VSS.n244 VSS.n196 6.83654
R787 VSS.n299 VSS.n165 6.83654
R788 VSS.n298 VSS.n167 6.83654
R789 VSS.n246 VSS.n167 6.83654
R790 VSS.n245 VSS.n165 6.83654
R791 VSS.n300 VSS.n196 6.83654
R792 VSS.n301 VSS.n199 6.83654
R793 VSS.n303 VSS.n200 6.83654
R794 VSS.n242 VSS.n162 6.83654
R795 VSS.n241 VSS.n161 6.83654
R796 VSS.n304 VSS.n204 6.83654
R797 VSS.n305 VSS.n206 6.83654
R798 VSS.n306 VSS.n207 6.83654
R799 VSS.n530 VSS.n130 6.69018
R800 VSS.n530 VSS.n117 6.69018
R801 VSS.n530 VSS.n126 6.69018
R802 VSS.n530 VSS.n120 6.69018
R803 VSS.n530 VSS.n122 6.69018
R804 VSS.n527 VSS.n145 6.69018
R805 VSS.n527 VSS.n133 6.69018
R806 VSS.n527 VSS.n140 6.69018
R807 VSS.n527 VSS.n136 6.69018
R808 VSS.n527 VSS.n138 6.69018
R809 VSS.t85 VSS.n155 6.67106
R810 VSS.n445 VSS.n444 6.61367
R811 VSS.n370 VSS.n347 6.51503
R812 VSS.n346 VSS.n337 6.5067
R813 VSS.n336 VSS.n327 6.5067
R814 VSS.n479 VSS.n478 6.34066
R815 VSS.n258 VSS.t17 6.19054
R816 VSS.n254 VSS.t14 6.19054
R817 VSS.t123 VSS.n213 6.12943
R818 VSS.n424 VSS.n423 6.09818
R819 VSS.n326 VSS.n314 6.04071
R820 VSS.n122 VSS.t129 5.92367
R821 VSS.t131 VSS.n122 5.92367
R822 VSS.t133 VSS.n120 5.92367
R823 VSS.n120 VSS.t134 5.92367
R824 VSS.n126 VSS.t136 5.92367
R825 VSS.t137 VSS.n126 5.92367
R826 VSS.t139 VSS.n117 5.92367
R827 VSS.t140 VSS.n117 5.92367
R828 VSS.n130 VSS.t142 5.92367
R829 VSS.t143 VSS.n130 5.92367
R830 VSS.n138 VSS.t145 5.92367
R831 VSS.t147 VSS.n138 5.92367
R832 VSS.t149 VSS.n136 5.92367
R833 VSS.n136 VSS.t150 5.92367
R834 VSS.n140 VSS.t152 5.92367
R835 VSS.t153 VSS.n140 5.92367
R836 VSS.t155 VSS.n133 5.92367
R837 VSS.n133 VSS.t156 5.92367
R838 VSS.n145 VSS.t158 5.92367
R839 VSS.t159 VSS.n145 5.92367
R840 VSS.t20 VSS.n2 4.16224
R841 VSS.n546 VSS.n545 5.91277
R842 VSS.n3 VSS.t29 4.15971
R843 VSS.n524 VSS.n520 5.84696
R844 VSS.n524 VSS.n153 5.84696
R845 VSS.n524 VSS.n155 5.84696
R846 VSS.n524 VSS.n212 5.84696
R847 VSS.n308 VSS.t79 5.71671
R848 VSS.n296 VSS.n13 5.66778
R849 VSS.n296 VSS.n265 5.66778
R850 VSS.n296 VSS.n29 1.30786
R851 VSS.n296 VSS.n16 5.66778
R852 VSS.n33 VSS.n271 0.00229996
R853 VSS.n296 VSS.n266 5.66778
R854 VSS.n35 VSS.n269 0.00229996
R855 VSS.n42 VSS.n40 0.00229996
R856 VSS.n68 VSS.n38 1.54575
R857 VSS.n45 VSS.n43 0.00229996
R858 VSS.n54 VSS.n52 0.00229996
R859 VSS.n215 VSS.n38 5.66778
R860 VSS.n60 VSS.n38 5.66778
R861 VSS.n221 VSS.n38 5.66778
R862 VSS.n539 VSS.n537 5.66717
R863 VSS.n539 VSS.n538 5.66717
R864 VSS.n539 VSS.n104 5.66717
R865 VSS.n539 VSS.n110 5.66717
R866 VSS.n539 VSS.n105 5.66717
R867 VSS.n539 VSS.n109 5.66717
R868 VSS.n539 VSS.n106 5.66717
R869 VSS.n539 VSS.n108 5.66717
R870 VSS.n540 VSS.n539 5.66717
R871 VSS.n539 VSS.n103 5.66717
R872 VSS.n539 VSS.n107 5.66717
R873 VSS.n530 VSS.n114 5.65086
R874 VSS.n531 VSS.n530 5.65086
R875 VSS.n530 VSS.n128 5.65086
R876 VSS.n530 VSS.n119 5.65086
R877 VSS.n527 VSS.n147 5.65086
R878 VSS.n527 VSS.n132 5.65086
R879 VSS.n527 VSS.n143 5.65086
R880 VSS.n527 VSS.n137 5.65086
R881 VSS.n282 VSS.n273 5.64018
R882 VSS.n283 VSS.n272 5.64018
R883 VSS.n288 VSS.n271 5.64018
R884 VSS.n290 VSS.n270 5.64018
R885 VSS.n291 VSS.n269 5.64018
R886 VSS.n294 VSS.n293 5.64018
R887 VSS.n42 VSS.n37 3.35165
R888 VSS.n232 VSS.n231 5.64018
R889 VSS.n45 VSS.n46 3.35165
R890 VSS.n55 VSS.n54 3.35165
R891 VSS.n74 VSS.n227 5.64018
R892 VSS.n223 VSS.n222 5.64018
R893 VSS.n220 VSS.n216 5.64018
R894 VSS.n237 VSS.n212 5.30908
R895 VSS.n309 VSS.n212 5.30908
R896 VSS.n545 VSS.t25 5.23693
R897 VSS.n310 VSS.n242 5.08323
R898 VSS.n310 VSS.n301 5.08323
R899 VSS.n524 VSS.n207 5.08323
R900 VSS.n524 VSS.n206 5.08323
R901 VSS.n524 VSS.n204 5.08323
R902 VSS.n524 VSS.n161 5.08323
R903 VSS.n524 VSS.n200 5.08323
R904 VSS.n524 VSS.n163 5.08323
R905 VSS.n524 VSS.n196 5.08323
R906 VSS.n524 VSS.n165 5.08323
R907 VSS.n524 VSS.n167 5.08323
R908 VSS.n213 VSS.t83 4.99445
R909 VSS.t125 VSS.t85 4.76745
R910 VSS.n302 VSS.t77 4.70796
R911 VSS.t78 VSS.n162 4.70796
R912 VSS.n548 VSS.n547 4.67815
R913 VSS.n267 VSS.t140 4.60256
R914 VSS.n217 VSS.t149 4.60256
R915 VSS.n524 VSS.n173 4.53583
R916 VSS.n524 VSS.n175 4.53583
R917 VSS.n524 VSS.n182 4.53583
R918 VSS.n218 VSS.n216 4.43191
R919 VSS.n293 VSS.n268 4.43035
R920 VSS.t27 VSS.n90 4.33185
R921 VSS.n4 VSS.n2 0.207283
R922 VSS.n296 VSS.n295 4.25119
R923 VSS.n219 VSS.n38 4.25112
R924 VSS.n530 VSS.n124 4.22744
R925 VSS.n527 VSS.n135 4.22744
R926 VSS.n512 VSS.n511 3.93263
R927 VSS.n539 VSS.n536 3.89224
R928 VSS.n536 VSS.n111 3.88607
R929 VSS.n535 VSS.n534 3.57733
R930 VSS.n477 VSS.n476 3.57193
R931 VSS.n356 VSS.t148 3.45423
R932 VSS.n141 VSS.t151 3.45423
R933 VSS.n142 VSS.t154 3.45423
R934 VSS.n146 VSS.t157 3.45423
R935 VSS.n123 VSS.t132 3.45423
R936 VSS.n127 VSS.t135 3.45423
R937 VSS.n115 VSS.t138 3.45423
R938 VSS.n532 VSS.t141 3.45423
R939 VSS.n350 VSS.t146 3.45313
R940 VSS.n476 VSS.t160 3.45313
R941 VSS.n112 VSS.t130 3.45313
R942 VSS.n351 VSS.t144 3.45313
R943 VSS.n524 VSS.n523 3.38758
R944 VSS.n524 VSS.n152 3.38758
R945 VSS.n524 VSS.n518 3.38758
R946 VSS.n524 VSS.n157 3.38758
R947 VSS.n524 VSS.n210 3.38758
R948 VSS.n524 VSS.n160 3.38758
R949 VSS.n524 VSS.n198 3.38758
R950 VSS.n524 VSS.n166 3.38758
R951 VSS.n524 VSS.n193 3.38758
R952 VSS.n524 VSS.n172 3.38758
R953 VSS.n524 VSS.n186 3.38758
R954 VSS.n524 VSS.n179 3.38758
R955 VSS.n358 VSS.n357 3.3755
R956 VSS.n355 VSS.n354 3.3755
R957 VSS.n353 VSS.n349 3.3755
R958 VSS.n352 VSS.n113 3.3755
R959 VSS.n534 VSS.n533 3.3755
R960 VSS.n296 VSS.n264 3.3055
R961 VSS.n260 VSS.t12 3.22826
R962 VSS.n248 VSS.t19 3.22826
R963 VSS.n249 VSS.t18 3.22826
R964 VSS.t63 VSS.t97 3.06083
R965 VSS.n188 VSS.t100 3.06083
R966 VSS.t102 VSS.n169 3.06083
R967 VSS.n524 VSS.n149 2.81806
R968 VSS.n524 VSS.n203 2.81806
R969 VSS.n524 VSS.n176 2.81806
R970 VSS.n108 VSS.t27 2.70759
R971 VSS.n308 VSS.t122 2.69048
R972 VSS.n523 VSS.t96 2.40123
R973 VSS.n179 VSS.t54 2.40087
R974 VSS.n208 VSS.t52 2.36029
R975 VSS.n516 VSS.t84 2.36019
R976 VSS.n522 VSS.t93 2.36016
R977 VSS.n185 VSS.t62 2.36006
R978 VSS.n197 VSS.t71 2.36006
R979 VSS.n209 VSS.t80 2.36006
R980 VSS.n190 VSS.t65 2.35993
R981 VSS.n151 VSS.t90 2.3598
R982 VSS.n178 VSS.t56 2.35975
R983 VSS.n184 VSS.t59 2.35975
R984 VSS.n192 VSS.t68 2.35975
R985 VSS.n517 VSS.t87 2.35938
R986 VSS.n201 VSS.t74 2.35933
R987 VSS.n202 VSS.t76 2.35895
R988 VSS.n298 VSS.t104 2.35423
R989 VSS.n245 VSS.t106 2.35423
R990 VSS.n300 VSS.t108 2.35423
R991 VSS.n240 VSS.t116 2.35423
R992 VSS.n305 VSS.t118 2.35423
R993 VSS.n238 VSS.t120 2.35423
R994 VSS.n267 VSS.n116 2.30153
R995 VSS.n217 VSS.n139 2.30153
R996 VSS.n524 VSS.n148 2.28106
R997 VSS.n524 VSS.n521 2.28106
R998 VSS.n524 VSS.n150 2.28106
R999 VSS.n524 VSS.n519 2.28106
R1000 VSS.n97 VSS.t4 2.21165
R1001 VSS.n94 VSS.t6 2.21107
R1002 VSS.n543 VSS.t10 2.21082
R1003 VSS.n96 VSS.t2 2.21075
R1004 VSS.n78 VSS.t1 2.21074
R1005 VSS.n547 VSS.t41 2.21046
R1006 VSS.n85 VSS.t48 2.21031
R1007 VSS.n86 VSS.t50 2.2101
R1008 VSS.n542 VSS.t8 2.21
R1009 VSS.n80 VSS.t46 2.20985
R1010 VSS.n83 VSS.t44 2.20978
R1011 VSS.n82 VSS.t42 2.2097
R1012 VSS.n86 VSS.t40 2.20268
R1013 VSS.n97 VSS.t24 2.2025
R1014 VSS.n85 VSS.t38 2.2024
R1015 VSS.n547 VSS.t31 2.20227
R1016 VSS.n78 VSS.t21 2.20201
R1017 VSS.n96 VSS.t22 2.20187
R1018 VSS.n82 VSS.t32 2.20172
R1019 VSS.n80 VSS.t36 2.2017
R1020 VSS.n543 VSS.t30 2.2017
R1021 VSS.n83 VSS.t34 2.20167
R1022 VSS.n542 VSS.t28 2.20157
R1023 VSS.n94 VSS.t26 2.2012
R1024 VSS.n538 VSS.n99 2.16617
R1025 VSS.n104 VSS.n93 2.16617
R1026 VSS.n110 VSS.n100 2.16617
R1027 VSS.n105 VSS.n92 2.16617
R1028 VSS.n109 VSS.n101 2.16617
R1029 VSS.n106 VSS.n91 2.16617
R1030 VSS.n108 VSS.n102 2.16617
R1031 VSS.n540 VSS.n90 2.16617
R1032 VSS.n541 VSS.n103 2.16617
R1033 VSS.n107 VSS.n89 2.16617
R1034 VSS.t124 VSS.n156 1.58948
R1035 VSS.n311 VSS.n38 1.58948
R1036 VSS.t127 VSS.t86 1.58948
R1037 VSS.n499 VSS.n498 1.30527
R1038 VSS.n524 VSS.n174 1.30348
R1039 VSS.n524 VSS.n183 1.30348
R1040 VSS.n524 VSS.n177 1.30348
R1041 VSS.n524 VSS.n181 1.30348
R1042 VSS.t104 VSS.t69 1.00924
R1043 VSS.t120 VSS.t82 1.00924
R1044 VSS.n236 VSS.n235 0.920695
R1045 VSS.n274 VSS.n236 0.882565
R1046 VSS.n489 VSS.n488 0.812182
R1047 VSS.t70 VSS.n164 0.672995
R1048 VSS.t51 VSS.n205 0.672995
R1049 VSS.n260 VSS.n259 0.513002
R1050 VSS.n253 VSS.n252 0.479883
R1051 VSS.n250 VSS.n77 0.479883
R1052 VSS.n409 VSS.n393 0.4405
R1053 VSS.n339 VSS.n338 0.4405
R1054 VSS.n329 VSS.n328 0.4405
R1055 VSS.n319 VSS.n318 0.4405
R1056 VSS.n369 VSS.n368 0.4405
R1057 VSS.n393 VSS.n392 0.4405
R1058 VSS.n338 VSS.n337 0.4405
R1059 VSS.n328 VSS.n327 0.4405
R1060 VSS.n318 VSS.n317 0.4405
R1061 VSS.n370 VSS.n369 0.4405
R1062 VSS.n307 VSS.n169 0.43769
R1063 VSS.n434 VSS.n433 0.424088
R1064 VSS.n373 VSS.n371 0.422335
R1065 VSS.n259 VSS.n258 0.411981
R1066 VSS.n255 VSS.n254 0.411981
R1067 VSS.n256 VSS.n255 0.370375
R1068 VSS.n255 VSS.n253 0.370375
R1069 VSS.n253 VSS.n77 0.370375
R1070 VSS.n381 VSS.n380 0.367167
R1071 VSS.n396 VSS.n395 0.367167
R1072 VSS.n398 VSS.n397 0.367167
R1073 VSS.n403 VSS.n399 0.367167
R1074 VSS.n414 VSS.n413 0.367167
R1075 VSS.n416 VSS.n415 0.367167
R1076 VSS.n420 VSS.n312 0.367167
R1077 VSS.n513 VSS.n512 0.367167
R1078 VSS.n408 VSS.n407 0.3635
R1079 VSS.n407 VSS.n406 0.3635
R1080 VSS.n426 VSS.n425 0.3635
R1081 VSS.n427 VSS.n426 0.3635
R1082 VSS.n430 VSS.n429 0.3635
R1083 VSS.n431 VSS.n430 0.3635
R1084 VSS.n343 VSS.n342 0.3635
R1085 VSS.n342 VSS.n341 0.3635
R1086 VSS.n333 VSS.n332 0.3635
R1087 VSS.n332 VSS.n331 0.3635
R1088 VSS.n323 VSS.n322 0.3635
R1089 VSS.n322 VSS.n321 0.3635
R1090 VSS.n365 VSS.n364 0.3635
R1091 VSS.n366 VSS.n365 0.3635
R1092 VSS.n378 VSS.n377 0.3635
R1093 VSS.n440 VSS.n437 0.3635
R1094 VSS.n438 VSS.n437 0.3635
R1095 VSS.n377 VSS.n376 0.3635
R1096 VSS.n374 VSS.n373 0.3635
R1097 VSS.n445 VSS.n439 0.338523
R1098 VSS.n353 VSS.n352 0.337235
R1099 VSS.n354 VSS.n353 0.337235
R1100 VSS.n310 VSS.n297 0.334254
R1101 VSS.n259 VSS.n257 0.3195
R1102 VSS.n257 VSS.n256 0.3195
R1103 VSS.n499 VSS.n326 0.31812
R1104 VSS.n479 VSS.n346 0.31812
R1105 VSS.n489 VSS.n336 0.31812
R1106 VSS.n478 VSS.n347 0.31812
R1107 VSS.n472 VSS.n471 0.288357
R1108 VSS.n550 VSS.n76 0.27725
R1109 VSS.n423 VSS.n422 0.276447
R1110 VSS.n392 VSS.n391 0.276447
R1111 VSS.n410 VSS.n409 0.276447
R1112 VSS.n410 VSS.n408 0.276447
R1113 VSS.n406 VSS.n405 0.276447
R1114 VSS.n428 VSS.n427 0.276447
R1115 VSS.n429 VSS.n428 0.276447
R1116 VSS.n432 VSS.n431 0.276447
R1117 VSS.n324 VSS.n323 0.276447
R1118 VSS.n321 VSS.n320 0.276447
R1119 VSS.n320 VSS.n319 0.276447
R1120 VSS.n317 VSS.n316 0.276447
R1121 VSS.n315 VSS.n314 0.276447
R1122 VSS.n344 VSS.n343 0.276188
R1123 VSS.n341 VSS.n340 0.276188
R1124 VSS.n340 VSS.n339 0.276188
R1125 VSS.n334 VSS.n333 0.276188
R1126 VSS.n331 VSS.n330 0.276188
R1127 VSS.n330 VSS.n329 0.276188
R1128 VSS.n364 VSS.n359 0.276188
R1129 VSS.n367 VSS.n366 0.276188
R1130 VSS.n368 VSS.n367 0.276188
R1131 VSS.n442 VSS.n440 0.276188
R1132 VSS.n439 VSS.n438 0.276188
R1133 VSS.n376 VSS.n375 0.276188
R1134 VSS.n375 VSS.n374 0.276188
R1135 VSS.n446 VSS.n435 0.2755
R1136 VSS.n451 VSS.n450 0.2755
R1137 VSS.n453 VSS.n452 0.2755
R1138 VSS.n457 VSS.n372 0.2755
R1139 VSS.n462 VSS.n461 0.2755
R1140 VSS.n464 VSS.n463 0.2755
R1141 VSS.n466 VSS.n361 0.2755
R1142 VSS.n471 VSS.n470 0.2755
R1143 VSS.n433 VSS.n432 0.271823
R1144 VSS.n425 VSS.n424 0.2645
R1145 VSS.n444 VSS.n378 0.2645
R1146 VSS.n547 VSS.n5 0.239722
R1147 VSS.n4 VSS.n78 0.239732
R1148 VSS.n549 VSS.n77 0.248
R1149 VSS.n84 VSS.n82 0.243424
R1150 VSS.n98 VSS.n96 0.243424
R1151 VSS.n80 VSS.n79 0.24245
R1152 VSS.n94 VSS.n88 0.24245
R1153 VSS.n352 VSS.n351 0.241827
R1154 VSS.n354 VSS.n350 0.241827
R1155 VSS.n83 VSS.n81 0.240796
R1156 VSS.n97 VSS.n95 0.240796
R1157 VSS.n87 VSS.n85 0.239822
R1158 VSS.n544 VSS.n542 0.239822
R1159 VSS.n4 VSS.n96 0.225219
R1160 VSS.n5 VSS.n82 0.225224
R1161 VSS.n85 VSS.n79 0.227974
R1162 VSS.n542 VSS.n88 0.227974
R1163 VSS.n309 VSS.n308 0.227498
R1164 VSS.n84 VSS.n83 0.227001
R1165 VSS.n98 VSS.n97 0.227001
R1166 VSS.n310 VSS.n236 0.22697
R1167 VSS.n87 VSS.n86 0.225646
R1168 VSS.n544 VSS.n543 0.225646
R1169 VSS.n81 VSS.n80 0.224672
R1170 VSS.n95 VSS.n94 0.224672
R1171 VSS.n2 VSS.n88 0.218846
R1172 VSS.n2 VSS.n98 0.218846
R1173 VSS.n0 VSS.n79 0.218846
R1174 VSS.n0 VSS.n84 0.218846
R1175 VSS.n2 VSS.n544 0.208386
R1176 VSS.n2 VSS.n95 0.208386
R1177 VSS.n0 VSS.n87 0.208386
R1178 VSS.n0 VSS.n81 0.208386
R1179 VSS.n422 VSS.n391 0.199447
R1180 VSS.n405 VSS.n390 0.199447
R1181 VSS.n325 VSS.n324 0.199447
R1182 VSS.n316 VSS.n315 0.199447
R1183 VSS.n345 VSS.n344 0.199188
R1184 VSS.n335 VSS.n334 0.199188
R1185 VSS.n359 VSS.n348 0.199188
R1186 VSS.n443 VSS.n442 0.199188
R1187 VSS.n282 VSS.n15 0.251491
R1188 VSS.n283 VSS.n282 0.189041
R1189 VSS.n288 VSS.n18 0.251491
R1190 VSS.n291 VSS.n290 0.189041
R1191 VSS.n62 VSS.n223 0.251491
R1192 VSS.n223 VSS.n216 0.189041
R1193 VSS.n435 VSS.n434 0.165999
R1194 VSS.n474 VSS.n358 0.161968
R1195 VSS.n284 VSS.n283 0.157715
R1196 VSS.n289 VSS.n288 0.157715
R1197 VSS.n292 VSS.n291 0.157715
R1198 VSS.n233 VSS.n37 0.220165
R1199 VSS.n232 VSS.n66 0.157715
R1200 VSS.n46 VSS.n228 0.220165
R1201 VSS.n55 VSS.n73 0.220165
R1202 VSS.n227 VSS.n226 0.157715
R1203 VSS.n15 VSS.n12 0.282573
R1204 VSS.n18 VSS.n287 0.219757
R1205 VSS.n290 VSS.n289 0.157378
R1206 VSS.n293 VSS.n292 0.157378
R1207 VSS.n233 VSS.n232 0.157378
R1208 VSS.n227 VSS.n73 0.157378
R1209 VSS.n62 VSS.n224 0.219757
R1210 VSS.n257 VSS.n248 0.143127
R1211 VSS.n256 VSS.n249 0.143127
R1212 VSS.n545 VSS.n2 0.136421
R1213 VSS.n275 VSS.n7 0.157714
R1214 VSS.n276 VSS.n275 0.126053
R1215 VSS.n277 VSS.n276 0.126053
R1216 VSS.n278 VSS.n277 0.126053
R1217 VSS.n279 VSS.n278 0.126053
R1218 VSS.n280 VSS.n279 0.126053
R1219 VSS.n281 VSS.n280 0.126053
R1220 VSS.n285 VSS.n284 0.126053
R1221 VSS.n286 VSS.n285 0.126053
R1222 VSS.n287 VSS.n286 0.126053
R1223 VSS.n234 VSS.n64 0.126053
R1224 VSS.n230 VSS.n66 0.126053
R1225 VSS.n230 VSS.n229 0.126053
R1226 VSS.n228 VSS.n214 0.126053
R1227 VSS.n50 VSS.n72 0.188868
R1228 VSS.n58 VSS.n224 0.188868
R1229 VSS.n514 VSS.n513 0.12605
R1230 VSS.n534 VSS.n113 0.121601
R1231 VSS.n349 VSS.n113 0.121601
R1232 VSS.n355 VSS.n349 0.121601
R1233 VSS.n358 VSS.n355 0.121601
R1234 VSS.n480 VSS.n479 0.102006
R1235 VSS.n490 VSS.n489 0.102006
R1236 VSS.n500 VSS.n499 0.102006
R1237 VSS.n422 VSS.n421 0.101071
R1238 VSS.n419 VSS.n391 0.101071
R1239 VSS.n411 VSS.n410 0.101071
R1240 VSS.n407 VSS.n400 0.101071
R1241 VSS.n405 VSS.n404 0.101071
R1242 VSS.n402 VSS.n390 0.101071
R1243 VSS.n426 VSS.n388 0.101071
R1244 VSS.n428 VSS.n386 0.101071
R1245 VSS.n430 VSS.n384 0.101071
R1246 VSS.n432 VSS.n382 0.101071
R1247 VSS.n480 VSS.n345 0.101071
R1248 VSS.n481 VSS.n344 0.101071
R1249 VSS.n483 VSS.n342 0.101071
R1250 VSS.n485 VSS.n340 0.101071
R1251 VSS.n490 VSS.n335 0.101071
R1252 VSS.n491 VSS.n334 0.101071
R1253 VSS.n493 VSS.n332 0.101071
R1254 VSS.n495 VSS.n330 0.101071
R1255 VSS.n500 VSS.n325 0.101071
R1256 VSS.n501 VSS.n324 0.101071
R1257 VSS.n503 VSS.n322 0.101071
R1258 VSS.n505 VSS.n320 0.101071
R1259 VSS.n509 VSS.n316 0.101071
R1260 VSS.n510 VSS.n315 0.101071
R1261 VSS.n475 VSS.n348 0.101071
R1262 VSS.n473 VSS.n359 0.101071
R1263 VSS.n365 VSS.n363 0.101071
R1264 VSS.n469 VSS.n367 0.101071
R1265 VSS.n443 VSS.n379 0.101071
R1266 VSS.n442 VSS.n441 0.101071
R1267 VSS.n449 VSS.n437 0.101071
R1268 VSS.n447 VSS.n439 0.101071
R1269 VSS.n455 VSS.n377 0.101071
R1270 VSS.n458 VSS.n375 0.101071
R1271 VSS.n460 VSS.n373 0.101071
R1272 VSS.n7 VSS.n274 0.185353
R1273 VSS.n235 VSS.n64 0.094443
R1274 VSS.n511 VSS.n510 0.0885
R1275 VSS.n510 VSS.n509 0.0885
R1276 VSS.n509 VSS.n508 0.0885
R1277 VSS.n508 VSS.n507 0.0885
R1278 VSS.n507 VSS.n506 0.0885
R1279 VSS.n506 VSS.n505 0.0885
R1280 VSS.n505 VSS.n504 0.0885
R1281 VSS.n504 VSS.n503 0.0885
R1282 VSS.n503 VSS.n502 0.0885
R1283 VSS.n502 VSS.n501 0.0885
R1284 VSS.n501 VSS.n500 0.0885
R1285 VSS.n498 VSS.n497 0.0885
R1286 VSS.n497 VSS.n496 0.0885
R1287 VSS.n496 VSS.n495 0.0885
R1288 VSS.n495 VSS.n494 0.0885
R1289 VSS.n494 VSS.n493 0.0885
R1290 VSS.n493 VSS.n492 0.0885
R1291 VSS.n492 VSS.n491 0.0885
R1292 VSS.n491 VSS.n490 0.0885
R1293 VSS.n488 VSS.n487 0.0885
R1294 VSS.n487 VSS.n486 0.0885
R1295 VSS.n486 VSS.n485 0.0885
R1296 VSS.n485 VSS.n484 0.0885
R1297 VSS.n484 VSS.n483 0.0885
R1298 VSS.n483 VSS.n482 0.0885
R1299 VSS.n482 VSS.n481 0.0885
R1300 VSS.n481 VSS.n480 0.0885
R1301 VSS.n535 VSS.n112 0.0846837
R1302 VSS.n123 VSS.n119 0.0779076
R1303 VSS.n128 VSS.n127 0.0779076
R1304 VSS.n531 VSS.n115 0.0779076
R1305 VSS.n143 VSS.n141 0.0779076
R1306 VSS.n142 VSS.n132 0.0779076
R1307 VSS.n147 VSS.n146 0.0779076
R1308 VSS.n423 VSS.n313 0.0759286
R1309 VSS.n431 VSS.n383 0.0759286
R1310 VSS.n429 VSS.n385 0.0759286
R1311 VSS.n427 VSS.n387 0.0759286
R1312 VSS.n425 VSS.n389 0.0759286
R1313 VSS.n406 VSS.n401 0.0759286
R1314 VSS.n412 VSS.n408 0.0759286
R1315 VSS.n409 VSS.n394 0.0759286
R1316 VSS.n417 VSS.n393 0.0759286
R1317 VSS.n418 VSS.n392 0.0759286
R1318 VSS.n488 VSS.n337 0.0759286
R1319 VSS.n487 VSS.n338 0.0759286
R1320 VSS.n486 VSS.n339 0.0759286
R1321 VSS.n484 VSS.n341 0.0759286
R1322 VSS.n482 VSS.n343 0.0759286
R1323 VSS.n498 VSS.n327 0.0759286
R1324 VSS.n497 VSS.n328 0.0759286
R1325 VSS.n496 VSS.n329 0.0759286
R1326 VSS.n494 VSS.n331 0.0759286
R1327 VSS.n492 VSS.n333 0.0759286
R1328 VSS.n511 VSS.n314 0.0759286
R1329 VSS.n508 VSS.n317 0.0759286
R1330 VSS.n507 VSS.n318 0.0759286
R1331 VSS.n506 VSS.n319 0.0759286
R1332 VSS.n504 VSS.n321 0.0759286
R1333 VSS.n502 VSS.n323 0.0759286
R1334 VSS.n468 VSS.n368 0.0759286
R1335 VSS.n467 VSS.n369 0.0759286
R1336 VSS.n465 VSS.n370 0.0759286
R1337 VSS.n366 VSS.n362 0.0759286
R1338 VSS.n364 VSS.n360 0.0759286
R1339 VSS.n448 VSS.n438 0.0759286
R1340 VSS.n440 VSS.n436 0.0759286
R1341 VSS.n459 VSS.n374 0.0759286
R1342 VSS.n456 VSS.n376 0.0759286
R1343 VSS.n454 VSS.n378 0.0759286
R1344 VSS.n124 VSS.n112 0.0594056
R1345 VSS.n356 VSS.n135 0.0594056
R1346 VSS.n533 VSS.n114 0.058826
R1347 VSS.n124 VSS.n123 0.0586497
R1348 VSS.n141 VSS.n135 0.0586497
R1349 VSS.n357 VSS.n137 0.0584906
R1350 VSS.n536 VSS.n535 0.0566224
R1351 VSS.n514 VSS.n76 0.0545
R1352 VSS.n186 VSS.n184 0.0539757
R1353 VSS.n202 VSS.n160 0.0529665
R1354 VSS.n465 VSS.n464 0.0528809
R1355 VSS.n152 VSS.n151 0.0527701
R1356 VSS.n523 VSS.n522 0.0519573
R1357 VSS.n512 VSS.n313 0.0518333
R1358 VSS.n201 VSS.n198 0.0517609
R1359 VSS.n185 VSS.n172 0.0509482
R1360 VSS.n179 VSS.n178 0.0507518
R1361 VSS.n210 VSS.n208 0.049939
R1362 VSS.n518 VSS.n517 0.0497426
R1363 VSS.n178 VSS.n176 0.0490925
R1364 VSS.n197 VSS.n166 0.0487334
R1365 VSS.n203 VSS.n201 0.0480833
R1366 VSS.n522 VSS.n149 0.0474161
R1367 VSS.n464 VSS.n371 0.0473412
R1368 VSS.n151 VSS.n149 0.0470742
R1369 VSS.n209 VSS.n157 0.0469115
R1370 VSS.n203 VSS.n202 0.0464069
R1371 VSS.n478 VSS.n477 0.046273
R1372 VSS.n193 VSS.n192 0.0457059
R1373 VSS.n184 VSS.n176 0.0453978
R1374 VSS.n192 VSS.n166 0.0448931
R1375 VSS.n518 VSS.n516 0.0438839
R1376 VSS.n210 VSS.n209 0.0436875
R1377 VSS.n190 VSS.n172 0.0426784
R1378 VSS.n198 VSS.n197 0.0418656
R1379 VSS.n517 VSS.n152 0.0408564
R1380 VSS.n208 VSS.n160 0.04066
R1381 VSS.n193 VSS.n191 0.0398472
R1382 VSS.n350 VSS.n137 0.0397443
R1383 VSS.n186 VSS.n185 0.0396508
R1384 VSS.n127 VSS.n119 0.039409
R1385 VSS.n128 VSS.n115 0.039409
R1386 VSS.n532 VSS.n531 0.039409
R1387 VSS.n351 VSS.n114 0.039409
R1388 VSS.n143 VSS.n142 0.039409
R1389 VSS.n146 VSS.n132 0.039409
R1390 VSS.n476 VSS.n147 0.039409
R1391 VSS.n515 VSS.n157 0.0386417
R1392 VSS.n433 VSS.n381 0.0302645
R1393 VSS.n421 VSS.n313 0.0298333
R1394 VSS.n419 VSS.n418 0.0298333
R1395 VSS.n418 VSS.n417 0.0298333
R1396 VSS.n411 VSS.n394 0.0298333
R1397 VSS.n412 VSS.n411 0.0298333
R1398 VSS.n401 VSS.n400 0.0298333
R1399 VSS.n404 VSS.n401 0.0298333
R1400 VSS.n402 VSS.n389 0.0298333
R1401 VSS.n389 VSS.n388 0.0298333
R1402 VSS.n387 VSS.n386 0.0298333
R1403 VSS.n386 VSS.n385 0.0298333
R1404 VSS.n384 VSS.n383 0.0298333
R1405 VSS.n383 VSS.n382 0.0298333
R1406 VSS.n420 VSS.n419 0.0225
R1407 VSS.n416 VSS.n394 0.0225
R1408 VSS.n413 VSS.n400 0.0225
R1409 VSS.n403 VSS.n402 0.0225
R1410 VSS.n397 VSS.n387 0.0225
R1411 VSS.n395 VSS.n384 0.0225
R1412 VSS.n448 VSS.n447 0.0214524
R1413 VSS.n449 VSS.n448 0.0214524
R1414 VSS.n441 VSS.n436 0.0214524
R1415 VSS.n441 VSS.n379 0.0214524
R1416 VSS.n455 VSS.n454 0.0214524
R1417 VSS.n456 VSS.n455 0.0214524
R1418 VSS.n459 VSS.n458 0.0214524
R1419 VSS.n460 VSS.n459 0.0214524
R1420 VSS.n468 VSS.n467 0.0214524
R1421 VSS.n469 VSS.n468 0.0214524
R1422 VSS.n363 VSS.n362 0.0214524
R1423 VSS.n363 VSS.n360 0.0214524
R1424 VSS.n533 VSS.n532 0.0195816
R1425 VSS.n357 VSS.n356 0.0195816
R1426 VSS VSS.n550 0.0185
R1427 VSS.n513 VSS.n312 0.0185
R1428 VSS.n415 VSS.n312 0.0185
R1429 VSS.n415 VSS.n414 0.0185
R1430 VSS.n414 VSS.n399 0.0185
R1431 VSS.n399 VSS.n398 0.0185
R1432 VSS.n398 VSS.n396 0.0185
R1433 VSS.n396 VSS.n380 0.0185
R1434 VSS.n434 VSS.n380 0.0185
R1435 VSS.n461 VSS.n371 0.0159153
R1436 VSS.n446 VSS.n445 0.0156425
R1437 VSS.n474 VSS.n473 0.0143286
R1438 VSS.n451 VSS.n435 0.0133571
R1439 VSS.n452 VSS.n451 0.0133571
R1440 VSS.n452 VSS.n372 0.0133571
R1441 VSS.n462 VSS.n372 0.0133571
R1442 VSS.n463 VSS.n462 0.0133571
R1443 VSS.n463 VSS.n361 0.0133571
R1444 VSS.n471 VSS.n361 0.0133571
R1445 VSS.n424 VSS.n390 0.0124467
R1446 VSS.n326 VSS.n325 0.0124467
R1447 VSS.n346 VSS.n345 0.0121878
R1448 VSS.n336 VSS.n335 0.0121878
R1449 VSS.n348 VSS.n347 0.0121878
R1450 VSS.n444 VSS.n443 0.0121878
R1451 VSS.n447 VSS.n446 0.0109762
R1452 VSS.n450 VSS.n449 0.0109762
R1453 VSS.n450 VSS.n436 0.0109762
R1454 VSS.n453 VSS.n379 0.0109762
R1455 VSS.n454 VSS.n453 0.0109762
R1456 VSS.n457 VSS.n456 0.0109762
R1457 VSS.n458 VSS.n457 0.0109762
R1458 VSS.n461 VSS.n460 0.0109762
R1459 VSS.n466 VSS.n465 0.0109762
R1460 VSS.n467 VSS.n466 0.0109762
R1461 VSS.n470 VSS.n469 0.0109762
R1462 VSS.n470 VSS.n362 0.0109762
R1463 VSS.n472 VSS.n360 0.0109762
R1464 VSS.n473 VSS.n472 0.0109762
R1465 VSS.n191 VSS.n190 0.0085734
R1466 VSS.n516 VSS.n515 0.0085734
R1467 VSS.n19 VSS.n8 0.00298407
R1468 VSS.n421 VSS.n420 0.00783333
R1469 VSS.n417 VSS.n416 0.00783333
R1470 VSS.n413 VSS.n412 0.00783333
R1471 VSS.n404 VSS.n403 0.00783333
R1472 VSS.n397 VSS.n388 0.00783333
R1473 VSS.n395 VSS.n385 0.00783333
R1474 VSS.n382 VSS.n381 0.00783333
R1475 VSS.n475 VSS.n474 0.00762381
R1476 VSS.n274 VSS.n111 0.00691667
R1477 VSS.n477 VSS.n475 0.00594762
R1478 VSS.n29 VSS.n272 0.00572691
R1479 VSS.n231 VSS.n68 0.00495229
R1480 VSS.n75 VSS.n57 0.00283308
R1481 VSS.n49 VSS.n47 0.00283308
R1482 VSS.n220 VSS.n219 0.002125
R1483 VSS.n219 VSS.n218 0.00187493
R1484 VSS.n273 VSS.n13 0.00166667
R1485 VSS.n272 VSS.n265 0.00166667
R1486 VSS.n271 VSS.n16 0.00166667
R1487 VSS.n34 VSS.n33 0.00169993
R1488 VSS.n269 VSS.n266 0.00166667
R1489 VSS.n36 VSS.n35 0.00169993
R1490 VSS.n40 VSS.n39 0.00169993
R1491 VSS.n71 VSS.n43 0.00169993
R1492 VSS.n52 VSS.n51 0.00169993
R1493 VSS.n225 VSS.n215 0.00166667
R1494 VSS.n222 VSS.n60 0.00166667
R1495 VSS.n221 VSS.n220 0.00166667
R1496 VSS.n295 VSS.n268 0.00162501
R1497 VSS.n225 VSS.n56 0.00199997
R1498 VSS.n51 VSS.n74 0.0015
R1499 VSS.n70 VSS.n48 0.00199997
R1500 VSS.n57 VSS.n56 0.00199997
R1501 VSS.n54 VSS.n53 0.00199997
R1502 VSS.n49 VSS.n48 0.00199997
R1503 VSS.n45 VSS.n44 0.00199997
R1504 VSS.n42 VSS.n41 0.00199997
R1505 VSS.n61 VSS.n60 0.00183332
R1506 VSS.n71 VSS.n70 0.0015
R1507 VSS.n231 VSS.n39 0.0015
R1508 VSS.n294 VSS.n36 0.0015
R1509 VSS.n270 VSS.n34 0.0015
R1510 VSS.n27 VSS.n11 0.00199997
R1511 VSS.n26 VSS.n9 0.00199997
R1512 VSS.n26 VSS.n11 0.00199997
R1513 VSS.n25 VSS.n9 0.00199997
R1514 VSS.n17 VSS.n16 0.00183332
R1515 VSS.n14 VSS.n13 0.00183332
R1516 VSS.n2 VSS.n1 0.00150549
R1517 VSS.n295 VSS.n294 0.00137498
R1518 VSS.n273 VSS.n265 0.00133332
R1519 VSS.n270 VSS.n266 0.00133332
R1520 VSS.n74 VSS.n215 0.00133332
R1521 VSS.n222 VSS.n221 0.00133332
R1522 VSS.n6 VSS.t25 14.5754
R1523 VSS.n5 VSS.n0 0.220344
R1524 a_11798_1860.n0 a_11798_1860.n4 9.42143
R1525 a_11798_1860.n1 a_11798_1860.n12 9.42143
R1526 a_11798_1860.n1 a_11798_1860.n5 9.42143
R1527 a_11798_1860.n1 a_11798_1860.n6 9.42143
R1528 a_11798_1860.n2 a_11798_1860.n9 9.42143
R1529 a_11798_1860.n2 a_11798_1860.n7 9.42143
R1530 a_11798_1860.n4 a_11798_1860.t15 3.60374
R1531 a_11798_1860.n5 a_11798_1860.t21 3.60255
R1532 a_11798_1860.n6 a_11798_1860.t22 3.60255
R1533 a_11798_1860.n7 a_11798_1860.t28 3.60255
R1534 a_11798_1860.n4 a_11798_1860.t16 3.45423
R1535 a_11798_1860.n13 a_11798_1860.t17 3.45423
R1536 a_11798_1860.n11 a_11798_1860.t19 3.45423
R1537 a_11798_1860.n5 a_11798_1860.t20 3.45423
R1538 a_11798_1860.n12 a_11798_1860.t18 3.45423
R1539 a_11798_1860.n6 a_11798_1860.t23 3.45423
R1540 a_11798_1860.n10 a_11798_1860.t24 3.45423
R1541 a_11798_1860.n8 a_11798_1860.t26 3.45423
R1542 a_11798_1860.n7 a_11798_1860.t27 3.45423
R1543 a_11798_1860.n9 a_11798_1860.t25 3.45423
R1544 a_11798_1860.t14 a_11798_1860.n3 2.61386
R1545 a_11798_1860.n0 a_11798_1860.t0 2.6103
R1546 a_11798_1860.n3 a_11798_1860.t13 2.56233
R1547 a_11798_1860.n3 a_11798_1860.t12 2.56233
R1548 a_11798_1860.n1 a_11798_1860.t5 2.56233
R1549 a_11798_1860.n0 a_11798_1860.t2 2.56233
R1550 a_11798_1860.n2 a_11798_1860.t11 2.56233
R1551 a_11798_1860.n1 a_11798_1860.t8 2.56207
R1552 a_11798_1860.n1 a_11798_1860.t7 2.56207
R1553 a_11798_1860.n1 a_11798_1860.t4 2.56173
R1554 a_11798_1860.n0 a_11798_1860.t1 2.56173
R1555 a_11798_1860.n2 a_11798_1860.t10 2.56173
R1556 a_11798_1860.n1 a_11798_1860.t9 2.56161
R1557 a_11798_1860.n1 a_11798_1860.t6 2.5616
R1558 a_11798_1860.n0 a_11798_1860.t3 2.56159
R1559 a_11798_1860.n2 a_11798_1860.n1 0.245563
R1560 a_11798_1860.n8 a_11798_1860.n7 0.225083
R1561 a_11798_1860.n6 a_11798_1860.n10 0.225083
R1562 a_11798_1860.n11 a_11798_1860.n5 0.225083
R1563 a_11798_1860.n4 a_11798_1860.n13 0.225083
R1564 a_11798_1860.n1 a_11798_1860.n0 0.196551
R1565 a_11798_1860.n13 a_11798_1860.n12 0.1875
R1566 a_11798_1860.n12 a_11798_1860.n11 0.1875
R1567 a_11798_1860.n10 a_11798_1860.n9 0.1875
R1568 a_11798_1860.n9 a_11798_1860.n8 0.1875
R1569 a_11798_1860.n3 a_11798_1860.n2 0.147538
R1570 a_5428_3064.n0 a_5428_3064.t2 36.3628
R1571 a_5428_3064.n0 a_5428_3064.t0 35.246
R1572 a_5428_3064.t1 a_5428_3064.n0 15.3137
R1573 a_1474_1770.n0 a_1474_1770.t2 60.5214
R1574 a_1474_1770.n0 a_1474_1770.t1 33.8343
R1575 a_1474_1770.n1 a_1474_1770.n0 12.0028
R1576 a_1474_1770.t0 a_1474_1770.n1 2.87353
R1577 a_1474_1770.t0 a_1474_1770.n1 2.86853
R1578 a_1954_3500.n0 a_1954_3500.t2 44.3673
R1579 a_1954_3500.n0 a_1954_3500.t0 27.0418
R1580 a_1954_3500.t1 a_1954_3500.n0 12.2034
R1581 a_1254_3500.n0 a_1254_3500.t2 36.0512
R1582 a_1254_3500.n0 a_1254_3500.t3 33.7412
R1583 a_1254_3500.n3 a_1254_3500.t1 26.8072
R1584 a_1254_3500.n1 a_1254_3500.t5 26.0905
R1585 a_1254_3500.n1 a_1254_3500.t4 24.7412
R1586 a_1254_3500.t0 a_1254_3500.n3 12.4381
R1587 a_1254_3500.n3 a_1254_3500.n2 9.512
R1588 a_1254_3500.n2 a_1254_3500.n1 9.0005
R1589 a_1254_3500.n2 a_1254_3500.n0 0.7705
R1590 a_2654_5520.n1 a_2654_5520.t4 36.3944
R1591 a_2654_5520.n0 a_2654_5520.t1 34.4012
R1592 a_2654_5520.n0 a_2654_5520.t3 22.0391
R1593 a_2654_5520.n2 a_2654_5520.n1 9.0005
R1594 a_2654_5520.n2 a_2654_5520.t0 5.84394
R1595 a_2654_5520.t2 a_2654_5520.n2 4.67685
R1596 a_2654_5520.n1 a_2654_5520.n0 0.3173
R1597 vco_bias_0.vbn_buf.n3 vco_bias_0.vbn_buf.t1 55.3125
R1598 vco_bias_0.vbn_buf.n1 vco_bias_0.vbn_buf.t4 34.2391
R1599 vco_bias_0.vbn_buf.n1 vco_bias_0.vbn_buf.t3 28.5544
R1600 vco_bias_0.vbn_buf.n2 vco_bias_0.vbn_buf.n1 23.0981
R1601 vco_bias_0.vbn_buf.n0 vco_bias_0.vbn_buf.t2 21.7736
R1602 vco_bias_0.vbn_buf.n2 vco_bias_0.vbn_buf.t0 21.4968
R1603 vco_bias_0.vbn_buf vco_bias_0.vbn_buf.n0 20.8275
R1604 vco_bias_0.vbn_buf.n3 vco_bias_0.vbn_buf.n2 3.1069
R1605 vco_bias_0.vbn_buf vco_bias_0.vbn_buf.n3 1.2149
R1606 vco_bias_0.vbn_buf.n0 vco_bias_0.vbn_buf 0.1105
C0 a_9400_4966# vco_bias_0.vbg_buf 0.05066f
C1 VDD rf_out_p 0.4468f
C2 a_6760_4930# vco_bias_0.vbg_buf 0.01207f
C3 a_6760_4930# vco_bias_0.vbn_buf 0.04276f
C4 VDD rf_out_n 0.46067f
C5 vco_bias_0.vbn_buf ibias_100u 0.0424f
C6 a_9400_4880# a_10100_4160# 0.15006f
C7 vdd_core vco_bias_0.vbg_buf 3.7479f
C8 VDD vco_bias_0.vbg_buf 0.71653f
C9 vdd_core vco_bias_0.vbn_buf 0.29548f
C10 VDD vco_bias_0.vbn_buf 0.42368f
C11 a_19100_4966# a_14668_3324# 0.04847f
C12 vco_bias_0.vbg_buf a_1560_1770# 0.03698f
C13 VDD a_16500_4160# 0.32132f
C14 rf_out_n rf_out_p 0.0144f
C15 vco_bias_0.vbn_buf a_1560_1770# 0.01568f
C16 vdd_core vtune 13.5168f
C17 vtune VDD 0.34199f
C18 a_9400_4966# a_9400_4880# 0.04847f
C19 vco_bias_0.vbn_buf rf_out_p 0.18271f
C20 vco_bias_0.vbn_buf rf_out_n 0.21445f
C21 a_16500_4160# rf_out_p 0.47919f
C22 vco_bias_0.vbn_buf vco_bias_0.vbg_buf 7.0738f
C23 a_9400_4880# vdd_core 0.15264p
C24 a_9400_4880# VDD 1.39697f
C25 vtune rf_out_p 0.03176f
C26 vdd_core a_14668_3324# 0.15264p
C27 VDD a_14668_3324# 1.31003f
C28 vtune rf_out_n 0.03176f
C29 vtune vco_bias_0.vbg_buf 0.07434f
C30 vtune vco_bias_0.vbn_buf 0.09134f
C31 a_9400_4880# rf_out_n 1.12362f
C32 a_14668_3324# rf_out_p 1.12362f
C33 a_9400_4880# vco_bias_0.vbg_buf 0.08477f
C34 a_9400_4880# vco_bias_0.vbn_buf 0.06463f
C35 vco_bias_0.vbg_buf a_14668_3324# 0.04293f
C36 di_en ibias_100u 0.20887f
C37 vco_bias_0.vbn_buf a_14668_3324# 0.05196f
C38 a_1160_2070# ibias_100u 0.03927f
C39 VDD di_en 0.23778f
C40 a_9400_4880# vtune 0.2399f
C41 a_14668_3324# a_16500_4160# 0.15006f
C42 vtune a_14668_3324# 0.23027f
C43 a_1160_2070# a_1560_1770# 0.60592f
C44 a_9400_4880# a_14668_3324# 0.12351f
C45 vco_bias_0.vbg_buf di_en 0.06389f
C46 vco_bias_0.vbn_buf di_en 0.04954f
C47 VDD a_10100_4160# 0.35416f
C48 vco_bias_0.vbn_buf a_1160_2070# 0.03723f
C49 vdd_core a_19100_4966# 0.08348f
C50 a_9400_4966# vdd_core 0.0801f
C51 a_10100_4160# rf_out_n 0.47919f
C52 VDD ibias_100u 0.1968f
C53 vco_bias_0.vbn_buf a_10100_4160# 0.01643f
C54 vco_bias_0.vbg_buf a_19100_4966# 0.03283f
C55 vdd_core VDD 1.71236f
C56 VDD a_1560_1770# 0.02701f
C57 ibias_100u VSS 3.1059f
C58 rf_out_p VSS 4.42943f
C59 rf_out_n VSS 4.40668f
C60 di_en VSS 1.43526f
C61 vdd_core VSS 3.7827p
C62 VDD VSS 45.82691f
C63 vtune VSS 4.02849f
C64 vco_bias_0.vbn_buf VSS 0.12539p
C65 vco_bias_0.vbn_buf.n0 VSS 0.11347f
C66 vco_bias_0.vbn_buf.n1 VSS 0.23593f
C67 vco_bias_0.vbn_buf.t0 VSS 0.10316f
C68 vco_bias_0.vbn_buf.n2 VSS 0.21664f
C69 vco_bias_0.vbn_buf.t1 VSS 2.00385f
C70 vco_bias_0.vbn_buf.n3 VSS 0.12201f
C71 a_2654_5520.t0 VSS 0.3876f
C72 a_2654_5520.t3 VSS 0.43521f
C73 a_2654_5520.n0 VSS 0.8291f
C74 a_2654_5520.n1 VSS 0.87471f
C75 a_2654_5520.n2 VSS 0.68233f
C76 a_2654_5520.t2 VSS 0.82453f
C77 a_1254_3500.t1 VSS 0.06689f
C78 a_1254_3500.n0 VSS 0.92133f
C79 a_1254_3500.n1 VSS 0.49535f
C80 a_1254_3500.n2 VSS 0.24439f
C81 a_1254_3500.n3 VSS 0.45099f
C82 a_1254_3500.t0 VSS 0.14276f
C83 a_1954_3500.t0 VSS 0.08774f
C84 a_1954_3500.n0 VSS 1.17442f
C85 a_1954_3500.t1 VSS 0.1847f
C86 a_1474_1770.t1 VSS 0.6427f
C87 a_1474_1770.t2 VSS 2.32994f
C88 a_1474_1770.n0 VSS 2.67795f
C89 a_1474_1770.n1 VSS 0.50911f
C90 a_1474_1770.t0 VSS 0.67013f
C91 a_5428_3064.t2 VSS 0.65938f
C92 a_5428_3064.n0 VSS 1.39401f
C93 a_5428_3064.t1 VSS 0.65316f
C94 a_11798_1860.n0 VSS 2.00542f
C95 a_11798_1860.n1 VSS 3.45403f
C96 a_11798_1860.n2 VSS 1.40912f
C97 a_11798_1860.n3 VSS 1.32792f
C98 a_11798_1860.n4 VSS 0.13917f
C99 a_11798_1860.n5 VSS 0.13917f
C100 a_11798_1860.n6 VSS 0.13917f
C101 a_11798_1860.n7 VSS 0.13917f
C102 a_11798_1860.t28 VSS 0.06536f
C103 a_11798_1860.t25 VSS 0.06995f
C104 a_11798_1860.t26 VSS 0.06995f
C105 a_11798_1860.t27 VSS 0.06995f
C106 a_11798_1860.n8 VSS 0.07813f
C107 a_11798_1860.n9 VSS 0.08176f
C108 a_11798_1860.t23 VSS 4.6161f
C109 a_11798_1860.t24 VSS 0.06995f
C110 a_11798_1860.n10 VSS 0.07813f
C111 a_11798_1860.t22 VSS 0.06536f
C112 a_11798_1860.t21 VSS 0.06536f
C113 a_11798_1860.t18 VSS 0.06995f
C114 a_11798_1860.t19 VSS 0.06995f
C115 a_11798_1860.t20 VSS 4.47985f
C116 a_11798_1860.n11 VSS 0.07813f
C117 a_11798_1860.n12 VSS 0.08176f
C118 a_11798_1860.t16 VSS 0.06995f
C119 a_11798_1860.t17 VSS 0.06995f
C120 a_11798_1860.n13 VSS 0.07813f
C121 a_11798_1860.t15 VSS 0.06536f
C122 a_11798_1860.t0 VSS 0.21078f
C123 a_11798_1860.t1 VSS 0.20507f
C124 a_11798_1860.t2 VSS 0.20507f
C125 a_11798_1860.t3 VSS 0.20507f
C126 a_11798_1860.t4 VSS 0.20507f
C127 a_11798_1860.t5 VSS 0.20507f
C128 a_11798_1860.t6 VSS 0.20507f
C129 a_11798_1860.t7 VSS 0.20506f
C130 a_11798_1860.t8 VSS 0.20506f
C131 a_11798_1860.t9 VSS 0.20507f
C132 a_11798_1860.t10 VSS 0.20507f
C133 a_11798_1860.t11 VSS 1.03577f
C134 a_11798_1860.t12 VSS 0.20507f
C135 a_11798_1860.t13 VSS 0.20507f
C136 a_11798_1860.t14 VSS 0.21074f
C137 VSS.t31 VSS 0.97005f
C138 VSS.t41 VSS 54.8415f
C139 VSS.t36 VSS 0.28406f
C140 VSS.t46 VSS 0.26528f
C141 VSS.t32 VSS 0.97005f
C142 VSS.t42 VSS 54.8415f
C143 VSS.t44 VSS 0.26528f
C144 VSS.t38 VSS 0.28406f
C145 VSS.t22 VSS 3.70511f
C146 VSS.t24 VSS 3.70511f
C147 VSS.t141 VSS 0.53957f
C148 VSS.t157 VSS 0.37416f
C149 VSS.t19 VSS 0.1327f
C150 VSS.t18 VSS 0.13145f
C151 VSS.t12 VSS 0.19817f
C152 VSS.t16 VSS 0.03718f
C153 VSS.t128 VSS 0.03524f
C154 VSS.t14 VSS 0.06319f
C155 VSS.t17 VSS 0.07707f
C156 VSS.t84 VSS 0.8307f
C157 VSS.t8 VSS 3.69986f
C158 VSS.t10 VSS 3.69986f
C159 vtune.t0 VSS 7.22342f
C160 vtune.t3 VSS 7.20927f
C161 vtune.n0 VSS 0.41124f
C162 vtune.t6 VSS 8.76749f
C163 vtune.n1 VSS 1.1151f
C164 VDD.t2 VSS 0.26575f
C165 VDD.t3 VSS 0.37033f
C166 VDD.n0 VSS 0.14875f
C167 VDD.t6 VSS 0.26575f
C168 VDD.t7 VSS 0.35525f
C169 VDD.n1 VSS 0.05481f
C170 VDD.n2 VSS 0.1655f
C171 VDD.t1 VSS 0.20615f
C172 VDD.t0 VSS 0.09332f
C173 VDD.n3 VSS 0.06854f
C174 VDD.n4 VSS 0.12511f
C175 VDD.t5 VSS 0.05576f
C176 VDD.t4 VSS 0.09332f
C177 VDD.n5 VSS 0.06854f
C178 VDD.n6 VSS 0.09647f
C179 VDD.t11 VSS 0.05561f
C180 VDD.t10 VSS 0.09332f
C181 VDD.n7 VSS 0.06854f
C182 VDD.n8 VSS 0.22123f
C183 VDD.t9 VSS 1.35767f
C184 VDD.t8 VSS 0.88278f
C185 VDD.n9 VSS 1.24753f
C186 vdd_core.n0 VSS 0.08489f
C187 vdd_core.n1 VSS 0.11397f
C188 vdd_core.n2 VSS 0.92963f
C189 vdd_core.n3 VSS 0.08489f
C190 vdd_core.n4 VSS 0.11397f
C191 vdd_core.n5 VSS 1.9577f
C192 vdd_core.n6 VSS 0.39987f
C193 vdd_core.n7 VSS 0.4866f
C194 vdd_core.n8 VSS 0.53833f
C195 vdd_core.n9 VSS 0.33043f
C196 vdd_core.n10 VSS 0.10119f
C197 vdd_core.n11 VSS 0.22701f
C198 vdd_core.n12 VSS 0.11657f
C199 vdd_core.n13 VSS 0.07526f
C200 vdd_core.n14 VSS 0.05507f
C201 vdd_core.n15 VSS 0.10119f
C202 vdd_core.n16 VSS 0.11657f
C203 vdd_core.n17 VSS 0.07366f
C204 vdd_core.n18 VSS 0.1028f
C205 vdd_core.n19 VSS 0.11496f
C206 vdd_core.n20 VSS 0.07526f
C207 vdd_core.n21 VSS 0.10119f
C208 vdd_core.n22 VSS 0.12107f
C209 vdd_core.n23 VSS 0.25789f
C210 vdd_core.n24 VSS 5.62231f
C211 vdd_core.n25 VSS 0.07526f
C212 vdd_core.n26 VSS 0.33043f
C213 vdd_core.n27 VSS 0.39243f
C214 vdd_core.n28 VSS 0.29485f
C215 vdd_core.n29 VSS 0.22666f
C216 vdd_core.n30 VSS 0.3785f
C217 vdd_core.n31 VSS 0.3785f
C218 vdd_core.n32 VSS 0.22943f
C219 vdd_core.n33 VSS 0.22943f
C220 vdd_core.n34 VSS 0.34712f
C221 vdd_core.n35 VSS 0.34712f
C222 vdd_core.n36 VSS 0.11496f
C223 vdd_core.n37 VSS 0.33043f
C224 vdd_core.n38 VSS 0.34853f
C225 vdd_core.n39 VSS 0.34853f
C226 vdd_core.n40 VSS 0.11496f
C227 vdd_core.n41 VSS 0.16256f
C228 vdd_core.n42 VSS 0.20951f
C229 vdd_core.n43 VSS 0.30872f
C230 vdd_core.n44 VSS 0.20951f
C231 vdd_core.n45 VSS 12.382f
C232 vdd_core.n46 VSS 5.36472f
C233 vdd_core.n47 VSS 0.16521f
C234 vdd_core.n48 VSS 0.30872f
C235 vdd_core.n49 VSS 0.24518f
C236 vdd_core.n50 VSS 0.24518f
C237 vdd_core.n51 VSS 0.3785f
C238 vdd_core.n52 VSS 0.3785f
C239 vdd_core.n53 VSS 0.22481f
C240 vdd_core.n54 VSS 0.22481f
C241 vdd_core.n55 VSS 0.22204f
C242 vdd_core.n56 VSS 0.34712f
C243 vdd_core.n57 VSS 0.22204f
C244 vdd_core.n58 VSS 0.34712f
C245 vdd_core.n59 VSS 0.11657f
C246 vdd_core.n60 VSS 0.11496f
C247 vdd_core.n61 VSS 0.11657f
C248 vdd_core.n62 VSS 0.11496f
C249 vdd_core.n63 VSS 0.33043f
C250 vdd_core.n64 VSS 0.31388f
C251 vdd_core.n65 VSS 0.22019f
C252 vdd_core.n66 VSS 0.34712f
C253 vdd_core.n67 VSS 0.34712f
C254 vdd_core.n68 VSS 0.22666f
C255 vdd_core.n69 VSS 0.22666f
C256 vdd_core.n70 VSS 0.3785f
C257 vdd_core.n71 VSS 0.3785f
C258 vdd_core.n72 VSS 0.22943f
C259 vdd_core.n73 VSS 0.22943f
C260 vdd_core.n74 VSS 0.34712f
C261 vdd_core.n75 VSS 0.34712f
C262 vdd_core.n76 VSS 0.20951f
C263 vdd_core.n77 VSS 0.20951f
C264 vdd_core.n78 VSS 0.11657f
C265 vdd_core.n79 VSS 0.12595f
C266 vdd_core.n80 VSS 0.22204f
C267 vdd_core.n81 VSS 0.22204f
C268 vdd_core.n82 VSS 0.11657f
C269 vdd_core.n83 VSS 0.34853f
C270 vdd_core.n84 VSS 0.30872f
C271 vdd_core.n85 VSS 0.16256f
C272 vdd_core.n86 VSS 12.382f
C273 vdd_core.n87 VSS 5.36472f
C274 vdd_core.n88 VSS 0.30872f
C275 vdd_core.n89 VSS 0.24518f
C276 vdd_core.n90 VSS 0.3785f
C277 vdd_core.n91 VSS 0.34712f
C278 vdd_core.n92 VSS 0.22481f
C279 vdd_core.n93 VSS 0.11496f
C280 vdd_core.n94 VSS 0.34712f
C281 vdd_core.n95 VSS 0.22481f
C282 vdd_core.n96 VSS 0.3785f
C283 vdd_core.n97 VSS 0.24518f
C284 vdd_core.n98 VSS 0.11496f
C285 vdd_core.n99 VSS 0.11496f
C286 vdd_core.n100 VSS 0.11496f
C287 vdd_core.n101 VSS 5.40925f
C288 vdd_core.n102 VSS 12.3374f
C289 vdd_core.n103 VSS 0.16256f
C290 vdd_core.n104 VSS 0.34853f
C291 vdd_core.n105 VSS 0.11657f
C292 vdd_core.n106 VSS 0.11496f
C293 vdd_core.t3 VSS 0.04267f
C294 vdd_core.n107 VSS 0.07706f
C295 vdd_core.n108 VSS 12.3734f
C296 vdd_core.n109 VSS 1.14332f
C297 vdd_core.t15 VSS 0.58208f
C298 vdd_core.t14 VSS 0.04306f
C299 vdd_core.t2 VSS 0.04251f
C300 vdd_core.n110 VSS 0.06801f
C301 vdd_core.t1 VSS 0.04251f
C302 vdd_core.n111 VSS 0.0819f
C303 vdd_core.n112 VSS 0.01811f
C304 vdd_core.n113 VSS 23.9142f
C305 vdd_core.n114 VSS 0.14402f
C306 vdd_core.n115 VSS 0.19348f
C307 vdd_core.n116 VSS 0.0963f
C308 vdd_core.n117 VSS 0.08404f
C309 vdd_core.n118 VSS 1.39258f
C310 vdd_core.n119 VSS 0.55371f
C311 vdd_core.n120 VSS 0.10048f
C312 vdd_core.t9 VSS 0.04251f
C313 vdd_core.t8 VSS 0.04251f
C314 vdd_core.t10 VSS 0.04306f
C315 vdd_core.n121 VSS 0.06855f
C316 vdd_core.n122 VSS 0.018f
C317 vdd_core.n123 VSS 12.3288f
C318 vdd_core.n124 VSS 0.8829f
C319 vdd_core.t5 VSS 0.04267f
C320 vdd_core.t12 VSS 0.41667f
C321 vdd_core.n125 VSS 0.08148f
C322 vdd_core.n126 VSS 0.07706f
C323 vdd_core.n127 VSS 0.63639f
C324 vdd_core.n128 VSS 13.1991f
C325 vdd_core.n129 VSS 22.4535f
C326 vdd_core.n130 VSS 1.93429f
C327 vdd_core.n131 VSS 0.35282f
C328 vdd_core.n132 VSS 0.07099f
C329 vdd_core.n133 VSS 0.06782f
C330 vdd_core.n134 VSS 0.03007f
C331 vdd_core.n135 VSS 0.0388f
C332 vdd_core.n136 VSS 0.15414f
C333 vdd_core.n137 VSS 0.09211f
C334 vdd_core.n138 VSS 0.13612f
C335 vdd_core.n139 VSS 0.03726f
C336 vdd_core.n140 VSS 0.02897f
C337 vdd_core.n141 VSS 0.0963f
C338 vdd_core.n142 VSS 0.08779f
C339 vdd_core.n143 VSS 0.08779f
C340 vdd_core.n144 VSS 0.08705f
C341 vdd_core.n145 VSS 0.02897f
C342 vdd_core.n146 VSS 0.03726f
C343 vdd_core.n147 VSS 0.08404f
C344 vdd_core.n148 VSS 4.243f
C345 vdd_core.n149 VSS 48.8276f
C346 vdd_core.n150 VSS 9.33552f
C347 vdd_core.n151 VSS 0.24782f
C348 vdd_core.n152 VSS 0.11496f
C349 vdd_core.n153 VSS 0.11657f
C350 vdd_core.n154 VSS 0.11496f
C351 vdd_core.n155 VSS 0.11657f
C352 vdd_core.n156 VSS 0.11496f
C353 vdd_core.n157 VSS 0.11657f
C354 vdd_core.n158 VSS 0.3719f
C355 vdd_core.n159 VSS 0.59057f
C356 vdd_core.n160 VSS 0.46559f
C357 vdd_core.n161 VSS 0.11657f
C358 vdd_core.n162 VSS 0.11496f
C359 vdd_core.n163 VSS 0.33043f
C360 vdd_core.n164 VSS 0.33043f
C361 vdd_core.n165 VSS 0.33043f
C362 vdd_core.n166 VSS 0.11496f
C363 vdd_core.n167 VSS 0.17003f
C364 vdd_core.n168 VSS 5.40925f
C365 vdd_core.n169 VSS 12.3374f
C366 vdd_core.n170 VSS 0.16256f
C367 vdd_core.n171 VSS 0.11657f
C368 vdd_core.n172 VSS 0.11657f
C369 vdd_core.n173 VSS 0.33043f
C370 vdd_core.n174 VSS 0.33043f
C371 vdd_core.n175 VSS 0.11657f
C372 vdd_core.n176 VSS 0.11496f
C373 vdd_core.n177 VSS 0.11657f
C374 vdd_core.n178 VSS 0.11496f
C375 vdd_core.n179 VSS 0.11657f
C376 vdd_core.n180 VSS 1.03552f
C377 vdd_core.n181 VSS 0.33043f
C378 vdd_core.n182 VSS 0.10119f
C379 vdd_core.n183 VSS 0.2268f
C380 vdd_core.n184 VSS 0.19835f
C381 vdd_core.n185 VSS 0.22734f
C382 vdd_core.n186 VSS 0.11657f
C383 vdd_core.n187 VSS 0.25789f
C384 vdd_core.n188 VSS 0.24841f
C385 vdd_core.n189 VSS 0.17727f
C386 vdd_core.n190 VSS 0.2268f
C387 vdd_core.n191 VSS 0.18048f
C388 vdd_core.n192 VSS 0.18048f
C389 vdd_core.n193 VSS 0.27776f
C390 vdd_core.n194 VSS 0.27776f
C391 vdd_core.n195 VSS 0.16547f
C392 vdd_core.n196 VSS 0.16547f
C393 vdd_core.n197 VSS 0.25484f
C394 vdd_core.n198 VSS 0.25484f
C395 vdd_core.n199 VSS 0.16344f
C396 vdd_core.n200 VSS 0.16344f
C397 vdd_core.n201 VSS 0.25578f
C398 vdd_core.n202 VSS 0.25578f
C399 vdd_core.n203 VSS 0.25262f
C400 vdd_core.n204 VSS 0.25368f
C401 vdd_core.n205 VSS 0.16209f
C402 vdd_core.n206 VSS 0.25484f
C403 vdd_core.n207 VSS 0.16681f
C404 vdd_core.n208 VSS 0.27776f
C405 vdd_core.n209 VSS 0.16884f
C406 vdd_core.n210 VSS 0.25484f
C407 vdd_core.n211 VSS 0.15421f
C408 vdd_core.n212 VSS 11.626f
C409 vdd_core.n213 VSS 0.12107f
C410 vdd_core.n214 VSS 0.11657f
C411 vdd_core.n215 VSS 0.07526f
C412 vdd_core.n216 VSS 0.05507f
C413 vdd_core.n217 VSS 0.33043f
C414 vdd_core.n218 VSS 0.05507f
C415 vdd_core.n219 VSS 0.33043f
C416 vdd_core.n220 VSS 0.33043f
C417 vdd_core.n221 VSS 0.05507f
C418 vdd_core.n222 VSS 0.10119f
C419 vdd_core.n223 VSS 0.11657f
C420 vdd_core.n224 VSS 0.07366f
C421 vdd_core.n225 VSS 0.05507f
C422 vdd_core.n226 VSS 0.1028f
C423 vdd_core.n227 VSS 0.11496f
C424 vdd_core.n228 VSS 0.07366f
C425 vdd_core.n229 VSS 0.05507f
C426 vdd_core.n230 VSS 0.33043f
C427 vdd_core.n231 VSS 0.94332f
C428 vdd_core.n232 VSS 0.05507f
C429 vdd_core.n233 VSS 0.12873f
C430 vdd_core.n234 VSS 5.57951f
C431 vdd_core.n235 VSS 11.6688f
C432 vdd_core.n236 VSS 0.15421f
C433 vdd_core.n237 VSS 0.25484f
C434 vdd_core.n238 VSS 0.16884f
C435 vdd_core.n239 VSS 0.27776f
C436 vdd_core.n240 VSS 0.16681f
C437 vdd_core.n241 VSS 0.25484f
C438 vdd_core.n242 VSS 0.16209f
C439 vdd_core.n243 VSS 0.25368f
C440 vdd_core.n244 VSS 0.25262f
C441 vdd_core.n245 VSS 0.22543f
C442 vdd_core.n246 VSS 1.19426f
C443 vdd_core.n247 VSS 0.0669f
C444 vdd_core.n248 VSS 1.58457f
C445 di_en.n0 VSS 0.49481f
C446 rf_out_n.n0 VSS 0.72152f
C447 rf_out_n.n1 VSS 0.89368f
C448 rf_out_n.t6 VSS 1.78866f
C449 rf_out_n.t5 VSS 4.26058f
C450 rf_out_n.t2 VSS 0.37952f
C451 rf_out_n.t1 VSS 0.11424f
C452 rf_out_n.t4 VSS 0.11424f
C453 rf_out_n.t3 VSS 0.11424f
C454 rf_out_n.t0 VSS 0.11424f
C455 rf_out_n.n2 VSS 0.87321f
C456 rf_out_p.n0 VSS 0.9865f
C457 rf_out_p.n1 VSS 0.61469f
C458 rf_out_p.t0 VSS 1.79234f
C459 rf_out_p.t1 VSS 4.37703f
C460 rf_out_p.t2 VSS 0.39731f
C461 rf_out_p.t5 VSS 0.11325f
C462 rf_out_p.t6 VSS 0.11325f
C463 rf_out_p.t3 VSS 0.11325f
C464 rf_out_p.t4 VSS 0.11325f
C465 rf_out_p.n2 VSS 0.86563f
C466 ibias_100u.t2 VSS 0.41135f
C467 ibias_100u.n0 VSS 0.3416f
C468 ibias_100u.n1 VSS 0.21757f
C469 ibias_100u.t0 VSS 0.19311f
C470 ibias_100u.n2 VSS 0.31984f
C471 ibias_100u.t3 VSS 2.10694f
C472 ibias_100u.n3 VSS 0.62542f
.ends
