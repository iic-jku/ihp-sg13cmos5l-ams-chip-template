* PEX produced on Tue Nov  3 07:37:09 PM CET 2026 using /foss/tools/sak/sak-pex.sh with m=3 and s=1 (extresist threshold=10000 mOhm, minres=1000 mOhm, mindelay=1 ps)
* NGSPICE file created from vco_top_pex.ext - technology: ihp-sg13cmos5l

.subckt vco_top_pex ibias_100u di_en VDD VSS vdd_core vtune rf_out_p rf_out_n
X0 VSS.t128 vdd_core.t3 vdd_core.t5 VSS.t127 sg13_lv_nmos ad=0.38p pd=2.38u as=0.38p ps=2.38u w=2u l=0.13u
X1 a_11798_1860# vco_bias_0.vbn_buf VSS.t53 VSS.t58 sg13_lv_nmos ad=0.95p pd=5.38u as=0.95p ps=5.38u w=5u l=0.5u
X2 rf_out_n a_9400_4880# a_11798_1860# VSS.t78 sg13_lv_nmos ad=0.38p pd=2.38u as=0.38p ps=2.38u w=2u l=0.13u
X3 rf_out_n a_9400_4880# a_11798_1860# VSS.t74 sg13_lv_nmos ad=0.38p pd=2.38u as=0.38p ps=2.38u w=2u l=0.13u
X4 VSS.t6 vco_bias_0.vbg_buf VSS.t5 VSS.t4 sg13_lv_nmos ad=2.72p pd=16.68u as=0 ps=0 w=8u l=10u
X5 VSS.t113 vdd_core.t0 vdd_core.t1 VSS.t112 sg13_lv_nmos ad=0.38p pd=2.38u as=0.38p ps=2.38u w=2u l=0.13u
X6 a_11798_1860# vco_bias_0.vbn_buf VSS.t60 VSS.t61 sg13_lv_nmos ad=0.95p pd=5.38u as=0.95p ps=5.38u w=5u l=0.5u
X7 VSS.t26 vco_bias_0.vbn_buf VSS.t26 VSS.t11 sg13_lv_nmos ad=1.52p pd=8.38u as=0 ps=0 w=8u l=10u
X8 a_11798_1860# a_14668_3324# rf_out_p VSS.t92 sg13_lv_nmos ad=0.38p pd=2.38u as=0.38p ps=2.38u w=2u l=0.13u
X9 a_11798_1860# vco_bias_0.vbn_buf VSS.t34 VSS.t35 sg13_lv_nmos ad=0.95p pd=5.38u as=0.95p ps=5.38u w=5u l=0.5u
X10 VSS.t41 vco_bias_0.vbn_buf a_11798_1860# VSS.t43 sg13_lv_nmos ad=0.95p pd=5.38u as=0.95p ps=5.38u w=5u l=0.5u
X11 a_11798_1860# vco_bias_0.vbn_buf VSS.t34 VSS.t37 sg13_lv_nmos ad=0.95p pd=5.38u as=0.95p ps=5.38u w=5u l=0.5u
X12 vdd_core.t18 vdd_core.t0 VSS.t105 VSS.t109 sg13_lv_nmos ad=0.38p pd=2.38u as=0.38p ps=2.38u w=2u l=0.13u
X13 VSS.t41 vco_bias_0.vbn_buf a_11798_1860# VSS.t45 sg13_lv_nmos ad=0.95p pd=5.38u as=0.95p ps=5.38u w=5u l=0.5u
X14 vdd_core.t14 vdd_core.t0 VSS.t105 VSS.t104 sg13_lv_nmos ad=0.38p pd=2.38u as=0.68p ps=4.68u w=2u l=0.13u
X15 VSS.t120 vdd_core.t3 vdd_core.t8 VSS.t122 sg13_lv_nmos ad=0.38p pd=2.38u as=0.38p ps=2.38u w=2u l=0.13u
X16 a_11798_1860# vco_bias_0.vbn_buf VSS.t53 VSS.t54 sg13_lv_nmos ad=0.95p pd=5.38u as=0.95p ps=5.38u w=5u l=0.5u
X17 a_11798_1860# a_14668_3324# rf_out_p VSS.t98 sg13_lv_nmos ad=0.38p pd=2.38u as=0.38p ps=2.38u w=2u l=0.13u
X18 rf_out_p a_14668_3324# a_11798_1860# VSS.t95 sg13_lv_nmos ad=0.38p pd=2.38u as=0.38p ps=2.38u w=2u l=0.13u
X19 ibias_100u ibias_100u VSS.t1 VSS.t0 sg13_lv_nmos ad=0.85p pd=5.68u as=0.85p ps=5.68u w=2.5u l=0.5u
X20 vco_bias_0.vbn_buf a_1254_3500# VSS.t81 VSS.t80 sg13_lv_nmos ad=0.34p pd=2.68u as=0.34p ps=2.68u w=1u l=0.13u
X21 VSS.t105 vdd_core.t0 vdd_core.t14 VSS.t106 sg13_lv_nmos ad=0.38p pd=2.38u as=0.38p ps=2.38u w=2u l=0.13u
X22 a_11798_1860# a_9400_4880# rf_out_n VSS.t69 sg13_lv_nmos ad=0.38p pd=2.38u as=0.38p ps=2.38u w=2u l=0.13u
X23 VSS.t6 vco_bias_0.vbg_buf VSS.t6 VSS.t7 sg13_lv_nmos ad=1.52p pd=8.38u as=0 ps=0 w=8u l=10u
X24 VSS.t34 vco_bias_0.vbn_buf a_11798_1860# VSS.t38 sg13_lv_nmos ad=0.95p pd=5.38u as=0.95p ps=5.38u w=5u l=0.5u
X25 a_11798_1860# a_9400_4880# rf_out_n VSS.t79 sg13_lv_nmos ad=0.68p pd=4.68u as=0.38p ps=2.38u w=2u l=0.13u
X26 a_1474_1770# a_5428_3064# VSS.t87 rppd l=8.5u w=0.5u
X27 VSS.t53 vco_bias_0.vbn_buf a_11798_1860# VSS.t52 sg13_lv_nmos ad=0.95p pd=5.38u as=0.95p ps=5.38u w=5u l=0.5u
X28 a_11798_1860# vco_bias_0.vbn_buf VSS.t41 VSS.t46 sg13_lv_nmos ad=0.95p pd=5.38u as=0.95p ps=5.38u w=5u l=0.5u
X29 a_11798_1860# a_9400_4880# rf_out_n VSS.t75 sg13_lv_nmos ad=0.38p pd=2.38u as=0.38p ps=2.38u w=2u l=0.13u
X30 a_11798_1860# a_9400_4880# rf_out_n VSS.t71 sg13_lv_nmos ad=0.38p pd=2.38u as=0.38p ps=2.38u w=2u l=0.13u
X31 vco_bias_0.vbg_buf a_14668_3324# VSS.t89 rhigh l=8u w=0.5u
X32 vdd_core.t4 vdd_core.t3 VSS.t128 VSS.t129 sg13_lv_nmos ad=0.38p pd=2.38u as=0.38p ps=2.38u w=2u l=0.13u
X33 VSS.t22 vco_bias_0.vbn_buf VSS.t22 VSS.t23 sg13_lv_nmos ad=1.52p pd=8.38u as=0 ps=0 w=8u l=10u
X34 VSS.t26 vco_bias_0.vbn_buf VSS.t22 VSS.t25 sg13_lv_nmos ad=1.52p pd=8.38u as=0 ps=0 w=8u l=10u
X35 vdd_core.t2 vdd_core.t0 VSS.t113 VSS.t114 sg13_lv_nmos ad=0.38p pd=2.38u as=0.38p ps=2.38u w=2u l=0.13u
X36 rf_out_p a_14668_3324# a_11798_1860# VSS.t93 sg13_lv_nmos ad=0.38p pd=2.38u as=0.38p ps=2.38u w=2u l=0.13u
X37 a_1254_3500# di_en VSS.t103 VSS.t82 sg13_lv_nmos ad=0.17p pd=1.68u as=0.17p ps=1.68u w=0.5u l=0.13u
X38 VSS.t9 vco_bias_0.vbg_buf VSS.t9 VSS.t10 sg13_lv_nmos ad=1.52p pd=8.38u as=0 ps=0 w=8u l=10u
X39 a_11798_1860# vco_bias_0.vbn_buf VSS.t34 VSS.t39 sg13_lv_nmos ad=0.95p pd=5.38u as=0.95p ps=5.38u w=5u l=0.5u
X40 VSS.t48 vco_bias_0.vbn_buf a_11798_1860# VSS.t47 sg13_lv_nmos ad=0.95p pd=5.38u as=0.95p ps=5.38u w=5u l=0.5u
N41 vdd_core.t26 vtune sg13_hv_svaricap l=0.3u w=30.08u
X42 a_11798_1860# a_14668_3324# rf_out_p VSS.t102 sg13_lv_nmos ad=0.68p pd=4.68u as=0.38p ps=2.38u w=2u l=0.13u
X43 rf_out_p a_14668_3324# a_11798_1860# VSS.t99 sg13_lv_nmos ad=0.38p pd=2.38u as=0.38p ps=2.38u w=2u l=0.13u
X44 a_11798_1860# a_14668_3324# rf_out_p VSS.t96 sg13_lv_nmos ad=0.38p pd=2.38u as=0.38p ps=2.38u w=2u l=0.13u
X45 VSS.t105 vdd_core.t0 vdd_core.t18 VSS.t110 sg13_lv_nmos ad=0.38p pd=2.38u as=0.38p ps=2.38u w=2u l=0.13u
X46 VSS.t9 vco_bias_0.vbg_buf VSS.t6 VSS.t8 sg13_lv_nmos ad=1.52p pd=8.38u as=0 ps=0 w=8u l=10u
X47 vdd_core.t10 vdd_core.t3 VSS.t120 VSS.t123 sg13_lv_nmos ad=0.38p pd=2.38u as=0.38p ps=2.38u w=2u l=0.13u
X48 rf_out_n a_9400_4880# a_11798_1860# VSS.t70 sg13_lv_nmos ad=0.38p pd=2.38u as=0.38p ps=2.38u w=2u l=0.13u
X49 vdd_core.t7 vdd_core.t3 VSS.t118 VSS.t117 sg13_lv_nmos ad=0.38p pd=2.38u as=0.68p ps=4.68u w=2u l=0.13u
X50 a_1474_1770# a_2654_5520# VDD VDD sg13_lv_pmos ad=1.7p pd=10.68u as=1.7p ps=10.68u w=5u l=0.5u
N51 vdd_core.t22 vtune sg13_hv_svaricap l=0.3u w=30.08u
X52 VSS.t63 vco_bias_0.vbn_buf a_11798_1860# VSS.t62 sg13_lv_nmos ad=0.95p pd=5.38u as=0.95p ps=5.38u w=5u l=0.5u
X53 a_11798_1860# vco_bias_0.vbn_buf VSS.t53 VSS.t56 sg13_lv_nmos ad=0.95p pd=5.38u as=0.95p ps=5.38u w=5u l=0.5u
X54 a_11798_1860# vco_bias_0.vbn_buf VSS.t19 VSS.t18 sg13_lv_nmos ad=0.95p pd=5.38u as=1.7p ps=10.68u w=5u l=0.5u
X55 vdd_core.t16 vdd_core.t0 VSS.t105 VSS.t107 sg13_lv_nmos ad=0.38p pd=2.38u as=0.38p ps=2.38u w=2u l=0.13u
X56 VDD rf_out_n VSS.t85 rppd l=1.65u w=10u
X57 VSS.t22 vco_bias_0.vbn_buf VSS.t22 VSS.t7 sg13_lv_nmos ad=1.52p pd=8.38u as=0 ps=0 w=8u l=10u
X58 VSS.t120 vdd_core.t3 vdd_core.t7 VSS.t119 sg13_lv_nmos ad=0.38p pd=2.38u as=0.38p ps=2.38u w=2u l=0.13u
X59 VSS.t41 vco_bias_0.vbn_buf a_11798_1860# VSS.t40 sg13_lv_nmos ad=0.95p pd=5.38u as=0.95p ps=5.38u w=5u l=0.5u
X60 VSS.t26 vco_bias_0.vbn_buf VSS.t22 VSS.t10 sg13_lv_nmos ad=1.52p pd=8.38u as=0 ps=0 w=8u l=10u
X61 rf_out_n a_9400_4880# a_11798_1860# VSS.t76 sg13_lv_nmos ad=0.38p pd=2.38u as=0.38p ps=2.38u w=2u l=0.13u
X62 rf_out_n a_9400_4880# a_11798_1860# VSS.t72 sg13_lv_nmos ad=0.38p pd=2.38u as=0.38p ps=2.38u w=2u l=0.13u
X63 VSS.t22 vco_bias_0.vbn_buf VSS.t22 VSS.t24 sg13_lv_nmos ad=1.52p pd=8.38u as=0 ps=0 w=8u l=10u
X64 VSS.t12 vco_bias_0.vbg_buf VSS.t9 VSS.t11 sg13_lv_nmos ad=1.52p pd=8.38u as=0 ps=0 w=8u l=10u
X65 a_11798_1860# a_14668_3324# rf_out_p VSS.t94 sg13_lv_nmos ad=0.38p pd=2.38u as=0.38p ps=2.38u w=2u l=0.13u
X66 rf_out_p a_14668_3324# a_11798_1860# VSS.t91 sg13_lv_nmos ad=0.38p pd=2.38u as=0.68p ps=4.68u w=2u l=0.13u
X67 ibias_100u a_1254_3500# VSS.t84 VSS.t80 sg13_lv_nmos ad=0.34p pd=2.68u as=0.34p ps=2.68u w=1u l=0.13u
X68 VSS.t9 vco_bias_0.vbg_buf VSS.t9 VSS.t10 sg13_lv_nmos ad=1.52p pd=8.38u as=0 ps=0 w=8u l=10u
X69 VSS.t53 vco_bias_0.vbn_buf a_11798_1860# VSS.t55 sg13_lv_nmos ad=0.95p pd=5.38u as=0.95p ps=5.38u w=5u l=0.5u
X70 VSS.t34 vco_bias_0.vbn_buf a_11798_1860# VSS.t33 sg13_lv_nmos ad=0.95p pd=5.38u as=0.95p ps=5.38u w=5u l=0.5u
N71 vdd_core.t24 vtune sg13_hv_svaricap l=0.3u w=30.08u
X72 a_11798_1860# vco_bias_0.vbn_buf VSS.t63 VSS.t64 sg13_lv_nmos ad=0.95p pd=5.38u as=0.95p ps=5.38u w=5u l=0.5u
X73 a_2654_5520# a_1954_3500# VDD VDD sg13_lv_pmos ad=0.34p pd=2.68u as=0.34p ps=2.68u w=1u l=0.13u
X74 a_11798_1860# vco_bias_0.vbn_buf VSS.t63 VSS.t66 sg13_lv_nmos ad=0.95p pd=5.38u as=0.95p ps=5.38u w=5u l=0.5u
X75 VSS.t131 vdd_core.t3 vdd_core.t4 VSS.t130 sg13_lv_nmos ad=0.68p pd=4.68u as=0.38p ps=2.38u w=2u l=0.13u
X76 VSS.t116 vdd_core.t0 vdd_core.t2 VSS.t115 sg13_lv_nmos ad=0.68p pd=4.68u as=0.38p ps=2.38u w=2u l=0.13u
X77 a_1954_3500# a_1254_3500# VSS.t83 VSS.t82 sg13_lv_nmos ad=0.17p pd=1.68u as=0.17p ps=1.68u w=0.5u l=0.13u
X78 a_11798_1860# a_14668_3324# rf_out_p VSS.t100 sg13_lv_nmos ad=0.38p pd=2.38u as=0.38p ps=2.38u w=2u l=0.13u
X79 vco_bias_0.vbg_buf a_9400_4880# VSS.t86 rhigh l=8u w=0.5u
X80 VSS.t9 vco_bias_0.vbg_buf VSS.t6 VSS.t8 sg13_lv_nmos ad=1.52p pd=8.38u as=0 ps=0 w=8u l=10u
X81 a_1254_3500# di_en VDD VDD sg13_lv_pmos ad=0.34p pd=2.68u as=0.34p ps=2.68u w=1u l=0.13u
X82 VSS.t22 vco_bias_0.vbn_buf VSS.t22 VSS.t8 sg13_lv_nmos ad=1.52p pd=8.38u as=0 ps=0 w=8u l=10u
X83 a_11798_1860# vco_bias_0.vbn_buf VSS.t41 VSS.t42 sg13_lv_nmos ad=0.95p pd=5.38u as=0.95p ps=5.38u w=5u l=0.5u
X84 a_1474_1770# vco_bias_0.vbg_buf VSS.t88 rhigh l=32u w=0.5u
X85 a_5428_3064# a_5428_3064# VSS.t3 VSS.t0 sg13_lv_nmos ad=0.85p pd=5.68u as=0.85p ps=5.68u w=2.5u l=0.5u
X86 VSS.t48 vco_bias_0.vbn_buf a_11798_1860# VSS.t50 sg13_lv_nmos ad=0.95p pd=5.38u as=0.95p ps=5.38u w=5u l=0.5u
X87 VSS.t125 vdd_core.t3 vdd_core.t10 VSS.t124 sg13_lv_nmos ad=0.38p pd=2.38u as=0.38p ps=2.38u w=2u l=0.13u
X88 VSS.t63 vco_bias_0.vbn_buf a_11798_1860# VSS.t65 sg13_lv_nmos ad=0.95p pd=5.38u as=0.95p ps=5.38u w=5u l=0.5u
X89 a_11798_1860# a_9400_4880# rf_out_n VSS.t77 sg13_lv_nmos ad=0.38p pd=2.38u as=0.38p ps=2.38u w=2u l=0.13u
X90 a_11798_1860# a_9400_4880# rf_out_n VSS.t73 sg13_lv_nmos ad=0.38p pd=2.38u as=0.38p ps=2.38u w=2u l=0.13u
X91 VSS.t63 vco_bias_0.vbn_buf a_11798_1860# VSS.t67 sg13_lv_nmos ad=1.7p pd=10.68u as=0.95p ps=5.38u w=5u l=0.5u
X92 VSS.t22 vco_bias_0.vbn_buf VSS.t21 VSS.t20 sg13_lv_nmos ad=2.72p pd=16.68u as=0 ps=0 w=8u l=10u
X93 VSS.t6 vco_bias_0.vbg_buf VSS.t5 VSS.t4 sg13_lv_nmos ad=2.72p pd=16.68u as=0 ps=0 w=8u l=10u
X94 a_2654_5520# ibias_100u VSS.t2 VSS.t0 sg13_lv_nmos ad=0.85p pd=5.68u as=0.85p ps=5.68u w=2.5u l=0.5u
X95 VSS.t12 vco_bias_0.vbg_buf VSS.t9 VSS.t11 sg13_lv_nmos ad=1.52p pd=8.38u as=0 ps=0 w=8u l=10u
X96 VSS.t105 vdd_core.t0 vdd_core.t16 VSS.t108 sg13_lv_nmos ad=0.38p pd=2.38u as=0.38p ps=2.38u w=2u l=0.13u
X97 vdd_core.t5 vdd_core.t3 VSS.t125 VSS.t126 sg13_lv_nmos ad=0.38p pd=2.38u as=0.38p ps=2.38u w=2u l=0.13u
X98 ibias_100u vco_bias_0.vbn_buf VSS.t88 rhigh l=32u w=0.5u
X99 vdd_core.t1 vdd_core.t0 VSS.t105 VSS.t111 sg13_lv_nmos ad=0.38p pd=2.38u as=0.38p ps=2.38u w=2u l=0.13u
X100 vdd_core.t8 vdd_core.t3 VSS.t120 VSS.t121 sg13_lv_nmos ad=0.38p pd=2.38u as=0.38p ps=2.38u w=2u l=0.13u
N101 vdd_core.t23 vtune sg13_hv_svaricap l=0.3u w=30.08u
X102 a_11798_1860# vco_bias_0.vbn_buf VSS.t48 VSS.t49 sg13_lv_nmos ad=0.95p pd=5.38u as=0.95p ps=5.38u w=5u l=0.5u
X103 VSS.t26 vco_bias_0.vbn_buf VSS.t26 VSS.t27 sg13_lv_nmos ad=1.52p pd=8.38u as=0 ps=0 w=8u l=10u
X104 VSS.t53 vco_bias_0.vbn_buf a_11798_1860# VSS.t57 sg13_lv_nmos ad=0.95p pd=5.38u as=0.95p ps=5.38u w=5u l=0.5u
X105 a_11798_1860# vco_bias_0.vbn_buf VSS.t48 VSS.t51 sg13_lv_nmos ad=0.95p pd=5.38u as=0.95p ps=5.38u w=5u l=0.5u
X106 VSS.t60 vco_bias_0.vbn_buf a_11798_1860# VSS.t59 sg13_lv_nmos ad=0.95p pd=5.38u as=0.95p ps=5.38u w=5u l=0.5u
X107 rf_out_p a_14668_3324# a_11798_1860# VSS.t101 sg13_lv_nmos ad=0.38p pd=2.38u as=0.38p ps=2.38u w=2u l=0.13u
X108 a_2654_5520# a_2654_5520# VDD VDD sg13_lv_pmos ad=1.7p pd=10.68u as=1.7p ps=10.68u w=5u l=0.5u
X109 rf_out_p a_14668_3324# a_11798_1860# VSS.t97 sg13_lv_nmos ad=0.38p pd=2.38u as=0.38p ps=2.38u w=2u l=0.13u
N110 vdd_core.t25 vtune sg13_hv_svaricap l=0.3u w=30.08u
N111 vdd_core.t27 vtune sg13_hv_svaricap l=0.3u w=30.08u
X112 rf_out_n a_9400_4880# a_11798_1860# VSS.t68 sg13_lv_nmos ad=0.38p pd=2.38u as=0.68p ps=4.68u w=2u l=0.13u
X113 VSS.t22 vco_bias_0.vbn_buf VSS.t21 VSS.t4 sg13_lv_nmos ad=2.72p pd=16.68u as=0 ps=0 w=8u l=10u
X114 VSS.t34 vco_bias_0.vbn_buf a_11798_1860# VSS.t36 sg13_lv_nmos ad=0.95p pd=5.38u as=0.95p ps=5.38u w=5u l=0.5u
X115 VSS.t6 vco_bias_0.vbg_buf VSS.t6 VSS.t7 sg13_lv_nmos ad=1.52p pd=8.38u as=0 ps=0 w=8u l=10u
X116 a_11798_1860# vco_bias_0.vbn_buf VSS.t41 VSS.t44 sg13_lv_nmos ad=0.95p pd=5.38u as=0.95p ps=5.38u w=5u l=0.5u
X117 VDD rf_out_p VSS.t90 rppd l=1.65u w=10u
X118 a_1954_3500# a_1254_3500# VDD VDD sg13_lv_pmos ad=0.34p pd=2.68u as=0.34p ps=2.68u w=1u l=0.13u
R0 vdd_core.n107 vdd_core.t3 40.8971
R1 vdd_core.n122 vdd_core.t0 22.6771
R2 vdd_core.n81 vdd_core.n80 6.52948
R3 vdd_core.n43 vdd_core.n42 6.52948
R4 vdd_core.n96 vdd_core.n95 6.47038
R5 vdd_core.n156 vdd_core.n155 6.47038
R6 vdd_core.n217 vdd_core.n216 6.05177
R7 vdd_core.n194 vdd_core.n26 6.00132
R8 vdd_core.n102 vdd_core.t2 4.77599
R9 vdd_core.n104 vdd_core.t14 4.77599
R10 vdd_core.n117 vdd_core.t4 4.77599
R11 vdd_core.n118 vdd_core.t7 4.77599
R12 vdd_core.n102 vdd_core.t1 4.72949
R13 vdd_core.n103 vdd_core.t18 4.72949
R14 vdd_core.n104 vdd_core.t16 4.72949
R15 vdd_core.n117 vdd_core.t5 4.72949
R16 vdd_core.n119 vdd_core.t10 4.72949
R17 vdd_core.n118 vdd_core.t8 4.72949
R18 vdd_core.n100 vdd_core.t22 4.15353
R19 vdd_core.n115 vdd_core.t23 4.13448
R20 vdd_core.n137 vdd_core.n136 3.55422
R21 vdd_core.n100 vdd_core.t24 3.41873
R22 vdd_core.n101 vdd_core.t26 3.41873
R23 vdd_core.n115 vdd_core.t25 3.39968
R24 vdd_core.n116 vdd_core.t27 3.39968
R25 vdd_core.n141 vdd_core.n111 3.34302
R26 vdd_core.n130 vdd_core.n109 3.13182
R27 vdd_core vdd_core.n230 3.11017
R28 vdd_core.n128 vdd_core.n114 2.4579
R29 vdd_core.n135 vdd_core.n134 2.3523
R30 vdd_core.n139 vdd_core.n110 2.3523
R31 vdd_core.n142 vdd_core.n108 2.2467
R32 vdd_core.n132 vdd_core.n131 2.2467
R33 vdd_core.n9 vdd_core.n109 0.0886235
R34 vdd_core.n124 vdd_core.n123 1.94587
R35 vdd_core.n127 vdd_core.n126 1.79979
R36 vdd_core.n136 vdd_core.n129 1.72436
R37 vdd_core.n138 vdd_core.n137 1.72436
R38 vdd_core.n123 vdd_core.n122 1.66963
R39 vdd_core.n141 vdd_core.n140 1.64893
R40 vdd_core.n133 vdd_core.n111 1.64893
R41 vdd_core.n130 vdd_core.n10 0.134007
R42 vdd_core.n106 vdd_core.n105 1.5005
R43 vdd_core.n121 vdd_core.n120 1.5005
R44 vdd_core.n123 vdd_core.n112 1.44601
R45 vdd_core.n125 vdd_core.n113 1.16033
R46 vdd_core.n106 vdd_core.n101 0.8321
R47 vdd_core.n101 vdd_core.n100 0.7353
R48 vdd_core.n116 vdd_core.n115 0.7353
R49 vdd_core.n6 vdd_core.n3 0.56175
R50 vdd_core.n230 vdd_core.n229 0.5505
R51 vdd_core.n16 vdd_core.n11 0.5505
R52 vdd_core.n199 vdd_core.n198 0.5505
R53 vdd_core.n201 vdd_core.n200 0.5505
R54 vdd_core.n203 vdd_core.n202 0.5505
R55 vdd_core.n207 vdd_core.n163 0.5505
R56 vdd_core.n212 vdd_core.n211 0.5505
R57 vdd_core.n214 vdd_core.n213 0.5505
R58 vdd_core.n8 vdd_core.n6 0.227933
R59 vdd_core.n159 vdd_core.n6 0.5505
R60 vdd_core.n6 vdd_core.n1 0.5505
R61 vdd_core.n56 vdd_core.n6 0.5505
R62 vdd_core.n153 vdd_core.n6 0.5505
R63 vdd_core.n6 vdd_core.n2 0.5505
R64 vdd_core.n6 vdd_core.n0 0.5505
R65 vdd_core.n146 vdd_core.n6 0.5505
R66 vdd_core.n143 vdd_core.n6 0.5505
R67 vdd_core.n6 vdd_core.n4 0.5505
R68 vdd_core.n6 vdd_core.n5 0.480521
R69 vdd_core.n228 vdd_core.n13 0.446709
R70 vdd_core.n228 vdd_core.n227 0.445751
R71 vdd_core.n91 vdd_core.n78 0.4405
R72 vdd_core.n83 vdd_core.n82 0.4405
R73 vdd_core.n46 vdd_core.n40 0.4405
R74 vdd_core.n45 vdd_core.n44 0.4405
R75 vdd_core.n174 vdd_core.n172 0.4405
R76 vdd_core.n173 vdd_core.n165 0.4405
R77 vdd_core.n95 vdd_core.n78 0.4405
R78 vdd_core.n82 vdd_core.n81 0.4405
R79 vdd_core.n155 vdd_core.n40 0.4405
R80 vdd_core.n44 vdd_core.n43 0.4405
R81 vdd_core.n172 vdd_core.n171 0.4405
R82 vdd_core.n166 vdd_core.n165 0.4405
R83 vdd_core.n121 vdd_core.n116 0.43698
R84 vdd_core.n125 vdd_core.n124 0.421631
R85 vdd_core.n89 vdd_core.n88 0.3635
R86 vdd_core.n88 vdd_core.n75 0.3635
R87 vdd_core.n72 vdd_core.n70 0.3635
R88 vdd_core.n70 vdd_core.n68 0.3635
R89 vdd_core.n64 vdd_core.n62 0.3635
R90 vdd_core.n62 vdd_core.n60 0.3635
R91 vdd_core.n86 vdd_core.n85 0.3635
R92 vdd_core.n85 vdd_core.n74 0.3635
R93 vdd_core.n71 vdd_core.n69 0.3635
R94 vdd_core.n69 vdd_core.n67 0.3635
R95 vdd_core.n63 vdd_core.n61 0.3635
R96 vdd_core.n61 vdd_core.n59 0.3635
R97 vdd_core.n54 vdd_core.n50 0.3635
R98 vdd_core.n54 vdd_core.n53 0.3635
R99 vdd_core.n39 vdd_core.n33 0.3635
R100 vdd_core.n33 vdd_core.n31 0.3635
R101 vdd_core.n52 vdd_core.n49 0.3635
R102 vdd_core.n52 vdd_core.n51 0.3635
R103 vdd_core.n41 vdd_core.n32 0.3635
R104 vdd_core.n32 vdd_core.n30 0.3635
R105 vdd_core.n180 vdd_core.n178 0.3635
R106 vdd_core.n182 vdd_core.n180 0.3635
R107 vdd_core.n193 vdd_core.n192 0.3635
R108 vdd_core.n192 vdd_core.n191 0.3635
R109 vdd_core.n189 vdd_core.n188 0.3635
R110 vdd_core.n188 vdd_core.n187 0.3635
R111 vdd_core.n167 vdd_core.n166 0.3635
R112 vdd_core.n179 vdd_core.n177 0.3635
R113 vdd_core.n181 vdd_core.n179 0.3635
R114 vdd_core.n219 vdd_core.n218 0.3635
R115 vdd_core.n220 vdd_core.n219 0.3635
R116 vdd_core.n223 vdd_core.n222 0.3635
R117 vdd_core.n224 vdd_core.n223 0.3635
R118 vdd_core.n107 vdd_core.n106 0.3525
R119 vdd_core.n149 vdd_core.n59 0.345639
R120 vdd_core.n151 vdd_core.n150 0.299759
R121 vdd_core.n169 vdd_core.n26 0.276447
R122 vdd_core.n171 vdd_core.n170 0.276447
R123 vdd_core.n176 vdd_core.n174 0.276447
R124 vdd_core.n178 vdd_core.n176 0.276447
R125 vdd_core.n184 vdd_core.n182 0.276447
R126 vdd_core.n191 vdd_core.n190 0.276447
R127 vdd_core.n190 vdd_core.n189 0.276447
R128 vdd_core.n187 vdd_core.n186 0.276447
R129 vdd_core.n185 vdd_core.n13 0.276447
R130 vdd_core.n216 vdd_core.n25 0.276447
R131 vdd_core.n175 vdd_core.n173 0.276447
R132 vdd_core.n177 vdd_core.n175 0.276447
R133 vdd_core.n183 vdd_core.n181 0.276447
R134 vdd_core.n221 vdd_core.n220 0.276447
R135 vdd_core.n222 vdd_core.n221 0.276447
R136 vdd_core.n225 vdd_core.n224 0.276447
R137 vdd_core.n227 vdd_core.n226 0.276447
R138 vdd_core.n91 vdd_core.n90 0.276188
R139 vdd_core.n90 vdd_core.n89 0.276188
R140 vdd_core.n98 vdd_core.n75 0.276188
R141 vdd_core.n68 vdd_core.n66 0.276188
R142 vdd_core.n66 vdd_core.n64 0.276188
R143 vdd_core.n151 vdd_core.n60 0.276188
R144 vdd_core.n84 vdd_core.n83 0.276188
R145 vdd_core.n86 vdd_core.n84 0.276188
R146 vdd_core.n77 vdd_core.n74 0.276188
R147 vdd_core.n67 vdd_core.n65 0.276188
R148 vdd_core.n65 vdd_core.n63 0.276188
R149 vdd_core.n48 vdd_core.n46 0.276188
R150 vdd_core.n50 vdd_core.n48 0.276188
R151 vdd_core.n53 vdd_core.n36 0.276188
R152 vdd_core.n31 vdd_core.n29 0.276188
R153 vdd_core.n29 vdd_core.n7 0.328994
R154 vdd_core.n47 vdd_core.n45 0.276188
R155 vdd_core.n49 vdd_core.n47 0.276188
R156 vdd_core.n51 vdd_core.n35 0.276188
R157 vdd_core.n30 vdd_core.n28 0.276188
R158 vdd_core.n28 vdd_core.n8 0.30781
R159 vdd_core.n138 vdd_core.n112 0.264545
R160 vdd_core.n122 vdd_core.n121 0.2645
R161 vdd_core.n96 vdd_core.n72 0.2645
R162 vdd_core.n80 vdd_core.n71 0.2645
R163 vdd_core.n156 vdd_core.n39 0.2645
R164 vdd_core.n42 vdd_core.n41 0.2645
R165 vdd_core.n194 vdd_core.n193 0.2645
R166 vdd_core.n218 vdd_core.n217 0.2645
R167 vdd_core.n10 vdd_core.n132 0.449962
R168 vdd_core.n113 vdd_core.n112 0.249794
R169 vdd_core.n170 vdd_core.n169 0.199447
R170 vdd_core.n195 vdd_core.n184 0.199447
R171 vdd_core.n186 vdd_core.n185 0.199447
R172 vdd_core.n167 vdd_core.n25 0.199447
R173 vdd_core.n183 vdd_core.n24 0.199447
R174 vdd_core.n226 vdd_core.n225 0.199447
R175 vdd_core.n98 vdd_core.n97 0.199188
R176 vdd_core.n79 vdd_core.n77 0.199188
R177 vdd_core.n157 vdd_core.n36 0.199188
R178 vdd_core.n38 vdd_core.n35 0.199188
R179 vdd_core.n127 vdd_core.n124 0.195018
R180 vdd_core.n140 vdd_core.n108 0.1061
R181 vdd_core.n133 vdd_core.n132 0.1061
R182 vdd_core.n134 vdd_core.n129 0.1061
R183 vdd_core.n128 vdd_core.n127 0.1061
R184 vdd_core.n139 vdd_core.n138 0.1061
R185 vdd_core.n213 vdd_core.n6 0.1019
R186 vdd_core.n90 vdd_core.n3 0.101071
R187 vdd_core.n88 vdd_core.n76 0.101071
R188 vdd_core.n99 vdd_core.n98 0.101071
R189 vdd_core.n97 vdd_core.n73 0.101071
R190 vdd_core.n144 vdd_core.n70 0.101071
R191 vdd_core.n146 vdd_core.n66 0.101071
R192 vdd_core.n148 vdd_core.n62 0.101071
R193 vdd_core.n152 vdd_core.n151 0.101071
R194 vdd_core.n84 vdd_core.n3 0.101071
R195 vdd_core.n85 vdd_core.n76 0.101071
R196 vdd_core.n99 vdd_core.n77 0.101071
R197 vdd_core.n79 vdd_core.n73 0.101071
R198 vdd_core.n144 vdd_core.n69 0.101071
R199 vdd_core.n146 vdd_core.n65 0.101071
R200 vdd_core.n148 vdd_core.n61 0.101071
R201 vdd_core.n57 vdd_core.n48 0.101071
R202 vdd_core.n55 vdd_core.n54 0.101071
R203 vdd_core.n1 vdd_core.n36 0.101071
R204 vdd_core.n158 vdd_core.n157 0.101071
R205 vdd_core.n159 vdd_core.n33 0.101071
R206 vdd_core.n161 vdd_core.n29 0.101071
R207 vdd_core.n7 vdd_core.n6 0.329061
R208 vdd_core.n57 vdd_core.n47 0.101071
R209 vdd_core.n55 vdd_core.n52 0.101071
R210 vdd_core.n1 vdd_core.n35 0.101071
R211 vdd_core.n158 vdd_core.n38 0.101071
R212 vdd_core.n159 vdd_core.n32 0.101071
R213 vdd_core.n161 vdd_core.n28 0.101071
R214 vdd_core.n169 vdd_core.n27 0.101071
R215 vdd_core.n170 vdd_core.n168 0.101071
R216 vdd_core.n208 vdd_core.n176 0.101071
R217 vdd_core.n205 vdd_core.n180 0.101071
R218 vdd_core.n197 vdd_core.n184 0.101071
R219 vdd_core.n196 vdd_core.n195 0.101071
R220 vdd_core.n192 vdd_core.n22 0.101071
R221 vdd_core.n190 vdd_core.n20 0.101071
R222 vdd_core.n188 vdd_core.n18 0.101071
R223 vdd_core.n186 vdd_core.n15 0.101071
R224 vdd_core.n185 vdd_core.n14 0.101071
R225 vdd_core.n27 vdd_core.n25 0.101071
R226 vdd_core.n168 vdd_core.n167 0.101071
R227 vdd_core.n208 vdd_core.n175 0.101071
R228 vdd_core.n205 vdd_core.n179 0.101071
R229 vdd_core.n197 vdd_core.n183 0.101071
R230 vdd_core.n196 vdd_core.n24 0.101071
R231 vdd_core.n219 vdd_core.n22 0.101071
R232 vdd_core.n221 vdd_core.n20 0.101071
R233 vdd_core.n223 vdd_core.n18 0.101071
R234 vdd_core.n225 vdd_core.n15 0.101071
R235 vdd_core.n226 vdd_core.n14 0.101071
R236 vdd_core.n9 vdd_core.n10 0.872565
R237 vdd_core.n9 vdd_core.n108 0.433741
R238 vdd_core.n134 vdd_core.n133 0.0759286
R239 vdd_core.n129 vdd_core.n128 0.0759286
R240 vdd_core.n140 vdd_core.n139 0.0759286
R241 vdd_core.n94 vdd_core.n81 0.0759286
R242 vdd_core.n95 vdd_core.n94 0.0759286
R243 vdd_core.n0 vdd_core.n60 0.0759286
R244 vdd_core.n147 vdd_core.n64 0.0759286
R245 vdd_core.n145 vdd_core.n68 0.0759286
R246 vdd_core.n143 vdd_core.n72 0.0759286
R247 vdd_core.n4 vdd_core.n75 0.0759286
R248 vdd_core.n89 vdd_core.n87 0.0759286
R249 vdd_core.n92 vdd_core.n91 0.0759286
R250 vdd_core.n93 vdd_core.n78 0.0759286
R251 vdd_core.n0 vdd_core.n59 0.0759286
R252 vdd_core.n147 vdd_core.n63 0.0759286
R253 vdd_core.n145 vdd_core.n67 0.0759286
R254 vdd_core.n143 vdd_core.n71 0.0759286
R255 vdd_core.n4 vdd_core.n74 0.0759286
R256 vdd_core.n87 vdd_core.n86 0.0759286
R257 vdd_core.n93 vdd_core.n82 0.0759286
R258 vdd_core.n92 vdd_core.n83 0.0759286
R259 vdd_core.n154 vdd_core.n43 0.0759286
R260 vdd_core.n155 vdd_core.n154 0.0759286
R261 vdd_core.n162 vdd_core.n7 0.0141268
R262 vdd_core.n160 vdd_core.n31 0.0759286
R263 vdd_core.n39 vdd_core.n34 0.0759286
R264 vdd_core.n53 vdd_core.n37 0.0759286
R265 vdd_core.n56 vdd_core.n50 0.0759286
R266 vdd_core.n58 vdd_core.n46 0.0759286
R267 vdd_core.n153 vdd_core.n40 0.0759286
R268 vdd_core.n162 vdd_core.n8 0.0399629
R269 vdd_core.n160 vdd_core.n30 0.0759286
R270 vdd_core.n41 vdd_core.n34 0.0759286
R271 vdd_core.n51 vdd_core.n37 0.0759286
R272 vdd_core.n56 vdd_core.n49 0.0759286
R273 vdd_core.n153 vdd_core.n44 0.0759286
R274 vdd_core.n58 vdd_core.n45 0.0759286
R275 vdd_core.n216 vdd_core.n215 0.0759286
R276 vdd_core.n215 vdd_core.n26 0.0759286
R277 vdd_core.n13 vdd_core.n12 0.0759286
R278 vdd_core.n187 vdd_core.n17 0.0759286
R279 vdd_core.n189 vdd_core.n19 0.0759286
R280 vdd_core.n191 vdd_core.n21 0.0759286
R281 vdd_core.n193 vdd_core.n23 0.0759286
R282 vdd_core.n204 vdd_core.n182 0.0759286
R283 vdd_core.n206 vdd_core.n178 0.0759286
R284 vdd_core.n209 vdd_core.n174 0.0759286
R285 vdd_core.n210 vdd_core.n172 0.0759286
R286 vdd_core.n171 vdd_core.n164 0.0759286
R287 vdd_core.n227 vdd_core.n12 0.0759286
R288 vdd_core.n224 vdd_core.n17 0.0759286
R289 vdd_core.n222 vdd_core.n19 0.0759286
R290 vdd_core.n220 vdd_core.n21 0.0759286
R291 vdd_core.n218 vdd_core.n23 0.0759286
R292 vdd_core.n204 vdd_core.n181 0.0759286
R293 vdd_core.n206 vdd_core.n177 0.0759286
R294 vdd_core.n166 vdd_core.n164 0.0759286
R295 vdd_core.n210 vdd_core.n165 0.0759286
R296 vdd_core.n209 vdd_core.n173 0.0759286
R297 vdd_core.n154 vdd_core.n2 0.0738333
R298 vdd_core.n142 vdd_core.n109 0.0621
R299 vdd_core.n131 vdd_core.n130 0.0621
R300 vdd_core.n135 vdd_core.n111 0.0621
R301 vdd_core.n136 vdd_core.n114 0.0621
R302 vdd_core.n137 vdd_core.n113 0.0621
R303 vdd_core.n141 vdd_core.n110 0.0621
R304 vdd_core.n103 vdd_core.n102 0.0470078
R305 vdd_core.n119 vdd_core.n118 0.0470078
R306 vdd_core.n126 vdd_core.n125 0.0383489
R307 vdd_core.n162 vdd_core.n161 0.0371667
R308 vdd_core.n161 vdd_core.n160 0.0371667
R309 vdd_core.n160 vdd_core.n159 0.0371667
R310 vdd_core.n159 vdd_core.n34 0.0371667
R311 vdd_core.n158 vdd_core.n34 0.0371667
R312 vdd_core.n1 vdd_core.n158 0.0371667
R313 vdd_core.n1 vdd_core.n37 0.0371667
R314 vdd_core.n55 vdd_core.n37 0.0371667
R315 vdd_core.n56 vdd_core.n55 0.0371667
R316 vdd_core.n57 vdd_core.n56 0.0371667
R317 vdd_core.n58 vdd_core.n57 0.0371667
R318 vdd_core.n153 vdd_core.n58 0.0371667
R319 vdd_core.n154 vdd_core.n153 0.0371667
R320 vdd_core.n150 vdd_core.n2 0.0371667
R321 vdd_core.n0 vdd_core.n152 0.0371667
R322 vdd_core.n0 vdd_core.n148 0.0371667
R323 vdd_core.n148 vdd_core.n147 0.0371667
R324 vdd_core.n147 vdd_core.n146 0.0371667
R325 vdd_core.n146 vdd_core.n145 0.0371667
R326 vdd_core.n145 vdd_core.n144 0.0371667
R327 vdd_core.n144 vdd_core.n143 0.0371667
R328 vdd_core.n143 vdd_core.n73 0.0371667
R329 vdd_core.n99 vdd_core.n73 0.0371667
R330 vdd_core.n4 vdd_core.n99 0.0371667
R331 vdd_core.n4 vdd_core.n76 0.0371667
R332 vdd_core.n87 vdd_core.n76 0.0371667
R333 vdd_core.n87 vdd_core.n3 0.0371667
R334 vdd_core.n92 vdd_core.n3 0.0371667
R335 vdd_core.n93 vdd_core.n92 0.0371667
R336 vdd_core.n94 vdd_core.n93 0.0371667
R337 vdd_core.n14 vdd_core.n12 0.0371667
R338 vdd_core.n15 vdd_core.n14 0.0371667
R339 vdd_core.n18 vdd_core.n17 0.0371667
R340 vdd_core.n19 vdd_core.n18 0.0371667
R341 vdd_core.n21 vdd_core.n20 0.0371667
R342 vdd_core.n22 vdd_core.n21 0.0371667
R343 vdd_core.n196 vdd_core.n23 0.0371667
R344 vdd_core.n197 vdd_core.n196 0.0371667
R345 vdd_core.n205 vdd_core.n204 0.0371667
R346 vdd_core.n206 vdd_core.n205 0.0371667
R347 vdd_core.n209 vdd_core.n208 0.0371667
R348 vdd_core.n210 vdd_core.n209 0.0371667
R349 vdd_core.n168 vdd_core.n164 0.0371667
R350 vdd_core.n168 vdd_core.n27 0.0371667
R351 vdd_core.n105 vdd_core.n104 0.033329
R352 vdd_core.n120 vdd_core.n117 0.033329
R353 vdd_core.n142 vdd_core.n141 0.0319286
R354 vdd_core.n131 vdd_core.n111 0.0319286
R355 vdd_core.n136 vdd_core.n135 0.0319286
R356 vdd_core.n126 vdd_core.n114 0.0319286
R357 vdd_core.n137 vdd_core.n110 0.0319286
R358 vdd_core.n229 vdd_core.n12 0.028
R359 vdd_core.n17 vdd_core.n16 0.028
R360 vdd_core.n198 vdd_core.n20 0.028
R361 vdd_core.n200 vdd_core.n23 0.028
R362 vdd_core.n204 vdd_core.n203 0.028
R363 vdd_core.n208 vdd_core.n207 0.028
R364 vdd_core.n211 vdd_core.n164 0.028
R365 vdd_core.n215 vdd_core.n214 0.028
R366 vdd_core.n150 vdd_core.n149 0.0261384
R367 vdd_core.n230 vdd_core.n11 0.023
R368 vdd_core.n199 vdd_core.n11 0.023
R369 vdd_core.n201 vdd_core.n199 0.023
R370 vdd_core.n202 vdd_core.n201 0.023
R371 vdd_core.n202 vdd_core.n163 0.023
R372 vdd_core.n212 vdd_core.n163 0.023
R373 vdd_core.n213 vdd_core.n212 0.023
R374 vdd_core.n105 vdd_core.n103 0.0141788
R375 vdd_core.n120 vdd_core.n119 0.0141788
R376 vdd_core.n195 vdd_core.n194 0.0124467
R377 vdd_core.n217 vdd_core.n24 0.0124467
R378 vdd_core.n97 vdd_core.n96 0.0121878
R379 vdd_core.n80 vdd_core.n79 0.0121878
R380 vdd_core.n157 vdd_core.n156 0.0121878
R381 vdd_core.n42 vdd_core.n38 0.0121878
R382 vdd_core.n229 vdd_core.n228 0.0113759
R383 vdd_core.n16 vdd_core.n15 0.00966667
R384 vdd_core.n198 vdd_core.n19 0.00966667
R385 vdd_core.n200 vdd_core.n22 0.00966667
R386 vdd_core.n203 vdd_core.n197 0.00966667
R387 vdd_core.n207 vdd_core.n206 0.00966667
R388 vdd_core.n211 vdd_core.n210 0.00966667
R389 vdd_core.n214 vdd_core.n27 0.00966667
R390 vdd_core.n5 vdd_core.n142 1.45833
R391 vdd_core.n152 vdd_core.n149 0.00944821
R392 vdd_core.n107 vdd_core.n5 1.79724
R393 VSS.t97 VSS.t43 4127.1
R394 VSS.n6 VSS.n81 2432.04
R395 VSS.n447 VSS.n81 1880.72
R396 VSS.n440 VSS.t89 1316.73
R397 VSS.t82 VSS.n81 900.284
R398 VSS.t86 VSS.t87 804.431
R399 VSS.n233 VSS.n232 712.367
R400 VSS.n230 VSS.t85 552.61
R401 VSS.t87 VSS.t88 547.362
R402 VSS.t89 VSS.t90 374.546
R403 VSS.t85 VSS.n124 254.446
R404 VSS.n443 VSS.n442 251.589
R405 VSS.n230 VSS.t86 168.756
R406 VSS.n229 VSS.n222 141.554
R407 VSS.t90 VSS.n439 132.113
R408 VSS.t88 VSS.n229 71.2493
R409 VSS.t0 VSS.t80 70.7775
R410 VSS.n223 VSS.n222 47.1851
R411 VSS.n263 VSS.n262 40.7645
R412 VSS.n232 VSS.t11 37.202
R413 VSS.n10 VSS.t4 7.15726
R414 VSS.n5 VSS.n8 11.1786
R415 VSS.n122 VSS.t38 35.0371
R416 VSS.n448 VSS.n447 33.8949
R417 VSS.n126 VSS.t35 33.2884
R418 VSS.n223 VSS.t0 33.0298
R419 VSS.t36 VSS.n126 29.7909
R420 VSS.t18 VSS.n124 28.8551
R421 VSS.t37 VSS.n122 28.0421
R422 VSS.n125 VSS.t33 27.4296
R423 VSS.n128 VSS.t69 26.6691
R424 VSS.t71 VSS.n119 26.6691
R425 VSS.n130 VSS.t73 26.6691
R426 VSS.n9 VSS.t12 0.0012688
R427 VSS.t33 VSS.n123 23.9329
R428 VSS.t80 VSS.t82 23.5928
R429 VSS.t68 VSS.n121 22.6205
R430 VSS.t43 VSS.n131 22.5291
R431 VSS.n9 VSS.t10 11.5007
R432 VSS.t12 VSS.t7 11.5006
R433 VSS.n127 VSS.t37 20.4345
R434 VSS.n6 VSS.t8 39.0914
R435 VSS.n129 VSS.t42 20.1113
R436 VSS.t79 VSS.t46 19.8391
R437 VSS.t91 VSS.t52 19.8391
R438 VSS.t44 VSS.n116 19.5029
R439 VSS.t55 VSS.n140 19.5029
R440 VSS.t61 VSS.n103 19.3829
R441 VSS.n127 VSS.t36 18.6866
R442 VSS.t65 VSS.n436 18.4749
R443 VSS.n217 VSS.t49 18.1579
R444 VSS.n268 VSS.t50 18.1579
R445 VSS.t70 VSS.n119 17.9253
R446 VSS.n130 VSS.t72 17.9253
R447 VSS.n444 VSS.n443 17.0005
R448 VSS.n444 VSS.n82 17.0005
R449 VSS.n444 VSS.n90 17.0005
R450 VSS.n444 VSS.n84 17.0005
R451 VSS.n444 VSS.n88 17.0005
R452 VSS.n445 VSS.n444 17.0005
R453 VSS.n441 VSS.n440 17.0005
R454 VSS.n441 VSS.t131 17.0005
R455 VSS.n441 VSS.n92 17.0005
R456 VSS.n441 VSS.n99 17.0005
R457 VSS.n441 VSS.n94 17.0005
R458 VSS.n441 VSS.n97 17.0005
R459 VSS.n442 VSS.n441 17.0005
R460 VSS.n274 VSS.n142 17.0005
R461 VSS.n274 VSS.n106 17.0005
R462 VSS.n274 VSS.n141 17.0005
R463 VSS.n274 VSS.n212 17.0005
R464 VSS.n274 VSS.n273 17.0005
R465 VSS.n439 VSS.n438 17.0005
R466 VSS.n438 VSS.n104 17.0005
R467 VSS.n438 VSS.n142 17.0005
R468 VSS.n438 VSS.n106 17.0005
R469 VSS.n438 VSS.n141 17.0005
R470 VSS.n274 VSS.n108 17.0005
R471 VSS.n274 VSS.n140 17.0005
R472 VSS.n274 VSS.n213 17.0005
R473 VSS.n274 VSS.n272 17.0005
R474 VSS.n274 VSS.n109 17.0005
R475 VSS.n274 VSS.n271 17.0005
R476 VSS.n274 VSS.n214 17.0005
R477 VSS.n274 VSS.n138 17.0005
R478 VSS.n274 VSS.n215 17.0005
R479 VSS.n274 VSS.n270 17.0005
R480 VSS.n274 VSS.n216 17.0005
R481 VSS.n274 VSS.n268 17.0005
R482 VSS.n274 VSS.n217 17.0005
R483 VSS.n274 VSS.n267 17.0005
R484 VSS.n274 VSS.n219 17.0005
R485 VSS.n274 VSS.n266 17.0005
R486 VSS.n274 VSS.n114 17.0005
R487 VSS.n274 VSS.n265 17.0005
R488 VSS.n274 VSS.n220 17.0005
R489 VSS.n274 VSS.n133 17.0005
R490 VSS.n274 VSS.n221 17.0005
R491 VSS.n274 VSS.n264 17.0005
R492 VSS.n274 VSS.n116 17.0005
R493 VSS.n274 VSS.n131 17.0005
R494 VSS.n438 VSS.n108 17.0005
R495 VSS.n438 VSS.n140 17.0005
R496 VSS.n438 VSS.n109 17.0005
R497 VSS.n438 VSS.n138 17.0005
R498 VSS.n438 VSS.n111 17.0005
R499 VSS.n438 VSS.n136 17.0005
R500 VSS.n438 VSS.n114 17.0005
R501 VSS.n438 VSS.n133 17.0005
R502 VSS.n438 VSS.n116 17.0005
R503 VSS.n438 VSS.n131 17.0005
R504 VSS.n274 VSS.n233 17.0005
R505 VSS.n275 VSS.n274 17.0005
R506 VSS.n438 VSS.n117 17.0005
R507 VSS.n438 VSS.n130 17.0005
R508 VSS.n438 VSS.n118 17.0005
R509 VSS.n438 VSS.n129 17.0005
R510 VSS.n438 VSS.n119 17.0005
R511 VSS.n438 VSS.n128 17.0005
R512 VSS.n438 VSS.n124 17.0005
R513 VSS.n223 VSS.t103 17.0005
R514 VSS.t83 VSS.n223 17.0005
R515 VSS.t84 VSS.n222 17.0005
R516 VSS.t81 VSS.n222 17.0005
R517 VSS.t56 VSS.n108 16.8129
R518 VSS.t66 VSS.n101 16.7178
R519 VSS.n436 VSS.t64 16.659
R520 VSS.n103 VSS.t62 15.751
R521 VSS.t35 VSS.n123 15.1883
R522 VSS.n439 VSS.t67 14.9823
R523 VSS.n437 VSS.t66 14.901
R524 VSS.n128 VSS.t39 14.865
R525 VSS.n435 VSS.t102 14.2208
R526 VSS.t47 VSS.n219 14.1229
R527 VSS.n270 VSS.t51 14.1229
R528 VSS.t101 VSS.n104 13.8474
R529 VSS.t74 VSS.n116 13.7866
R530 VSS.t76 VSS.n133 13.7866
R531 VSS.t78 VSS.n114 13.7866
R532 VSS.t92 VSS.n138 13.7866
R533 VSS.t94 VSS.n109 13.7866
R534 VSS.n140 VSS.t96 13.7866
R535 VSS.n218 VSS.n135 13.6726
R536 VSS.n269 VSS.n112 13.6726
R537 VSS.t38 VSS.n121 13.4403
R538 VSS.t62 VSS.n102 13.0858
R539 VSS.t20 VSS.n2 3.97241
R540 VSS.n445 VSS.n0 90.9594
R541 VSS.n231 VSS.n230 12.6504
R542 VSS.t43 VSS.n263 12.4359
R543 VSS.n209 VSS.t99 12.2584
R544 VSS.t64 VSS.n102 12.1771
R545 VSS.t72 VSS.n118 11.8046
R546 VSS.n125 VSS.t18 11.6916
R547 VSS.n229 VSS.t1 11.3338
R548 VSS.n229 VSS.t2 11.3338
R549 VSS.n229 VSS.t3 11.3338
R550 VSS.t69 VSS.n120 10.9917
R551 VSS.n120 VSS.t40 10.5545
R552 VSS.t57 VSS.n106 10.4424
R553 VSS.t77 VSS.t45 10.4242
R554 VSS.t93 VSS.t54 10.4242
R555 VSS.n437 VSS.t65 10.3618
R556 VSS.t45 VSS.n133 10.0879
R557 VSS.t54 VSS.n109 10.0879
R558 VSS.n450 VSS.n449 9.75612
R559 VSS.n3 VSS.t23 4.68649
R560 VSS.t42 VSS.n118 9.61869
R561 VSS.n435 VSS.t61 9.4531
R562 VSS.n212 VSS.t98 9.3074
R563 VSS.n142 VSS.t100 9.3074
R564 VSS.t40 VSS.t70 9.1815
R565 VSS.n3 VSS.n1 0.0014883
R566 VSS.n131 VSS.t74 9.07918
R567 VSS.n221 VSS.t76 9.07918
R568 VSS.n265 VSS.t78 9.07918
R569 VSS.n214 VSS.t92 9.07918
R570 VSS.n272 VSS.t94 9.07918
R571 VSS.t96 VSS.n108 9.07918
R572 VSS.n10 VSS.t12 0.0101344
R573 VSS.t11 VSS.n231 8.87329
R574 VSS.n267 VSS.t47 8.74293
R575 VSS.t51 VSS.n111 8.74293
R576 VSS.n101 VSS.t67 8.54511
R577 VSS.n209 VSS.n57 2.42956
R578 VSS.n209 VSS.n58 3.40102
R579 VSS.n209 VSS.n60 3.40102
R580 VSS.n209 VSS.n62 1.88985
R581 VSS.n66 VSS.n65 0.00216799
R582 VSS.n65 VSS.n67 0.00172462
R583 VSS.n67 VSS.n68 0.00170812
R584 VSS.n68 VSS.n69 0.00166658
R585 VSS.n209 VSS.n71 2.83417
R586 VSS.n71 VSS.n70 0.00166658
R587 VSS.n70 VSS.n18 0.00149997
R588 VSS.n209 VSS.n73 2.83417
R589 VSS.n73 VSS.n72 0.00166658
R590 VSS.n72 VSS.n21 0.00149997
R591 VSS.n209 VSS.n74 3.40102
R592 VSS.n209 VSS.n76 8.501
R593 VSS.n262 VSS.n35 2.42956
R594 VSS.n262 VSS.n38 1.21462
R595 VSS.n38 VSS.n37 0.00173723
R596 VSS.n37 VSS.n39 0.00173273
R597 VSS.n39 VSS.n40 0.00172462
R598 VSS.n40 VSS.n41 0.00170812
R599 VSS.n41 VSS.n42 0.00166658
R600 VSS.n262 VSS.n43 4.251
R601 VSS.n262 VSS.n45 2.12569
R602 VSS.n45 VSS.n44 0.00170812
R603 VSS.n44 VSS.n46 0.00166658
R604 VSS.n262 VSS.n47 3.40102
R605 VSS.n262 VSS.n49 3.40102
R606 VSS.n262 VSS.n51 2.42956
R607 VSS.n262 VSS.n53 8.501
R608 VSS.n1 VSS.n7 2.21354
R609 VSS.n1 VSS.n4 1.31288
R610 VSS.n53 VSS.n237 8.5005
R611 VSS.n76 VSS.n187 8.5005
R612 VSS.n56 VSS.n55 8.48544
R613 VSS.n12 VSS.n11 3.35165
R614 VSS.n193 VSS.n59 8.48544
R615 VSS.n195 VSS.n61 8.48544
R616 VSS.n197 VSS.n63 8.48544
R617 VSS.n198 VSS.n64 8.48544
R618 VSS.n198 VSS.n14 0.219757
R619 VSS.n199 VSS.n65 8.48544
R620 VSS.n200 VSS.n67 8.48544
R621 VSS.n201 VSS.n68 8.48544
R622 VSS.n202 VSS.n69 8.48544
R623 VSS.n202 VSS.n16 0.188868
R624 VSS.n16 VSS.n15 4.21231
R625 VSS.n203 VSS.n70 8.48544
R626 VSS.n19 VSS.n18 3.35165
R627 VSS.n204 VSS.n190 8.48544
R628 VSS.n205 VSS.n72 8.48544
R629 VSS.n22 VSS.n21 3.35165
R630 VSS.n207 VSS.n75 8.48544
R631 VSS.n77 VSS.n208 3.6016
R632 VSS.n245 VSS.n36 8.48544
R633 VSS.n25 VSS.n24 3.35165
R634 VSS.n246 VSS.n243 8.48544
R635 VSS.n247 VSS.n37 8.48544
R636 VSS.n248 VSS.n39 8.48544
R637 VSS.n249 VSS.n40 8.48544
R638 VSS.n250 VSS.n41 8.48544
R639 VSS.n251 VSS.n42 8.48544
R640 VSS.n251 VSS.n27 0.188868
R641 VSS.n27 VSS.n26 4.21231
R642 VSS.n27 VSS.n29 0.251683
R643 VSS.n29 VSS.n28 4.21231
R644 VSS.n252 VSS.n44 8.48544
R645 VSS.n253 VSS.n46 8.48544
R646 VSS.n253 VSS.n31 0.219757
R647 VSS.n254 VSS.n48 8.48544
R648 VSS.n256 VSS.n50 8.48544
R649 VSS.n259 VSS.n52 8.48544
R650 VSS.n34 VSS.n33 3.35165
R651 VSS.n54 VSS.n261 3.6016
R652 VSS.n451 VSS.n450 8.10482
R653 VSS.n449 VSS.t21 7.76695
R654 VSS.t59 VSS.n104 7.71842
R655 VSS.t41 VSS.n78 7.56743
R656 VSS.t53 VSS.n434 7.56743
R657 VSS.t8 VSS.n8 6.97856
R658 VSS.n276 VSS.n85 6.97252
R659 VSS.n105 VSS.t101 6.89806
R660 VSS.n269 VSS.n111 6.83654
R661 VSS.n218 VSS.n136 6.83654
R662 VSS.n213 VSS.n139 6.83654
R663 VSS.n271 VSS.n110 6.83654
R664 VSS.n215 VSS.n137 6.83654
R665 VSS.n268 VSS.n113 6.83654
R666 VSS.n219 VSS.n134 6.83654
R667 VSS.n265 VSS.n115 6.83654
R668 VSS.n221 VSS.n132 6.83654
R669 VSS.n264 VSS.n132 6.83654
R670 VSS.n220 VSS.n115 6.83654
R671 VSS.n266 VSS.n134 6.83654
R672 VSS.n267 VSS.n135 6.83654
R673 VSS.n217 VSS.n113 6.83654
R674 VSS.n216 VSS.n112 6.83654
R675 VSS.n270 VSS.n137 6.83654
R676 VSS.n214 VSS.n110 6.83654
R677 VSS.n272 VSS.n139 6.83654
R678 VSS.n444 VSS.n91 6.83237
R679 VSS.n444 VSS.n83 6.83237
R680 VSS.n444 VSS.n89 6.83237
R681 VSS.n444 VSS.n86 6.83237
R682 VSS.n444 VSS.n87 6.83237
R683 VSS.n441 VSS.n100 6.83237
R684 VSS.n441 VSS.n93 6.83237
R685 VSS.n441 VSS.n98 6.83237
R686 VSS.n441 VSS.n95 6.83237
R687 VSS.n441 VSS.n96 6.83237
R688 VSS.n397 VSS.t128 6.7505
R689 VSS.n279 VSS.t120 6.7505
R690 VSS.n278 VSS.n182 6.7505
R691 VSS.n181 VSS.n180 6.7505
R692 VSS.n183 VSS.n277 6.7505
R693 VSS.n276 VSS.t113 6.7505
R694 VSS.t58 VSS.n105 6.67106
R695 VSS.n366 VSS.n365 6.61367
R696 VSS.n291 VSS.n178 6.51503
R697 VSS.n177 VSS.n168 6.5067
R698 VSS.n167 VSS.n158 6.5067
R699 VSS.n399 VSS.n398 6.34066
R700 VSS.n445 VSS.t104 6.22913
R701 VSS.n88 VSS.t106 6.22913
R702 VSS.n88 VSS.t107 6.22913
R703 VSS.t108 VSS.n84 6.22913
R704 VSS.t109 VSS.n84 6.22913
R705 VSS.n90 VSS.t110 6.22913
R706 VSS.n90 VSS.t111 6.22913
R707 VSS.t114 VSS.n82 6.22913
R708 VSS.n443 VSS.t115 6.22913
R709 VSS.n442 VSS.t117 6.22913
R710 VSS.n97 VSS.t119 6.22913
R711 VSS.t122 VSS.n94 6.22913
R712 VSS.t123 VSS.n94 6.22913
R713 VSS.n99 VSS.t124 6.22913
R714 VSS.n99 VSS.t126 6.22913
R715 VSS.t127 VSS.n92 6.22913
R716 VSS.t129 VSS.n92 6.22913
R717 VSS.n440 VSS.t130 6.22913
R718 VSS.t98 VSS.n141 6.12943
R719 VSS.n345 VSS.n344 6.09818
R720 VSS.n157 VSS.n145 6.04071
R721 VSS.n438 VSS.n436 5.84696
R722 VSS.n438 VSS.n103 5.84696
R723 VSS.n438 VSS.n105 5.84696
R724 VSS.n438 VSS.n107 5.84696
R725 VSS.n77 VSS.n76 0.00140582
R726 VSS.n54 VSS.n53 0.00140582
R727 VSS.t97 VSS.t56 5.71671
R728 VSS.t27 VSS.n0 3.97303
R729 VSS.n1 VSS.n2 0.00130465
R730 VSS.n210 VSS.n57 8.48744
R731 VSS.n60 VSS.n192 0.00229996
R732 VSS.n62 VSS.n191 0.00261099
R733 VSS.n209 VSS.n66 1.30786
R734 VSS.n209 VSS.n17 5.66778
R735 VSS.n209 VSS.n20 5.66778
R736 VSS.n74 VSS.n189 0.00229996
R737 VSS.n209 VSS.n186 5.66778
R738 VSS.n35 VSS.n244 8.48744
R739 VSS.n262 VSS.n23 5.66778
R740 VSS.n47 VSS.n30 0.00229996
R741 VSS.n49 VSS.n242 0.00229996
R742 VSS.n262 VSS.n234 5.66778
R743 VSS.n51 VSS.n240 0.00249991
R744 VSS.n262 VSS.n32 5.66778
R745 VSS.n262 VSS.n235 5.66778
R746 VSS.n262 VSS.n236 5.66778
R747 VSS.n184 VSS.n4 0.608774
R748 VSS.n444 VSS.t116 5.65086
R749 VSS.n441 VSS.t118 5.65086
R750 VSS.n194 VSS.n192 5.64018
R751 VSS.n196 VSS.n191 5.64018
R752 VSS.n14 VSS.n13 3.35165
R753 VSS.n206 VSS.n189 5.64018
R754 VSS.n208 VSS.n188 5.64018
R755 VSS.n31 VSS.n30 3.35165
R756 VSS.n255 VSS.n242 5.64018
R757 VSS.n257 VSS.n241 5.64018
R758 VSS.n258 VSS.n240 5.64018
R759 VSS.n260 VSS.n239 5.64018
R760 VSS.n261 VSS.n238 5.64018
R761 VSS.n5 VSS.t24 13.2404
R762 VSS.n87 VSS.t104 5.41447
R763 VSS.t106 VSS.n87 5.41447
R764 VSS.t107 VSS.n86 5.41447
R765 VSS.n86 VSS.t108 5.41447
R766 VSS.n89 VSS.t109 5.41447
R767 VSS.t110 VSS.n89 5.41447
R768 VSS.t111 VSS.n83 5.41447
R769 VSS.t112 VSS.n83 5.41447
R770 VSS.n91 VSS.t114 5.41447
R771 VSS.t115 VSS.n91 5.41447
R772 VSS.n96 VSS.t117 5.41447
R773 VSS.t119 VSS.n96 5.41447
R774 VSS.t121 VSS.n95 5.41447
R775 VSS.n95 VSS.t122 5.41447
R776 VSS.n98 VSS.t123 5.41447
R777 VSS.t124 VSS.n98 5.41447
R778 VSS.t126 VSS.n93 5.41447
R779 VSS.n93 VSS.t127 5.41447
R780 VSS.n100 VSS.t129 5.41447
R781 VSS.t130 VSS.n100 5.41447
R782 VSS.n273 VSS.n107 5.30908
R783 VSS.n212 VSS.n107 5.30908
R784 VSS.n274 VSS.n269 5.08323
R785 VSS.n274 VSS.n218 5.08323
R786 VSS.n438 VSS.n139 5.08323
R787 VSS.n438 VSS.n110 5.08323
R788 VSS.n438 VSS.n137 5.08323
R789 VSS.n438 VSS.n112 5.08323
R790 VSS.n438 VSS.n113 5.08323
R791 VSS.n438 VSS.n135 5.08323
R792 VSS.n438 VSS.n134 5.08323
R793 VSS.n438 VSS.n115 5.08323
R794 VSS.n438 VSS.n132 5.08323
R795 VSS.n141 VSS.t57 4.99445
R796 VSS.t100 VSS.t58 4.76745
R797 VSS.t49 VSS.n136 4.70796
R798 VSS.t50 VSS.n216 4.70796
R799 VSS.n449 VSS.t5 4.67815
R800 VSS.n438 VSS.n120 4.53583
R801 VSS.n438 VSS.n122 4.53583
R802 VSS.n438 VSS.n126 4.53583
R803 VSS.n80 VSS.n448 4.25146
R804 VSS.n2 VSS.n446 4.25175
R805 VSS.n237 VSS.t112 4.15292
R806 VSS.n187 VSS.t121 4.15292
R807 VSS.n432 VSS.n431 3.93263
R808 VSS.n85 VSS.n184 3.89324
R809 VSS.n85 VSS.n275 3.88607
R810 VSS.n262 VSS.n233 3.3055
R811 VSS.t39 VSS.t68 3.06083
R812 VSS.n129 VSS.t71 3.06083
R813 VSS.t73 VSS.n117 3.06083
R814 VSS.n4 VSS.t25 5.03583
R815 VSS.n264 VSS.t75 2.35423
R816 VSS.n220 VSS.t77 2.35423
R817 VSS.n266 VSS.t79 2.35423
R818 VSS.n215 VSS.t91 2.35423
R819 VSS.n271 VSS.t93 2.35423
R820 VSS.n213 VSS.t95 2.35423
R821 VSS.n438 VSS.n101 2.28106
R822 VSS.n438 VSS.n437 2.28106
R823 VSS.n438 VSS.n102 2.28106
R824 VSS.n438 VSS.n435 2.28106
R825 VSS.n237 VSS.n82 2.07671
R826 VSS.n187 VSS.n97 2.07671
R827 VSS.n7 VSS.t25 6.12732
R828 VSS.n184 VSS.n7 2.32394
R829 VSS.t99 VSS.n106 1.58948
R830 VSS.n209 VSS.n142 1.58948
R831 VSS.t102 VSS.t59 1.58948
R832 VSS.n441 VSS.t125 1.34379
R833 VSS.n419 VSS.n418 1.30527
R834 VSS.n438 VSS.n121 1.30348
R835 VSS.n438 VSS.n127 1.30348
R836 VSS.n438 VSS.n123 1.30348
R837 VSS.n438 VSS.n125 1.30348
R838 VSS.n444 VSS.t105 1.22907
R839 VSS.t75 VSS.t44 1.00924
R840 VSS.t95 VSS.t55 1.00924
R841 VSS.n211 VSS.n210 0.943138
R842 VSS.n211 VSS.n185 0.882565
R843 VSS.n409 VSS.n408 0.812182
R844 VSS.n438 VSS.t34 0.751614
R845 VSS.n438 VSS.t60 0.751406
R846 VSS.t46 VSS.n114 0.672995
R847 VSS.t52 VSS.n138 0.672995
R848 VSS.n451 VSS.n78 0.5531
R849 VSS.t3 VSS.n228 0.513002
R850 VSS.n224 VSS.t83 0.479883
R851 VSS.t103 VSS.n79 0.479883
R852 VSS.n330 VSS.n314 0.4405
R853 VSS.n170 VSS.n169 0.4405
R854 VSS.n160 VSS.n159 0.4405
R855 VSS.n150 VSS.n149 0.4405
R856 VSS.n290 VSS.n289 0.4405
R857 VSS.n314 VSS.n313 0.4405
R858 VSS.n169 VSS.n168 0.4405
R859 VSS.n159 VSS.n158 0.4405
R860 VSS.n149 VSS.n148 0.4405
R861 VSS.n291 VSS.n290 0.4405
R862 VSS.t43 VSS.n117 0.43769
R863 VSS.n355 VSS.n354 0.424088
R864 VSS.n294 VSS.n292 0.422335
R865 VSS.n446 VSS.t22 0.419324
R866 VSS.n5 VSS.n1 0.287903
R867 VSS.t6 VSS.n80 0.416438
R868 VSS.n228 VSS.t81 0.411981
R869 VSS.n225 VSS.t84 0.411981
R870 VSS.n438 VSS.t48 0.380624
R871 VSS.n226 VSS.n225 0.370375
R872 VSS.n225 VSS.n224 0.370375
R873 VSS.n224 VSS.n79 0.370375
R874 VSS.n85 VSS.t105 0.36789
R875 VSS.n302 VSS.n301 0.367167
R876 VSS.n317 VSS.n316 0.367167
R877 VSS.n319 VSS.n318 0.367167
R878 VSS.n324 VSS.n320 0.367167
R879 VSS.n335 VSS.n334 0.367167
R880 VSS.n337 VSS.n336 0.367167
R881 VSS.n341 VSS.n143 0.367167
R882 VSS.n433 VSS.n432 0.367167
R883 VSS.n329 VSS.n328 0.3635
R884 VSS.n328 VSS.n327 0.3635
R885 VSS.n347 VSS.n346 0.3635
R886 VSS.n348 VSS.n347 0.3635
R887 VSS.n351 VSS.n350 0.3635
R888 VSS.n352 VSS.n351 0.3635
R889 VSS.n174 VSS.n173 0.3635
R890 VSS.n173 VSS.n172 0.3635
R891 VSS.n164 VSS.n163 0.3635
R892 VSS.n163 VSS.n162 0.3635
R893 VSS.n154 VSS.n153 0.3635
R894 VSS.n153 VSS.n152 0.3635
R895 VSS.n286 VSS.n285 0.3635
R896 VSS.n287 VSS.n286 0.3635
R897 VSS.n299 VSS.n298 0.3635
R898 VSS.n361 VSS.n358 0.3635
R899 VSS.n359 VSS.n358 0.3635
R900 VSS.n298 VSS.n297 0.3635
R901 VSS.n295 VSS.n294 0.3635
R902 VSS.n366 VSS.n360 0.338523
R903 VSS.n181 VSS.n183 0.337235
R904 VSS.n182 VSS.n181 0.337235
R905 VSS.n274 VSS.n263 0.334254
R906 VSS.n228 VSS.n227 0.3195
R907 VSS.n227 VSS.n226 0.3195
R908 VSS.n419 VSS.n157 0.31812
R909 VSS.n399 VSS.n177 0.31812
R910 VSS.n409 VSS.n167 0.31812
R911 VSS.n398 VSS.n178 0.31812
R912 VSS.t41 VSS.t48 0.288377
R913 VSS.n393 VSS.n392 0.288357
R914 VSS.t48 VSS.t53 0.287524
R915 VSS.n182 VSS.t118 0.281071
R916 VSS.n183 VSS.t116 0.280736
R917 VSS.n344 VSS.n343 0.276447
R918 VSS.n313 VSS.n312 0.276447
R919 VSS.n331 VSS.n330 0.276447
R920 VSS.n331 VSS.n329 0.276447
R921 VSS.n327 VSS.n326 0.276447
R922 VSS.n349 VSS.n348 0.276447
R923 VSS.n350 VSS.n349 0.276447
R924 VSS.n353 VSS.n352 0.276447
R925 VSS.n155 VSS.n154 0.276447
R926 VSS.n152 VSS.n151 0.276447
R927 VSS.n151 VSS.n150 0.276447
R928 VSS.n148 VSS.n147 0.276447
R929 VSS.n146 VSS.n145 0.276447
R930 VSS.n175 VSS.n174 0.276188
R931 VSS.n172 VSS.n171 0.276188
R932 VSS.n171 VSS.n170 0.276188
R933 VSS.n165 VSS.n164 0.276188
R934 VSS.n162 VSS.n161 0.276188
R935 VSS.n161 VSS.n160 0.276188
R936 VSS.n285 VSS.n280 0.276188
R937 VSS.n288 VSS.n287 0.276188
R938 VSS.n289 VSS.n288 0.276188
R939 VSS.n363 VSS.n361 0.276188
R940 VSS.n360 VSS.n359 0.276188
R941 VSS.n297 VSS.n296 0.276188
R942 VSS.n296 VSS.n295 0.276188
R943 VSS.n367 VSS.n356 0.2755
R944 VSS.n372 VSS.n371 0.2755
R945 VSS.n374 VSS.n373 0.2755
R946 VSS.n378 VSS.n293 0.2755
R947 VSS.n383 VSS.n382 0.2755
R948 VSS.n385 VSS.n384 0.2755
R949 VSS.n387 VSS.n282 0.2755
R950 VSS.n392 VSS.n391 0.2755
R951 VSS.n354 VSS.n353 0.271823
R952 VSS.n346 VSS.n345 0.2645
R953 VSS.n365 VSS.n299 0.2645
R954 VSS.n450 VSS.n79 0.248
R955 VSS.t105 VSS.t113 0.24686
R956 VSS.t120 VSS.t125 0.229011
R957 VSS.n273 VSS.t97 0.227498
R958 VSS.n274 VSS.n211 0.22697
R959 VSS.t128 VSS.t125 0.219636
R960 VSS.n434 VSS.n433 0.21125
R961 VSS.t6 VSS.t9 0.208963
R962 VSS.n343 VSS.n312 0.199447
R963 VSS.n326 VSS.n311 0.199447
R964 VSS.n156 VSS.n155 0.199447
R965 VSS.n147 VSS.n146 0.199447
R966 VSS.n176 VSS.n175 0.199188
R967 VSS.n166 VSS.n165 0.199188
R968 VSS.n280 VSS.n179 0.199188
R969 VSS.n364 VSS.n363 0.199188
R970 VSS.t60 VSS.t53 0.190334
R971 VSS.t34 VSS.t41 0.18941
R972 VSS.n258 VSS.n257 0.189041
R973 VSS.n260 VSS.n34 0.251491
R974 VSS.n261 VSS.n260 0.189041
R975 VSS.n206 VSS.n22 0.251491
R976 VSS.n356 VSS.n355 0.165999
R977 VSS.n395 VSS.n279 0.161968
R978 VSS.n246 VSS.n25 0.220165
R979 VSS.n254 VSS.n31 0.220165
R980 VSS.n256 VSS.n255 0.157715
R981 VSS.n259 VSS.n258 0.157715
R982 VSS.n193 VSS.n12 0.220165
R983 VSS.n195 VSS.n194 0.157715
R984 VSS.n197 VSS.n196 0.157715
R985 VSS.n199 VSS.n14 0.220165
R986 VSS.n204 VSS.n19 0.220165
R987 VSS.n207 VSS.n206 0.157715
R988 VSS.n25 VSS.n245 0.219757
R989 VSS.n255 VSS.n254 0.157378
R990 VSS.n257 VSS.n256 0.157378
R991 VSS.n34 VSS.n259 0.219757
R992 VSS.n12 VSS.n55 0.219757
R993 VSS.n194 VSS.n193 0.157378
R994 VSS.n196 VSS.n195 0.157378
R995 VSS.n19 VSS.n203 0.219757
R996 VSS.n22 VSS.n205 0.219757
R997 VSS.n208 VSS.n207 0.157378
R998 VSS.t22 VSS.t26 0.156231
R999 VSS.n244 VSS.n185 0.14486
R1000 VSS.n227 VSS.t2 0.143127
R1001 VSS.n226 VSS.t1 0.143127
R1002 VSS.t60 VSS.t63 0.138758
R1003 VSS.t19 VSS.t34 0.138503
R1004 VSS.n245 VSS.n244 0.126053
R1005 VSS.n247 VSS.n246 0.126053
R1006 VSS.n248 VSS.n247 0.126053
R1007 VSS.n249 VSS.n248 0.126053
R1008 VSS.n250 VSS.n249 0.126053
R1009 VSS.n251 VSS.n250 0.126053
R1010 VSS.n252 VSS.n29 0.188868
R1011 VSS.n253 VSS.n252 0.126053
R1012 VSS.n210 VSS.n55 0.126053
R1013 VSS.n198 VSS.n197 0.126053
R1014 VSS.n200 VSS.n199 0.126053
R1015 VSS.n201 VSS.n200 0.126053
R1016 VSS.n202 VSS.n201 0.126053
R1017 VSS.n203 VSS.n16 0.188868
R1018 VSS.n205 VSS.n204 0.126053
R1019 VSS.n277 VSS.n276 0.121601
R1020 VSS.n277 VSS.n180 0.121601
R1021 VSS.n278 VSS.n180 0.121601
R1022 VSS.n279 VSS.n278 0.121601
R1023 VSS.n434 VSS.n78 0.1076
R1024 VSS.n400 VSS.n399 0.102006
R1025 VSS.n410 VSS.n409 0.102006
R1026 VSS.n420 VSS.n419 0.102006
R1027 VSS.n343 VSS.n342 0.101071
R1028 VSS.n340 VSS.n312 0.101071
R1029 VSS.n332 VSS.n331 0.101071
R1030 VSS.n328 VSS.n321 0.101071
R1031 VSS.n326 VSS.n325 0.101071
R1032 VSS.n323 VSS.n311 0.101071
R1033 VSS.n347 VSS.n309 0.101071
R1034 VSS.n349 VSS.n307 0.101071
R1035 VSS.n351 VSS.n305 0.101071
R1036 VSS.n353 VSS.n303 0.101071
R1037 VSS.n400 VSS.n176 0.101071
R1038 VSS.n401 VSS.n175 0.101071
R1039 VSS.n403 VSS.n173 0.101071
R1040 VSS.n405 VSS.n171 0.101071
R1041 VSS.n410 VSS.n166 0.101071
R1042 VSS.n411 VSS.n165 0.101071
R1043 VSS.n413 VSS.n163 0.101071
R1044 VSS.n415 VSS.n161 0.101071
R1045 VSS.n420 VSS.n156 0.101071
R1046 VSS.n421 VSS.n155 0.101071
R1047 VSS.n423 VSS.n153 0.101071
R1048 VSS.n425 VSS.n151 0.101071
R1049 VSS.n429 VSS.n147 0.101071
R1050 VSS.n430 VSS.n146 0.101071
R1051 VSS.n396 VSS.n179 0.101071
R1052 VSS.n394 VSS.n280 0.101071
R1053 VSS.n286 VSS.n284 0.101071
R1054 VSS.n390 VSS.n288 0.101071
R1055 VSS.n364 VSS.n300 0.101071
R1056 VSS.n363 VSS.n362 0.101071
R1057 VSS.n370 VSS.n358 0.101071
R1058 VSS.n368 VSS.n360 0.101071
R1059 VSS.n376 VSS.n298 0.101071
R1060 VSS.n379 VSS.n296 0.101071
R1061 VSS.n381 VSS.n294 0.101071
R1062 VSS.n431 VSS.n430 0.0885
R1063 VSS.n430 VSS.n429 0.0885
R1064 VSS.n429 VSS.n428 0.0885
R1065 VSS.n428 VSS.n427 0.0885
R1066 VSS.n427 VSS.n426 0.0885
R1067 VSS.n426 VSS.n425 0.0885
R1068 VSS.n425 VSS.n424 0.0885
R1069 VSS.n424 VSS.n423 0.0885
R1070 VSS.n423 VSS.n422 0.0885
R1071 VSS.n422 VSS.n421 0.0885
R1072 VSS.n421 VSS.n420 0.0885
R1073 VSS.n418 VSS.n417 0.0885
R1074 VSS.n417 VSS.n416 0.0885
R1075 VSS.n416 VSS.n415 0.0885
R1076 VSS.n415 VSS.n414 0.0885
R1077 VSS.n414 VSS.n413 0.0885
R1078 VSS.n413 VSS.n412 0.0885
R1079 VSS.n412 VSS.n411 0.0885
R1080 VSS.n411 VSS.n410 0.0885
R1081 VSS.n408 VSS.n407 0.0885
R1082 VSS.n407 VSS.n406 0.0885
R1083 VSS.n406 VSS.n405 0.0885
R1084 VSS.n405 VSS.n404 0.0885
R1085 VSS.n404 VSS.n403 0.0885
R1086 VSS.n403 VSS.n402 0.0885
R1087 VSS.n402 VSS.n401 0.0885
R1088 VSS.n401 VSS.n400 0.0885
R1089 VSS.n344 VSS.n144 0.0759286
R1090 VSS.n352 VSS.n304 0.0759286
R1091 VSS.n350 VSS.n306 0.0759286
R1092 VSS.n348 VSS.n308 0.0759286
R1093 VSS.n346 VSS.n310 0.0759286
R1094 VSS.n327 VSS.n322 0.0759286
R1095 VSS.n333 VSS.n329 0.0759286
R1096 VSS.n330 VSS.n315 0.0759286
R1097 VSS.n338 VSS.n314 0.0759286
R1098 VSS.n339 VSS.n313 0.0759286
R1099 VSS.n408 VSS.n168 0.0759286
R1100 VSS.n407 VSS.n169 0.0759286
R1101 VSS.n406 VSS.n170 0.0759286
R1102 VSS.n404 VSS.n172 0.0759286
R1103 VSS.n402 VSS.n174 0.0759286
R1104 VSS.n418 VSS.n158 0.0759286
R1105 VSS.n417 VSS.n159 0.0759286
R1106 VSS.n416 VSS.n160 0.0759286
R1107 VSS.n414 VSS.n162 0.0759286
R1108 VSS.n412 VSS.n164 0.0759286
R1109 VSS.n431 VSS.n145 0.0759286
R1110 VSS.n428 VSS.n148 0.0759286
R1111 VSS.n427 VSS.n149 0.0759286
R1112 VSS.n426 VSS.n150 0.0759286
R1113 VSS.n424 VSS.n152 0.0759286
R1114 VSS.n422 VSS.n154 0.0759286
R1115 VSS.n389 VSS.n289 0.0759286
R1116 VSS.n388 VSS.n290 0.0759286
R1117 VSS.n386 VSS.n291 0.0759286
R1118 VSS.n287 VSS.n283 0.0759286
R1119 VSS.n285 VSS.n281 0.0759286
R1120 VSS.n369 VSS.n359 0.0759286
R1121 VSS.n361 VSS.n357 0.0759286
R1122 VSS.n380 VSS.n295 0.0759286
R1123 VSS.n377 VSS.n297 0.0759286
R1124 VSS.n375 VSS.n299 0.0759286
R1125 VSS.t113 VSS.t116 0.058826
R1126 VSS.t120 VSS.t118 0.0584906
R1127 VSS.n386 VSS.n385 0.0528809
R1128 VSS.n432 VSS.n144 0.0518333
R1129 VSS.n447 VSS.n10 12.1692
R1130 VSS.n385 VSS.n292 0.0473412
R1131 VSS.n398 VSS.n397 0.046273
R1132 VSS VSS.n451 0.03605
R1133 VSS.n354 VSS.n302 0.0302645
R1134 VSS.n342 VSS.n144 0.0298333
R1135 VSS.n340 VSS.n339 0.0298333
R1136 VSS.n339 VSS.n338 0.0298333
R1137 VSS.n332 VSS.n315 0.0298333
R1138 VSS.n333 VSS.n332 0.0298333
R1139 VSS.n322 VSS.n321 0.0298333
R1140 VSS.n325 VSS.n322 0.0298333
R1141 VSS.n323 VSS.n310 0.0298333
R1142 VSS.n310 VSS.n309 0.0298333
R1143 VSS.n308 VSS.n307 0.0298333
R1144 VSS.n307 VSS.n306 0.0298333
R1145 VSS.n305 VSS.n304 0.0298333
R1146 VSS.n304 VSS.n303 0.0298333
R1147 VSS.t128 VSS.t131 0.0285612
R1148 VSS.n341 VSS.n340 0.0225
R1149 VSS.n337 VSS.n315 0.0225
R1150 VSS.n334 VSS.n321 0.0225
R1151 VSS.n324 VSS.n323 0.0225
R1152 VSS.n318 VSS.n308 0.0225
R1153 VSS.n316 VSS.n305 0.0225
R1154 VSS.n369 VSS.n368 0.0214524
R1155 VSS.n370 VSS.n369 0.0214524
R1156 VSS.n362 VSS.n357 0.0214524
R1157 VSS.n362 VSS.n300 0.0214524
R1158 VSS.n376 VSS.n375 0.0214524
R1159 VSS.n377 VSS.n376 0.0214524
R1160 VSS.n380 VSS.n379 0.0214524
R1161 VSS.n381 VSS.n380 0.0214524
R1162 VSS.n389 VSS.n388 0.0214524
R1163 VSS.n390 VSS.n389 0.0214524
R1164 VSS.n284 VSS.n283 0.0214524
R1165 VSS.n284 VSS.n281 0.0214524
R1166 VSS.n433 VSS.n143 0.0185
R1167 VSS.n336 VSS.n143 0.0185
R1168 VSS.n336 VSS.n335 0.0185
R1169 VSS.n335 VSS.n320 0.0185
R1170 VSS.n320 VSS.n319 0.0185
R1171 VSS.n319 VSS.n317 0.0185
R1172 VSS.n317 VSS.n301 0.0185
R1173 VSS.n355 VSS.n301 0.0185
R1174 VSS.n382 VSS.n292 0.0159153
R1175 VSS.n367 VSS.n366 0.0156425
R1176 VSS.n446 VSS.t21 0.0152453
R1177 VSS.t5 VSS.n80 0.0152453
R1178 VSS.n395 VSS.n394 0.0143286
R1179 VSS.n372 VSS.n356 0.0133571
R1180 VSS.n373 VSS.n372 0.0133571
R1181 VSS.n373 VSS.n293 0.0133571
R1182 VSS.n383 VSS.n293 0.0133571
R1183 VSS.n384 VSS.n383 0.0133571
R1184 VSS.n384 VSS.n282 0.0133571
R1185 VSS.n392 VSS.n282 0.0133571
R1186 VSS.n345 VSS.n311 0.0124467
R1187 VSS.n157 VSS.n156 0.0124467
R1188 VSS.n177 VSS.n176 0.0121878
R1189 VSS.n167 VSS.n166 0.0121878
R1190 VSS.n179 VSS.n178 0.0121878
R1191 VSS.n365 VSS.n364 0.0121878
R1192 VSS.n368 VSS.n367 0.0109762
R1193 VSS.n371 VSS.n370 0.0109762
R1194 VSS.n371 VSS.n357 0.0109762
R1195 VSS.n374 VSS.n300 0.0109762
R1196 VSS.n375 VSS.n374 0.0109762
R1197 VSS.n378 VSS.n377 0.0109762
R1198 VSS.n379 VSS.n378 0.0109762
R1199 VSS.n382 VSS.n381 0.0109762
R1200 VSS.n387 VSS.n386 0.0109762
R1201 VSS.n388 VSS.n387 0.0109762
R1202 VSS.n391 VSS.n390 0.0109762
R1203 VSS.n391 VSS.n283 0.0109762
R1204 VSS.n393 VSS.n281 0.0109762
R1205 VSS.n394 VSS.n393 0.0109762
R1206 VSS.n8 VSS.t12 0.00815127
R1207 VSS.n342 VSS.n341 0.00783333
R1208 VSS.n338 VSS.n337 0.00783333
R1209 VSS.n334 VSS.n333 0.00783333
R1210 VSS.n325 VSS.n324 0.00783333
R1211 VSS.n318 VSS.n309 0.00783333
R1212 VSS.n316 VSS.n306 0.00783333
R1213 VSS.n303 VSS.n302 0.00783333
R1214 VSS.n396 VSS.n395 0.00762381
R1215 VSS.n275 VSS.n185 0.00691667
R1216 VSS.n397 VSS.n396 0.00594762
R1217 VSS.n66 VSS.n13 0.00572691
R1218 VSS.n38 VSS.n243 0.00592384
R1219 VSS.n63 VSS.n64 0.00399966
R1220 VSS.n45 VSS.n28 0.00362425
R1221 VSS.n56 VSS.n11 0.00299994
R1222 VSS.n52 VSS.n33 0.00299994
R1223 VSS.n36 VSS.n24 0.00299994
R1224 VSS.t12 VSS.t6 0.00296056
R1225 VSS.t22 VSS.n1 0.00204721
R1226 VSS.n36 VSS.n35 0.00149995
R1227 VSS.n243 VSS.n23 0.00166667
R1228 VSS.n48 VSS.n47 0.00169993
R1229 VSS.n50 VSS.n49 0.00169993
R1230 VSS.n240 VSS.n234 0.00166667
R1231 VSS.n52 VSS.n51 0.00149995
R1232 VSS.n239 VSS.n32 0.00166667
R1233 VSS.n238 VSS.n235 0.00166667
R1234 VSS.n57 VSS.n56 0.00149995
R1235 VSS.n59 VSS.n58 0.00169993
R1236 VSS.n61 VSS.n60 0.00169993
R1237 VSS.n63 VSS.n62 0.00138884
R1238 VSS.n190 VSS.n17 0.00166667
R1239 VSS.n189 VSS.n20 0.00166667
R1240 VSS.n75 VSS.n74 0.00169993
R1241 VSS.n77 VSS.n186 0.00276078
R1242 VSS.n73 VSS.n190 0.00283308
R1243 VSS.n71 VSS.n15 0.00283308
R1244 VSS.n58 VSS.n11 0.00279996
R1245 VSS.n188 VSS.n75 0.0015
R1246 VSS.n191 VSS.n61 0.0015
R1247 VSS.n192 VSS.n59 0.0015
R1248 VSS.n54 VSS.n236 0.00276078
R1249 VSS.n241 VSS.n50 0.0015
R1250 VSS.n242 VSS.n48 0.0015
R1251 VSS.n43 VSS.n26 0.00199997
R1252 VSS.n46 VSS.n30 0.00199997
R1253 VSS.n43 VSS.n28 0.00199997
R1254 VSS.n42 VSS.n26 0.00199997
R1255 VSS.n69 VSS.n15 0.00199997
R1256 VSS.n64 VSS.n13 0.00199997
R1257 VSS.n33 VSS.n32 0.00183332
R1258 VSS.n24 VSS.n23 0.00183332
R1259 VSS.n21 VSS.n20 0.00183332
R1260 VSS.n18 VSS.n17 0.00183332
R1261 VSS.n232 VSS.t12 0.00150012
R1262 VSS.n6 VSS.t12 0.00156145
R1263 VSS.n188 VSS.n186 0.00133332
R1264 VSS.n241 VSS.n234 0.00133332
R1265 VSS.n239 VSS.n235 0.00133332
R1266 VSS.n238 VSS.n236 0.00133332
R1267 VSS.n448 VSS.t12 0.00109217
R1268 VSS.n230 VSS.n9 33.4245
R1269 VSS.n231 VSS.t12 0.00174083
R1270 VSS.n1 VSS.n0 0.00166383
R1271 VSS.t24 VSS.n3 5.22346
C0 VDD a_14668_3324# 1.26121f
C1 vco_bias_0.vbg_buf a_14668_3324# 0.04106f
C2 a_1254_3500# a_1954_3500# 0.68546f
C3 a_2654_5520# a_1474_1770# 1.58315f
C4 a_2654_5520# VDD 1.33799f
C5 vco_bias_0.vbg_buf a_2654_5520# 0.2279f
C6 a_5428_3064# a_6760_4930# 0.06026f
C7 vtune VDD 0.34468f
C8 vco_bias_0.vbg_buf a_9400_4966# 0.05066f
C9 vco_bias_0.vbg_buf vtune 0.07434f
C10 VDD di_en 0.23778f
C11 vco_bias_0.vbg_buf di_en 0.06389f
C12 a_14668_3324# a_11798_1860# 0.42263f
C13 vtune a_14668_3324# 0.19347f
C14 a_9400_4880# vdd_core 0.15264p
C15 a_1474_1770# a_1954_3500# 0.10623f
C16 VDD a_1954_3500# 0.2499f
C17 vco_bias_0.vbg_buf a_1954_3500# 0.09645f
C18 vco_bias_0.vbn_buf rf_out_p 0.18271f
C19 a_5428_3064# vco_bias_0.vbn_buf 1.33114f
C20 vco_bias_0.vbn_buf vdd_core 0.11036f
C21 vtune a_11798_1860# 0.35352f
C22 rf_out_n a_10100_4160# 0.47919f
C23 a_9400_4880# rf_out_n 0.74832f
C24 a_2654_5520# a_1954_3500# 0.19776f
C25 vco_bias_0.vbn_buf ibias_100u 0.0424f
C26 vco_bias_0.vbn_buf rf_out_n 0.21187f
C27 vco_bias_0.vbn_buf a_1254_3500# 0.20161f
C28 a_1474_1770# a_6760_4930# 0.03094f
C29 rf_out_p a_16500_4160# 0.47919f
C30 vco_bias_0.vbg_buf a_6760_4930# 0.01207f
C31 a_1560_1770# a_1474_1770# 0.03564f
C32 a_1560_1770# VDD 0.02705f
C33 vco_bias_0.vbg_buf a_1560_1770# 0.03564f
C34 a_1160_2070# a_1560_1770# 0.60592f
C35 VDD a_10100_4160# 0.35416f
C36 a_9400_4880# VDD 1.3464f
C37 a_9400_4880# vco_bias_0.vbg_buf 0.0829f
C38 rf_out_p rf_out_n 0.0144f
C39 a_9400_4880# a_14668_3324# 0.09717f
C40 a_5428_3064# a_1254_3500# 0.01008f
C41 vco_bias_0.vbn_buf a_1474_1770# 0.56919f
C42 vco_bias_0.vbn_buf VDD 0.42369f
C43 vco_bias_0.vbg_buf vco_bias_0.vbn_buf 7.0653f
C44 a_1160_2070# vco_bias_0.vbn_buf 0.03589f
C45 vco_bias_0.vbn_buf a_14668_3324# 0.05139f
C46 ibias_100u a_1254_3500# 0.74091f
C47 a_9400_4880# a_11798_1860# 0.42263f
C48 a_9400_4880# a_9400_4966# 0.04847f
C49 a_9400_4880# vtune 0.20309f
C50 a_19100_4966# vdd_core 0.08348f
C51 a_2654_5520# vco_bias_0.vbn_buf 0.29456f
C52 a_5428_3064# a_1474_1770# 0.69174f
C53 vco_bias_0.vbn_buf a_11798_1860# 6.1891f
C54 vco_bias_0.vbn_buf vtune 0.09134f
C55 rf_out_p VDD 0.45091f
C56 VDD a_16500_4160# 0.32132f
C57 VDD vdd_core 0.68654f
C58 vco_bias_0.vbn_buf di_en 0.04954f
C59 vco_bias_0.vbg_buf a_5428_3064# 0.05862f
C60 vco_bias_0.vbg_buf vdd_core 3.55902f
C61 rf_out_p a_14668_3324# 0.74832f
C62 a_14668_3324# a_16500_4160# 0.15006f
C63 a_14668_3324# vdd_core 0.15264p
C64 ibias_100u a_1474_1770# 0.41864f
C65 a_1474_1770# a_1254_3500# 0.16094f
C66 ibias_100u VDD 0.19675f
C67 vco_bias_0.vbn_buf a_1954_3500# 0.08537f
C68 a_1160_2070# ibias_100u 0.03793f
C69 a_2654_5520# a_5428_3064# 0.17543f
C70 VDD rf_out_n 0.46478f
C71 VDD a_1254_3500# 0.25114f
C72 vco_bias_0.vbg_buf a_1254_3500# 0.10514f
C73 rf_out_p a_11798_1860# 2.93481f
C74 rf_out_p vtune 0.03176f
C75 a_9400_4966# vdd_core 0.0801f
C76 vtune vdd_core 13.3525f
C77 a_2654_5520# ibias_100u 0.70174f
C78 a_2654_5520# a_1254_3500# 0.1486f
C79 a_19100_4966# vco_bias_0.vbg_buf 0.03283f
C80 rf_out_n a_11798_1860# 2.93481f
C81 vtune rf_out_n 0.03176f
C82 a_9400_4880# a_10100_4160# 0.15006f
C83 a_19100_4966# a_14668_3324# 0.04847f
C84 ibias_100u di_en 0.20785f
C85 vco_bias_0.vbn_buf a_6760_4930# 0.04276f
C86 di_en a_1254_3500# 0.38176f
C87 VDD a_1474_1770# 0.30901f
C88 vco_bias_0.vbg_buf a_1474_1770# 0.05405f
C89 a_1160_2070# a_1474_1770# 0.02728f
C90 a_1560_1770# vco_bias_0.vbn_buf 0.01263f
C91 vco_bias_0.vbg_buf VDD 0.71134f
C92 vco_bias_0.vbn_buf a_10100_4160# 0.01643f
C93 a_9400_4880# vco_bias_0.vbn_buf 0.06406f
C94 ibias_100u a_1954_3500# 0.33716f
C95 ibias_100u VSS 1.98242f
C96 rf_out_p VSS 8.65491f
C97 rf_out_n VSS 8.47924f
C98 vdd_core VSS 3.7736p
C99 VDD VSS 34.41872f
C100 vtune VSS 15.30125f
C101 a_11798_1860# VSS 83.91852f
C102 a_1474_1770# VSS 5.64333f
C103 VSS.t6 VSS 55.99659f
C104 VSS.t9 VSS 0.83341f
C105 VSS.t113 VSS 0.24627f
C106 VSS.t128 VSS 0.22249f
C107 VSS.t53 VSS 62.565f
C108 VSS.t48 VSS 0.99121f
C109 VSS.t34 VSS 0.60634f
C110 VSS.t2 VSS 0.1436f
C111 VSS.t1 VSS 1.46328f
C112 VSS.t103 VSS 0.57441f
C113 VSS.t84 VSS 0.2872f
C114 VSS.t81 VSS 1.21267f
C115 VSS.t3 VSS 1.23878f
C116 VSS.t5 VSS 55.73131f
C117 vdd_core.n0 VSS 0.11568f
C118 vdd_core.n1 VSS 0.1173f
C119 vdd_core.n2 VSS 0.16625f
C120 vdd_core.n3 VSS 0.12674f
C121 vdd_core.n4 VSS 0.11568f
C122 vdd_core.n5 VSS 71.37389f
C123 vdd_core.n6 VSS 13.9526f
C124 vdd_core.n7 VSS 0.53901f
C125 vdd_core.n8 VSS 0.26617f
C126 vdd_core.n9 VSS 0.48966f
C127 vdd_core.n10 VSS 0.54171f
C128 vdd_core.n11 VSS 0.3325f
C129 vdd_core.n12 VSS 0.10183f
C130 vdd_core.n13 VSS 0.22844f
C131 vdd_core.n14 VSS 0.1173f
C132 vdd_core.n15 VSS 0.07574f
C133 vdd_core.n16 VSS 0.05542f
C134 vdd_core.n17 VSS 0.10183f
C135 vdd_core.n18 VSS 0.1173f
C136 vdd_core.n19 VSS 0.07412f
C137 vdd_core.n20 VSS 0.10345f
C138 vdd_core.n21 VSS 0.11568f
C139 vdd_core.n22 VSS 0.07574f
C140 vdd_core.n23 VSS 0.10183f
C141 vdd_core.n24 VSS 0.12183f
C142 vdd_core.n25 VSS 0.25951f
C143 vdd_core.n26 VSS 5.65767f
C144 vdd_core.n27 VSS 0.07574f
C145 vdd_core.n28 VSS 0.41141f
C146 vdd_core.n29 VSS 0.42265f
C147 vdd_core.n30 VSS 0.23087f
C148 vdd_core.n31 VSS 0.23087f
C149 vdd_core.n32 VSS 0.34931f
C150 vdd_core.n33 VSS 0.34931f
C151 vdd_core.n34 VSS 0.11568f
C152 vdd_core.n35 VSS 0.35072f
C153 vdd_core.n36 VSS 0.35072f
C154 vdd_core.n37 VSS 0.11568f
C155 vdd_core.n38 VSS 0.16358f
C156 vdd_core.n39 VSS 0.21082f
C157 vdd_core.n40 VSS 0.31066f
C158 vdd_core.n41 VSS 0.21082f
C159 vdd_core.n42 VSS 12.4598f
C160 vdd_core.n43 VSS 5.39845f
C161 vdd_core.n44 VSS 0.31066f
C162 vdd_core.n45 VSS 0.24672f
C163 vdd_core.n46 VSS 0.24672f
C164 vdd_core.n47 VSS 0.38088f
C165 vdd_core.n48 VSS 0.38088f
C166 vdd_core.n49 VSS 0.22622f
C167 vdd_core.n50 VSS 0.22622f
C168 vdd_core.n51 VSS 0.22343f
C169 vdd_core.n52 VSS 0.34931f
C170 vdd_core.n53 VSS 0.22343f
C171 vdd_core.n54 VSS 0.34931f
C172 vdd_core.n55 VSS 0.1173f
C173 vdd_core.n56 VSS 0.11568f
C174 vdd_core.n57 VSS 0.1173f
C175 vdd_core.n58 VSS 0.11568f
C176 vdd_core.n59 VSS 0.31585f
C177 vdd_core.n60 VSS 0.22157f
C178 vdd_core.n61 VSS 0.34931f
C179 vdd_core.n62 VSS 0.34931f
C180 vdd_core.n63 VSS 0.22808f
C181 vdd_core.n64 VSS 0.22808f
C182 vdd_core.n65 VSS 0.38088f
C183 vdd_core.n66 VSS 0.38088f
C184 vdd_core.n67 VSS 0.23087f
C185 vdd_core.n68 VSS 0.23087f
C186 vdd_core.n69 VSS 0.34931f
C187 vdd_core.n70 VSS 0.34931f
C188 vdd_core.n71 VSS 0.21082f
C189 vdd_core.n72 VSS 0.21082f
C190 vdd_core.n73 VSS 0.1173f
C191 vdd_core.n74 VSS 0.22343f
C192 vdd_core.n75 VSS 0.22343f
C193 vdd_core.n76 VSS 0.1173f
C194 vdd_core.n77 VSS 0.35072f
C195 vdd_core.n78 VSS 0.31066f
C196 vdd_core.n79 VSS 0.16358f
C197 vdd_core.n80 VSS 12.4598f
C198 vdd_core.n81 VSS 5.39845f
C199 vdd_core.n82 VSS 0.31066f
C200 vdd_core.n83 VSS 0.24672f
C201 vdd_core.n84 VSS 0.38088f
C202 vdd_core.n85 VSS 0.34931f
C203 vdd_core.n86 VSS 0.22622f
C204 vdd_core.n87 VSS 0.11568f
C205 vdd_core.n88 VSS 0.34931f
C206 vdd_core.n89 VSS 0.22622f
C207 vdd_core.n90 VSS 0.38088f
C208 vdd_core.n91 VSS 0.24672f
C209 vdd_core.n92 VSS 0.11568f
C210 vdd_core.n93 VSS 0.11568f
C211 vdd_core.n94 VSS 0.11568f
C212 vdd_core.n95 VSS 5.44327f
C213 vdd_core.n96 VSS 12.415f
C214 vdd_core.n97 VSS 0.16358f
C215 vdd_core.n98 VSS 0.35072f
C216 vdd_core.n99 VSS 0.1173f
C217 vdd_core.n100 VSS 7.18743f
C218 vdd_core.n101 VSS 0.53399f
C219 vdd_core.t2 VSS 0.04342f
C220 vdd_core.t1 VSS 0.28905f
C221 vdd_core.n102 VSS 0.16774f
C222 vdd_core.t18 VSS 0.04278f
C223 vdd_core.n103 VSS 0.07038f
C224 vdd_core.t14 VSS 0.04342f
C225 vdd_core.t16 VSS 0.04278f
C226 vdd_core.n104 VSS 0.15437f
C227 vdd_core.n105 VSS 0.04546f
C228 vdd_core.n106 VSS 0.31057f
C229 vdd_core.n107 VSS 13.7941f
C230 vdd_core.n108 VSS 0.14493f
C231 vdd_core.n109 VSS 0.1947f
C232 vdd_core.n110 VSS 0.0969f
C233 vdd_core.n111 VSS 0.08457f
C234 vdd_core.n112 VSS 1.40134f
C235 vdd_core.n113 VSS 0.55719f
C236 vdd_core.n114 VSS 0.10111f
C237 vdd_core.n115 VSS 7.34609f
C238 vdd_core.n116 VSS 0.42745f
C239 vdd_core.t4 VSS 0.04342f
C240 vdd_core.t5 VSS 0.26528f
C241 vdd_core.n117 VSS 0.15437f
C242 vdd_core.t7 VSS 0.04342f
C243 vdd_core.t8 VSS 0.04278f
C244 vdd_core.n118 VSS 0.16774f
C245 vdd_core.t10 VSS 0.04278f
C246 vdd_core.n119 VSS 0.07038f
C247 vdd_core.n120 VSS 0.04546f
C248 vdd_core.n121 VSS 0.1838f
C249 vdd_core.n122 VSS 7.72715f
C250 vdd_core.n123 VSS 31.123f
C251 vdd_core.n124 VSS 1.94646f
C252 vdd_core.n125 VSS 0.35504f
C253 vdd_core.n126 VSS 0.07144f
C254 vdd_core.n127 VSS 0.06825f
C255 vdd_core.n128 VSS 0.03026f
C256 vdd_core.n129 VSS 0.03905f
C257 vdd_core.n130 VSS 0.15511f
C258 vdd_core.n131 VSS 0.09269f
C259 vdd_core.n132 VSS 0.13697f
C260 vdd_core.n133 VSS 0.03749f
C261 vdd_core.n134 VSS 0.02915f
C262 vdd_core.n135 VSS 0.0969f
C263 vdd_core.n136 VSS 0.08834f
C264 vdd_core.n137 VSS 0.08834f
C265 vdd_core.n138 VSS 0.0876f
C266 vdd_core.n139 VSS 0.02915f
C267 vdd_core.n140 VSS 0.03749f
C268 vdd_core.n141 VSS 0.08457f
C269 vdd_core.n142 VSS 2.13837f
C270 vdd_core.n143 VSS 0.11568f
C271 vdd_core.n144 VSS 0.1173f
C272 vdd_core.n145 VSS 0.11568f
C273 vdd_core.n146 VSS 0.1173f
C274 vdd_core.n147 VSS 0.11568f
C275 vdd_core.n148 VSS 0.1173f
C276 vdd_core.n149 VSS 0.37424f
C277 vdd_core.n150 VSS 0.59429f
C278 vdd_core.n151 VSS 0.46852f
C279 vdd_core.n152 VSS 0.1173f
C280 vdd_core.n153 VSS 0.11568f
C281 vdd_core.n154 VSS 0.1711f
C282 vdd_core.n155 VSS 5.44327f
C283 vdd_core.n156 VSS 12.415f
C284 vdd_core.n157 VSS 0.16358f
C285 vdd_core.n158 VSS 0.1173f
C286 vdd_core.n159 VSS 0.1173f
C287 vdd_core.n160 VSS 0.11568f
C288 vdd_core.n161 VSS 0.1173f
C289 vdd_core.n162 VSS 0.18957f
C290 vdd_core.n163 VSS 0.3325f
C291 vdd_core.n164 VSS 0.10183f
C292 vdd_core.n165 VSS 0.22823f
C293 vdd_core.n166 VSS 0.1996f
C294 vdd_core.n167 VSS 0.22877f
C295 vdd_core.n168 VSS 0.1173f
C296 vdd_core.n169 VSS 0.25951f
C297 vdd_core.n170 VSS 0.24998f
C298 vdd_core.n171 VSS 0.17839f
C299 vdd_core.n172 VSS 0.22823f
C300 vdd_core.n173 VSS 0.18161f
C301 vdd_core.n174 VSS 0.18161f
C302 vdd_core.n175 VSS 0.2795f
C303 vdd_core.n176 VSS 0.2795f
C304 vdd_core.n177 VSS 0.16651f
C305 vdd_core.n178 VSS 0.16651f
C306 vdd_core.n179 VSS 0.25644f
C307 vdd_core.n180 VSS 0.25644f
C308 vdd_core.n181 VSS 0.16447f
C309 vdd_core.n182 VSS 0.16447f
C310 vdd_core.n183 VSS 0.25739f
C311 vdd_core.n184 VSS 0.25739f
C312 vdd_core.n185 VSS 0.25421f
C313 vdd_core.n186 VSS 0.25527f
C314 vdd_core.n187 VSS 0.16311f
C315 vdd_core.n188 VSS 0.25644f
C316 vdd_core.n189 VSS 0.16786f
C317 vdd_core.n190 VSS 0.2795f
C318 vdd_core.n191 VSS 0.1699f
C319 vdd_core.n192 VSS 0.25644f
C320 vdd_core.n193 VSS 0.15518f
C321 vdd_core.n194 VSS 11.6991f
C322 vdd_core.n195 VSS 0.12183f
C323 vdd_core.n196 VSS 0.1173f
C324 vdd_core.n197 VSS 0.07574f
C325 vdd_core.n198 VSS 0.05542f
C326 vdd_core.n199 VSS 0.3325f
C327 vdd_core.n200 VSS 0.05542f
C328 vdd_core.n201 VSS 0.3325f
C329 vdd_core.n202 VSS 0.3325f
C330 vdd_core.n203 VSS 0.05542f
C331 vdd_core.n204 VSS 0.10183f
C332 vdd_core.n205 VSS 0.1173f
C333 vdd_core.n206 VSS 0.07412f
C334 vdd_core.n207 VSS 0.05542f
C335 vdd_core.n208 VSS 0.10345f
C336 vdd_core.n209 VSS 0.11568f
C337 vdd_core.n210 VSS 0.07412f
C338 vdd_core.n211 VSS 0.05542f
C339 vdd_core.n212 VSS 0.3325f
C340 vdd_core.n213 VSS 0.94925f
C341 vdd_core.n214 VSS 0.05542f
C342 vdd_core.n215 VSS 0.12954f
C343 vdd_core.n216 VSS 5.6146f
C344 vdd_core.n217 VSS 11.7421f
C345 vdd_core.n218 VSS 0.15518f
C346 vdd_core.n219 VSS 0.25644f
C347 vdd_core.n220 VSS 0.1699f
C348 vdd_core.n221 VSS 0.2795f
C349 vdd_core.n222 VSS 0.16786f
C350 vdd_core.n223 VSS 0.25644f
C351 vdd_core.n224 VSS 0.16311f
C352 vdd_core.n225 VSS 0.25527f
C353 vdd_core.n226 VSS 0.25421f
C354 vdd_core.n227 VSS 0.22685f
C355 vdd_core.n228 VSS 1.20177f
C356 vdd_core.n229 VSS 0.06732f
C357 vdd_core.n230 VSS 1.08788f
.ends
