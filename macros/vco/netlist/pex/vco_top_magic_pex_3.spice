* PEX produced on Wed Nov  4 01:43:26 PM CET 2026 using /foss/tools/sak/sak-pex.sh with m=3 and s=1 (extresist threshold=1000 mOhm, minres=100 mOhm, mindelay=0 ps)
* NGSPICE file created from vco_top_pex.ext - technology: ihp-sg13cmos5l

.subckt vco_top_pex ibias_100u di_en VDD VSS vdd_core vtune rf_out_p rf_out_n
X0 VSS.t157 vdd_core.t0 vdd_core.t18 VSS.t156 sg13_lv_nmos ad=0.38p pd=2.38u as=0.38p ps=2.38u w=2u l=0.13u
X1 a_11798_1860.t11 vco_bias_0.vbn_buf.t2 VSS.t84 VSS.t85 sg13_lv_nmos ad=0.95p pd=5.38u as=0.95p ps=5.38u w=5u l=0.5u
X2 rf_out_n.t5 a_9400_4880# a_11798_1860.t20 VSS.t107 sg13_lv_nmos ad=0.38p pd=2.38u as=0.38p ps=2.38u w=2u l=0.13u
X3 rf_out_n.t1 a_9400_4880# a_11798_1860.t18 VSS.t103 sg13_lv_nmos ad=0.38p pd=2.38u as=0.38p ps=2.38u w=2u l=0.13u
X4 VSS.t42 vco_bias_0.vbg_buf VSS.t41 VSS.t0 sg13_lv_nmos ad=2.72p pd=16.68u as=0 ps=0 w=8u l=10u
X5 VSS.t141 vdd_core.t2 vdd_core.t8 VSS.t140 sg13_lv_nmos ad=0.38p pd=2.38u as=0.38p ps=2.38u w=2u l=0.13u
X6 a_11798_1860.t12 vco_bias_0.vbn_buf.t2 VSS.t87 VSS.t88 sg13_lv_nmos ad=0.95p pd=5.38u as=0.95p ps=5.38u w=5u l=0.5u
X7 VSS.t10 vco_bias_0.vbn_buf.t3 VSS.t8 VSS.t9 sg13_lv_nmos ad=1.52p pd=8.38u as=0 ps=0 w=8u l=10u
X8 a_11798_1860.t23 a_14668_3324# rf_out_p.t1 VSS.t117 sg13_lv_nmos ad=0.38p pd=2.38u as=0.38p ps=2.38u w=2u l=0.13u
X9 a_11798_1860.t1 vco_bias_0.vbn_buf.t2 VSS.t58 VSS.t57 sg13_lv_nmos ad=0.95p pd=5.38u as=0.95p ps=5.38u w=5u l=0.5u
X10 VSS.t68 vco_bias_0.vbn_buf.t2 a_11798_1860.t4 VSS.t67 sg13_lv_nmos ad=0.95p pd=5.38u as=0.95p ps=5.38u w=5u l=0.5u
X11 a_11798_1860.t2 vco_bias_0.vbn_buf.t2 VSS.t61 VSS.t62 sg13_lv_nmos ad=0.95p pd=5.38u as=0.95p ps=5.38u w=5u l=0.5u
X12 vdd_core.t7 vdd_core.t2 VSS.t135 VSS.t136 sg13_lv_nmos ad=0.38p pd=2.38u as=0.38p ps=2.38u w=2u l=0.13u
X13 VSS.t71 vco_bias_0.vbn_buf.t2 a_11798_1860.t5 VSS.t72 sg13_lv_nmos ad=0.95p pd=5.38u as=0.95p ps=5.38u w=5u l=0.5u
X14 vdd_core.t4 vdd_core.t2 VSS.t130 VSS.t129 sg13_lv_nmos ad=0.38p pd=2.38u as=0.68p ps=4.68u w=2u l=0.13u
X15 VSS.t151 vdd_core.t0 vdd_core.t10 VSS.t150 sg13_lv_nmos ad=0.38p pd=2.38u as=0.38p ps=2.38u w=2u l=0.13u
X16 a_11798_1860.t9 vco_bias_0.vbn_buf.t2 VSS.t54 VSS.t81 sg13_lv_nmos ad=0.95p pd=5.38u as=0.95p ps=5.38u w=5u l=0.5u
X17 a_11798_1860.t26 a_14668_3324# rf_out_p.t5 VSS.t123 sg13_lv_nmos ad=0.38p pd=2.38u as=0.38p ps=2.38u w=2u l=0.13u
X18 rf_out_p.t3 a_14668_3324# a_11798_1860.t24 VSS.t120 sg13_lv_nmos ad=0.38p pd=2.38u as=0.38p ps=2.38u w=2u l=0.13u
X19 ibias_100u.t2 ibias_100u.t1 VSS.t18 VSS.t11 sg13_lv_nmos ad=0.85p pd=5.68u as=0.85p ps=5.68u w=2.5u l=0.5u
X20 vco_bias_0.vbn_buf.t0 a_1254_3500.t2 VSS.t17 VSS.t13 sg13_lv_nmos ad=0.34p pd=2.68u as=0.34p ps=2.68u w=1u l=0.13u
X21 VSS.t132 vdd_core.t2 vdd_core.t4 VSS.t131 sg13_lv_nmos ad=0.38p pd=2.38u as=0.38p ps=2.38u w=2u l=0.13u
X22 a_11798_1860.t16 a_9400_4880# rf_out_n.t0 VSS.t98 sg13_lv_nmos ad=0.38p pd=2.38u as=0.38p ps=2.38u w=2u l=0.13u
X23 VSS.t44 vco_bias_0.vbg_buf VSS.t42 VSS.t3 sg13_lv_nmos ad=1.52p pd=8.38u as=0 ps=0 w=8u l=10u
X24 VSS.t64 vco_bias_0.vbn_buf.t2 a_11798_1860.t2 VSS.t63 sg13_lv_nmos ad=0.95p pd=5.38u as=0.95p ps=5.38u w=5u l=0.5u
X25 a_11798_1860.t21 a_9400_4880# rf_out_n.t5 VSS.t108 sg13_lv_nmos ad=0.68p pd=4.68u as=0.38p ps=2.38u w=2u l=0.13u
X26 a_1474_1770.t1 a_5428_3064.t2 VSS.t111 rppd l=8.5u w=0.5u
X27 VSS.t54 vco_bias_0.vbn_buf.t2 a_11798_1860.t8 VSS.t53 sg13_lv_nmos ad=0.95p pd=5.38u as=0.95p ps=5.38u w=5u l=0.5u
X28 a_11798_1860.t6 vco_bias_0.vbn_buf.t2 VSS.t71 VSS.t70 sg13_lv_nmos ad=0.95p pd=5.38u as=0.95p ps=5.38u w=5u l=0.5u
X29 a_11798_1860.t19 a_9400_4880# rf_out_n.t1 VSS.t104 sg13_lv_nmos ad=0.38p pd=2.38u as=0.38p ps=2.38u w=2u l=0.13u
X30 a_11798_1860.t17 a_9400_4880# rf_out_n.t3 VSS.t100 sg13_lv_nmos ad=0.38p pd=2.38u as=0.38p ps=2.38u w=2u l=0.13u
X31 vco_bias_0.vbg_buf a_14668_3324# VSS.t114 rhigh l=8u w=0.5u
X32 vdd_core.t1 vdd_core.t0 VSS.t157 VSS.t158 sg13_lv_nmos ad=0.38p pd=2.38u as=0.38p ps=2.38u w=2u l=0.13u
X33 VSS.t24 vco_bias_0.vbn_buf.t4 VSS.t22 VSS.t23 sg13_lv_nmos ad=1.52p pd=8.38u as=0 ps=0 w=8u l=10u
X34 VSS.t28 vco_bias_0.vbn_buf.t4 VSS.t26 VSS.t27 sg13_lv_nmos ad=1.52p pd=8.38u as=0 ps=0 w=8u l=10u
X35 vdd_core.t3 vdd_core.t2 VSS.t141 VSS.t142 sg13_lv_nmos ad=0.38p pd=2.38u as=0.38p ps=2.38u w=2u l=0.13u
X36 rf_out_p.t2 a_14668_3324# a_11798_1860.t23 VSS.t118 sg13_lv_nmos ad=0.38p pd=2.38u as=0.38p ps=2.38u w=2u l=0.13u
X37 a_1254_3500.t1 di_en.t0 VSS.t128 VSS.t15 sg13_lv_nmos ad=0.17p pd=1.68u as=0.17p ps=1.68u w=0.5u l=0.13u
X38 VSS.t38 vco_bias_0.vbg_buf VSS.t36 VSS.t7 sg13_lv_nmos ad=1.52p pd=8.38u as=0 ps=0 w=8u l=10u
X39 a_11798_1860.t3 vco_bias_0.vbn_buf.t2 VSS.t64 VSS.t65 sg13_lv_nmos ad=0.95p pd=5.38u as=0.95p ps=5.38u w=5u l=0.5u
X40 VSS.t74 vco_bias_0.vbn_buf.t2 a_11798_1860.t6 VSS.t73 sg13_lv_nmos ad=0.95p pd=5.38u as=0.95p ps=5.38u w=5u l=0.5u
N41 vdd_core.t26 vtune.t0 sg13_hv_svaricap l=0.3u w=30.08u
X42 a_11798_1860.t28 a_14668_3324# rf_out_p.t4 VSS.t127 sg13_lv_nmos ad=0.68p pd=4.68u as=0.38p ps=2.38u w=2u l=0.13u
X43 rf_out_p.t6 a_14668_3324# a_11798_1860.t26 VSS.t124 sg13_lv_nmos ad=0.38p pd=2.38u as=0.38p ps=2.38u w=2u l=0.13u
X44 a_11798_1860.t25 a_14668_3324# rf_out_p.t3 VSS.t121 sg13_lv_nmos ad=0.38p pd=2.38u as=0.38p ps=2.38u w=2u l=0.13u
X45 VSS.t138 vdd_core.t2 vdd_core.t7 VSS.t137 sg13_lv_nmos ad=0.38p pd=2.38u as=0.38p ps=2.38u w=2u l=0.13u
X46 VSS.t36 vco_bias_0.vbg_buf VSS.t34 VSS.t5 sg13_lv_nmos ad=1.52p pd=8.38u as=0 ps=0 w=8u l=10u
X47 vdd_core.t16 vdd_core.t0 VSS.t151 VSS.t152 sg13_lv_nmos ad=0.38p pd=2.38u as=0.38p ps=2.38u w=2u l=0.13u
X48 rf_out_n.t3 a_9400_4880# a_11798_1860.t16 VSS.t99 sg13_lv_nmos ad=0.38p pd=2.38u as=0.38p ps=2.38u w=2u l=0.13u
X49 vdd_core.t9 vdd_core.t0 VSS.t146 VSS.t145 sg13_lv_nmos ad=0.38p pd=2.38u as=0.68p ps=4.68u w=2u l=0.13u
X50 a_1474_1770.t0 a_2654_5520.t4 VDD.t3 VDD.t2 sg13_lv_pmos ad=1.7p pd=10.68u as=1.7p ps=10.68u w=5u l=0.5u
N51 vdd_core.t22 vtune.t6 sg13_hv_svaricap l=0.3u w=30.08u
X52 VSS.t90 vco_bias_0.vbn_buf.t2 a_11798_1860.t12 VSS.t89 sg13_lv_nmos ad=0.95p pd=5.38u as=0.95p ps=5.38u w=5u l=0.5u
X53 a_11798_1860.t10 vco_bias_0.vbn_buf.t2 VSS.t80 VSS.t79 sg13_lv_nmos ad=0.95p pd=5.38u as=0.95p ps=5.38u w=5u l=0.5u
X54 a_11798_1860.t0 vco_bias_0.vbn_buf.t2 VSS.t56 VSS.t55 sg13_lv_nmos ad=0.95p pd=5.38u as=1.7p ps=10.68u w=5u l=0.5u
X55 vdd_core.t5 vdd_core.t2 VSS.t132 VSS.t133 sg13_lv_nmos ad=0.38p pd=2.38u as=0.38p ps=2.38u w=2u l=0.13u
X56 VDD.t8 rf_out_n.t6 VSS.t109 rppd l=1.65u w=10u
X57 VSS.t4 vco_bias_0.vbn_buf.t3 VSS.t2 VSS.t3 sg13_lv_nmos ad=1.52p pd=8.38u as=0 ps=0 w=8u l=10u
X58 VSS.t148 vdd_core.t0 vdd_core.t9 VSS.t147 sg13_lv_nmos ad=0.38p pd=2.38u as=0.38p ps=2.38u w=2u l=0.13u
X59 VSS.t52 vco_bias_0.vbn_buf.t2 a_11798_1860.t3 VSS.t51 sg13_lv_nmos ad=0.95p pd=5.38u as=0.95p ps=5.38u w=5u l=0.5u
X60 VSS.t8 vco_bias_0.vbn_buf.t3 VSS.t6 VSS.t7 sg13_lv_nmos ad=1.52p pd=8.38u as=0 ps=0 w=8u l=10u
X61 rf_out_n.t2 a_9400_4880# a_11798_1860.t19 VSS.t105 sg13_lv_nmos ad=0.38p pd=2.38u as=0.38p ps=2.38u w=2u l=0.13u
X62 rf_out_n.t4 a_9400_4880# a_11798_1860.t17 VSS.t101 sg13_lv_nmos ad=0.38p pd=2.38u as=0.38p ps=2.38u w=2u l=0.13u
X63 VSS.t26 vco_bias_0.vbn_buf.t4 VSS.t24 VSS.t25 sg13_lv_nmos ad=1.52p pd=8.38u as=0 ps=0 w=8u l=10u
X64 VSS.t40 vco_bias_0.vbg_buf VSS.t38 VSS.t9 sg13_lv_nmos ad=1.52p pd=8.38u as=0 ps=0 w=8u l=10u
X65 a_11798_1860.t24 a_14668_3324# rf_out_p.t2 VSS.t119 sg13_lv_nmos ad=0.38p pd=2.38u as=0.38p ps=2.38u w=2u l=0.13u
X66 rf_out_p.t1 a_14668_3324# a_11798_1860.t22 VSS.t116 sg13_lv_nmos ad=0.38p pd=2.38u as=0.68p ps=4.68u w=2u l=0.13u
X67 ibias_100u.t0 a_1254_3500.t3 VSS.t14 VSS.t13 sg13_lv_nmos ad=0.34p pd=2.68u as=0.34p ps=2.68u w=1u l=0.13u
X68 VSS.t48 vco_bias_0.vbg_buf VSS.t46 VSS.t7 sg13_lv_nmos ad=1.52p pd=8.38u as=0 ps=0 w=8u l=10u
X69 VSS.t80 vco_bias_0.vbn_buf.t2 a_11798_1860.t9 VSS.t82 sg13_lv_nmos ad=0.95p pd=5.38u as=0.95p ps=5.38u w=5u l=0.5u
X70 VSS.t58 vco_bias_0.vbn_buf.t2 a_11798_1860.t0 VSS.t59 sg13_lv_nmos ad=0.95p pd=5.38u as=0.95p ps=5.38u w=5u l=0.5u
N71 vdd_core.t24 vtune.t3 sg13_hv_svaricap l=0.3u w=30.08u
X72 a_11798_1860.t13 vco_bias_0.vbn_buf.t2 VSS.t90 VSS.t91 sg13_lv_nmos ad=0.95p pd=5.38u as=0.95p ps=5.38u w=5u l=0.5u
X73 a_2654_5520.t3 a_1954_3500.t2 VDD.t1 VDD.t0 sg13_lv_pmos ad=0.34p pd=2.68u as=0.34p ps=2.68u w=1u l=0.13u
X74 a_11798_1860.t14 vco_bias_0.vbn_buf.t2 VSS.t93 VSS.t94 sg13_lv_nmos ad=0.95p pd=5.38u as=0.95p ps=5.38u w=5u l=0.5u
X75 VSS.t160 vdd_core.t0 vdd_core.t1 VSS.t159 sg13_lv_nmos ad=0.68p pd=4.68u as=0.38p ps=2.38u w=2u l=0.13u
X76 VSS.t144 vdd_core.t2 vdd_core.t3 VSS.t143 sg13_lv_nmos ad=0.68p pd=4.68u as=0.38p ps=2.38u w=2u l=0.13u
X77 a_1954_3500.t0 a_1254_3500.t4 VSS.t16 VSS.t15 sg13_lv_nmos ad=0.17p pd=1.68u as=0.17p ps=1.68u w=0.5u l=0.13u
X78 a_11798_1860.t27 a_14668_3324# rf_out_p.t6 VSS.t125 sg13_lv_nmos ad=0.38p pd=2.38u as=0.38p ps=2.38u w=2u l=0.13u
X79 vco_bias_0.vbg_buf a_9400_4880# VSS.t110 rhigh l=8u w=0.5u
X80 VSS.t46 vco_bias_0.vbg_buf VSS.t44 VSS.t5 sg13_lv_nmos ad=1.52p pd=8.38u as=0 ps=0 w=8u l=10u
X81 a_1254_3500.t0 di_en.t1 VDD.t11 VDD.t10 sg13_lv_pmos ad=0.34p pd=2.68u as=0.34p ps=2.68u w=1u l=0.13u
X82 VSS.t6 vco_bias_0.vbn_buf.t3 VSS.t4 VSS.t5 sg13_lv_nmos ad=1.52p pd=8.38u as=0 ps=0 w=8u l=10u
X83 a_11798_1860.t4 vco_bias_0.vbn_buf.t2 VSS.t52 VSS.t66 sg13_lv_nmos ad=0.95p pd=5.38u as=0.95p ps=5.38u w=5u l=0.5u
X84 a_1474_1770.t2 vco_bias_0.vbg_buf VSS.t112 rhigh l=32u w=0.5u
X85 a_5428_3064.t1 a_5428_3064.t0 VSS.t12 VSS.t11 sg13_lv_nmos ad=0.85p pd=5.68u as=0.85p ps=5.68u w=2.5u l=0.5u
X86 VSS.t76 vco_bias_0.vbn_buf.t2 a_11798_1860.t7 VSS.t78 sg13_lv_nmos ad=0.95p pd=5.38u as=0.95p ps=5.38u w=5u l=0.5u
X87 VSS.t154 vdd_core.t0 vdd_core.t16 VSS.t153 sg13_lv_nmos ad=0.38p pd=2.38u as=0.38p ps=2.38u w=2u l=0.13u
X88 VSS.t93 vco_bias_0.vbn_buf.t2 a_11798_1860.t13 VSS.t92 sg13_lv_nmos ad=0.95p pd=5.38u as=0.95p ps=5.38u w=5u l=0.5u
X89 a_11798_1860.t20 a_9400_4880# rf_out_n.t2 VSS.t106 sg13_lv_nmos ad=0.38p pd=2.38u as=0.38p ps=2.38u w=2u l=0.13u
X90 a_11798_1860.t18 a_9400_4880# rf_out_n.t4 VSS.t102 sg13_lv_nmos ad=0.38p pd=2.38u as=0.38p ps=2.38u w=2u l=0.13u
X91 VSS.t96 vco_bias_0.vbn_buf.t2 a_11798_1860.t14 VSS.t95 sg13_lv_nmos ad=1.7p pd=10.68u as=0.95p ps=5.38u w=5u l=0.5u
X92 VSS.t22 vco_bias_0.vbn_buf.t4 VSS.t21 VSS.t20 sg13_lv_nmos ad=2.72p pd=16.68u as=0 ps=0 w=8u l=10u
X93 VSS.t32 vco_bias_0.vbg_buf VSS.t31 VSS.t0 sg13_lv_nmos ad=2.72p pd=16.68u as=0 ps=0 w=8u l=10u
X94 a_2654_5520.t0 ibias_100u.t4 VSS.t19 VSS.t11 sg13_lv_nmos ad=0.85p pd=5.68u as=0.85p ps=5.68u w=2.5u l=0.5u
X95 VSS.t50 vco_bias_0.vbg_buf VSS.t48 VSS.t9 sg13_lv_nmos ad=1.52p pd=8.38u as=0 ps=0 w=8u l=10u
X96 VSS.t135 vdd_core.t2 vdd_core.t5 VSS.t134 sg13_lv_nmos ad=0.38p pd=2.38u as=0.38p ps=2.38u w=2u l=0.13u
X97 vdd_core.t18 vdd_core.t0 VSS.t154 VSS.t155 sg13_lv_nmos ad=0.38p pd=2.38u as=0.38p ps=2.38u w=2u l=0.13u
X98 ibias_100u.t3 vco_bias_0.vbn_buf.t1 VSS.t113 rhigh l=32u w=0.5u
X99 vdd_core.t8 vdd_core.t2 VSS.t138 VSS.t139 sg13_lv_nmos ad=0.38p pd=2.38u as=0.38p ps=2.38u w=2u l=0.13u
X100 vdd_core.t10 vdd_core.t0 VSS.t148 VSS.t149 sg13_lv_nmos ad=0.38p pd=2.38u as=0.38p ps=2.38u w=2u l=0.13u
N101 vdd_core.t23 vtune.t6 sg13_hv_svaricap l=0.3u w=30.08u
X102 a_11798_1860.t7 vco_bias_0.vbn_buf.t2 VSS.t74 VSS.t77 sg13_lv_nmos ad=0.95p pd=5.38u as=0.95p ps=5.38u w=5u l=0.5u
X103 VSS.t30 vco_bias_0.vbn_buf.t4 VSS.t28 VSS.t29 sg13_lv_nmos ad=1.52p pd=8.38u as=0 ps=0 w=8u l=10u
X104 VSS.t84 vco_bias_0.vbn_buf.t2 a_11798_1860.t10 VSS.t83 sg13_lv_nmos ad=0.95p pd=5.38u as=0.95p ps=5.38u w=5u l=0.5u
X105 a_11798_1860.t8 vco_bias_0.vbn_buf.t2 VSS.t76 VSS.t75 sg13_lv_nmos ad=0.95p pd=5.38u as=0.95p ps=5.38u w=5u l=0.5u
X106 VSS.t87 vco_bias_0.vbn_buf.t2 a_11798_1860.t11 VSS.t86 sg13_lv_nmos ad=0.95p pd=5.38u as=0.95p ps=5.38u w=5u l=0.5u
X107 rf_out_p.t4 a_14668_3324# a_11798_1860.t27 VSS.t126 sg13_lv_nmos ad=0.38p pd=2.38u as=0.38p ps=2.38u w=2u l=0.13u
X108 a_2654_5520.t2 a_2654_5520.t1 VDD.t7 VDD.t6 sg13_lv_pmos ad=1.7p pd=10.68u as=1.7p ps=10.68u w=5u l=0.5u
X109 rf_out_p.t5 a_14668_3324# a_11798_1860.t25 VSS.t122 sg13_lv_nmos ad=0.38p pd=2.38u as=0.38p ps=2.38u w=2u l=0.13u
N110 vdd_core.t25 vtune.t3 sg13_hv_svaricap l=0.3u w=30.08u
N111 vdd_core.t27 vtune.t0 sg13_hv_svaricap l=0.3u w=30.08u
X112 rf_out_n.t0 a_9400_4880# a_11798_1860.t15 VSS.t97 sg13_lv_nmos ad=0.38p pd=2.38u as=0.68p ps=4.68u w=2u l=0.13u
X113 VSS.t2 vco_bias_0.vbn_buf.t3 VSS.t1 VSS.t0 sg13_lv_nmos ad=2.72p pd=16.68u as=0 ps=0 w=8u l=10u
X114 VSS.t61 vco_bias_0.vbn_buf.t2 a_11798_1860.t1 VSS.t60 sg13_lv_nmos ad=0.95p pd=5.38u as=0.95p ps=5.38u w=5u l=0.5u
X115 VSS.t34 vco_bias_0.vbg_buf VSS.t32 VSS.t3 sg13_lv_nmos ad=1.52p pd=8.38u as=0 ps=0 w=8u l=10u
X116 a_11798_1860.t5 vco_bias_0.vbn_buf.t2 VSS.t68 VSS.t69 sg13_lv_nmos ad=0.95p pd=5.38u as=0.95p ps=5.38u w=5u l=0.5u
X117 VDD.t9 rf_out_p.t0 VSS.t115 rppd l=1.65u w=10u
X118 a_1954_3500.t1 a_1254_3500.t5 VDD.t5 VDD.t4 sg13_lv_pmos ad=0.34p pd=2.68u as=0.34p ps=2.68u w=1u l=0.13u
R0 ibias_100u.n3 ibias_100u.t3 54.3738
R1 ibias_100u.n0 ibias_100u.t4 34.6784
R2 ibias_100u.n1 ibias_100u.t1 34.2252
R3 ibias_100u.n2 ibias_100u.t0 20.5585
R4 ibias_100u.n0 ibias_100u.t2 14.6093
R5 ibias_100u.n3 ibias_100u.n2 1.7473
R6 ibias_100u ibias_100u.n3 1.2149
R7 ibias_100u.n2 ibias_100u.n1 0.5351
R8 ibias_100u.n1 ibias_100u.n0 0.3173
R9 rf_out_p rf_out_p.n2 7.11117
R10 rf_out_p.n0 rf_out_p.t1 4.77599
R11 rf_out_p.n1 rf_out_p.t4 4.72949
R12 rf_out_p.n1 rf_out_p.t6 4.72949
R13 rf_out_p.n0 rf_out_p.t5 4.72949
R14 rf_out_p.n0 rf_out_p.t3 4.72949
R15 rf_out_p.n0 rf_out_p.t2 4.72949
R16 rf_out_p.n2 rf_out_p.t0 2.40801
R17 rf_out_p.n2 rf_out_p.n1 0.685593
R18 rf_out_p.n1 rf_out_p.n0 0.186531
R19 rf_out_n rf_out_n.n2 7.11117
R20 rf_out_n.n0 rf_out_n.t5 4.77599
R21 rf_out_n.n0 rf_out_n.t2 4.72949
R22 rf_out_n.n0 rf_out_n.t1 4.72949
R23 rf_out_n.n1 rf_out_n.t4 4.72949
R24 rf_out_n.n1 rf_out_n.t3 4.72949
R25 rf_out_n.n1 rf_out_n.t0 4.72949
R26 rf_out_n.n2 rf_out_n.t6 2.40801
R27 rf_out_n.n2 rf_out_n.n1 0.685593
R28 rf_out_n.n1 rf_out_n.n0 0.186531
R29 di_en.n0 di_en.t1 26.3252
R30 di_en.n0 di_en.t0 24.5065
R31 di_en di_en.n0 10.1632
R32 vdd_core.n87 vdd_core.n86 6.52948
R33 vdd_core.n46 vdd_core.n45 6.52948
R34 vdd_core.n102 vdd_core.n101 6.47038
R35 vdd_core.n169 vdd_core.n168 6.47038
R36 vdd_core.n235 vdd_core.n234 6.05177
R37 vdd_core.n212 vdd_core.n24 6.00132
R38 vdd_core.n3 vdd_core.t3 4.76919
R39 vdd_core.n0 vdd_core.t9 4.76919
R40 vdd_core.n107 vdd_core.t4 4.74635
R41 vdd_core.n126 vdd_core.t1 4.74635
R42 vdd_core.n4 vdd_core.t8 4.72949
R43 vdd_core.n110 vdd_core.t7 4.72949
R44 vdd_core.n111 vdd_core.t5 4.72949
R45 vdd_core.n125 vdd_core.t18 4.72949
R46 vdd_core.n121 vdd_core.t16 4.72949
R47 vdd_core.n1 vdd_core.t10 4.72949
R48 vdd_core.n113 vdd_core.t0 4.17215
R49 vdd_core.n128 vdd_core.t2 4.00826
R50 vdd_core.n108 vdd_core.t22 3.71265
R51 vdd_core.n123 vdd_core.t23 3.6936
R52 vdd_core.n143 vdd_core.n142 3.55422
R53 vdd_core.n108 vdd_core.t24 3.41873
R54 vdd_core.n109 vdd_core.t26 3.41873
R55 vdd_core.n123 vdd_core.t25 3.39968
R56 vdd_core.n124 vdd_core.t27 3.39968
R57 vdd_core.n147 vdd_core.n117 3.34302
R58 vdd_core.n136 vdd_core.n115 3.13182
R59 vdd_core.n134 vdd_core.n120 2.4579
R60 vdd_core.n141 vdd_core.n140 2.3523
R61 vdd_core.n145 vdd_core.n116 2.3523
R62 vdd_core.n4 vdd_core.n3 0.0338961
R63 vdd_core.n1 vdd_core.n0 0.0338961
R64 vdd_core.n148 vdd_core.n114 2.2467
R65 vdd_core.n138 vdd_core.n137 2.2467
R66 vdd_core.n7 vdd_core.n115 0.0886235
R67 vdd_core.n130 vdd_core.n129 1.94587
R68 vdd_core.n149 vdd_core.n148 1.86783
R69 vdd_core.n133 vdd_core.n132 1.79979
R70 vdd_core.n142 vdd_core.n135 1.72436
R71 vdd_core.n144 vdd_core.n143 1.72436
R72 vdd_core.n147 vdd_core.n146 1.64893
R73 vdd_core.n139 vdd_core.n117 1.64893
R74 vdd_core.n136 vdd_core.n8 0.134007
R75 vdd_core.n129 vdd_core.n118 1.44601
R76 vdd_core.n131 vdd_core.n119 1.16033
R77 vdd_core.n2 vdd_core.n107 1.12056
R78 vdd_core.n127 vdd_core.n126 1.12056
R79 vdd_core vdd_core.n248 0.9603
R80 vdd_core.n150 vdd_core.n149 0.917955
R81 vdd_core.n129 vdd_core.n128 0.833239
R82 vdd_core.n2 vdd_core.n112 0.741487
R83 vdd_core.n127 vdd_core.n122 0.741487
R84 vdd_core.n150 vdd_core.n79 0.56175
R85 vdd_core.n248 vdd_core.n247 0.5505
R86 vdd_core.n14 vdd_core.n9 0.5505
R87 vdd_core.n217 vdd_core.n216 0.5505
R88 vdd_core.n219 vdd_core.n218 0.5505
R89 vdd_core.n221 vdd_core.n220 0.5505
R90 vdd_core.n225 vdd_core.n181 0.5505
R91 vdd_core.n230 vdd_core.n229 0.5505
R92 vdd_core.n232 vdd_core.n231 0.5505
R93 vdd_core.n178 vdd_core.n26 0.5505
R94 vdd_core.n175 vdd_core.n174 0.5505
R95 vdd_core.n173 vdd_core.n172 0.5505
R96 vdd_core.n60 vdd_core.n37 0.5505
R97 vdd_core.n166 vdd_core.n165 0.5505
R98 vdd_core.n164 vdd_core.n47 0.5505
R99 vdd_core.n163 vdd_core.n162 0.5505
R100 vdd_core.n155 vdd_core.n63 0.5505
R101 vdd_core.n152 vdd_core.n151 0.5505
R102 vdd_core.n150 vdd_core.n106 0.5505
R103 vdd_core.n246 vdd_core.n11 0.446709
R104 vdd_core.n246 vdd_core.n245 0.445751
R105 vdd_core.n97 vdd_core.n84 0.4405
R106 vdd_core.n89 vdd_core.n88 0.4405
R107 vdd_core.n50 vdd_core.n43 0.4405
R108 vdd_core.n49 vdd_core.n48 0.4405
R109 vdd_core.n192 vdd_core.n190 0.4405
R110 vdd_core.n191 vdd_core.n183 0.4405
R111 vdd_core.n101 vdd_core.n84 0.4405
R112 vdd_core.n88 vdd_core.n87 0.4405
R113 vdd_core.n168 vdd_core.n43 0.4405
R114 vdd_core.n48 vdd_core.n46 0.4405
R115 vdd_core.n190 vdd_core.n189 0.4405
R116 vdd_core.n184 vdd_core.n183 0.4405
R117 vdd_core.n131 vdd_core.n130 0.421631
R118 vdd_core.n95 vdd_core.n94 0.3635
R119 vdd_core.n94 vdd_core.n81 0.3635
R120 vdd_core.n77 vdd_core.n75 0.3635
R121 vdd_core.n75 vdd_core.n73 0.3635
R122 vdd_core.n69 vdd_core.n67 0.3635
R123 vdd_core.n67 vdd_core.n65 0.3635
R124 vdd_core.n92 vdd_core.n91 0.3635
R125 vdd_core.n91 vdd_core.n80 0.3635
R126 vdd_core.n76 vdd_core.n74 0.3635
R127 vdd_core.n74 vdd_core.n72 0.3635
R128 vdd_core.n68 vdd_core.n66 0.3635
R129 vdd_core.n66 vdd_core.n64 0.3635
R130 vdd_core.n58 vdd_core.n54 0.3635
R131 vdd_core.n58 vdd_core.n57 0.3635
R132 vdd_core.n42 vdd_core.n35 0.3635
R133 vdd_core.n35 vdd_core.n33 0.3635
R134 vdd_core.n29 vdd_core.n27 0.3635
R135 vdd_core.n27 vdd_core.n5 0.421153
R136 vdd_core.n56 vdd_core.n53 0.3635
R137 vdd_core.n56 vdd_core.n55 0.3635
R138 vdd_core.n44 vdd_core.n34 0.3635
R139 vdd_core.n34 vdd_core.n32 0.3635
R140 vdd_core.n198 vdd_core.n196 0.3635
R141 vdd_core.n200 vdd_core.n198 0.3635
R142 vdd_core.n211 vdd_core.n210 0.3635
R143 vdd_core.n210 vdd_core.n209 0.3635
R144 vdd_core.n207 vdd_core.n206 0.3635
R145 vdd_core.n206 vdd_core.n205 0.3635
R146 vdd_core.n185 vdd_core.n184 0.3635
R147 vdd_core.n197 vdd_core.n195 0.3635
R148 vdd_core.n199 vdd_core.n197 0.3635
R149 vdd_core.n237 vdd_core.n236 0.3635
R150 vdd_core.n238 vdd_core.n237 0.3635
R151 vdd_core.n241 vdd_core.n240 0.3635
R152 vdd_core.n242 vdd_core.n241 0.3635
R153 vdd_core.n158 vdd_core.n64 0.345639
R154 vdd_core.n2 vdd_core.n109 0.33314
R155 vdd_core.n160 vdd_core.n159 0.299759
R156 vdd_core.n109 vdd_core.n108 0.29442
R157 vdd_core.n124 vdd_core.n123 0.29442
R158 vdd_core.n187 vdd_core.n24 0.276447
R159 vdd_core.n189 vdd_core.n188 0.276447
R160 vdd_core.n194 vdd_core.n192 0.276447
R161 vdd_core.n196 vdd_core.n194 0.276447
R162 vdd_core.n202 vdd_core.n200 0.276447
R163 vdd_core.n209 vdd_core.n208 0.276447
R164 vdd_core.n208 vdd_core.n207 0.276447
R165 vdd_core.n205 vdd_core.n204 0.276447
R166 vdd_core.n203 vdd_core.n11 0.276447
R167 vdd_core.n234 vdd_core.n23 0.276447
R168 vdd_core.n193 vdd_core.n191 0.276447
R169 vdd_core.n195 vdd_core.n193 0.276447
R170 vdd_core.n201 vdd_core.n199 0.276447
R171 vdd_core.n239 vdd_core.n238 0.276447
R172 vdd_core.n240 vdd_core.n239 0.276447
R173 vdd_core.n243 vdd_core.n242 0.276447
R174 vdd_core.n245 vdd_core.n244 0.276447
R175 vdd_core.n97 vdd_core.n96 0.276188
R176 vdd_core.n96 vdd_core.n95 0.276188
R177 vdd_core.n104 vdd_core.n81 0.276188
R178 vdd_core.n73 vdd_core.n71 0.276188
R179 vdd_core.n71 vdd_core.n69 0.276188
R180 vdd_core.n160 vdd_core.n65 0.276188
R181 vdd_core.n90 vdd_core.n89 0.276188
R182 vdd_core.n92 vdd_core.n90 0.276188
R183 vdd_core.n83 vdd_core.n80 0.276188
R184 vdd_core.n72 vdd_core.n70 0.276188
R185 vdd_core.n70 vdd_core.n68 0.276188
R186 vdd_core.n52 vdd_core.n50 0.276188
R187 vdd_core.n54 vdd_core.n52 0.276188
R188 vdd_core.n57 vdd_core.n39 0.276188
R189 vdd_core.n33 vdd_core.n31 0.276188
R190 vdd_core.n31 vdd_core.n29 0.276188
R191 vdd_core.n51 vdd_core.n49 0.276188
R192 vdd_core.n53 vdd_core.n51 0.276188
R193 vdd_core.n55 vdd_core.n38 0.276188
R194 vdd_core.n32 vdd_core.n30 0.276188
R195 vdd_core.n30 vdd_core.n28 0.276188
R196 vdd_core.n144 vdd_core.n118 0.264545
R197 vdd_core.n102 vdd_core.n77 0.2645
R198 vdd_core.n86 vdd_core.n76 0.2645
R199 vdd_core.n169 vdd_core.n42 0.2645
R200 vdd_core.n45 vdd_core.n44 0.2645
R201 vdd_core.n212 vdd_core.n211 0.2645
R202 vdd_core.n236 vdd_core.n235 0.2645
R203 vdd_core.n8 vdd_core.n138 0.449962
R204 vdd_core.n119 vdd_core.n118 0.249794
R205 vdd_core.n188 vdd_core.n187 0.199447
R206 vdd_core.n213 vdd_core.n202 0.199447
R207 vdd_core.n204 vdd_core.n203 0.199447
R208 vdd_core.n185 vdd_core.n23 0.199447
R209 vdd_core.n201 vdd_core.n22 0.199447
R210 vdd_core.n244 vdd_core.n243 0.199447
R211 vdd_core.n104 vdd_core.n103 0.199188
R212 vdd_core.n85 vdd_core.n83 0.199188
R213 vdd_core.n170 vdd_core.n39 0.199188
R214 vdd_core.n41 vdd_core.n38 0.199188
R215 vdd_core.n133 vdd_core.n130 0.195018
R216 vdd_core.n127 vdd_core.n124 0.175092
R217 vdd_core.n146 vdd_core.n114 0.1061
R218 vdd_core.n139 vdd_core.n138 0.1061
R219 vdd_core.n140 vdd_core.n135 0.1061
R220 vdd_core.n134 vdd_core.n133 0.1061
R221 vdd_core.n145 vdd_core.n144 0.1061
R222 vdd_core.n113 vdd_core.n2 0.102521
R223 vdd_core.n231 vdd_core.n180 0.1019
R224 vdd_core.n96 vdd_core.n79 0.101071
R225 vdd_core.n94 vdd_core.n82 0.101071
R226 vdd_core.n105 vdd_core.n104 0.101071
R227 vdd_core.n103 vdd_core.n78 0.101071
R228 vdd_core.n153 vdd_core.n75 0.101071
R229 vdd_core.n155 vdd_core.n71 0.101071
R230 vdd_core.n157 vdd_core.n67 0.101071
R231 vdd_core.n161 vdd_core.n160 0.101071
R232 vdd_core.n90 vdd_core.n79 0.101071
R233 vdd_core.n91 vdd_core.n82 0.101071
R234 vdd_core.n105 vdd_core.n83 0.101071
R235 vdd_core.n85 vdd_core.n78 0.101071
R236 vdd_core.n153 vdd_core.n74 0.101071
R237 vdd_core.n155 vdd_core.n70 0.101071
R238 vdd_core.n157 vdd_core.n66 0.101071
R239 vdd_core.n61 vdd_core.n52 0.101071
R240 vdd_core.n59 vdd_core.n58 0.101071
R241 vdd_core.n172 vdd_core.n39 0.101071
R242 vdd_core.n171 vdd_core.n170 0.101071
R243 vdd_core.n175 vdd_core.n35 0.101071
R244 vdd_core.n177 vdd_core.n31 0.101071
R245 vdd_core.n179 vdd_core.n27 0.101071
R246 vdd_core.n61 vdd_core.n51 0.101071
R247 vdd_core.n59 vdd_core.n56 0.101071
R248 vdd_core.n172 vdd_core.n38 0.101071
R249 vdd_core.n171 vdd_core.n41 0.101071
R250 vdd_core.n175 vdd_core.n34 0.101071
R251 vdd_core.n177 vdd_core.n30 0.101071
R252 vdd_core.n179 vdd_core.n6 0.00761283
R253 vdd_core.n187 vdd_core.n25 0.101071
R254 vdd_core.n188 vdd_core.n186 0.101071
R255 vdd_core.n226 vdd_core.n194 0.101071
R256 vdd_core.n223 vdd_core.n198 0.101071
R257 vdd_core.n215 vdd_core.n202 0.101071
R258 vdd_core.n214 vdd_core.n213 0.101071
R259 vdd_core.n210 vdd_core.n20 0.101071
R260 vdd_core.n208 vdd_core.n18 0.101071
R261 vdd_core.n206 vdd_core.n16 0.101071
R262 vdd_core.n204 vdd_core.n13 0.101071
R263 vdd_core.n203 vdd_core.n12 0.101071
R264 vdd_core.n25 vdd_core.n23 0.101071
R265 vdd_core.n186 vdd_core.n185 0.101071
R266 vdd_core.n226 vdd_core.n193 0.101071
R267 vdd_core.n223 vdd_core.n197 0.101071
R268 vdd_core.n215 vdd_core.n201 0.101071
R269 vdd_core.n214 vdd_core.n22 0.101071
R270 vdd_core.n237 vdd_core.n20 0.101071
R271 vdd_core.n239 vdd_core.n18 0.101071
R272 vdd_core.n241 vdd_core.n16 0.101071
R273 vdd_core.n243 vdd_core.n13 0.101071
R274 vdd_core.n244 vdd_core.n12 0.101071
R275 vdd_core.n128 vdd_core.n127 0.0955821
R276 vdd_core.n7 vdd_core.n8 0.872565
R277 vdd_core.n7 vdd_core.n114 0.433741
R278 vdd_core.n140 vdd_core.n139 0.0759286
R279 vdd_core.n135 vdd_core.n134 0.0759286
R280 vdd_core.n146 vdd_core.n145 0.0759286
R281 vdd_core.n100 vdd_core.n87 0.0759286
R282 vdd_core.n101 vdd_core.n100 0.0759286
R283 vdd_core.n162 vdd_core.n65 0.0759286
R284 vdd_core.n156 vdd_core.n69 0.0759286
R285 vdd_core.n154 vdd_core.n73 0.0759286
R286 vdd_core.n152 vdd_core.n77 0.0759286
R287 vdd_core.n106 vdd_core.n81 0.0759286
R288 vdd_core.n95 vdd_core.n93 0.0759286
R289 vdd_core.n98 vdd_core.n97 0.0759286
R290 vdd_core.n99 vdd_core.n84 0.0759286
R291 vdd_core.n162 vdd_core.n64 0.0759286
R292 vdd_core.n156 vdd_core.n68 0.0759286
R293 vdd_core.n154 vdd_core.n72 0.0759286
R294 vdd_core.n152 vdd_core.n76 0.0759286
R295 vdd_core.n106 vdd_core.n80 0.0759286
R296 vdd_core.n93 vdd_core.n92 0.0759286
R297 vdd_core.n99 vdd_core.n88 0.0759286
R298 vdd_core.n98 vdd_core.n89 0.0759286
R299 vdd_core.n167 vdd_core.n46 0.0759286
R300 vdd_core.n168 vdd_core.n167 0.0759286
R301 vdd_core.n178 vdd_core.n29 0.0759286
R302 vdd_core.n176 vdd_core.n33 0.0759286
R303 vdd_core.n42 vdd_core.n36 0.0759286
R304 vdd_core.n57 vdd_core.n40 0.0759286
R305 vdd_core.n60 vdd_core.n54 0.0759286
R306 vdd_core.n62 vdd_core.n50 0.0759286
R307 vdd_core.n166 vdd_core.n43 0.0759286
R308 vdd_core.n6 vdd_core.n28 0.439821
R309 vdd_core.n178 vdd_core.n28 0.0759286
R310 vdd_core.n176 vdd_core.n32 0.0759286
R311 vdd_core.n44 vdd_core.n36 0.0759286
R312 vdd_core.n55 vdd_core.n40 0.0759286
R313 vdd_core.n60 vdd_core.n53 0.0759286
R314 vdd_core.n166 vdd_core.n48 0.0759286
R315 vdd_core.n62 vdd_core.n49 0.0759286
R316 vdd_core.n234 vdd_core.n233 0.0759286
R317 vdd_core.n233 vdd_core.n24 0.0759286
R318 vdd_core.n11 vdd_core.n10 0.0759286
R319 vdd_core.n205 vdd_core.n15 0.0759286
R320 vdd_core.n207 vdd_core.n17 0.0759286
R321 vdd_core.n209 vdd_core.n19 0.0759286
R322 vdd_core.n211 vdd_core.n21 0.0759286
R323 vdd_core.n222 vdd_core.n200 0.0759286
R324 vdd_core.n224 vdd_core.n196 0.0759286
R325 vdd_core.n227 vdd_core.n192 0.0759286
R326 vdd_core.n228 vdd_core.n190 0.0759286
R327 vdd_core.n189 vdd_core.n182 0.0759286
R328 vdd_core.n245 vdd_core.n10 0.0759286
R329 vdd_core.n242 vdd_core.n15 0.0759286
R330 vdd_core.n240 vdd_core.n17 0.0759286
R331 vdd_core.n238 vdd_core.n19 0.0759286
R332 vdd_core.n236 vdd_core.n21 0.0759286
R333 vdd_core.n222 vdd_core.n199 0.0759286
R334 vdd_core.n224 vdd_core.n195 0.0759286
R335 vdd_core.n184 vdd_core.n182 0.0759286
R336 vdd_core.n228 vdd_core.n183 0.0759286
R337 vdd_core.n227 vdd_core.n191 0.0759286
R338 vdd_core.n167 vdd_core.n47 0.0738333
R339 vdd_core.n148 vdd_core.n115 0.0621
R340 vdd_core.n137 vdd_core.n136 0.0621
R341 vdd_core.n141 vdd_core.n117 0.0621
R342 vdd_core.n142 vdd_core.n120 0.0621
R343 vdd_core.n143 vdd_core.n119 0.0621
R344 vdd_core.n147 vdd_core.n116 0.0621
R345 vdd_core.n132 vdd_core.n131 0.0383489
R346 vdd_core.n5 vdd_core.n6 0.0351511
R347 vdd_core.n179 vdd_core.n178 0.0371667
R348 vdd_core.n178 vdd_core.n177 0.0371667
R349 vdd_core.n177 vdd_core.n176 0.0371667
R350 vdd_core.n176 vdd_core.n175 0.0371667
R351 vdd_core.n175 vdd_core.n36 0.0371667
R352 vdd_core.n171 vdd_core.n36 0.0371667
R353 vdd_core.n172 vdd_core.n171 0.0371667
R354 vdd_core.n172 vdd_core.n40 0.0371667
R355 vdd_core.n59 vdd_core.n40 0.0371667
R356 vdd_core.n60 vdd_core.n59 0.0371667
R357 vdd_core.n61 vdd_core.n60 0.0371667
R358 vdd_core.n62 vdd_core.n61 0.0371667
R359 vdd_core.n166 vdd_core.n62 0.0371667
R360 vdd_core.n167 vdd_core.n166 0.0371667
R361 vdd_core.n159 vdd_core.n47 0.0371667
R362 vdd_core.n162 vdd_core.n161 0.0371667
R363 vdd_core.n162 vdd_core.n157 0.0371667
R364 vdd_core.n157 vdd_core.n156 0.0371667
R365 vdd_core.n156 vdd_core.n155 0.0371667
R366 vdd_core.n155 vdd_core.n154 0.0371667
R367 vdd_core.n154 vdd_core.n153 0.0371667
R368 vdd_core.n153 vdd_core.n152 0.0371667
R369 vdd_core.n152 vdd_core.n78 0.0371667
R370 vdd_core.n105 vdd_core.n78 0.0371667
R371 vdd_core.n106 vdd_core.n105 0.0371667
R372 vdd_core.n106 vdd_core.n82 0.0371667
R373 vdd_core.n93 vdd_core.n82 0.0371667
R374 vdd_core.n93 vdd_core.n79 0.0371667
R375 vdd_core.n98 vdd_core.n79 0.0371667
R376 vdd_core.n99 vdd_core.n98 0.0371667
R377 vdd_core.n100 vdd_core.n99 0.0371667
R378 vdd_core.n12 vdd_core.n10 0.0371667
R379 vdd_core.n13 vdd_core.n12 0.0371667
R380 vdd_core.n16 vdd_core.n15 0.0371667
R381 vdd_core.n17 vdd_core.n16 0.0371667
R382 vdd_core.n19 vdd_core.n18 0.0371667
R383 vdd_core.n20 vdd_core.n19 0.0371667
R384 vdd_core.n214 vdd_core.n21 0.0371667
R385 vdd_core.n215 vdd_core.n214 0.0371667
R386 vdd_core.n223 vdd_core.n222 0.0371667
R387 vdd_core.n224 vdd_core.n223 0.0371667
R388 vdd_core.n227 vdd_core.n226 0.0371667
R389 vdd_core.n228 vdd_core.n227 0.0371667
R390 vdd_core.n186 vdd_core.n182 0.0371667
R391 vdd_core.n186 vdd_core.n25 0.0371667
R392 vdd_core.n148 vdd_core.n147 0.0319286
R393 vdd_core.n137 vdd_core.n117 0.0319286
R394 vdd_core.n142 vdd_core.n141 0.0319286
R395 vdd_core.n132 vdd_core.n120 0.0319286
R396 vdd_core.n143 vdd_core.n116 0.0319286
R397 vdd_core.n111 vdd_core.n107 0.0310403
R398 vdd_core.n126 vdd_core.n125 0.0310403
R399 vdd_core.n3 vdd_core.n2 0.59294
R400 vdd_core.n247 vdd_core.n10 0.028
R401 vdd_core.n15 vdd_core.n14 0.028
R402 vdd_core.n216 vdd_core.n18 0.028
R403 vdd_core.n218 vdd_core.n21 0.028
R404 vdd_core.n222 vdd_core.n221 0.028
R405 vdd_core.n226 vdd_core.n225 0.028
R406 vdd_core.n229 vdd_core.n182 0.028
R407 vdd_core.n233 vdd_core.n232 0.028
R408 vdd_core.n159 vdd_core.n158 0.0261384
R409 vdd_core.n125 vdd_core.n122 0.0260771
R410 vdd_core.n112 vdd_core.n111 0.0257351
R411 vdd_core.n112 vdd_core.n110 0.0233414
R412 vdd_core.n248 vdd_core.n9 0.023
R413 vdd_core.n217 vdd_core.n9 0.023
R414 vdd_core.n219 vdd_core.n217 0.023
R415 vdd_core.n220 vdd_core.n219 0.023
R416 vdd_core.n220 vdd_core.n181 0.023
R417 vdd_core.n230 vdd_core.n181 0.023
R418 vdd_core.n231 vdd_core.n230 0.023
R419 vdd_core.n180 vdd_core.n26 0.023
R420 vdd_core.n174 vdd_core.n26 0.023
R421 vdd_core.n174 vdd_core.n173 0.023
R422 vdd_core.n173 vdd_core.n37 0.023
R423 vdd_core.n165 vdd_core.n37 0.023
R424 vdd_core.n165 vdd_core.n164 0.023
R425 vdd_core.n164 vdd_core.n163 0.023
R426 vdd_core.n163 vdd_core.n63 0.023
R427 vdd_core.n151 vdd_core.n63 0.023
R428 vdd_core.n122 vdd_core.n121 0.0229994
R429 vdd_core.n110 vdd_core.n4 0.022386
R430 vdd_core.n121 vdd_core.n1 0.022386
R431 vdd_core.n127 vdd_core.n0 0.59294
R432 vdd_core.n213 vdd_core.n212 0.0124467
R433 vdd_core.n235 vdd_core.n22 0.0124467
R434 vdd_core.n103 vdd_core.n102 0.0121878
R435 vdd_core.n86 vdd_core.n85 0.0121878
R436 vdd_core.n170 vdd_core.n169 0.0121878
R437 vdd_core.n45 vdd_core.n41 0.0121878
R438 vdd_core.n151 vdd_core.n150 0.01175
R439 vdd_core.n247 vdd_core.n246 0.0113759
R440 vdd_core.n14 vdd_core.n13 0.00966667
R441 vdd_core.n216 vdd_core.n17 0.00966667
R442 vdd_core.n218 vdd_core.n20 0.00966667
R443 vdd_core.n221 vdd_core.n215 0.00966667
R444 vdd_core.n225 vdd_core.n224 0.00966667
R445 vdd_core.n229 vdd_core.n228 0.00966667
R446 vdd_core.n232 vdd_core.n25 0.00966667
R447 vdd_core.n161 vdd_core.n158 0.00944821
R448 vdd_core.n113 vdd_core.n149 1.16529
R449 vdd_core.n5 vdd_core.n180 0.578991
R450 VDD VDD.n9 17.9801
R451 VDD VDD.n8 17.071
R452 VDD.n7 VDD.t10 17.0005
R453 VDD.n5 VDD.t4 17.0005
R454 VDD.n3 VDD.t0 17.0005
R455 VDD.n1 VDD.t6 11.3356
R456 VDD.n0 VDD.t2 11.3356
R457 VDD.n7 VDD.t11 6.19097
R458 VDD.n5 VDD.t5 6.19097
R459 VDD.n3 VDD.t1 6.19097
R460 VDD.n9 VDD.t9 4.22454
R461 VDD.n1 VDD.t7 2.44293
R462 VDD.n0 VDD.t3 2.44281
R463 VDD.n2 VDD.n0 1.42463
R464 VDD.n4 VDD.n2 0.851625
R465 VDD.n8 VDD.n7 0.751488
R466 VDD.n6 VDD.n5 0.751488
R467 VDD.n4 VDD.n3 0.751488
R468 VDD.n9 VDD.t8 0.517741
R469 VDD.n8 VDD.n6 0.370375
R470 VDD.n6 VDD.n4 0.370375
R471 VDD.n2 VDD.n1 0.143127
R472 vtune vtune.n1 16.693
R473 vtune.n0 vtune.t0 16.1774
R474 vtune.n0 vtune.t3 14.7078
R475 vtune.n1 vtune.t6 14.7078
R476 vtune.n1 vtune.n0 1.4701
R477 VSS.n205 VSS.n204 4127.1
R478 VSS.n27 VSS.t15 1963.69
R479 VSS.n252 VSS.t114 1390.68
R480 VSS.t110 VSS.t111 804.431
R481 VSS.n192 VSS.n27 712.367
R482 VSS.n191 VSS.t109 552.61
R483 VSS.t111 VSS.n190 547.362
R484 VSS.t114 VSS.t115 374.546
R485 VSS.n190 VSS.t113 287.356
R486 VSS.n255 VSS.n254 278.832
R487 VSS.t109 VSS.n114 254.446
R488 VSS.n191 VSS.t110 168.756
R489 VSS.t113 VSS.t112 141.554
R490 VSS.n189 VSS.n175 141.554
R491 VSS.t115 VSS.n251 132.113
R492 VSS.n45 VSS.n257 100.391
R493 VSS.n190 VSS.n189 71.2493
R494 VSS.t11 VSS.t13 70.7775
R495 VSS.n179 VSS.n175 47.1851
R496 VSS.n195 VSS.n194 40.7645
R497 VSS.n27 VSS.t9 7.16456
R498 VSS.n110 VSS.t63 35.0371
R499 VSS.n116 VSS.t57 33.2884
R500 VSS.n179 VSS.t11 33.0298
R501 VSS.t60 VSS.n116 29.7909
R502 VSS.t55 VSS.n114 28.8551
R503 VSS.t62 VSS.n110 28.0421
R504 VSS.n115 VSS.t59 27.4296
R505 VSS.n118 VSS.t98 26.6691
R506 VSS.t100 VSS.n107 26.6691
R507 VSS.n120 VSS.t102 26.6691
R508 VSS.t3 VSS.n27 11.5004
R509 VSS.t7 VSS.n27 11.5013
R510 VSS.t59 VSS.n111 23.9329
R511 VSS.t13 VSS.t15 23.5928
R512 VSS.t97 VSS.n109 22.6205
R513 VSS.n204 VSS.n121 22.5291
R514 VSS.n117 VSS.t62 20.4345
R515 VSS.n119 VSS.t66 20.1113
R516 VSS.t108 VSS.t70 19.8391
R517 VSS.t116 VSS.t53 19.8391
R518 VSS.t69 VSS.n104 19.5029
R519 VSS.t82 VSS.n133 19.5029
R520 VSS.t88 VSS.n91 19.3829
R521 VSS.n117 VSS.t60 18.6866
R522 VSS.t92 VSS.n246 18.4749
R523 VSS.n170 VSS.t77 18.1579
R524 VSS.n200 VSS.t78 18.1579
R525 VSS.t99 VSS.n107 17.9253
R526 VSS.n120 VSS.t101 17.9253
R527 VSS.n180 VSS.t16 17.4597
R528 VSS.n178 VSS.t128 17.4597
R529 VSS.n256 VSS.n255 17.0005
R530 VSS.n256 VSS.n68 17.0005
R531 VSS.n256 VSS.n77 17.0005
R532 VSS.n256 VSS.n70 17.0005
R533 VSS.n256 VSS.n75 17.0005
R534 VSS.n257 VSS.n256 17.0005
R535 VSS.n253 VSS.n252 17.0005
R536 VSS.n253 VSS.n79 17.0005
R537 VSS.n253 VSS.n86 17.0005
R538 VSS.n253 VSS.n81 17.0005
R539 VSS.n253 VSS.n84 17.0005
R540 VSS.n254 VSS.n253 17.0005
R541 VSS.n207 VSS.n136 17.0005
R542 VSS.n207 VSS.n94 17.0005
R543 VSS.n207 VSS.n135 17.0005
R544 VSS.n207 VSS.n164 17.0005
R545 VSS.n207 VSS.n206 17.0005
R546 VSS.n207 VSS.n95 17.0005
R547 VSS.n207 VSS.n133 17.0005
R548 VSS.n207 VSS.n165 17.0005
R549 VSS.n207 VSS.n203 17.0005
R550 VSS.n207 VSS.n96 17.0005
R551 VSS.n207 VSS.n202 17.0005
R552 VSS.n207 VSS.n166 17.0005
R553 VSS.n207 VSS.n129 17.0005
R554 VSS.n207 VSS.n167 17.0005
R555 VSS.n207 VSS.n201 17.0005
R556 VSS.n207 VSS.n168 17.0005
R557 VSS.n207 VSS.n200 17.0005
R558 VSS.n207 VSS.n170 17.0005
R559 VSS.n207 VSS.n199 17.0005
R560 VSS.n207 VSS.n172 17.0005
R561 VSS.n207 VSS.n198 17.0005
R562 VSS.n207 VSS.n101 17.0005
R563 VSS.n207 VSS.n197 17.0005
R564 VSS.n207 VSS.n173 17.0005
R565 VSS.n207 VSS.n122 17.0005
R566 VSS.n207 VSS.n174 17.0005
R567 VSS.n207 VSS.n196 17.0005
R568 VSS.n207 VSS.n104 17.0005
R569 VSS.n207 VSS.n121 17.0005
R570 VSS.n207 VSS.n192 17.0005
R571 VSS.n43 VSS.n44 0.829068
R572 VSS.n251 VSS.n250 17.0005
R573 VSS.n250 VSS.n92 17.0005
R574 VSS.n250 VSS.n136 17.0005
R575 VSS.n250 VSS.n94 17.0005
R576 VSS.n250 VSS.n135 17.0005
R577 VSS.n250 VSS.n95 17.0005
R578 VSS.n250 VSS.n133 17.0005
R579 VSS.n250 VSS.n96 17.0005
R580 VSS.n250 VSS.n129 17.0005
R581 VSS.n250 VSS.n98 17.0005
R582 VSS.n250 VSS.n124 17.0005
R583 VSS.n250 VSS.n101 17.0005
R584 VSS.n250 VSS.n122 17.0005
R585 VSS.n250 VSS.n104 17.0005
R586 VSS.n250 VSS.n121 17.0005
R587 VSS.n250 VSS.n105 17.0005
R588 VSS.n250 VSS.n120 17.0005
R589 VSS.n250 VSS.n106 17.0005
R590 VSS.n250 VSS.n119 17.0005
R591 VSS.n250 VSS.n107 17.0005
R592 VSS.n250 VSS.n118 17.0005
R593 VSS.n250 VSS.n114 17.0005
R594 VSS.n179 VSS.n178 17.0005
R595 VSS.n180 VSS.n179 17.0005
R596 VSS.n182 VSS.n175 17.0005
R597 VSS.n186 VSS.n175 17.0005
R598 VSS.t79 VSS.n95 16.8129
R599 VSS.t94 VSS.n88 16.7178
R600 VSS.n246 VSS.t91 16.659
R601 VSS.n91 VSS.t89 15.751
R602 VSS.t57 VSS.n111 15.1883
R603 VSS.n251 VSS.t95 14.9823
R604 VSS.n247 VSS.t94 14.901
R605 VSS.n118 VSS.t65 14.865
R606 VSS.n245 VSS.t127 14.2208
R607 VSS.t73 VSS.n172 14.1229
R608 VSS.n201 VSS.t75 14.1229
R609 VSS.n45 VSS.t29 4.16041
R610 VSS.t126 VSS.n92 13.8474
R611 VSS.t103 VSS.n104 13.7866
R612 VSS.t105 VSS.n122 13.7866
R613 VSS.t107 VSS.n101 13.7866
R614 VSS.t117 VSS.n129 13.7866
R615 VSS.t119 VSS.n96 13.7866
R616 VSS.n133 VSS.t121 13.7866
R617 VSS.n169 VSS.n97 13.6726
R618 VSS.n171 VSS.n123 13.6726
R619 VSS.t63 VSS.n109 13.4403
R620 VSS.t89 VSS.n90 13.0858
R621 VSS.n27 VSS.n191 9.17979
R622 VSS.n204 VSS.n195 12.4359
R623 VSS.n163 VSS.t124 12.2584
R624 VSS.t91 VSS.n90 12.1771
R625 VSS.t101 VSS.n106 11.8046
R626 VSS.n115 VSS.t55 11.6916
R627 VSS.n189 VSS.n177 11.3338
R628 VSS.n189 VSS.n176 11.3338
R629 VSS.n189 VSS.n188 11.3338
R630 VSS.t98 VSS.n108 10.9917
R631 VSS.n108 VSS.t51 10.5545
R632 VSS.t83 VSS.n94 10.4424
R633 VSS.t106 VSS.t72 10.4242
R634 VSS.t118 VSS.t81 10.4242
R635 VSS.n247 VSS.t92 10.3618
R636 VSS.t72 VSS.n122 10.0879
R637 VSS.t81 VSS.n96 10.0879
R638 VSS.n263 VSS.n262 9.75612
R639 VSS.n45 VSS.t23 4.98598
R640 VSS.t66 VSS.n106 9.61869
R641 VSS.n245 VSS.t88 9.4531
R642 VSS.n164 VSS.t123 9.3074
R643 VSS.n136 VSS.t125 9.3074
R644 VSS.n27 VSS.n47 11.5906
R645 VSS.t51 VSS.t99 9.1815
R646 VSS.n121 VSS.t103 9.07918
R647 VSS.n174 VSS.t105 9.07918
R648 VSS.n197 VSS.t107 9.07918
R649 VSS.n166 VSS.t117 9.07918
R650 VSS.n203 VSS.t119 9.07918
R651 VSS.t121 VSS.n95 9.07918
R652 VSS.t0 VSS.n27 7.16186
R653 VSS.n199 VSS.t73 8.74293
R654 VSS.t75 VSS.n168 8.74293
R655 VSS.n88 VSS.t95 8.54511
R656 VSS.n194 VSS.n28 0.25696
R657 VSS.n163 VSS.n41 0.249764
R658 VSS.n45 VSS.n49 2.22314
R659 VSS.n41 VSS.n162 8.53756
R660 VSS.n28 VSS.n193 8.54656
R661 VSS VSS.n263 8.10482
R662 VSS.n262 VSS.n52 7.76695
R663 VSS.t86 VSS.n92 7.71842
R664 VSS.n1 VSS.n42 7.56743
R665 VSS.n5 VSS.n244 7.56743
R666 VSS.n204 VSS.t67 7.43274
R667 VSS.n27 VSS.t5 5.92142
R668 VSS.n257 VSS.t129 6.90359
R669 VSS.n75 VSS.t131 6.90359
R670 VSS.n75 VSS.t133 6.90359
R671 VSS.t134 VSS.n70 6.90359
R672 VSS.t136 VSS.n70 6.90359
R673 VSS.n77 VSS.t137 6.90359
R674 VSS.n77 VSS.t139 6.90359
R675 VSS.t142 VSS.n68 6.90359
R676 VSS.n255 VSS.t143 6.90359
R677 VSS.n254 VSS.t145 6.90359
R678 VSS.n84 VSS.t147 6.90359
R679 VSS.t150 VSS.n81 6.90359
R680 VSS.t152 VSS.n81 6.90359
R681 VSS.n86 VSS.t153 6.90359
R682 VSS.n86 VSS.t155 6.90359
R683 VSS.t156 VSS.n79 6.90359
R684 VSS.t158 VSS.n79 6.90359
R685 VSS.n252 VSS.t159 6.90359
R686 VSS.n93 VSS.t126 6.89806
R687 VSS.n171 VSS.n124 6.83654
R688 VSS.n165 VSS.n131 6.83654
R689 VSS.n166 VSS.n130 6.83654
R690 VSS.n167 VSS.n128 6.83654
R691 VSS.n200 VSS.n99 6.83654
R692 VSS.n198 VSS.n100 6.83654
R693 VSS.n197 VSS.n102 6.83654
R694 VSS.n196 VSS.n103 6.83654
R695 VSS.n174 VSS.n103 6.83654
R696 VSS.n173 VSS.n102 6.83654
R697 VSS.n172 VSS.n100 6.83654
R698 VSS.n199 VSS.n123 6.83654
R699 VSS.n170 VSS.n99 6.83654
R700 VSS.n169 VSS.n98 6.83654
R701 VSS.n168 VSS.n97 6.83654
R702 VSS.n201 VSS.n128 6.83654
R703 VSS.n202 VSS.n130 6.83654
R704 VSS.n203 VSS.n131 6.83654
R705 VSS.n256 VSS.n78 6.69018
R706 VSS.n256 VSS.n69 6.69018
R707 VSS.n256 VSS.n76 6.69018
R708 VSS.n256 VSS.n71 6.69018
R709 VSS.n256 VSS.n72 6.69018
R710 VSS.n253 VSS.n87 6.69018
R711 VSS.n253 VSS.n80 6.69018
R712 VSS.n253 VSS.n85 6.69018
R713 VSS.n253 VSS.n82 6.69018
R714 VSS.n253 VSS.n83 6.69018
R715 VSS.t85 VSS.n93 6.67106
R716 VSS.n35 VSS.n33 6.5067
R717 VSS.n39 VSS.n37 6.5067
R718 VSS.n186 VSS.t17 6.19054
R719 VSS.n182 VSS.t14 6.19054
R720 VSS.t123 VSS.n135 6.12943
R721 VSS.n31 VSS.n29 6.04071
R722 VSS.n72 VSS.t129 5.92367
R723 VSS.t131 VSS.n72 5.92367
R724 VSS.t133 VSS.n71 5.92367
R725 VSS.n71 VSS.t134 5.92367
R726 VSS.n76 VSS.t136 5.92367
R727 VSS.t137 VSS.n76 5.92367
R728 VSS.t139 VSS.n69 5.92367
R729 VSS.t140 VSS.n69 5.92367
R730 VSS.n78 VSS.t142 5.92367
R731 VSS.t143 VSS.n78 5.92367
R732 VSS.n83 VSS.t145 5.92367
R733 VSS.t147 VSS.n83 5.92367
R734 VSS.t149 VSS.n82 5.92367
R735 VSS.n82 VSS.t150 5.92367
R736 VSS.n85 VSS.t152 5.92367
R737 VSS.t153 VSS.n85 5.92367
R738 VSS.t155 VSS.n80 5.92367
R739 VSS.n80 VSS.t156 5.92367
R740 VSS.n87 VSS.t158 5.92367
R741 VSS.t159 VSS.n87 5.92367
R742 VSS.n45 VSS.t20 4.1614
R743 VSS.n250 VSS.n246 5.84696
R744 VSS.n250 VSS.n91 5.84696
R745 VSS.n250 VSS.n93 5.84696
R746 VSS.n250 VSS.n134 5.84696
R747 VSS.n205 VSS.t79 5.71671
R748 VSS.n46 VSS.n45 1.33836
R749 VSS.n161 VSS.n46 0.607936
R750 VSS.n256 VSS.n23 2.7974
R751 VSS.n23 VSS.n16 0.0585658
R752 VSS.n15 VSS.n17 0.0585658
R753 VSS.n256 VSS.n15 2.7974
R754 VSS.n21 VSS.n22 0.0585658
R755 VSS.n253 VSS.n21 2.7974
R756 VSS.n253 VSS.n20 5.65086
R757 VSS.n253 VSS.n11 5.65086
R758 VSS.n47 VSS.t25 3.85837
R759 VSS.n164 VSS.n134 5.30908
R760 VSS.n206 VSS.n134 5.30908
R761 VSS.n207 VSS.n169 5.08323
R762 VSS.n207 VSS.n171 5.08323
R763 VSS.n250 VSS.n131 5.08323
R764 VSS.n250 VSS.n130 5.08323
R765 VSS.n250 VSS.n128 5.08323
R766 VSS.n250 VSS.n97 5.08323
R767 VSS.n250 VSS.n99 5.08323
R768 VSS.n250 VSS.n123 5.08323
R769 VSS.n250 VSS.n100 5.08323
R770 VSS.n250 VSS.n102 5.08323
R771 VSS.n250 VSS.n103 5.08323
R772 VSS.n135 VSS.t83 4.99445
R773 VSS.t125 VSS.t85 4.76745
R774 VSS.t77 VSS.n124 4.70796
R775 VSS.t78 VSS.n98 4.70796
R776 VSS.n262 VSS.n261 4.67815
R777 VSS.n193 VSS.t140 4.60256
R778 VSS.n162 VSS.t149 4.60256
R779 VSS.n250 VSS.n108 4.53583
R780 VSS.n250 VSS.n110 4.53583
R781 VSS.n250 VSS.n116 4.53583
R782 VSS.n52 VSS.n48 0.239727
R783 VSS.n256 VSS.n74 4.22744
R784 VSS.n253 VSS.n25 4.22744
R785 VSS.n208 VSS.n161 3.89224
R786 VSS.n208 VSS.n43 3.88607
R787 VSS.n210 VSS.n209 3.57733
R788 VSS.n24 VSS.n22 3.57193
R789 VSS.n26 VSS.t148 3.45423
R790 VSS.n19 VSS.t151 3.45423
R791 VSS.n20 VSS.t154 3.45423
R792 VSS.n18 VSS.t157 3.45423
R793 VSS.n73 VSS.t132 3.45423
R794 VSS.n14 VSS.t135 3.45423
R795 VSS.n17 VSS.t138 3.45423
R796 VSS.n16 VSS.t141 3.45423
R797 VSS.n11 VSS.t146 3.45313
R798 VSS.n22 VSS.t160 3.45313
R799 VSS.n160 VSS.t130 3.45313
R800 VSS.n159 VSS.t144 3.45313
R801 VSS.n250 VSS.n249 3.38758
R802 VSS.n250 VSS.n4 1.11025
R803 VSS.n250 VSS.n10 1.67243
R804 VSS.n10 VSS.n9 0.0452147
R805 VSS.n250 VSS.n2 1.11047
R806 VSS.n250 VSS.n13 1.67243
R807 VSS.n13 VSS.n12 0.0452147
R808 VSS.n250 VSS.n113 3.38758
R809 VSS.n216 VSS.n26 3.3755
R810 VSS.n215 VSS.n214 3.3755
R811 VSS.n213 VSS.n158 3.3755
R812 VSS.n212 VSS.n211 3.3755
R813 VSS.n210 VSS.n16 3.3755
R814 VSS.n194 VSS.n192 3.3055
R815 VSS.n188 VSS.t12 3.22826
R816 VSS.n176 VSS.t19 3.22826
R817 VSS.n177 VSS.t18 3.22826
R818 VSS.t65 VSS.t97 3.06083
R819 VSS.n119 VSS.t100 3.06083
R820 VSS.t102 VSS.n105 3.06083
R821 VSS.n250 VSS.n89 2.81806
R822 VSS.n250 VSS.n127 2.81806
R823 VSS.n250 VSS.n3 2.81806
R824 VSS.n46 VSS.t27 5.37901
R825 VSS.n205 VSS.t122 2.69048
R826 VSS.n113 VSS.t56 2.40164
R827 VSS.n249 VSS.t96 2.40039
R828 VSS.n8 VSS.t87 2.3605
R829 VSS.n6 VSS.t71 2.36013
R830 VSS.n1 VSS.t52 2.36001
R831 VSS.n125 VSS.t74 2.36001
R832 VSS.n132 VSS.t80 2.36001
R833 VSS.n126 VSS.t76 2.35987
R834 VSS.n248 VSS.t93 2.35987
R835 VSS.n112 VSS.t58 2.35975
R836 VSS.n9 VSS.t54 2.35975
R837 VSS.n7 VSS.t90 2.35975
R838 VSS.n12 VSS.t64 2.35963
R839 VSS.n3 VSS.t61 2.35954
R840 VSS.n2 VSS.t68 2.35933
R841 VSS.n5 VSS.t84 2.35901
R842 VSS.n196 VSS.t104 2.35423
R843 VSS.n173 VSS.t106 2.35423
R844 VSS.n198 VSS.t108 2.35423
R845 VSS.n167 VSS.t116 2.35423
R846 VSS.n202 VSS.t118 2.35423
R847 VSS.n165 VSS.t120 2.35423
R848 VSS.n193 VSS.n68 2.30153
R849 VSS.n162 VSS.n84 2.30153
R850 VSS.n250 VSS.n88 2.28106
R851 VSS.n250 VSS.n247 2.28106
R852 VSS.n250 VSS.n90 2.28106
R853 VSS.n250 VSS.n245 2.28106
R854 VSS.n63 VSS.t6 2.21154
R855 VSS.n65 VSS.t2 2.21139
R856 VSS.n54 VSS.t46 2.21087
R857 VSS.n57 VSS.t44 2.21084
R858 VSS.n259 VSS.t10 2.21084
R859 VSS.n66 VSS.t4 2.21072
R860 VSS.n56 VSS.t42 2.21063
R861 VSS.n52 VSS.t1 2.21057
R862 VSS.n59 VSS.t48 2.21049
R863 VSS.n261 VSS.t41 2.21043
R864 VSS.n60 VSS.t50 2.21005
R865 VSS.n258 VSS.t8 2.20978
R866 VSS.n60 VSS.t40 2.20287
R867 VSS.n57 VSS.t34 2.20213
R868 VSS.n258 VSS.t28 2.20175
R869 VSS.n56 VSS.t32 2.20163
R870 VSS.n261 VSS.t31 2.20163
R871 VSS.n259 VSS.t30 2.20157
R872 VSS.n59 VSS.t38 2.20154
R873 VSS.n63 VSS.t26 2.20136
R874 VSS.n65 VSS.t22 2.20131
R875 VSS.n54 VSS.t36 2.20127
R876 VSS.n52 VSS.t21 2.20125
R877 VSS.n66 VSS.t24 2.20088
R878 VSS.n49 VSS.t27 6.64572
R879 VSS.n161 VSS.n49 2.38879
R880 VSS.t124 VSS.n94 1.58948
R881 VSS.n163 VSS.n136 1.58948
R882 VSS.t127 VSS.t86 1.58948
R883 VSS.n250 VSS.n109 1.30348
R884 VSS.n250 VSS.n117 1.30348
R885 VSS.n250 VSS.n111 1.30348
R886 VSS.n250 VSS.n115 1.30348
R887 VSS.t104 VSS.t69 1.00924
R888 VSS.t120 VSS.t82 1.00924
R889 VSS.n41 VSS.n44 1.94389
R890 VSS.t70 VSS.n101 0.672995
R891 VSS.t53 VSS.n129 0.672995
R892 VSS.n188 VSS.n187 0.513002
R893 VSS.n181 VSS.n180 0.479883
R894 VSS.n178 VSS.n51 0.479883
R895 VSS.n153 VSS.n152 0.4405
R896 VSS.n147 VSS.n146 0.4405
R897 VSS.n141 VSS.n140 0.4405
R898 VSS.n152 VSS.n33 0.4405
R899 VSS.n146 VSS.n37 0.4405
R900 VSS.n140 VSS.n139 0.4405
R901 VSS.n204 VSS.n105 0.43769
R902 VSS.n187 VSS.n186 0.411981
R903 VSS.n183 VSS.n182 0.411981
R904 VSS.n184 VSS.n183 0.370375
R905 VSS.n183 VSS.n181 0.370375
R906 VSS.n181 VSS.n51 0.370375
R907 VSS.n244 VSS.n0 0.162668
R908 VSS.n157 VSS.n156 0.3635
R909 VSS.n156 VSS.n155 0.3635
R910 VSS.n151 VSS.n150 0.3635
R911 VSS.n150 VSS.n149 0.3635
R912 VSS.n145 VSS.n144 0.3635
R913 VSS.n144 VSS.n143 0.3635
R914 VSS.n213 VSS.n212 0.337235
R915 VSS.n214 VSS.n213 0.337235
R916 VSS.n207 VSS.n195 0.334254
R917 VSS.n187 VSS.n185 0.3195
R918 VSS.n185 VSS.n184 0.3195
R919 VSS.n32 VSS.n31 0.0682217
R920 VSS.n36 VSS.n35 0.0680996
R921 VSS.n40 VSS.n39 0.0680996
R922 VSS.n30 VSS.n145 0.276447
R923 VSS.n143 VSS.n142 0.276447
R924 VSS.n142 VSS.n141 0.276447
R925 VSS.n139 VSS.n138 0.276447
R926 VSS.n137 VSS.n29 0.276447
R927 VSS.n34 VSS.n157 0.276188
R928 VSS.n155 VSS.n154 0.276188
R929 VSS.n154 VSS.n153 0.276188
R930 VSS.n38 VSS.n151 0.276188
R931 VSS.n149 VSS.n148 0.276188
R932 VSS.n148 VSS.n147 0.276188
R933 VSS.n261 VSS.n50 0.239711
R934 VSS.n65 VSS.n48 0.225221
R935 VSS.n263 VSS.n51 0.248
R936 VSS.n58 VSS.n56 0.243424
R937 VSS.n67 VSS.n65 0.243424
R938 VSS.n54 VSS.n53 0.24245
R939 VSS.n63 VSS.n62 0.24245
R940 VSS.n212 VSS.n159 0.241827
R941 VSS.n214 VSS.n11 0.241827
R942 VSS.n57 VSS.n55 0.240796
R943 VSS.n66 VSS.n64 0.240796
R944 VSS.n61 VSS.n59 0.239822
R945 VSS.n260 VSS.n258 0.239822
R946 VSS.n45 VSS.n48 0.207279
R947 VSS.n50 VSS.n56 0.225229
R948 VSS.n59 VSS.n53 0.227974
R949 VSS.n258 VSS.n62 0.227974
R950 VSS.n206 VSS.n205 0.227498
R951 VSS.n58 VSS.n57 0.227001
R952 VSS.n67 VSS.n66 0.227001
R953 VSS.n207 VSS.n44 0.213606
R954 VSS.n61 VSS.n60 0.225646
R955 VSS.n260 VSS.n259 0.225646
R956 VSS.n55 VSS.n54 0.224672
R957 VSS.n64 VSS.n63 0.224672
R958 VSS.n45 VSS.n62 0.218846
R959 VSS.n45 VSS.n67 0.218846
R960 VSS.n27 VSS.n53 0.218846
R961 VSS.n27 VSS.n58 0.218846
R962 VSS.n45 VSS.n260 0.208386
R963 VSS.n45 VSS.n64 0.208386
R964 VSS.n27 VSS.n61 0.208386
R965 VSS.n27 VSS.n55 0.208386
R966 VSS.n31 VSS.n30 0.199447
R967 VSS.n138 VSS.n137 0.199447
R968 VSS.n35 VSS.n34 0.199188
R969 VSS.n39 VSS.n38 0.199188
R970 VSS.n24 VSS.n0 0.362654
R971 VSS.n24 VSS.n216 0.161968
R972 VSS.n185 VSS.n176 0.143127
R973 VSS.n184 VSS.n177 0.143127
R974 VSS.n211 VSS.n210 0.121601
R975 VSS.n211 VSS.n158 0.121601
R976 VSS.n215 VSS.n158 0.121601
R977 VSS.n216 VSS.n215 0.121601
R978 VSS.n36 VSS.n24 6.4329
R979 VSS.n40 VSS.n224 0.873355
R980 VSS.n32 VSS.n232 1.36641
R981 VSS.n217 VSS.n34 0.101071
R982 VSS.n219 VSS.n156 0.101071
R983 VSS.n221 VSS.n154 0.101071
R984 VSS.n225 VSS.n38 0.101071
R985 VSS.n227 VSS.n150 0.101071
R986 VSS.n229 VSS.n148 0.101071
R987 VSS.n233 VSS.n30 0.101071
R988 VSS.n235 VSS.n144 0.101071
R989 VSS.n237 VSS.n142 0.101071
R990 VSS.n241 VSS.n138 0.101071
R991 VSS.n242 VSS.n137 0.101071
R992 VSS.n28 VSS.n43 1.12614
R993 VSS.n50 VSS.n27 0.221871
R994 VSS.n233 VSS.n32 0.110483
R995 VSS.n243 VSS.n242 0.0885
R996 VSS.n242 VSS.n241 0.0885
R997 VSS.n241 VSS.n240 0.0885
R998 VSS.n240 VSS.n239 0.0885
R999 VSS.n239 VSS.n238 0.0885
R1000 VSS.n238 VSS.n237 0.0885
R1001 VSS.n237 VSS.n236 0.0885
R1002 VSS.n236 VSS.n235 0.0885
R1003 VSS.n235 VSS.n234 0.0885
R1004 VSS.n234 VSS.n233 0.0885
R1005 VSS.n232 VSS.n231 0.0885
R1006 VSS.n231 VSS.n230 0.0885
R1007 VSS.n230 VSS.n229 0.0885
R1008 VSS.n229 VSS.n228 0.0885
R1009 VSS.n228 VSS.n227 0.0885
R1010 VSS.n227 VSS.n226 0.0885
R1011 VSS.n226 VSS.n225 0.0885
R1012 VSS.n224 VSS.n223 0.0885
R1013 VSS.n223 VSS.n222 0.0885
R1014 VSS.n222 VSS.n221 0.0885
R1015 VSS.n221 VSS.n220 0.0885
R1016 VSS.n220 VSS.n219 0.0885
R1017 VSS.n219 VSS.n218 0.0885
R1018 VSS.n218 VSS.n217 0.0885
R1019 VSS.n209 VSS.n160 0.0846837
R1020 VSS.n17 VSS.n16 0.0779076
R1021 VSS VSS.n42 0.27725
R1022 VSS.n23 VSS.n159 0.0974748
R1023 VSS.n2 VSS.n6 0.134323
R1024 VSS.n5 VSS.n8 0.133313
R1025 VSS.n21 VSS.n18 0.0585658
R1026 VSS.n20 VSS.n18 0.116817
R1027 VSS.n20 VSS.n19 0.116817
R1028 VSS.n15 VSS.n14 0.0585658
R1029 VSS.n73 VSS.n14 0.116817
R1030 VSS.n26 VSS.n11 0.116817
R1031 VSS.n224 VSS.n33 0.0759286
R1032 VSS.n223 VSS.n152 0.0759286
R1033 VSS.n222 VSS.n153 0.0759286
R1034 VSS.n220 VSS.n155 0.0759286
R1035 VSS.n218 VSS.n157 0.0759286
R1036 VSS.n232 VSS.n37 0.0759286
R1037 VSS.n231 VSS.n146 0.0759286
R1038 VSS.n230 VSS.n147 0.0759286
R1039 VSS.n228 VSS.n149 0.0759286
R1040 VSS.n226 VSS.n151 0.0759286
R1041 VSS.n243 VSS.n29 0.0759286
R1042 VSS.n240 VSS.n139 0.0759286
R1043 VSS.n239 VSS.n140 0.0759286
R1044 VSS.n238 VSS.n141 0.0759286
R1045 VSS.n236 VSS.n143 0.0759286
R1046 VSS.n234 VSS.n145 0.0759286
R1047 VSS.n47 VSS.n45 0.0738328
R1048 VSS.n160 VSS.n74 0.0594056
R1049 VSS.n26 VSS.n25 0.0594056
R1050 VSS.n74 VSS.n73 0.0586497
R1051 VSS.n19 VSS.n25 0.0586497
R1052 VSS.n209 VSS.n208 0.0566224
R1053 VSS.n244 VSS.n42 0.0545
R1054 VSS.n12 VSS.n3 0.0539757
R1055 VSS.n126 VSS.n9 0.0529665
R1056 VSS.n8 VSS.n7 0.0527701
R1057 VSS.n249 VSS.n248 0.0519573
R1058 VSS.n125 VSS.n6 0.0517609
R1059 VSS.n113 VSS.n112 0.0507518
R1060 VSS.n127 VSS.n125 0.0480833
R1061 VSS.n248 VSS.n89 0.0474161
R1062 VSS.n7 VSS.n89 0.0470742
R1063 VSS.n132 VSS.n4 0.078073
R1064 VSS.n5 VSS.n4 0.0161352
R1065 VSS.n127 VSS.n126 0.0464069
R1066 VSS.n217 VSS.n36 0.110444
R1067 VSS.n225 VSS.n40 0.110444
R1068 VSS.n112 VSS.n3 0.0939903
R1069 VSS.n2 VSS.n1 0.0937261
R1070 VSS.n132 VSS.n10 0.0884022
R1071 VSS.n13 VSS.n1 0.0873931
R1072 VSS.n0 VSS.n243 4.03921
R1073 a_11798_1860.n0 a_11798_1860.n4 9.42143
R1074 a_11798_1860.n1 a_11798_1860.n12 9.42143
R1075 a_11798_1860.n1 a_11798_1860.n5 9.42143
R1076 a_11798_1860.n1 a_11798_1860.n6 9.42143
R1077 a_11798_1860.n2 a_11798_1860.n9 9.42143
R1078 a_11798_1860.n2 a_11798_1860.n7 9.42143
R1079 a_11798_1860.n4 a_11798_1860.t15 3.60374
R1080 a_11798_1860.n5 a_11798_1860.t21 3.60255
R1081 a_11798_1860.n6 a_11798_1860.t22 3.60255
R1082 a_11798_1860.n7 a_11798_1860.t28 3.60255
R1083 a_11798_1860.n4 a_11798_1860.t16 3.45423
R1084 a_11798_1860.n13 a_11798_1860.t17 3.45423
R1085 a_11798_1860.n11 a_11798_1860.t19 3.45423
R1086 a_11798_1860.n5 a_11798_1860.t20 3.45423
R1087 a_11798_1860.n12 a_11798_1860.t18 3.45423
R1088 a_11798_1860.n6 a_11798_1860.t23 3.45423
R1089 a_11798_1860.n10 a_11798_1860.t24 3.45423
R1090 a_11798_1860.n8 a_11798_1860.t26 3.45423
R1091 a_11798_1860.n7 a_11798_1860.t27 3.45423
R1092 a_11798_1860.n9 a_11798_1860.t25 3.45423
R1093 a_11798_1860.t14 a_11798_1860.n3 2.61386
R1094 a_11798_1860.n0 a_11798_1860.t0 2.61074
R1095 a_11798_1860.n1 a_11798_1860.t7 2.56233
R1096 a_11798_1860.n1 a_11798_1860.t9 2.5622
R1097 a_11798_1860.n2 a_11798_1860.t11 2.56207
R1098 a_11798_1860.n2 a_11798_1860.t10 2.56174
R1099 a_11798_1860.n3 a_11798_1860.t13 2.56173
R1100 a_11798_1860.n1 a_11798_1860.t6 2.56173
R1101 a_11798_1860.n0 a_11798_1860.t2 2.56173
R1102 a_11798_1860.n1 a_11798_1860.t4 2.56173
R1103 a_11798_1860.n1 a_11798_1860.t8 2.56161
R1104 a_11798_1860.n1 a_11798_1860.t5 2.56161
R1105 a_11798_1860.n0 a_11798_1860.t3 2.56161
R1106 a_11798_1860.n0 a_11798_1860.t1 2.5616
R1107 a_11798_1860.n3 a_11798_1860.t12 2.56128
R1108 a_11798_1860.n2 a_11798_1860.n1 0.245563
R1109 a_11798_1860.n8 a_11798_1860.n7 0.225083
R1110 a_11798_1860.n6 a_11798_1860.n10 0.225083
R1111 a_11798_1860.n11 a_11798_1860.n5 0.225083
R1112 a_11798_1860.n4 a_11798_1860.n13 0.225083
R1113 a_11798_1860.n1 a_11798_1860.n0 0.196551
R1114 a_11798_1860.n13 a_11798_1860.n12 0.1875
R1115 a_11798_1860.n12 a_11798_1860.n11 0.1875
R1116 a_11798_1860.n10 a_11798_1860.n9 0.1875
R1117 a_11798_1860.n9 a_11798_1860.n8 0.1875
R1118 a_11798_1860.n3 a_11798_1860.n2 0.147538
R1119 a_5428_3064.n0 a_5428_3064.t2 36.3628
R1120 a_5428_3064.n0 a_5428_3064.t0 35.246
R1121 a_5428_3064.t1 a_5428_3064.n0 15.3137
R1122 a_1474_1770.n0 a_1474_1770.t2 60.5214
R1123 a_1474_1770.n0 a_1474_1770.t1 33.8343
R1124 a_1474_1770.n1 a_1474_1770.n0 12.0028
R1125 a_1474_1770.t0 a_1474_1770.n1 2.87353
R1126 a_1474_1770.t0 a_1474_1770.n1 2.86853
R1127 a_1954_3500.n0 a_1954_3500.t2 44.3673
R1128 a_1954_3500.n0 a_1954_3500.t0 27.0418
R1129 a_1954_3500.t1 a_1954_3500.n0 12.2034
R1130 a_1254_3500.n0 a_1254_3500.t2 36.0512
R1131 a_1254_3500.n0 a_1254_3500.t3 33.7412
R1132 a_1254_3500.n3 a_1254_3500.t1 26.8072
R1133 a_1254_3500.n1 a_1254_3500.t5 26.0905
R1134 a_1254_3500.n1 a_1254_3500.t4 24.7412
R1135 a_1254_3500.t0 a_1254_3500.n3 12.4381
R1136 a_1254_3500.n3 a_1254_3500.n2 9.512
R1137 a_1254_3500.n2 a_1254_3500.n1 9.0005
R1138 a_1254_3500.n2 a_1254_3500.n0 0.7705
R1139 a_2654_5520.n1 a_2654_5520.t4 36.3944
R1140 a_2654_5520.n0 a_2654_5520.t1 34.4012
R1141 a_2654_5520.n0 a_2654_5520.t3 22.0391
R1142 a_2654_5520.n2 a_2654_5520.n1 9.0005
R1143 a_2654_5520.n2 a_2654_5520.t0 5.84394
R1144 a_2654_5520.t2 a_2654_5520.n2 4.67685
R1145 a_2654_5520.n1 a_2654_5520.n0 0.3173
R1146 vco_bias_0.vbn_buf.n3 vco_bias_0.vbn_buf.t1 55.3125
R1147 vco_bias_0.vbn_buf.n1 vco_bias_0.vbn_buf.t4 34.2391
R1148 vco_bias_0.vbn_buf.n1 vco_bias_0.vbn_buf.t3 28.5544
R1149 vco_bias_0.vbn_buf.n2 vco_bias_0.vbn_buf.n1 23.0981
R1150 vco_bias_0.vbn_buf.n0 vco_bias_0.vbn_buf.t2 21.7736
R1151 vco_bias_0.vbn_buf.n2 vco_bias_0.vbn_buf.t0 21.4968
R1152 vco_bias_0.vbn_buf vco_bias_0.vbn_buf.n0 20.8275
R1153 vco_bias_0.vbn_buf.n3 vco_bias_0.vbn_buf.n2 3.1069
R1154 vco_bias_0.vbn_buf vco_bias_0.vbn_buf.n3 1.2149
R1155 vco_bias_0.vbn_buf.n0 vco_bias_0.vbn_buf 0.1105
C0 ibias_100u di_en 0.20785f
C1 ibias_100u vco_bias_0.vbn_buf 0.0424f
C2 vco_bias_0.vbn_buf a_10100_4160# 0.01643f
C3 ibias_100u VDD 0.19675f
C4 a_6760_4930# vco_bias_0.vbn_buf 0.04276f
C5 VDD a_10100_4160# 0.35416f
C6 vtune rf_out_n 0.03176f
C7 a_9400_4880# rf_out_n 0.74832f
C8 vdd_core a_9400_4966# 0.0801f
C9 a_1560_1770# vco_bias_0.vbn_buf 0.01263f
C10 a_1560_1770# VDD 0.02705f
C11 vco_bias_0.vbn_buf di_en 0.04954f
C12 a_9400_4966# vco_bias_0.vbg_buf 0.05066f
C13 a_19100_4966# vdd_core 0.08348f
C14 a_6760_4930# vco_bias_0.vbg_buf 0.01207f
C15 VDD di_en 0.23778f
C16 VDD vco_bias_0.vbn_buf 0.42369f
C17 rf_out_p vco_bias_0.vbn_buf 0.18271f
C18 a_9400_4880# a_10100_4160# 0.15006f
C19 vdd_core vco_bias_0.vbn_buf 0.29548f
C20 a_9400_4880# a_9400_4966# 0.04847f
C21 a_19100_4966# vco_bias_0.vbg_buf 0.03283f
C22 rf_out_p VDD 0.45091f
C23 a_1560_1770# vco_bias_0.vbg_buf 0.03564f
C24 vdd_core VDD 1.71236f
C25 di_en vco_bias_0.vbg_buf 0.06389f
C26 ibias_100u a_1160_2070# 0.03793f
C27 a_19100_4966# a_14668_3324# 0.04847f
C28 vco_bias_0.vbn_buf vco_bias_0.vbg_buf 7.0653f
C29 rf_out_n a_10100_4160# 0.47919f
C30 VDD vco_bias_0.vbg_buf 0.71134f
C31 vtune vco_bias_0.vbn_buf 0.09134f
C32 vdd_core vco_bias_0.vbg_buf 3.7479f
C33 a_14668_3324# vco_bias_0.vbn_buf 0.05139f
C34 VDD a_16500_4160# 0.32132f
C35 rf_out_p a_16500_4160# 0.47919f
C36 a_9400_4880# vco_bias_0.vbn_buf 0.06406f
C37 vtune VDD 0.34468f
C38 rf_out_p vtune 0.03176f
C39 a_14668_3324# VDD 1.26121f
C40 a_1160_2070# a_1560_1770# 0.60592f
C41 a_14668_3324# rf_out_p 0.74832f
C42 vdd_core vtune 13.5146f
C43 a_9400_4880# VDD 1.3464f
C44 a_14668_3324# vdd_core 0.15264p
C45 a_9400_4880# vdd_core 0.15264p
C46 a_1160_2070# vco_bias_0.vbn_buf 0.03589f
C47 vco_bias_0.vbn_buf rf_out_n 0.21187f
C48 vtune vco_bias_0.vbg_buf 0.07434f
C49 a_14668_3324# vco_bias_0.vbg_buf 0.04106f
C50 VDD rf_out_n 0.46478f
C51 rf_out_p rf_out_n 0.0144f
C52 a_9400_4880# vco_bias_0.vbg_buf 0.0829f
C53 a_14668_3324# a_16500_4160# 0.15006f
C54 a_14668_3324# vtune 0.19347f
C55 a_9400_4880# vtune 0.20309f
C56 a_9400_4880# a_14668_3324# 0.09717f
C57 ibias_100u VSS 3.04847f
C58 rf_out_p VSS 4.45776f
C59 rf_out_n VSS 4.43878f
C60 di_en VSS 1.43665f
C61 vdd_core VSS 3.7827p
C62 VDD VSS 45.77975f
C63 vtune VSS 4.05654f
C64 vco_bias_0.vbn_buf VSS 0.1252p
C65 vco_bias_0.vbn_buf.n0 VSS 0.11278f
C66 vco_bias_0.vbn_buf.n1 VSS 0.23315f
C67 vco_bias_0.vbn_buf.t0 VSS 0.10315f
C68 vco_bias_0.vbn_buf.n2 VSS 0.21656f
C69 vco_bias_0.vbn_buf.t1 VSS 2.00251f
C70 vco_bias_0.vbn_buf.n3 VSS 0.12052f
C71 a_2654_5520.t0 VSS 0.38842f
C72 a_2654_5520.t3 VSS 0.43521f
C73 a_2654_5520.n0 VSS 0.8291f
C74 a_2654_5520.n1 VSS 0.87472f
C75 a_2654_5520.n2 VSS 0.68233f
C76 a_2654_5520.t2 VSS 0.82453f
C77 a_1254_3500.t1 VSS 0.06686f
C78 a_1254_3500.n0 VSS 0.92133f
C79 a_1254_3500.n1 VSS 0.49535f
C80 a_1254_3500.n2 VSS 0.24439f
C81 a_1254_3500.n3 VSS 0.45099f
C82 a_1254_3500.t0 VSS 0.14271f
C83 a_1954_3500.t0 VSS 0.08774f
C84 a_1954_3500.n0 VSS 1.17442f
C85 a_1954_3500.t1 VSS 0.1847f
C86 a_1474_1770.t1 VSS 0.64325f
C87 a_1474_1770.t2 VSS 2.31521f
C88 a_1474_1770.n0 VSS 2.68115f
C89 a_1474_1770.n1 VSS 0.51269f
C90 a_1474_1770.t0 VSS 0.67253f
C91 a_5428_3064.t2 VSS 0.65938f
C92 a_5428_3064.n0 VSS 1.39401f
C93 a_5428_3064.t1 VSS 0.65316f
C94 a_11798_1860.n0 VSS 2.0034f
C95 a_11798_1860.n1 VSS 3.45054f
C96 a_11798_1860.n2 VSS 1.4077f
C97 a_11798_1860.n3 VSS 1.32658f
C98 a_11798_1860.n4 VSS 0.13903f
C99 a_11798_1860.n5 VSS 0.13903f
C100 a_11798_1860.n6 VSS 0.13903f
C101 a_11798_1860.n7 VSS 0.13903f
C102 a_11798_1860.t28 VSS 0.0653f
C103 a_11798_1860.t25 VSS 0.06988f
C104 a_11798_1860.t26 VSS 0.06988f
C105 a_11798_1860.t27 VSS 0.06988f
C106 a_11798_1860.n8 VSS 0.07805f
C107 a_11798_1860.n9 VSS 0.08168f
C108 a_11798_1860.t23 VSS 4.48405f
C109 a_11798_1860.t24 VSS 0.06988f
C110 a_11798_1860.n10 VSS 0.07805f
C111 a_11798_1860.t22 VSS 0.0653f
C112 a_11798_1860.t21 VSS 0.0653f
C113 a_11798_1860.t18 VSS 0.06988f
C114 a_11798_1860.t19 VSS 0.06988f
C115 a_11798_1860.t20 VSS 4.34857f
C116 a_11798_1860.n11 VSS 0.07805f
C117 a_11798_1860.n12 VSS 0.08168f
C118 a_11798_1860.t16 VSS 0.06988f
C119 a_11798_1860.t17 VSS 0.06988f
C120 a_11798_1860.n13 VSS 0.07805f
C121 a_11798_1860.t15 VSS 0.0653f
C122 a_11798_1860.t0 VSS 0.21057f
C123 a_11798_1860.t1 VSS 0.20486f
C124 a_11798_1860.t2 VSS 0.20486f
C125 a_11798_1860.t3 VSS 0.20486f
C126 a_11798_1860.t4 VSS 0.20486f
C127 a_11798_1860.t5 VSS 0.20486f
C128 a_11798_1860.t6 VSS 0.20486f
C129 a_11798_1860.t7 VSS 0.20486f
C130 a_11798_1860.t8 VSS 0.20486f
C131 a_11798_1860.t9 VSS 0.20486f
C132 a_11798_1860.t10 VSS 0.20486f
C133 a_11798_1860.t11 VSS 1.03486f
C134 a_11798_1860.t12 VSS 0.20486f
C135 a_11798_1860.t13 VSS 0.20486f
C136 a_11798_1860.t14 VSS 0.21053f
C137 VSS.t31 VSS 0.97007f
C138 VSS.t41 VSS 54.7625f
C139 VSS.t36 VSS 0.28406f
C140 VSS.t46 VSS 0.26528f
C141 VSS.t32 VSS 0.97007f
C142 VSS.t42 VSS 54.7625f
C143 VSS.t44 VSS 0.26528f
C144 VSS.t38 VSS 0.28406f
C145 VSS.t22 VSS 3.70285f
C146 VSS.t24 VSS 3.70285f
C147 VSS.t157 VSS 0.37416f
C148 VSS.t84 VSS 0.83f
C149 VSS.t19 VSS 0.13353f
C150 VSS.t18 VSS 0.13227f
C151 VSS.t12 VSS 0.19817f
C152 VSS.t16 VSS 0.03718f
C153 VSS.t128 VSS 0.0352f
C154 VSS.t14 VSS 0.06319f
C155 VSS.t17 VSS 0.07707f
C156 VSS.t141 VSS 0.53956f
C157 VSS.t8 VSS 3.69775f
C158 VSS.t10 VSS 3.69775f
C159 vtune.t0 VSS 7.20321f
C160 vtune.t3 VSS 7.18915f
C161 vtune.n0 VSS 0.40877f
C162 vtune.t6 VSS 8.74735f
C163 vtune.n1 VSS 1.10946f
C164 VDD.t2 VSS 0.26329f
C165 VDD.t3 VSS 0.36993f
C166 VDD.n0 VSS 0.14737f
C167 VDD.t6 VSS 0.26329f
C168 VDD.t7 VSS 0.35484f
C169 VDD.n1 VSS 0.0543f
C170 VDD.n2 VSS 0.16397f
C171 VDD.t1 VSS 0.20608f
C172 VDD.t0 VSS 0.09246f
C173 VDD.n3 VSS 0.0679f
C174 VDD.n4 VSS 0.12395f
C175 VDD.t5 VSS 0.05569f
C176 VDD.t4 VSS 0.09246f
C177 VDD.n5 VSS 0.0679f
C178 VDD.n6 VSS 0.09558f
C179 VDD.t11 VSS 0.05549f
C180 VDD.t10 VSS 0.09246f
C181 VDD.n7 VSS 0.0679f
C182 VDD.n8 VSS 0.21904f
C183 VDD.t9 VSS 1.35256f
C184 VDD.t8 VSS 0.88196f
C185 VDD.n9 VSS 1.23582f
C186 vdd_core.n0 VSS 0.08489f
C187 vdd_core.n1 VSS 0.11397f
C188 vdd_core.n2 VSS 0.92962f
C189 vdd_core.n3 VSS 0.08489f
C190 vdd_core.n4 VSS 0.11397f
C191 vdd_core.n5 VSS 1.95769f
C192 vdd_core.n6 VSS 0.39987f
C193 vdd_core.n7 VSS 0.4866f
C194 vdd_core.n8 VSS 0.53833f
C195 vdd_core.n9 VSS 0.33042f
C196 vdd_core.n10 VSS 0.10119f
C197 vdd_core.n11 VSS 0.22701f
C198 vdd_core.n12 VSS 0.11657f
C199 vdd_core.n13 VSS 0.07526f
C200 vdd_core.n14 VSS 0.05507f
C201 vdd_core.n15 VSS 0.10119f
C202 vdd_core.n16 VSS 0.11657f
C203 vdd_core.n17 VSS 0.07366f
C204 vdd_core.n18 VSS 0.1028f
C205 vdd_core.n19 VSS 0.11496f
C206 vdd_core.n20 VSS 0.07526f
C207 vdd_core.n21 VSS 0.10119f
C208 vdd_core.n22 VSS 0.12107f
C209 vdd_core.n23 VSS 0.25789f
C210 vdd_core.n24 VSS 5.62227f
C211 vdd_core.n25 VSS 0.07526f
C212 vdd_core.n26 VSS 0.33042f
C213 vdd_core.n27 VSS 0.39243f
C214 vdd_core.n28 VSS 0.29485f
C215 vdd_core.n29 VSS 0.22665f
C216 vdd_core.n30 VSS 0.3785f
C217 vdd_core.n31 VSS 0.3785f
C218 vdd_core.n32 VSS 0.22943f
C219 vdd_core.n33 VSS 0.22943f
C220 vdd_core.n34 VSS 0.34712f
C221 vdd_core.n35 VSS 0.34712f
C222 vdd_core.n36 VSS 0.11496f
C223 vdd_core.n37 VSS 0.33042f
C224 vdd_core.n38 VSS 0.34853f
C225 vdd_core.n39 VSS 0.34853f
C226 vdd_core.n40 VSS 0.11496f
C227 vdd_core.n41 VSS 0.16256f
C228 vdd_core.n42 VSS 0.20951f
C229 vdd_core.n43 VSS 0.30872f
C230 vdd_core.n44 VSS 0.20951f
C231 vdd_core.n45 VSS 12.3819f
C232 vdd_core.n46 VSS 5.36468f
C233 vdd_core.n47 VSS 0.16521f
C234 vdd_core.n48 VSS 0.30872f
C235 vdd_core.n49 VSS 0.24518f
C236 vdd_core.n50 VSS 0.24518f
C237 vdd_core.n51 VSS 0.3785f
C238 vdd_core.n52 VSS 0.3785f
C239 vdd_core.n53 VSS 0.22481f
C240 vdd_core.n54 VSS 0.22481f
C241 vdd_core.n55 VSS 0.22204f
C242 vdd_core.n56 VSS 0.34712f
C243 vdd_core.n57 VSS 0.22204f
C244 vdd_core.n58 VSS 0.34712f
C245 vdd_core.n59 VSS 0.11657f
C246 vdd_core.n60 VSS 0.11496f
C247 vdd_core.n61 VSS 0.11657f
C248 vdd_core.n62 VSS 0.11496f
C249 vdd_core.n63 VSS 0.33042f
C250 vdd_core.n64 VSS 0.31388f
C251 vdd_core.n65 VSS 0.22019f
C252 vdd_core.n66 VSS 0.34712f
C253 vdd_core.n67 VSS 0.34712f
C254 vdd_core.n68 VSS 0.22665f
C255 vdd_core.n69 VSS 0.22665f
C256 vdd_core.n70 VSS 0.3785f
C257 vdd_core.n71 VSS 0.3785f
C258 vdd_core.n72 VSS 0.22943f
C259 vdd_core.n73 VSS 0.22943f
C260 vdd_core.n74 VSS 0.34712f
C261 vdd_core.n75 VSS 0.34712f
C262 vdd_core.n76 VSS 0.20951f
C263 vdd_core.n77 VSS 0.20951f
C264 vdd_core.n78 VSS 0.11657f
C265 vdd_core.n79 VSS 0.12595f
C266 vdd_core.n80 VSS 0.22204f
C267 vdd_core.n81 VSS 0.22204f
C268 vdd_core.n82 VSS 0.11657f
C269 vdd_core.n83 VSS 0.34853f
C270 vdd_core.n84 VSS 0.30872f
C271 vdd_core.n85 VSS 0.16256f
C272 vdd_core.n86 VSS 12.3819f
C273 vdd_core.n87 VSS 5.36468f
C274 vdd_core.n88 VSS 0.30872f
C275 vdd_core.n89 VSS 0.24518f
C276 vdd_core.n90 VSS 0.3785f
C277 vdd_core.n91 VSS 0.34712f
C278 vdd_core.n92 VSS 0.22481f
C279 vdd_core.n93 VSS 0.11496f
C280 vdd_core.n94 VSS 0.34712f
C281 vdd_core.n95 VSS 0.22481f
C282 vdd_core.n96 VSS 0.3785f
C283 vdd_core.n97 VSS 0.24518f
C284 vdd_core.n98 VSS 0.11496f
C285 vdd_core.n99 VSS 0.11496f
C286 vdd_core.n100 VSS 0.11496f
C287 vdd_core.n101 VSS 5.40921f
C288 vdd_core.n102 VSS 12.3374f
C289 vdd_core.n103 VSS 0.16256f
C290 vdd_core.n104 VSS 0.34853f
C291 vdd_core.n105 VSS 0.11657f
C292 vdd_core.n106 VSS 0.11496f
C293 vdd_core.t4 VSS 0.04267f
C294 vdd_core.n107 VSS 0.07706f
C295 vdd_core.n108 VSS 12.3733f
C296 vdd_core.n109 VSS 1.14331f
C297 vdd_core.t8 VSS 0.58207f
C298 vdd_core.t3 VSS 0.04306f
C299 vdd_core.t7 VSS 0.04251f
C300 vdd_core.n110 VSS 0.06801f
C301 vdd_core.t5 VSS 0.04251f
C302 vdd_core.n111 VSS 0.0819f
C303 vdd_core.n112 VSS 0.01811f
C304 vdd_core.n113 VSS 23.9141f
C305 vdd_core.n114 VSS 0.14402f
C306 vdd_core.n115 VSS 0.19348f
C307 vdd_core.n116 VSS 0.0963f
C308 vdd_core.n117 VSS 0.08404f
C309 vdd_core.n118 VSS 1.39257f
C310 vdd_core.n119 VSS 0.55371f
C311 vdd_core.n120 VSS 0.10048f
C312 vdd_core.t16 VSS 0.04251f
C313 vdd_core.t10 VSS 0.04251f
C314 vdd_core.t9 VSS 0.04306f
C315 vdd_core.n121 VSS 0.06855f
C316 vdd_core.n122 VSS 0.018f
C317 vdd_core.n123 VSS 12.3287f
C318 vdd_core.n124 VSS 0.8829f
C319 vdd_core.t1 VSS 0.04267f
C320 vdd_core.t18 VSS 0.41667f
C321 vdd_core.n125 VSS 0.08148f
C322 vdd_core.n126 VSS 0.07706f
C323 vdd_core.n127 VSS 0.63638f
C324 vdd_core.n128 VSS 13.199f
C325 vdd_core.n129 VSS 22.4533f
C326 vdd_core.n130 VSS 1.93428f
C327 vdd_core.n131 VSS 0.35282f
C328 vdd_core.n132 VSS 0.07099f
C329 vdd_core.n133 VSS 0.06782f
C330 vdd_core.n134 VSS 0.03007f
C331 vdd_core.n135 VSS 0.0388f
C332 vdd_core.n136 VSS 0.15414f
C333 vdd_core.n137 VSS 0.09211f
C334 vdd_core.n138 VSS 0.13611f
C335 vdd_core.n139 VSS 0.03726f
C336 vdd_core.n140 VSS 0.02897f
C337 vdd_core.n141 VSS 0.0963f
C338 vdd_core.n142 VSS 0.08779f
C339 vdd_core.n143 VSS 0.08779f
C340 vdd_core.n144 VSS 0.08705f
C341 vdd_core.n145 VSS 0.02897f
C342 vdd_core.n146 VSS 0.03726f
C343 vdd_core.n147 VSS 0.08404f
C344 vdd_core.n148 VSS 4.24297f
C345 vdd_core.n149 VSS 48.8273f
C346 vdd_core.n150 VSS 9.33546f
C347 vdd_core.n151 VSS 0.24782f
C348 vdd_core.n152 VSS 0.11496f
C349 vdd_core.n153 VSS 0.11657f
C350 vdd_core.n154 VSS 0.11496f
C351 vdd_core.n155 VSS 0.11657f
C352 vdd_core.n156 VSS 0.11496f
C353 vdd_core.n157 VSS 0.11657f
C354 vdd_core.n158 VSS 0.3719f
C355 vdd_core.n159 VSS 0.59057f
C356 vdd_core.n160 VSS 0.46559f
C357 vdd_core.n161 VSS 0.11657f
C358 vdd_core.n162 VSS 0.11496f
C359 vdd_core.n163 VSS 0.33042f
C360 vdd_core.n164 VSS 0.33042f
C361 vdd_core.n165 VSS 0.33042f
C362 vdd_core.n166 VSS 0.11496f
C363 vdd_core.n167 VSS 0.17003f
C364 vdd_core.n168 VSS 5.40921f
C365 vdd_core.n169 VSS 12.3374f
C366 vdd_core.n170 VSS 0.16256f
C367 vdd_core.n171 VSS 0.11657f
C368 vdd_core.n172 VSS 0.11657f
C369 vdd_core.n173 VSS 0.33042f
C370 vdd_core.n174 VSS 0.33042f
C371 vdd_core.n175 VSS 0.11657f
C372 vdd_core.n176 VSS 0.11496f
C373 vdd_core.n177 VSS 0.11657f
C374 vdd_core.n178 VSS 0.11496f
C375 vdd_core.n179 VSS 0.11657f
C376 vdd_core.n180 VSS 1.03552f
C377 vdd_core.n181 VSS 0.33042f
C378 vdd_core.n182 VSS 0.10119f
C379 vdd_core.n183 VSS 0.2268f
C380 vdd_core.n184 VSS 0.19835f
C381 vdd_core.n185 VSS 0.22734f
C382 vdd_core.n186 VSS 0.11657f
C383 vdd_core.n187 VSS 0.25789f
C384 vdd_core.n188 VSS 0.24841f
C385 vdd_core.n189 VSS 0.17727f
C386 vdd_core.n190 VSS 0.2268f
C387 vdd_core.n191 VSS 0.18048f
C388 vdd_core.n192 VSS 0.18048f
C389 vdd_core.n193 VSS 0.27775f
C390 vdd_core.n194 VSS 0.27775f
C391 vdd_core.n195 VSS 0.16546f
C392 vdd_core.n196 VSS 0.16546f
C393 vdd_core.n197 VSS 0.25484f
C394 vdd_core.n198 VSS 0.25484f
C395 vdd_core.n199 VSS 0.16344f
C396 vdd_core.n200 VSS 0.16344f
C397 vdd_core.n201 VSS 0.25578f
C398 vdd_core.n202 VSS 0.25578f
C399 vdd_core.n203 VSS 0.25262f
C400 vdd_core.n204 VSS 0.25368f
C401 vdd_core.n205 VSS 0.16209f
C402 vdd_core.n206 VSS 0.25484f
C403 vdd_core.n207 VSS 0.16681f
C404 vdd_core.n208 VSS 0.27775f
C405 vdd_core.n209 VSS 0.16884f
C406 vdd_core.n210 VSS 0.25484f
C407 vdd_core.n211 VSS 0.15421f
C408 vdd_core.n212 VSS 11.6259f
C409 vdd_core.n213 VSS 0.12107f
C410 vdd_core.n214 VSS 0.11657f
C411 vdd_core.n215 VSS 0.07526f
C412 vdd_core.n216 VSS 0.05507f
C413 vdd_core.n217 VSS 0.33042f
C414 vdd_core.n218 VSS 0.05507f
C415 vdd_core.n219 VSS 0.33042f
C416 vdd_core.n220 VSS 0.33042f
C417 vdd_core.n221 VSS 0.05507f
C418 vdd_core.n222 VSS 0.10119f
C419 vdd_core.n223 VSS 0.11657f
C420 vdd_core.n224 VSS 0.07366f
C421 vdd_core.n225 VSS 0.05507f
C422 vdd_core.n226 VSS 0.1028f
C423 vdd_core.n227 VSS 0.11496f
C424 vdd_core.n228 VSS 0.07366f
C425 vdd_core.n229 VSS 0.05507f
C426 vdd_core.n230 VSS 0.33042f
C427 vdd_core.n231 VSS 0.94332f
C428 vdd_core.n232 VSS 0.05507f
C429 vdd_core.n233 VSS 0.12873f
C430 vdd_core.n234 VSS 5.57947f
C431 vdd_core.n235 VSS 11.6687f
C432 vdd_core.n236 VSS 0.15421f
C433 vdd_core.n237 VSS 0.25484f
C434 vdd_core.n238 VSS 0.16884f
C435 vdd_core.n239 VSS 0.27775f
C436 vdd_core.n240 VSS 0.16681f
C437 vdd_core.n241 VSS 0.25484f
C438 vdd_core.n242 VSS 0.16209f
C439 vdd_core.n243 VSS 0.25368f
C440 vdd_core.n244 VSS 0.25262f
C441 vdd_core.n245 VSS 0.22543f
C442 vdd_core.n246 VSS 1.19425f
C443 vdd_core.n247 VSS 0.0669f
C444 vdd_core.n248 VSS 1.58456f
C445 di_en.n0 VSS 0.49428f
C446 rf_out_n.n0 VSS 0.67025f
C447 rf_out_n.n1 VSS 0.83016f
C448 rf_out_n.t6 VSS 1.71803f
C449 rf_out_n.t5 VSS 4.12113f
C450 rf_out_n.t2 VSS 0.3714f
C451 rf_out_n.t1 VSS 0.10612f
C452 rf_out_n.t4 VSS 0.10612f
C453 rf_out_n.t3 VSS 0.10612f
C454 rf_out_n.t0 VSS 0.10612f
C455 rf_out_n.n2 VSS 0.81115f
C456 rf_out_p.n0 VSS 0.91627f
C457 rf_out_p.n1 VSS 0.57093f
C458 rf_out_p.t0 VSS 1.7222f
C459 rf_out_p.t1 VSS 4.23688f
C460 rf_out_p.t2 VSS 0.38925f
C461 rf_out_p.t3 VSS 0.10519f
C462 rf_out_p.t5 VSS 0.10519f
C463 rf_out_p.t6 VSS 0.10519f
C464 rf_out_p.t4 VSS 0.10519f
C465 rf_out_p.n2 VSS 0.804f
C466 ibias_100u.t2 VSS 0.41391f
C467 ibias_100u.n0 VSS 0.34372f
C468 ibias_100u.n1 VSS 0.21893f
C469 ibias_100u.t0 VSS 0.19392f
C470 ibias_100u.n2 VSS 0.32183f
C471 ibias_100u.t3 VSS 2.0985f
C472 ibias_100u.n3 VSS 0.61912f
.ends
