* PEX produced on Sat Nov  7 10:24:49 PM CET 2026 using /foss/tools/sak/sak-pex.sh with m=3 and s=1 (extresist threshold=1000 mOhm, minres=100 mOhm, mindelay=0 ps)
* NGSPICE file created from vco_top_pex.ext - technology: ihp-sg13cmos5l

.subckt vco_top_pex di_en VDD VSS vtune rf_out_p rf_out_n
X0 a_5060_3702.t0 vco_feed_0.en_b.t4 VSS.t20 VSS.t19 sg13_lv_nmos ad=0.34p pd=2.68u as=0.34p ps=2.68u w=1u l=0.13u
X1 VSS.t46 vco_feed_0.vdd_core.t11 vco_feed_0.vdd_core.t18 VSS.t45 sg13_lv_nmos ad=0.38p pd=2.38u as=0.38p ps=2.38u w=2u l=0.13u
X2 a_11798_1860.t18 vco_bias_0.vbn_buf.t2 VSS.t100 VSS.t101 sg13_lv_nmos ad=0.95p pd=5.38u as=0.95p ps=5.38u w=5u l=0.5u
X3 rf_out_n.t2 a_9400_4880# a_11798_1860.t5 VSS.t16 sg13_lv_nmos ad=0.38p pd=2.38u as=0.38p ps=2.38u w=2u l=0.13u
X4 VSS.t128 vco_bias_0.vbg_buf VSS.t127 VSS.t21 sg13_lv_nmos ad=2.72p pd=16.68u as=0 ps=0 w=8u l=10u
X5 vco_feed_0.en_b.t0 di_en.t0 VSS.t154 VSS.t153 sg13_lv_nmos ad=0.17p pd=1.68u as=0.17p ps=1.68u w=0.5u l=0.13u
X6 rf_out_n.t1 a_9400_4880# a_11798_1860.t3 VSS.t12 sg13_lv_nmos ad=0.38p pd=2.38u as=0.38p ps=2.38u w=2u l=0.13u
X7 VSS.t60 vco_feed_0.vdd_core.t0 vco_feed_0.vdd_core.t7 VSS.t59 sg13_lv_nmos ad=0.38p pd=2.38u as=0.38p ps=2.38u w=2u l=0.13u
X8 a_11798_1860.t19 vco_bias_0.vbn_buf.t2 VSS.t103 VSS.t108 sg13_lv_nmos ad=0.95p pd=5.38u as=0.95p ps=5.38u w=5u l=0.5u
X9 VDD.t34 vco_feed_0.en_b.t2 a_19774_346.t14 VDD.t4 sg13_lv_pmos ad=0.57p pd=3.38u as=0.57p ps=3.38u w=3u l=0.13u
X10 a_19774_346.t2 vco_feed_0.en_b.t2 VDD.t8 VDD.t4 sg13_lv_pmos ad=0.57p pd=3.38u as=0.57p ps=3.38u w=3u l=0.13u
X11 VSS.t31 vco_bias_0.vbn_buf.t3 VSS.t29 VSS.t30 sg13_lv_nmos ad=1.52p pd=8.38u as=0 ps=0 w=8u l=10u
X12 a_5560_6408.t1 a_5560_4622.t0 VSS.t18 rppd l=8.5u w=0.5u
X13 a_19774_346.t15 vco_feed_0.en_b.t2 VDD.t34 VDD.t4 sg13_lv_pmos ad=0.57p pd=3.38u as=0.57p ps=3.38u w=3u l=0.13u
X14 VDD.t10 vco_feed_0.en_b.t2 a_19774_346.t2 VDD.t4 sg13_lv_pmos ad=0.57p pd=3.38u as=0.57p ps=3.38u w=3u l=0.13u
X15 a_11798_1860.t23 a_14668_3324# rf_out_p.t3 VSS.t141 sg13_lv_nmos ad=0.38p pd=2.38u as=0.38p ps=2.38u w=2u l=0.13u
X16 a_11798_1860.t8 vco_bias_0.vbn_buf.t2 VSS.t70 VSS.t71 sg13_lv_nmos ad=0.95p pd=5.38u as=0.95p ps=5.38u w=5u l=0.5u
X17 VDD.t36 vco_feed_0.en_b.t2 a_19774_346.t15 VDD.t4 sg13_lv_pmos ad=1.02p pd=6.68u as=0.57p ps=3.38u w=3u l=0.13u
X18 a_19774_346.t3 vco_feed_0.en_b.t2 VDD.t10 VDD.t4 sg13_lv_pmos ad=0.57p pd=3.38u as=0.57p ps=3.38u w=3u l=0.13u
X19 VSS.t82 vco_bias_0.vbn_buf.t2 a_11798_1860.t11 VSS.t81 sg13_lv_nmos ad=0.95p pd=5.38u as=0.95p ps=5.38u w=5u l=0.5u
X20 a_11798_1860.t9 vco_bias_0.vbn_buf.t2 VSS.t73 VSS.t74 sg13_lv_nmos ad=0.95p pd=5.38u as=0.95p ps=5.38u w=5u l=0.5u
X21 vco_feed_0.vdd_core.t5 vco_feed_0.vdd_core.t0 VSS.t54 VSS.t55 sg13_lv_nmos ad=0.38p pd=2.38u as=0.38p ps=2.38u w=2u l=0.13u
X22 VSS.t85 vco_bias_0.vbn_buf.t2 a_11798_1860.t12 VSS.t84 sg13_lv_nmos ad=0.95p pd=5.38u as=0.95p ps=5.38u w=5u l=0.5u
X23 vco_feed_0.vdd_core.t1 vco_feed_0.vdd_core.t0 VSS.t51 VSS.t50 sg13_lv_nmos ad=0.38p pd=2.38u as=0.68p ps=4.68u w=2u l=0.13u
X24 VSS.t40 vco_feed_0.vdd_core.t11 vco_feed_0.vdd_core.t14 VSS.t39 sg13_lv_nmos ad=0.38p pd=2.38u as=0.38p ps=2.38u w=2u l=0.13u
X25 a_11798_1860.t16 vco_bias_0.vbn_buf.t2 VSS.t96 VSS.t97 sg13_lv_nmos ad=0.95p pd=5.38u as=0.95p ps=5.38u w=5u l=0.5u
X26 a_11798_1860.t26 a_14668_3324# rf_out_p.t2 VSS.t147 sg13_lv_nmos ad=0.38p pd=2.38u as=0.38p ps=2.38u w=2u l=0.13u
X27 rf_out_p.t1 a_14668_3324# a_11798_1860.t24 VSS.t144 sg13_lv_nmos ad=0.38p pd=2.38u as=0.38p ps=2.38u w=2u l=0.13u
X28 VDD.t12 vco_feed_0.en_b.t2 a_19774_346.t3 VDD.t4 sg13_lv_pmos ad=0.57p pd=3.38u as=0.57p ps=3.38u w=3u l=0.13u
X29 VSS.t49 vco_feed_0.vdd_core.t0 vco_feed_0.vdd_core.t1 VSS.t52 sg13_lv_nmos ad=0.38p pd=2.38u as=0.38p ps=2.38u w=2u l=0.13u
X30 VDD.t44 VDD.t42 VDD.t43 VDD.t0 sg13_lv_pmos ad=0.34p pd=2.68u as=0 ps=0 w=1u l=0.13u
X31 VDD.t47 VDD.t45 VDD.t46 VDD.t0 sg13_lv_pmos ad=1.7p pd=10.68u as=0 ps=0 w=5u l=0.5u
X32 a_11798_1860.t1 a_9400_4880# rf_out_n.t3 VSS.t7 sg13_lv_nmos ad=0.38p pd=2.38u as=0.38p ps=2.38u w=2u l=0.13u
X33 VSS.t130 vco_bias_0.vbg_buf VSS.t128 VSS.t24 sg13_lv_nmos ad=1.52p pd=8.38u as=0 ps=0 w=8u l=10u
X34 a_6568_6836.t0 a_5948_5116.t2 VDD.t1 VDD.t0 sg13_lv_pmos ad=0.34p pd=2.68u as=0.34p ps=2.68u w=1u l=0.13u
X35 VDD.t20 vco_feed_0.en_b.t2 a_19774_346.t6 VDD.t4 sg13_lv_pmos ad=0.57p pd=3.38u as=0.57p ps=3.38u w=3u l=0.13u
X36 a_19774_346.t4 vco_feed_0.en_b.t2 VDD.t12 VDD.t4 sg13_lv_pmos ad=0.57p pd=3.38u as=0.57p ps=3.38u w=3u l=0.13u
X37 vco_feed_0.en_b.t1 di_en.t1 VDD.t41 VDD.t0 sg13_lv_pmos ad=0.34p pd=2.68u as=0.34p ps=2.68u w=1u l=0.13u
X38 VSS.t76 vco_bias_0.vbn_buf.t2 a_11798_1860.t9 VSS.t75 sg13_lv_nmos ad=0.95p pd=5.38u as=0.95p ps=5.38u w=5u l=0.5u
X39 a_11798_1860.t6 a_9400_4880# rf_out_n.t2 VSS.t17 sg13_lv_nmos ad=0.68p pd=4.68u as=0.38p ps=2.38u w=2u l=0.13u
X40 VSS.t96 vco_bias_0.vbn_buf.t2 a_11798_1860.t15 VSS.t95 sg13_lv_nmos ad=0.95p pd=5.38u as=0.95p ps=5.38u w=5u l=0.5u
X41 a_11798_1860.t13 vco_bias_0.vbn_buf.t2 VSS.t85 VSS.t86 sg13_lv_nmos ad=0.95p pd=5.38u as=0.95p ps=5.38u w=5u l=0.5u
X42 a_11798_1860.t4 a_9400_4880# rf_out_n.t1 VSS.t13 sg13_lv_nmos ad=0.38p pd=2.38u as=0.38p ps=2.38u w=2u l=0.13u
X43 a_19774_346.t7 vco_feed_0.en_b.t2 VDD.t20 VDD.t4 sg13_lv_pmos ad=0.57p pd=3.38u as=0.57p ps=3.38u w=3u l=0.13u
X44 VDD.t14 vco_feed_0.en_b.t2 a_19774_346.t4 VDD.t4 sg13_lv_pmos ad=0.57p pd=3.38u as=0.57p ps=3.38u w=3u l=0.13u
X45 a_11798_1860.t2 a_9400_4880# rf_out_n.t4 VSS.t9 sg13_lv_nmos ad=0.38p pd=2.38u as=0.38p ps=2.38u w=2u l=0.13u
X46 vco_bias_0.vbg_buf a_14668_3324# VSS.t4 rhigh l=8u w=0.5u
X47 a_19774_346.t16 vco_feed_0.vdd_core.t22 VSS.t174 rppd l=8.8u w=17.3u
X48 vco_feed_0.vdd_core.t20 vco_feed_0.vdd_core.t11 VSS.t46 VSS.t47 sg13_lv_nmos ad=0.38p pd=2.38u as=0.38p ps=2.38u w=2u l=0.13u
X49 VSS.t167 vco_bias_0.vbn_buf.t4 VSS.t165 VSS.t166 sg13_lv_nmos ad=1.52p pd=8.38u as=0 ps=0 w=8u l=10u
X50 VSS.t171 vco_bias_0.vbn_buf.t4 VSS.t169 VSS.t170 sg13_lv_nmos ad=1.52p pd=8.38u as=0 ps=0 w=8u l=10u
X51 vco_feed_0.vdd_core.t9 vco_feed_0.vdd_core.t0 VSS.t60 VSS.t61 sg13_lv_nmos ad=0.38p pd=2.38u as=0.38p ps=2.38u w=2u l=0.13u
X52 rf_out_p.t4 a_14668_3324# a_11798_1860.t23 VSS.t142 sg13_lv_nmos ad=0.38p pd=2.38u as=0.38p ps=2.38u w=2u l=0.13u
X53 VDD.t17 vco_feed_0.en_b.t2 a_19774_346.t7 VDD.t4 sg13_lv_pmos ad=0.57p pd=3.38u as=0.57p ps=3.38u w=3u l=0.13u
X54 a_19774_346.t5 vco_feed_0.en_b.t2 VDD.t14 VDD.t4 sg13_lv_pmos ad=0.57p pd=3.38u as=0.57p ps=3.38u w=3u l=0.13u
X55 a_19774_346.t8 vco_feed_0.en_b.t2 VDD.t17 VDD.t4 sg13_lv_pmos ad=0.57p pd=3.38u as=0.57p ps=3.38u w=3u l=0.13u
X56 VDD.t16 vco_feed_0.en_b.t2 a_19774_346.t5 VDD.t4 sg13_lv_pmos ad=0.57p pd=3.38u as=0.57p ps=3.38u w=3u l=0.13u
X57 VSS.t124 vco_bias_0.vbg_buf VSS.t122 VSS.t28 sg13_lv_nmos ad=1.52p pd=8.38u as=0 ps=0 w=8u l=10u
X58 a_5560_6408.t2 a_6568_6836.t4 VDD.t39 VDD.t0 sg13_lv_pmos ad=1.7p pd=10.68u as=1.7p ps=10.68u w=5u l=0.5u
X59 a_11798_1860.t10 vco_bias_0.vbn_buf.t2 VSS.t76 VSS.t77 sg13_lv_nmos ad=0.95p pd=5.38u as=0.95p ps=5.38u w=5u l=0.5u
X60 VSS.t88 vco_bias_0.vbn_buf.t2 a_11798_1860.t13 VSS.t87 sg13_lv_nmos ad=0.95p pd=5.38u as=0.95p ps=5.38u w=5u l=0.5u
N61 vco_feed_0.vdd_core.t27 vtune.t5 sg13_hv_svaricap l=0.3u w=30.08u
X62 a_11798_1860.t28 a_14668_3324# rf_out_p.t5 VSS.t151 sg13_lv_nmos ad=0.68p pd=4.68u as=0.38p ps=2.38u w=2u l=0.13u
X63 rf_out_p.t6 a_14668_3324# a_11798_1860.t26 VSS.t148 sg13_lv_nmos ad=0.38p pd=2.38u as=0.38p ps=2.38u w=2u l=0.13u
X64 a_5060_6408.t0 vco_feed_0.en_b.t6 VDD.t2 VDD.t0 sg13_lv_pmos ad=0.68p pd=4.68u as=0.68p ps=4.68u w=2u l=0.13u
X65 VDD.t22 vco_feed_0.en_b.t2 a_19774_346.t8 VDD.t4 sg13_lv_pmos ad=0.57p pd=3.38u as=0.57p ps=3.38u w=3u l=0.13u
X66 a_11798_1860.t25 a_14668_3324# rf_out_p.t1 VSS.t145 sg13_lv_nmos ad=0.38p pd=2.38u as=0.38p ps=2.38u w=2u l=0.13u
X67 a_19774_346.t6 vco_feed_0.en_b.t2 VDD.t16 VDD.t4 sg13_lv_pmos ad=0.57p pd=3.38u as=0.57p ps=3.38u w=3u l=0.13u
X68 VSS.t57 vco_feed_0.vdd_core.t0 vco_feed_0.vdd_core.t5 VSS.t56 sg13_lv_nmos ad=0.38p pd=2.38u as=0.38p ps=2.38u w=2u l=0.13u
X69 VSS.t122 vco_bias_0.vbg_buf VSS.t120 VSS.t26 sg13_lv_nmos ad=1.52p pd=8.38u as=0 ps=0 w=8u l=10u
X70 vco_feed_0.vdd_core.t16 vco_feed_0.vdd_core.t11 VSS.t40 VSS.t41 sg13_lv_nmos ad=0.38p pd=2.38u as=0.38p ps=2.38u w=2u l=0.13u
X71 rf_out_n.t4 a_9400_4880# a_11798_1860.t1 VSS.t8 sg13_lv_nmos ad=0.38p pd=2.38u as=0.38p ps=2.38u w=2u l=0.13u
X72 vco_feed_0.vdd_core.t12 vco_feed_0.vdd_core.t11 VSS.t33 VSS.t32 sg13_lv_nmos ad=0.38p pd=2.38u as=0.68p ps=4.68u w=2u l=0.13u
X73 VDD.t27 vco_feed_0.en_b.t2 a_19774_346.t11 VDD.t4 sg13_lv_pmos ad=0.57p pd=3.38u as=0.57p ps=3.38u w=3u l=0.13u
X74 a_19774_346.t9 vco_feed_0.en_b.t2 VDD.t22 VDD.t4 sg13_lv_pmos ad=0.57p pd=3.38u as=0.57p ps=3.38u w=3u l=0.13u
N75 vco_feed_0.vdd_core.t23 vtune.t0 sg13_hv_svaricap l=0.3u w=30.08u
X76 VSS.t105 vco_bias_0.vbn_buf.t2 a_11798_1860.t19 VSS.t109 sg13_lv_nmos ad=0.95p pd=5.38u as=0.95p ps=5.38u w=5u l=0.5u
X77 a_11798_1860.t17 vco_bias_0.vbn_buf.t2 VSS.t93 VSS.t92 sg13_lv_nmos ad=0.95p pd=5.38u as=0.95p ps=5.38u w=5u l=0.5u
X78 a_11798_1860.t7 vco_bias_0.vbn_buf.t2 VSS.t68 VSS.t67 sg13_lv_nmos ad=0.95p pd=5.38u as=1.7p ps=10.68u w=5u l=0.5u
X79 vco_feed_0.vdd_core.t3 vco_feed_0.vdd_core.t0 VSS.t49 VSS.t48 sg13_lv_nmos ad=0.38p pd=2.38u as=0.38p ps=2.38u w=2u l=0.13u
X80 VSS.t25 vco_bias_0.vbn_buf.t3 VSS.t23 VSS.t24 sg13_lv_nmos ad=1.52p pd=8.38u as=0 ps=0 w=8u l=10u
X81 VSS.t158 VSS.t155 VSS.t157 VSS.t156 sg13_lv_nmos ad=0.85p pd=5.68u as=0 ps=0 w=2.5u l=0.5u
X82 VDD.t40 rf_out_n.t6 VSS.t152 rppd l=1.65u w=10u
X83 VSS.t35 vco_feed_0.vdd_core.t11 vco_feed_0.vdd_core.t12 VSS.t34 sg13_lv_nmos ad=0.38p pd=2.38u as=0.38p ps=2.38u w=2u l=0.13u
X84 VSS.t29 vco_bias_0.vbn_buf.t3 VSS.t27 VSS.t28 sg13_lv_nmos ad=1.52p pd=8.38u as=0 ps=0 w=8u l=10u
X85 VSS.t79 vco_bias_0.vbn_buf.t2 a_11798_1860.t10 VSS.t78 sg13_lv_nmos ad=0.95p pd=5.38u as=0.95p ps=5.38u w=5u l=0.5u
X86 rf_out_n.t5 a_9400_4880# a_11798_1860.t4 VSS.t14 sg13_lv_nmos ad=0.38p pd=2.38u as=0.38p ps=2.38u w=2u l=0.13u
X87 a_19774_346.t12 vco_feed_0.en_b.t2 VDD.t27 VDD.t4 sg13_lv_pmos ad=0.57p pd=3.38u as=0.57p ps=3.38u w=3u l=0.13u
X88 VDD.t24 vco_feed_0.en_b.t2 a_19774_346.t9 VDD.t4 sg13_lv_pmos ad=0.57p pd=3.38u as=0.57p ps=3.38u w=3u l=0.13u
X89 rf_out_n.t0 a_9400_4880# a_11798_1860.t2 VSS.t10 sg13_lv_nmos ad=0.38p pd=2.38u as=0.38p ps=2.38u w=2u l=0.13u
X90 VSS.t169 vco_bias_0.vbn_buf.t4 VSS.t167 VSS.t168 sg13_lv_nmos ad=1.52p pd=8.38u as=0 ps=0 w=8u l=10u
X91 VSS.t126 vco_bias_0.vbg_buf VSS.t124 VSS.t30 sg13_lv_nmos ad=1.52p pd=8.38u as=0 ps=0 w=8u l=10u
X92 VDD.t50 VDD.t48 VDD.t49 VDD.t0 sg13_lv_pmos ad=1.7p pd=10.68u as=0 ps=0 w=5u l=0.5u
X93 a_5560_4622.t2 a_5560_4622.t1 VSS.t114 VSS.t113 sg13_lv_nmos ad=0.85p pd=5.68u as=0.85p ps=5.68u w=2.5u l=0.5u
X94 VDD.t26 vco_feed_0.en_b.t2 a_19774_346.t12 VDD.t4 sg13_lv_pmos ad=0.57p pd=3.38u as=0.57p ps=3.38u w=3u l=0.13u
X95 a_11798_1860.t24 a_14668_3324# rf_out_p.t4 VSS.t143 sg13_lv_nmos ad=0.38p pd=2.38u as=0.38p ps=2.38u w=2u l=0.13u
X96 rf_out_p.t3 a_14668_3324# a_11798_1860.t22 VSS.t140 sg13_lv_nmos ad=0.38p pd=2.38u as=0.68p ps=4.68u w=2u l=0.13u
X97 a_19774_346.t10 vco_feed_0.en_b.t2 VDD.t24 VDD.t4 sg13_lv_pmos ad=0.57p pd=3.38u as=0.57p ps=3.38u w=3u l=0.13u
X98 VSS.t134 vco_bias_0.vbg_buf VSS.t132 VSS.t28 sg13_lv_nmos ad=1.52p pd=8.38u as=0 ps=0 w=8u l=10u
X99 VDD.t28 vco_feed_0.en_b.t2 a_19774_346.t10 VDD.t4 sg13_lv_pmos ad=0.57p pd=3.38u as=0.57p ps=3.38u w=3u l=0.13u
X100 VSS.t93 vco_bias_0.vbn_buf.t2 a_11798_1860.t16 VSS.t98 sg13_lv_nmos ad=0.95p pd=5.38u as=0.95p ps=5.38u w=5u l=0.5u
N101 vco_feed_0.vdd_core.t25 vtune.t3 sg13_hv_svaricap l=0.3u w=30.08u
X102 VSS.t70 vco_bias_0.vbn_buf.t2 a_11798_1860.t7 VSS.t69 sg13_lv_nmos ad=0.95p pd=5.38u as=0.95p ps=5.38u w=5u l=0.5u
X103 a_6568_6836.t2 a_6568_6836.t1 VDD.t38 VDD.t0 sg13_lv_pmos ad=1.7p pd=10.68u as=1.7p ps=10.68u w=5u l=0.5u
X104 a_11798_1860.t20 vco_bias_0.vbn_buf.t2 VSS.t105 VSS.t104 sg13_lv_nmos ad=0.95p pd=5.38u as=0.95p ps=5.38u w=5u l=0.5u
X105 VSS.t37 vco_feed_0.vdd_core.t11 vco_feed_0.vdd_core.t20 VSS.t36 sg13_lv_nmos ad=0.68p pd=4.68u as=0.38p ps=2.38u w=2u l=0.13u
X106 a_11798_1860.t21 vco_bias_0.vbn_buf.t2 VSS.t107 VSS.t110 sg13_lv_nmos ad=0.95p pd=5.38u as=0.95p ps=5.38u w=5u l=0.5u
X107 VSS.t63 vco_feed_0.vdd_core.t0 vco_feed_0.vdd_core.t9 VSS.t62 sg13_lv_nmos ad=0.68p pd=4.68u as=0.38p ps=2.38u w=2u l=0.13u
X108 a_11798_1860.t27 a_14668_3324# rf_out_p.t6 VSS.t149 sg13_lv_nmos ad=0.38p pd=2.38u as=0.38p ps=2.38u w=2u l=0.13u
X109 vco_bias_0.vbg_buf a_9400_4880# VSS.t64 rhigh l=8u w=0.5u
X110 VSS.t132 vco_bias_0.vbg_buf VSS.t130 VSS.t26 sg13_lv_nmos ad=1.52p pd=8.38u as=0 ps=0 w=8u l=10u
X111 a_19774_346.t11 vco_feed_0.en_b.t2 VDD.t28 VDD.t4 sg13_lv_pmos ad=0.57p pd=3.38u as=0.57p ps=3.38u w=3u l=0.13u
X112 a_6568_6836.t3 a_5060_3702.t5 VSS.t3 VSS.t2 sg13_lv_nmos ad=0.85p pd=5.68u as=0.85p ps=5.68u w=2.5u l=0.5u
X113 VSS.t27 vco_bias_0.vbn_buf.t3 VSS.t25 VSS.t26 sg13_lv_nmos ad=1.52p pd=8.38u as=0 ps=0 w=8u l=10u
X114 a_5948_5116.t1 vco_feed_0.en_b.t5 VSS.t139 VSS.t138 sg13_lv_nmos ad=0.17p pd=1.68u as=0.17p ps=1.68u w=0.5u l=0.13u
X115 a_11798_1860.t11 vco_bias_0.vbn_buf.t2 VSS.t79 VSS.t80 sg13_lv_nmos ad=0.95p pd=5.38u as=0.95p ps=5.38u w=5u l=0.5u
X116 vco_bias_0.vbg_buf a_5560_6408.t0 VSS.t5 rhigh l=32u w=0.5u
X117 VSS.t91 vco_bias_0.vbn_buf.t2 a_11798_1860.t14 VSS.t90 sg13_lv_nmos ad=0.95p pd=5.38u as=0.95p ps=5.38u w=5u l=0.5u
X118 VSS.t43 vco_feed_0.vdd_core.t11 vco_feed_0.vdd_core.t16 VSS.t42 sg13_lv_nmos ad=0.38p pd=2.38u as=0.38p ps=2.38u w=2u l=0.13u
X119 a_19774_346.t0 vco_feed_0.en_b.t2 VDD.t5 VDD.t4 sg13_lv_pmos ad=0.57p pd=3.38u as=1.02p ps=6.68u w=3u l=0.13u
X120 VSS.t107 vco_bias_0.vbn_buf.t2 a_11798_1860.t20 VSS.t106 sg13_lv_nmos ad=0.95p pd=5.38u as=0.95p ps=5.38u w=5u l=0.5u
X121 a_11798_1860.t5 a_9400_4880# rf_out_n.t5 VSS.t15 sg13_lv_nmos ad=0.38p pd=2.38u as=0.38p ps=2.38u w=2u l=0.13u
X122 a_11798_1860.t3 a_9400_4880# rf_out_n.t0 VSS.t11 sg13_lv_nmos ad=0.38p pd=2.38u as=0.38p ps=2.38u w=2u l=0.13u
X123 VDD.t6 vco_feed_0.en_b.t2 a_19774_346.t0 VDD.t4 sg13_lv_pmos ad=0.57p pd=3.38u as=0.57p ps=3.38u w=3u l=0.13u
X124 VSS.t112 vco_bias_0.vbn_buf.t2 a_11798_1860.t21 VSS.t111 sg13_lv_nmos ad=1.7p pd=10.68u as=0.95p ps=5.38u w=5u l=0.5u
X125 VSS.t165 vco_bias_0.vbn_buf.t4 VSS.t164 VSS.t163 sg13_lv_nmos ad=2.72p pd=16.68u as=0 ps=0 w=8u l=10u
X126 VSS.t118 vco_bias_0.vbg_buf VSS.t117 VSS.t21 sg13_lv_nmos ad=2.72p pd=16.68u as=0 ps=0 w=8u l=10u
X127 VSS.t136 vco_bias_0.vbg_buf VSS.t134 VSS.t30 sg13_lv_nmos ad=1.52p pd=8.38u as=0 ps=0 w=8u l=10u
X128 VSS.t54 vco_feed_0.vdd_core.t0 vco_feed_0.vdd_core.t3 VSS.t53 sg13_lv_nmos ad=0.38p pd=2.38u as=0.38p ps=2.38u w=2u l=0.13u
X129 vco_feed_0.vdd_core.t18 vco_feed_0.vdd_core.t11 VSS.t43 VSS.t44 sg13_lv_nmos ad=0.38p pd=2.38u as=0.38p ps=2.38u w=2u l=0.13u
X130 vco_bias_0.vbn_buf.t0 a_5060_3702.t4 VSS.t137 rhigh l=32u w=0.5u
X131 vco_feed_0.vdd_core.t7 vco_feed_0.vdd_core.t0 VSS.t57 VSS.t58 sg13_lv_nmos ad=0.38p pd=2.38u as=0.38p ps=2.38u w=2u l=0.13u
X132 vco_feed_0.vdd_core.t14 vco_feed_0.vdd_core.t11 VSS.t35 VSS.t38 sg13_lv_nmos ad=0.38p pd=2.38u as=0.38p ps=2.38u w=2u l=0.13u
N133 vco_feed_0.vdd_core.t24 vtune.t0 sg13_hv_svaricap l=0.3u w=30.08u
X134 a_19774_346.t1 vco_feed_0.en_b.t2 VDD.t6 VDD.t4 sg13_lv_pmos ad=0.57p pd=3.38u as=0.57p ps=3.38u w=3u l=0.13u
X135 a_19774_346.t13 vco_feed_0.en_b.t2 VDD.t26 VDD.t4 sg13_lv_pmos ad=0.57p pd=3.38u as=0.57p ps=3.38u w=3u l=0.13u
X136 a_11798_1860.t14 vco_bias_0.vbn_buf.t2 VSS.t88 VSS.t89 sg13_lv_nmos ad=0.95p pd=5.38u as=0.95p ps=5.38u w=5u l=0.5u
X137 VSS.t162 VSS.t159 VSS.t161 VSS.t160 sg13_lv_nmos ad=0.85p pd=5.68u as=0 ps=0 w=2.5u l=0.5u
X138 VSS.t173 vco_bias_0.vbn_buf.t4 VSS.t171 VSS.t172 sg13_lv_nmos ad=1.52p pd=8.38u as=0 ps=0 w=8u l=10u
X139 a_5060_6408.t1 a_5060_3702.t1 VSS.t65 rppd l=13.1u w=0.5u
X140 VSS.t100 vco_bias_0.vbn_buf.t2 a_11798_1860.t17 VSS.t99 sg13_lv_nmos ad=0.95p pd=5.38u as=0.95p ps=5.38u w=5u l=0.5u
X141 a_11798_1860.t15 vco_bias_0.vbn_buf.t2 VSS.t91 VSS.t94 sg13_lv_nmos ad=0.95p pd=5.38u as=0.95p ps=5.38u w=5u l=0.5u
X142 VSS.t103 vco_bias_0.vbn_buf.t2 a_11798_1860.t18 VSS.t102 sg13_lv_nmos ad=0.95p pd=5.38u as=0.95p ps=5.38u w=5u l=0.5u
X143 rf_out_p.t5 a_14668_3324# a_11798_1860.t27 VSS.t150 sg13_lv_nmos ad=0.38p pd=2.38u as=0.38p ps=2.38u w=2u l=0.13u
X144 rf_out_p.t2 a_14668_3324# a_11798_1860.t25 VSS.t146 sg13_lv_nmos ad=0.38p pd=2.38u as=0.38p ps=2.38u w=2u l=0.13u
X145 VDD.t32 vco_feed_0.en_b.t2 a_19774_346.t13 VDD.t4 sg13_lv_pmos ad=0.57p pd=3.38u as=0.57p ps=3.38u w=3u l=0.13u
N146 vco_feed_0.vdd_core.t26 vtune.t3 sg13_hv_svaricap l=0.3u w=30.08u
X147 a_5948_5116.t0 vco_feed_0.en_b.t7 VDD.t3 VDD.t0 sg13_lv_pmos ad=0.34p pd=2.68u as=0.34p ps=2.68u w=1u l=0.13u
N148 vco_feed_0.vdd_core.t28 vtune.t5 sg13_hv_svaricap l=0.3u w=30.08u
X149 a_5060_3702.t3 a_5060_3702.t2 VSS.t116 VSS.t115 sg13_lv_nmos ad=0.85p pd=5.68u as=0.85p ps=5.68u w=2.5u l=0.5u
X150 rf_out_n.t3 a_9400_4880# a_11798_1860.t0 VSS.t6 sg13_lv_nmos ad=0.38p pd=2.38u as=0.68p ps=4.68u w=2u l=0.13u
X151 VSS.t23 vco_bias_0.vbn_buf.t3 VSS.t22 VSS.t21 sg13_lv_nmos ad=2.72p pd=16.68u as=0 ps=0 w=8u l=10u
X152 vco_bias_0.vbn_buf.t1 vco_feed_0.en_b.t3 VSS.t1 VSS.t0 sg13_lv_nmos ad=0.34p pd=2.68u as=0.34p ps=2.68u w=1u l=0.13u
X153 a_19774_346.t14 vco_feed_0.en_b.t2 VDD.t32 VDD.t4 sg13_lv_pmos ad=0.57p pd=3.38u as=0.57p ps=3.38u w=3u l=0.13u
X154 VSS.t73 vco_bias_0.vbn_buf.t2 a_11798_1860.t8 VSS.t72 sg13_lv_nmos ad=0.95p pd=5.38u as=0.95p ps=5.38u w=5u l=0.5u
X155 VSS.t120 vco_bias_0.vbg_buf VSS.t118 VSS.t24 sg13_lv_nmos ad=1.52p pd=8.38u as=0 ps=0 w=8u l=10u
X156 VDD.t8 vco_feed_0.en_b.t2 a_19774_346.t1 VDD.t4 sg13_lv_pmos ad=0.57p pd=3.38u as=0.57p ps=3.38u w=3u l=0.13u
X157 a_11798_1860.t12 vco_bias_0.vbn_buf.t2 VSS.t82 VSS.t83 sg13_lv_nmos ad=0.95p pd=5.38u as=0.95p ps=5.38u w=5u l=0.5u
X158 VDD.t37 rf_out_p.t0 VSS.t66 rppd l=1.65u w=10u
R0 rf_out_p.n0 rf_out_p.t3 6.56137
R1 rf_out_p.n1 rf_out_p.t5 6.52949
R2 rf_out_p.n1 rf_out_p.t6 6.52949
R3 rf_out_p.n0 rf_out_p.t2 6.52949
R4 rf_out_p.n0 rf_out_p.t1 6.52949
R5 rf_out_p.n0 rf_out_p.t4 6.52949
R6 rf_out_p rf_out_p.n2 2.38105
R7 rf_out_p.n2 rf_out_p.t0 1.62005
R8 rf_out_p.n1 rf_out_p.n0 0.128045
R9 rf_out_p.n2 rf_out_p.n1 0.117417
R10 rf_out_n.n0 rf_out_n.t2 6.56137
R11 rf_out_n.n0 rf_out_n.t5 6.52949
R12 rf_out_n.n0 rf_out_n.t1 6.52949
R13 rf_out_n.n1 rf_out_n.t0 6.52949
R14 rf_out_n.n1 rf_out_n.t4 6.52949
R15 rf_out_n.n1 rf_out_n.t3 6.52949
R16 rf_out_n rf_out_n.n2 2.38105
R17 rf_out_n.n2 rf_out_n.t6 1.62005
R18 rf_out_n.n1 rf_out_n.n0 0.128045
R19 rf_out_n.n2 rf_out_n.n1 0.117417
R20 di_en.n0 di_en.t0 21.6583
R21 di_en.n0 di_en.t1 19.605
R22 di_en di_en.n0 14.2289
R23 VDD VDD.n24 24.0135
R24 VDD.n17 VDD.t48 17.5809
R25 VDD.n0 VDD.t45 17.5809
R26 VDD.n60 VDD.n1 1.2602
R27 VDD.n18 VDD.t49 2.54583
R28 VDD.n2 VDD.t42 15.8062
R29 VDD.n20 VDD.n29 3.37066
R30 VDD.n25 VDD.t43 6.07554
R31 VDD.n2 VDD.t44 6.07554
R32 VDD.n19 VDD.t1 6.07554
R33 VDD.n23 VDD.t41 6.07554
R34 VDD.n24 VDD.t3 6.07554
R35 VDD.n1 VDD.n19 0.0656783
R36 VDD.n54 VDD.n22 0.830556
R37 VDD.n22 VDD.n29 2.80696
R38 VDD.n52 VDD.n51 0.0585658
R39 VDD.n51 VDD.n29 2.7974
R40 VDD.n50 VDD.n48 0.0585658
R41 VDD.n48 VDD.n29 2.7974
R42 VDD.n47 VDD.n30 0.066765
R43 VDD.n21 VDD.n42 0.0585658
R44 VDD.n42 VDD.n29 2.7974
R45 VDD.n41 VDD.n37 0.0585658
R46 VDD.n37 VDD.n29 2.7974
R47 VDD.n28 VDD.n29 2.37707
R48 VDD.n19 VDD.n23 0.1061
R49 VDD.n30 VDD.n29 2.3909
R50 VDD.n27 VDD.n28 0.0743661
R51 VDD.n58 VDD.n57 3.7073
R52 VDD.n25 VDD.t2 3.45404
R53 VDD.n24 VDD.n60 3.37539
R54 VDD.n60 VDD.n0 1.51113
R55 VDD.n60 VDD.n18 1.16155
R56 VDD.n32 VDD.t17 2.57245
R57 VDD.n17 VDD.t50 2.36422
R58 VDD.n33 VDD.t39 2.36398
R59 VDD.n17 VDD.t38 2.36392
R60 VDD.n0 VDD.t46 2.36348
R61 VDD.n0 VDD.t47 2.36308
R62 VDD.n3 VDD.n55 2.10932
R63 VDD.n54 VDD.n16 2.10932
R64 VDD.n55 VDD.t5 2.06537
R65 VDD.n54 VDD.t36 2.06537
R66 VDD.n26 VDD.t6 2.06506
R67 VDD.n35 VDD.t8 2.06506
R68 VDD.n38 VDD.t10 2.06506
R69 VDD.n40 VDD.t12 2.06506
R70 VDD.n43 VDD.t14 2.06506
R71 VDD.n44 VDD.t16 2.06506
R72 VDD.n45 VDD.t20 2.06506
R73 VDD.n53 VDD.t22 2.06506
R74 VDD.n9 VDD.t24 2.06506
R75 VDD.n8 VDD.t28 2.06506
R76 VDD.n12 VDD.t27 2.06506
R77 VDD.n11 VDD.t26 2.06506
R78 VDD.n15 VDD.t32 2.06506
R79 VDD.n14 VDD.t34 2.06506
R80 VDD.n3 VDD.n26 2.01733
R81 VDD.n4 VDD.n35 2.01733
R82 VDD.n4 VDD.n38 2.01733
R83 VDD.n5 VDD.n40 2.01733
R84 VDD.n5 VDD.n43 2.01733
R85 VDD.n6 VDD.n44 2.01733
R86 VDD.n6 VDD.n45 2.01733
R87 VDD.n53 VDD.n7 2.01733
R88 VDD.n10 VDD.n9 2.01733
R89 VDD.n10 VDD.n8 2.01733
R90 VDD.n13 VDD.n12 2.01733
R91 VDD.n13 VDD.n11 2.01733
R92 VDD.n16 VDD.n15 2.01733
R93 VDD.n16 VDD.n14 2.01733
R94 VDD.n57 VDD.n56 1.88605
R95 VDD.n59 VDD.n58 1.88605
R96 VDD.n55 VDD.n27 0.811613
R97 VDD.n27 VDD.n26 0.75308
R98 VDD.n36 VDD.n35 0.75308
R99 VDD.n34 VDD.n38 0.75308
R100 VDD.n41 VDD.n40 0.75308
R101 VDD.n39 VDD.n43 0.75308
R102 VDD.n21 VDD.n44 0.75308
R103 VDD.n21 VDD.n45 0.75308
R104 VDD.n31 VDD.n53 0.75308
R105 VDD.n47 VDD.n9 0.75308
R106 VDD.n46 VDD.n8 0.75308
R107 VDD.n50 VDD.n12 0.75308
R108 VDD.n49 VDD.n11 0.75308
R109 VDD.n52 VDD.n15 0.75308
R110 VDD.n22 VDD.n14 0.75308
R111 VDD.n56 VDD.n7 0.656341
R112 VDD VDD.n59 0.597573
R113 VDD.n57 VDD.t37 0.517741
R114 VDD.n58 VDD.t40 0.517741
R115 VDD.n60 VDD.t0 0.395849
R116 VDD.n59 VDD.n56 0.35172
R117 VDD.n29 VDD.t4 0.347439
R118 VDD.n0 VDD.n33 0.222999
R119 VDD.n2 VDD.n25 0.199822
R120 VDD.n16 VDD.n13 0.183684
R121 VDD.n13 VDD.n10 0.183684
R122 VDD.n10 VDD.n7 0.183684
R123 VDD.n7 VDD.n6 0.183684
R124 VDD.n6 VDD.n5 0.183684
R125 VDD.n5 VDD.n4 0.183684
R126 VDD.n4 VDD.n3 0.183684
R127 VDD.n33 VDD.n17 0.181347
R128 VDD.n28 VDD.n36 0.099072
R129 VDD.n32 VDD.n31 0.174604
R130 VDD.n52 VDD.n22 0.155757
R131 VDD.n7 VDD.n32 0.152545
R132 VDD.n24 VDD.n23 0.152127
R133 VDD.n18 VDD.n17 0.0814646
R134 VDD.n2 VDD.n1 0.0766266
R135 VDD.n0 VDD.n25 0.139213
R136 VDD.n49 VDD.n51 0.0585658
R137 VDD.n50 VDD.n49 0.116817
R138 VDD.n46 VDD.n48 0.0585658
R139 VDD.n47 VDD.n46 0.116817
R140 VDD.n31 VDD.n30 0.0501977
R141 VDD.n39 VDD.n42 0.0585658
R142 VDD.n41 VDD.n39 0.116817
R143 VDD.n34 VDD.n37 0.0585658
R144 VDD.n36 VDD.n34 0.116817
R145 VDD.n21 VDD.n20 0.116756
R146 VDD.n20 VDD.n32 0.116351
R147 vtune vtune.n1 16.693
R148 vtune.n0 vtune.t5 16.1774
R149 vtune.n0 vtune.t3 14.7078
R150 vtune.n1 vtune.t0 14.7078
R151 vtune.n1 vtune.n0 1.4701
R152 VSS.n572 VSS.t174 2.59877e+06
R153 VSS.n572 VSS.n116 6446.43
R154 VSS.n473 VSS.n116 4127.1
R155 VSS.t174 VSS.n115 1913.69
R156 VSS.n1 VSS.t137 1472.93
R157 VSS.n573 VSS.n115 956.177
R158 VSS.n574 VSS.n573 756.904
R159 VSS.n573 VSS.t4 686.107
R160 VSS.n464 VSS.t64 666.034
R161 VSS.t4 VSS.t66 405.473
R162 VSS.t64 VSS.n463 301.341
R163 VSS.n577 VSS.n576 278.832
R164 VSS.t18 VSS.t65 251.089
R165 VSS.t152 VSS.n152 236.65
R166 VSS.t5 VSS.t137 200.87
R167 VSS.t65 VSS.t5 175.762
R168 VSS.n454 VSS.t18 145.13
R169 VSS.n572 VSS.n571 130.981
R170 VSS.n461 VSS.t2 45.0201
R171 VSS.t160 VSS.n462 44.0139
R172 VSS.n474 VSS.n472 43.5761
R173 VSS.n456 VSS.t153 43.2932
R174 VSS.n1 VSS.t26 6.04936
R175 VSS.n459 VSS.t113 41.0027
R176 VSS.n1 VSS.t21 7.43125
R177 VSS.n458 VSS.t0 39.4961
R178 VSS.t19 VSS.n456 34.254
R179 VSS.n1 VSS.n464 10.5292
R180 VSS.t156 VSS.n459 32.966
R181 VSS.n147 VSS.t75 32.8355
R182 VSS.n154 VSS.t71 31.2091
R183 VSS.n462 VSS.t115 29.9548
R184 VSS.t115 VSS.n461 28.9486
R185 VSS.n455 VSS.t138 28.4482
R186 VSS.t72 VSS.n154 27.9562
R187 VSS.t67 VSS.n152 26.837
R188 VSS.t74 VSS.n147 26.3297
R189 VSS.n460 VSS.t156 25.9964
R190 VSS.n153 VSS.t69 25.9797
R191 VSS.t24 VSS.n1 12.253
R192 VSS.n161 VSS.t7 24.804
R193 VSS.t9 VSS.n143 24.804
R194 VSS.n163 VSS.t11 24.804
R195 VSS.n457 VSS.t19 24.4308
R196 VSS.n1 VSS.t28 12.2529
R197 VSS.t69 VSS.n149 22.7276
R198 VSS.n473 VSS.n166 22.5291
R199 VSS.t6 VSS.n146 21.507
R200 VSS.t108 VSS.n124 20.8388
R201 VSS.t106 VSS.n568 19.8559
R202 VSS.t17 VSS.t86 19.8391
R203 VSS.t140 VSS.t95 19.8391
R204 VSS.t83 VSS.n140 19.5029
R205 VSS.t98 VSS.n185 19.5029
R206 VSS.n155 VSS.t74 19.4739
R207 VSS.t0 VSS.n457 19.4073
R208 VSS.n162 VSS.t80 18.7048
R209 VSS.t89 VSS.n391 18.1579
R210 VSS.n480 VSS.t90 18.1579
R211 VSS.t138 VSS.n454 18.0788
R212 VSS.t113 VSS.n458 17.9008
R213 VSS.n568 VSS.t104 17.89
R214 VSS.n155 VSS.t72 17.8483
R215 VSS.t110 VSS.n117 17.7669
R216 VSS.n436 VSS.t139 17.3443
R217 VSS.n438 VSS.t154 17.3443
R218 VSS.n578 VSS.n577 17.0005
R219 VSS.n578 VSS.n85 17.0005
R220 VSS.n578 VSS.n97 17.0005
R221 VSS.n578 VSS.n94 17.0005
R222 VSS.n578 VSS.n88 17.0005
R223 VSS.n578 VSS.n93 17.0005
R224 VSS.n2 VSS.n578 17.0005
R225 VSS.n575 VSS.n574 17.0005
R226 VSS.n575 VSS.n100 17.0005
R227 VSS.n575 VSS.n112 17.0005
R228 VSS.n575 VSS.n109 17.0005
R229 VSS.n575 VSS.n103 17.0005
R230 VSS.n575 VSS.n108 17.0005
R231 VSS.n576 VSS.n575 17.0005
R232 VSS.n485 VSS.n188 17.0005
R233 VSS.n485 VSS.n127 17.0005
R234 VSS.n485 VSS.n187 17.0005
R235 VSS.n485 VSS.n385 17.0005
R236 VSS.n485 VSS.n484 17.0005
R237 VSS.n485 VSS.n129 17.0005
R238 VSS.n485 VSS.n185 17.0005
R239 VSS.n485 VSS.n386 17.0005
R240 VSS.n485 VSS.n483 17.0005
R241 VSS.n485 VSS.n130 17.0005
R242 VSS.n485 VSS.n482 17.0005
R243 VSS.n485 VSS.n387 17.0005
R244 VSS.n485 VSS.n179 17.0005
R245 VSS.n485 VSS.n388 17.0005
R246 VSS.n485 VSS.n481 17.0005
R247 VSS.n485 VSS.n389 17.0005
R248 VSS.n485 VSS.n480 17.0005
R249 VSS.n485 VSS.n391 17.0005
R250 VSS.n485 VSS.n479 17.0005
R251 VSS.n485 VSS.n392 17.0005
R252 VSS.n485 VSS.n477 17.0005
R253 VSS.n485 VSS.n137 17.0005
R254 VSS.n485 VSS.n476 17.0005
R255 VSS.n485 VSS.n393 17.0005
R256 VSS.n485 VSS.n170 17.0005
R257 VSS.n485 VSS.n394 17.0005
R258 VSS.n485 VSS.n475 17.0005
R259 VSS.n485 VSS.n140 17.0005
R260 VSS.n485 VSS.n166 17.0005
R261 VSS.n485 VSS.n465 17.0005
R262 VSS.n486 VSS.n485 17.0005
R263 VSS.n571 VSS.n570 17.0005
R264 VSS.n570 VSS.n125 17.0005
R265 VSS.n570 VSS.n188 17.0005
R266 VSS.n570 VSS.n127 17.0005
R267 VSS.n570 VSS.n187 17.0005
R268 VSS.n570 VSS.n129 17.0005
R269 VSS.n570 VSS.n185 17.0005
R270 VSS.n570 VSS.n130 17.0005
R271 VSS.n570 VSS.n181 17.0005
R272 VSS.n570 VSS.n179 17.0005
R273 VSS.n570 VSS.n134 17.0005
R274 VSS.n570 VSS.n173 17.0005
R275 VSS.n570 VSS.n137 17.0005
R276 VSS.n570 VSS.n139 17.0005
R277 VSS.n570 VSS.n170 17.0005
R278 VSS.n570 VSS.n140 17.0005
R279 VSS.n570 VSS.n166 17.0005
R280 VSS.n570 VSS.n141 17.0005
R281 VSS.n570 VSS.n163 17.0005
R282 VSS.n570 VSS.n142 17.0005
R283 VSS.n570 VSS.n162 17.0005
R284 VSS.n570 VSS.n143 17.0005
R285 VSS.n570 VSS.n161 17.0005
R286 VSS.n570 VSS.n152 17.0005
R287 VSS.n453 VSS.n395 17.0005
R288 VSS.n453 VSS.n398 17.0005
R289 VSS.n454 VSS.n453 17.0005
R290 VSS.n124 VSS.t109 16.907
R291 VSS.n129 VSS.t92 16.8129
R292 VSS.t8 VSS.n143 16.6717
R293 VSS.n163 VSS.t10 16.6717
R294 VSS.n442 VSS.t155 16.4809
R295 VSS.n449 VSS.t159 16.4809
R296 VSS.n571 VSS.t111 16.2194
R297 VSS.n569 VSS.t110 15.8002
R298 VSS.t153 VSS.n455 15.3899
R299 VSS.n567 VSS.t151 15.0637
R300 VSS.t150 VSS.n125 14.9907
R301 VSS.t71 VSS.n149 14.5945
R302 VSS.n414 VSS.n402 14.3477
R303 VSS.n0 VSS.t168 3.85872
R304 VSS.n392 VSS.t87 14.1229
R305 VSS.n481 VSS.t94 14.1229
R306 VSS.n434 VSS.n433 14.0949
R307 VSS.n0 VSS.t172 4.16081
R308 VSS.t2 VSS.n460 13.9432
R309 VSS.t109 VSS.n121 13.835
R310 VSS.n161 VSS.t77 13.8254
R311 VSS.t12 VSS.n140 13.7866
R312 VSS.t14 VSS.n170 13.7866
R313 VSS.t16 VSS.n137 13.7866
R314 VSS.t141 VSS.n179 13.7866
R315 VSS.t143 VSS.n130 13.7866
R316 VSS.n185 VSS.t145 13.7866
R317 VSS.n390 VSS.n133 13.6726
R318 VSS.n478 VSS.n174 13.6726
R319 VSS.n416 VSS.n415 13.5948
R320 VSS.n419 VSS.n68 13.5948
R321 VSS.n414 VSS.n413 13.5948
R322 VSS.n383 VSS.t148 13.2705
R323 VSS.t75 VSS.n146 12.9689
R324 VSS.t104 VSS.n121 12.8513
R325 VSS.n474 VSS.n473 12.7436
R326 VSS.t66 VSS.n572 12.0418
R327 VSS.n153 VSS.t67 11.3424
R328 VSS.t99 VSS.n127 11.3046
R329 VSS.n463 VSS.t160 11.0303
R330 VSS.t10 VSS.n142 10.9791
R331 VSS.n569 VSS.t106 10.8861
R332 VSS.t7 VSS.n145 10.4718
R333 VSS.t15 VSS.t84 10.4242
R334 VSS.t142 VSS.t97 10.4242
R335 VSS.n0 VSS.t166 4.98355
R336 VSS.t84 VSS.n170 10.0879
R337 VSS.t97 VSS.n130 10.0879
R338 VSS.n385 VSS.t147 10.0759
R339 VSS.n188 VSS.t149 10.0759
R340 VSS.n145 VSS.t78 10.0651
R341 VSS.n567 VSS.t108 9.90241
R342 VSS.n584 VSS.n583 9.76416
R343 VSS.n1 VSS.n0 11.8905
R344 VSS.n166 VSS.t12 9.07918
R345 VSS.n394 VSS.t14 9.07918
R346 VSS.n476 VSS.t16 9.07918
R347 VSS.n387 VSS.t141 9.07918
R348 VSS.n483 VSS.t143 9.07918
R349 VSS.t145 VSS.n129 9.07918
R350 VSS.t80 VSS.n142 8.94601
R351 VSS.n117 VSS.t111 8.91945
R352 VSS.t87 VSS.n173 8.74293
R353 VSS.t94 VSS.n389 8.74293
R354 VSS.n585 VSS.n584 8.5413
R355 VSS.t78 VSS.t8 8.5394
R356 VSS.n18 VSS.n17 2.36459
R357 VSS.n472 VSS.n18 1.06219
R358 VSS.n472 VSS.n19 3.40102
R359 VSS.n472 VSS.n21 1.70026
R360 VSS.n21 VSS.n22 0.00299877
R361 VSS.n472 VSS.n24 1.21506
R362 VSS.n24 VSS.n31 0.00264251
R363 VSS.n32 VSS.n10 0.00149997
R364 VSS.n33 VSS.n34 4.21722
R365 VSS.n47 VSS.n48 0.00170812
R366 VSS.n48 VSS.n49 0.00166658
R367 VSS.n49 VSS.n36 0.00149997
R368 VSS.n383 VSS.n51 1.21462
R369 VSS.n51 VSS.n50 0.00173723
R370 VSS.n50 VSS.n52 0.00173273
R371 VSS.n52 VSS.n53 0.00172462
R372 VSS.n53 VSS.n54 0.00170812
R373 VSS.n54 VSS.n55 0.00166658
R374 VSS.n383 VSS.n56 3.40102
R375 VSS.n383 VSS.n58 4.251
R376 VSS.n383 VSS.n59 4.251
R377 VSS.n59 VSS.n43 0.00149997
R378 VSS.n383 VSS.n61 2.83417
R379 VSS.n61 VSS.n60 0.00166658
R380 VSS.n383 VSS.n62 3.40102
R381 VSS.n65 VSS.n64 0.00362179
R382 VSS.n383 VSS.n66 8.501
R383 VSS.n6 VSS.n358 2.38884
R384 VSS.n0 VSS.n6 2.22319
R385 VSS.n66 VSS.n361 8.5005
R386 VSS.n570 VSS.n566 8.49671
R387 VSS.n570 VSS.n160 8.49671
R388 VSS.n453 VSS.n396 8.49288
R389 VSS.n578 VSS.n96 8.49147
R390 VSS.n575 VSS.n111 8.49147
R391 VSS.n359 VSS.n17 0.308856
R392 VSS.n26 VSS.n25 2.77451
R393 VSS.n8 VSS.n7 3.35165
R394 VSS.n16 VSS.n30 0.405083
R395 VSS.n30 VSS.n29 0.31387
R396 VSS.n29 VSS.n28 0.31387
R397 VSS.n28 VSS.n27 0.31387
R398 VSS.n469 VSS.n31 8.48544
R399 VSS.n470 VSS.n32 8.48544
R400 VSS.n11 VSS.n10 3.35165
R401 VSS.n13 VSS.n12 0.00283274
R402 VSS.n367 VSS.n47 8.48544
R403 VSS.n368 VSS.n48 8.48544
R404 VSS.n369 VSS.n49 8.48544
R405 VSS.n37 VSS.n36 3.35165
R406 VSS.n370 VSS.n366 8.48544
R407 VSS.n371 VSS.n50 8.48544
R408 VSS.n372 VSS.n52 8.48544
R409 VSS.n373 VSS.n53 8.48544
R410 VSS.n374 VSS.n54 8.48544
R411 VSS.n375 VSS.n55 8.48544
R412 VSS.n375 VSS.n39 0.219757
R413 VSS.n376 VSS.n57 8.48544
R414 VSS.n377 VSS.n365 8.48544
R415 VSS.n377 VSS.n41 0.188868
R416 VSS.n41 VSS.n40 4.21231
R417 VSS.n44 VSS.n43 3.35165
R418 VSS.n378 VSS.n364 8.48544
R419 VSS.n379 VSS.n60 8.48544
R420 VSS.n379 VSS.n46 0.219757
R421 VSS.n380 VSS.n63 8.48544
R422 VSS.n382 VSS.n64 2.67037
R423 VSS.n66 VSS.n64 0.00237779
R424 VSS.t102 VSS.n125 8.35568
R425 VSS.n583 VSS.n69 7.76695
R426 VSS.n126 VSS.t150 7.32312
R427 VSS.t101 VSS.n126 7.07738
R428 VSS.n473 VSS.t81 6.91294
R429 VSS.n2 VSS.t50 6.90359
R430 VSS.n93 VSS.t52 6.90359
R431 VSS.n93 VSS.t48 6.90359
R432 VSS.t53 VSS.n88 6.90359
R433 VSS.t55 VSS.n88 6.90359
R434 VSS.n97 VSS.t56 6.90359
R435 VSS.n97 VSS.t58 6.90359
R436 VSS.t61 VSS.n85 6.90359
R437 VSS.n577 VSS.t62 6.90359
R438 VSS.n576 VSS.t32 6.90359
R439 VSS.n108 VSS.t34 6.90359
R440 VSS.t39 VSS.n103 6.90359
R441 VSS.t41 VSS.n103 6.90359
R442 VSS.n112 VSS.t42 6.90359
R443 VSS.n112 VSS.t44 6.90359
R444 VSS.t45 VSS.n100 6.90359
R445 VSS.t47 VSS.n100 6.90359
R446 VSS.n574 VSS.t36 6.90359
R447 VSS.n386 VSS.n182 6.83654
R448 VSS.n482 VSS.n131 6.83654
R449 VSS.n388 VSS.n178 6.83654
R450 VSS.n480 VSS.n135 6.83654
R451 VSS.n477 VSS.n136 6.83654
R452 VSS.n476 VSS.n138 6.83654
R453 VSS.n394 VSS.n167 6.83654
R454 VSS.n475 VSS.n167 6.83654
R455 VSS.n393 VSS.n138 6.83654
R456 VSS.n392 VSS.n136 6.83654
R457 VSS.n478 VSS.n173 6.83654
R458 VSS.n479 VSS.n174 6.83654
R459 VSS.n391 VSS.n135 6.83654
R460 VSS.n390 VSS.n134 6.83654
R461 VSS.n389 VSS.n133 6.83654
R462 VSS.n481 VSS.n178 6.83654
R463 VSS.n387 VSS.n131 6.83654
R464 VSS.n483 VSS.n182 6.83654
R465 VSS.n432 VSS.n431 6.75595
R466 VSS.n578 VSS.n98 6.69018
R467 VSS.n578 VSS.n87 6.69018
R468 VSS.n578 VSS.n95 6.69018
R469 VSS.n578 VSS.n90 6.69018
R470 VSS.n578 VSS.n91 6.69018
R471 VSS.n575 VSS.n113 6.69018
R472 VSS.n575 VSS.n102 6.69018
R473 VSS.n575 VSS.n110 6.69018
R474 VSS.n575 VSS.n105 6.69018
R475 VSS.n575 VSS.n106 6.69018
R476 VSS.t147 VSS.n187 6.63549
R477 VSS.n325 VSS.n324 6.61367
R478 VSS.n250 VSS.n227 6.51503
R479 VSS.n226 VSS.n217 6.5067
R480 VSS.n216 VSS.n207 6.5067
R481 VSS.n524 VSS.n523 6.34066
R482 VSS.n304 VSS.n303 6.09818
R483 VSS.n439 VSS.t20 6.07511
R484 VSS.n400 VSS.t1 6.07511
R485 VSS.n206 VSS.n194 6.04071
R486 VSS.n91 VSS.t50 5.92367
R487 VSS.t52 VSS.n91 5.92367
R488 VSS.t48 VSS.n90 5.92367
R489 VSS.n90 VSS.t53 5.92367
R490 VSS.n95 VSS.t55 5.92367
R491 VSS.t56 VSS.n95 5.92367
R492 VSS.t58 VSS.n87 5.92367
R493 VSS.t59 VSS.n87 5.92367
R494 VSS.n98 VSS.t61 5.92367
R495 VSS.t62 VSS.n98 5.92367
R496 VSS.n106 VSS.t32 5.92367
R497 VSS.t34 VSS.n106 5.92367
R498 VSS.t38 VSS.n105 5.92367
R499 VSS.n105 VSS.t39 5.92367
R500 VSS.n110 VSS.t41 5.92367
R501 VSS.t42 VSS.n110 5.92367
R502 VSS.t44 VSS.n102 5.92367
R503 VSS.n102 VSS.t45 5.92367
R504 VSS.n113 VSS.t47 5.92367
R505 VSS.t36 VSS.n113 5.92367
R506 VSS.t163 VSS.n0 4.16122
R507 VSS.t92 VSS.n116 5.71671
R508 VSS.n570 VSS.n568 5.70003
R509 VSS.n570 VSS.n124 5.70003
R510 VSS.n570 VSS.n126 5.70003
R511 VSS.n570 VSS.n186 5.70003
R512 VSS.n472 VSS.n14 2.12601
R513 VSS.n24 VSS.n23 0.00235648
R514 VSS.n472 VSS.n9 5.66778
R515 VSS.n472 VSS.n466 5.66778
R516 VSS.n472 VSS.n12 2.12576
R517 VSS.n383 VSS.n34 1.30791
R518 VSS.n383 VSS.n35 5.66778
R519 VSS.n56 VSS.n38 0.00229996
R520 VSS.n383 VSS.n42 5.66778
R521 VSS.n62 VSS.n45 0.00229996
R522 VSS.n383 VSS.n360 5.66778
R523 VSS.n383 VSS.n65 3.4009
R524 VSS.n4 VSS.n0 1.33836
R525 VSS.n358 VSS.n4 0.607936
R526 VSS.n570 VSS.n123 5.66016
R527 VSS.n570 VSS.n157 5.66016
R528 VSS.n453 VSS.n452 5.65335
R529 VSS.n453 VSS.n445 5.65335
R530 VSS.n578 VSS.n99 5.65086
R531 VSS.n578 VSS.n86 5.65086
R532 VSS.n578 VSS.n89 5.65086
R533 VSS.n575 VSS.n114 5.65086
R534 VSS.n575 VSS.n101 5.65086
R535 VSS.n575 VSS.n104 5.65086
R536 VSS.n16 VSS.n15 2.04599
R537 VSS.n30 VSS.n19 3.35165
R538 VSS.n29 VSS.n20 3.35165
R539 VSS.n28 VSS.n22 3.35165
R540 VSS.n27 VSS.n23 3.35165
R541 VSS.n471 VSS.n468 5.64018
R542 VSS.n471 VSS.n13 1.8649
R543 VSS.n39 VSS.n38 3.35165
R544 VSS.n46 VSS.n45 3.35165
R545 VSS.n381 VSS.n363 5.64018
R546 VSS.n382 VSS.n362 5.64018
R547 VSS.n385 VSS.n186 5.60293
R548 VSS.n484 VSS.n186 5.60293
R549 VSS.n187 VSS.t99 5.40679
R550 VSS.t149 VSS.t101 5.16105
R551 VSS.n485 VSS.n390 5.08323
R552 VSS.n485 VSS.n478 5.08323
R553 VSS.n570 VSS.n182 5.08323
R554 VSS.n570 VSS.n131 5.08323
R555 VSS.n570 VSS.n178 5.08323
R556 VSS.n570 VSS.n133 5.08323
R557 VSS.n570 VSS.n135 5.08323
R558 VSS.n570 VSS.n174 5.08323
R559 VSS.n570 VSS.n136 5.08323
R560 VSS.n570 VSS.n138 5.08323
R561 VSS.n570 VSS.n167 5.08323
R562 VSS.n464 VSS.t152 4.87987
R563 VSS.n479 VSS.t89 4.70796
R564 VSS.t90 VSS.n134 4.70796
R565 VSS.n570 VSS.n145 4.68877
R566 VSS.n570 VSS.n147 4.68877
R567 VSS.n570 VSS.n154 4.68877
R568 VSS.n583 VSS.n582 4.67815
R569 VSS.n467 VSS.t59 4.60256
R570 VSS.n361 VSS.t38 4.60256
R571 VSS.n467 VSS.n12 8.50233
R572 VSS.n412 VSS.n404 4.3831
R573 VSS.n463 VSS.n453 4.24177
R574 VSS.n570 VSS.n184 4.24049
R575 VSS.n570 VSS.n169 4.24049
R576 VSS.n453 VSS.n450 4.23094
R577 VSS.n453 VSS.n399 4.23094
R578 VSS.n453 VSS.n440 4.23094
R579 VSS.n578 VSS.n92 4.22744
R580 VSS.n575 VSS.n107 4.22744
R581 VSS.n557 VSS.n556 3.93263
R582 VSS.n487 VSS.n358 3.89224
R583 VSS.n487 VSS.n486 3.88607
R584 VSS.n472 VSS.n465 3.59762
R585 VSS.n522 VSS.n521 3.57193
R586 VSS.n570 VSS.n118 3.38773
R587 VSS.n570 VSS.n151 3.38773
R588 VSS.n570 VSS.n190 3.38758
R589 VSS.n570 VSS.n128 3.38758
R590 VSS.n570 VSS.n132 3.38758
R591 VSS.n570 VSS.n172 3.38758
R592 VSS.n570 VSS.n165 3.38758
R593 VSS.n570 VSS.n144 3.38758
R594 VSS.n511 VSS.n510 3.3755
R595 VSS.n509 VSS.n355 3.3755
R596 VSS.n508 VSS.n507 3.3755
R597 VSS.n453 VSS.n443 3.37539
R598 VSS.n453 VSS.n401 3.37539
R599 VSS.n453 VSS.n437 3.37539
R600 VSS.n452 VSS.t162 3.18948
R601 VSS.n441 VSS.t114 3.14902
R602 VSS.n397 VSS.t157 3.14902
R603 VSS.n444 VSS.t158 3.14902
R604 VSS.n446 VSS.t3 3.14902
R605 VSS.n448 VSS.t116 3.14902
R606 VSS.n451 VSS.t161 3.14902
R607 VSS.n158 VSS.n67 3.09542
R608 VSS.n561 VSS.n560 3.09542
R609 VSS.n563 VSS.n562 3.09542
R610 VSS.n565 VSS.n564 3.09542
R611 VSS.t77 VSS.t6 2.8468
R612 VSS.n162 VSS.t9 2.8468
R613 VSS.t11 VSS.n141 2.8468
R614 VSS.n570 VSS.n120 2.81806
R615 VSS.n570 VSS.n177 2.81806
R616 VSS.n570 VSS.n148 2.81806
R617 VSS.n453 VSS.n447 2.80331
R618 VSS.n502 VSS.n501 2.79907
R619 VSS.n494 VSS.n493 2.79907
R620 VSS.n520 VSS.t37 2.79558
R621 VSS.n501 VSS.t51 2.79558
R622 VSS.n493 VSS.t63 2.79558
R623 VSS.n236 VSS.t35 2.7955
R624 VSS.n234 VSS.t40 2.7955
R625 VSS.n232 VSS.t43 2.7955
R626 VSS.n230 VSS.t46 2.7955
R627 VSS.n499 VSS.t49 2.7955
R628 VSS.n497 VSS.t54 2.7955
R629 VSS.n490 VSS.t57 2.7955
R630 VSS.n492 VSS.t60 2.7955
R631 VSS.n237 VSS.t33 2.79532
R632 VSS.n436 VSS.n435 2.71772
R633 VSS.n4 VSS.t170 5.37901
R634 VSS.n116 VSS.t146 2.69048
R635 VSS.n520 VSS.n519 2.46348
R636 VSS.n513 VSS.n237 2.4382
R637 VSS.n475 VSS.t13 2.35423
R638 VSS.n393 VSS.t15 2.35423
R639 VSS.n477 VSS.t17 2.35423
R640 VSS.n388 VSS.t140 2.35423
R641 VSS.n482 VSS.t142 2.35423
R642 VSS.n386 VSS.t144 2.35423
R643 VSS.n514 VSS.n236 2.3138
R644 VSS.n515 VSS.n234 2.3138
R645 VSS.n518 VSS.n232 2.3138
R646 VSS.n519 VSS.n230 2.3138
R647 VSS.n502 VSS.n499 2.3138
R648 VSS.n503 VSS.n497 2.3138
R649 VSS.n495 VSS.n490 2.3138
R650 VSS.n494 VSS.n492 2.3138
R651 VSS.n467 VSS.n85 2.30153
R652 VSS.n361 VSS.n108 2.30153
R653 VSS.n513 VSS.n512 2.2505
R654 VSS.n582 VSS.t127 2.21122
R655 VSS.n71 VSS.t132 2.2112
R656 VSS.n579 VSS.t29 2.21069
R657 VSS.n80 VSS.t27 2.2106
R658 VSS.n77 VSS.t136 2.21049
R659 VSS.n73 VSS.t128 2.21028
R660 VSS.n69 VSS.t22 2.21005
R661 VSS.n82 VSS.t23 2.21005
R662 VSS.n76 VSS.t134 2.21003
R663 VSS.n83 VSS.t25 2.2099
R664 VSS.n580 VSS.t31 2.20985
R665 VSS.n74 VSS.t130 2.2097
R666 VSS.n579 VSS.t171 2.20297
R667 VSS.n80 VSS.t169 2.20243
R668 VSS.n69 VSS.t164 2.20242
R669 VSS.n73 VSS.t118 2.20236
R670 VSS.n71 VSS.t122 2.20215
R671 VSS.n82 VSS.t165 2.20212
R672 VSS.n580 VSS.t173 2.20194
R673 VSS.n83 VSS.t167 2.20186
R674 VSS.n74 VSS.t120 2.20165
R675 VSS.n76 VSS.t124 2.20134
R676 VSS.n77 VSS.t126 2.20098
R677 VSS.n582 VSS.t117 2.20076
R678 VSS.n115 VSS.n559 318.474
R679 VSS.n6 VSS.t170 6.64569
R680 VSS.n570 VSS.n117 2.15357
R681 VSS.n570 VSS.n569 2.15357
R682 VSS.n570 VSS.n121 2.15357
R683 VSS.n570 VSS.n567 2.15357
R684 VSS.t148 VSS.n127 1.72068
R685 VSS.n383 VSS.n188 1.72068
R686 VSS.t151 VSS.t102 1.72068
R687 VSS.n151 VSS.t68 1.61952
R688 VSS.n118 VSS.t112 1.61824
R689 VSS.n191 VSS.t103 1.47437
R690 VSS.n119 VSS.t107 1.47437
R691 VSS.n164 VSS.t79 1.47429
R692 VSS.n122 VSS.t105 1.47425
R693 VSS.n176 VSS.t91 1.47407
R694 VSS.n175 VSS.t88 1.47403
R695 VSS.n183 VSS.t93 1.47367
R696 VSS.n159 VSS.t76 1.47354
R697 VSS.n189 VSS.t100 1.47354
R698 VSS.n171 VSS.t85 1.47335
R699 VSS.n156 VSS.t73 1.47305
R700 VSS.n180 VSS.t96 1.47305
R701 VSS.n168 VSS.t82 1.47298
R702 VSS.n150 VSS.t70 1.47247
R703 VSS.n506 VSS.n488 1.42376
R704 VSS.n570 VSS.n146 1.40016
R705 VSS.n570 VSS.n155 1.40016
R706 VSS.n570 VSS.n149 1.40016
R707 VSS.n570 VSS.n153 1.40016
R708 VSS.n544 VSS.n543 1.30527
R709 VSS.n507 VSS.n506 1.23289
R710 VSS.t13 VSS.t83 1.00924
R711 VSS.t144 VSS.t98 1.00924
R712 VSS.n384 VSS.n359 0.882565
R713 VSS.n534 VSS.n533 0.812182
R714 VSS.n505 VSS.n504 0.7505
R715 VSS.n517 VSS.n516 0.7505
R716 VSS.t86 VSS.n137 0.672995
R717 VSS.t95 VSS.n179 0.672995
R718 VSS.n585 VSS.n67 0.648061
R719 VSS.n356 VSS.n237 0.561425
R720 VSS.n236 VSS.n235 0.561174
R721 VSS.n234 VSS.n233 0.561174
R722 VSS.n232 VSS.n231 0.561174
R723 VSS.n230 VSS.n229 0.561174
R724 VSS.n499 VSS.n498 0.561174
R725 VSS.n497 VSS.n496 0.561174
R726 VSS.n490 VSS.n489 0.561174
R727 VSS.n492 VSS.n491 0.561174
R728 VSS.n521 VSS.n520 0.56108
R729 VSS.n501 VSS.n500 0.56108
R730 VSS.n493 VSS.n357 0.56108
R731 VSS.n503 VSS.n502 0.485689
R732 VSS.n495 VSS.n494 0.485689
R733 VSS.n415 VSS.n68 0.471929
R734 VSS.n434 VSS.n415 0.471929
R735 VSS.n289 VSS.n273 0.4405
R736 VSS.n219 VSS.n218 0.4405
R737 VSS.n209 VSS.n208 0.4405
R738 VSS.n199 VSS.n198 0.4405
R739 VSS.n249 VSS.n248 0.4405
R740 VSS.n273 VSS.n272 0.4405
R741 VSS.n218 VSS.n217 0.4405
R742 VSS.n208 VSS.n207 0.4405
R743 VSS.n198 VSS.n197 0.4405
R744 VSS.n250 VSS.n249 0.4405
R745 VSS.n314 VSS.n313 0.424088
R746 VSS.n253 VSS.n251 0.422335
R747 VSS.n473 VSS.n141 0.407114
R748 VSS.n261 VSS.n260 0.367167
R749 VSS.n276 VSS.n275 0.367167
R750 VSS.n278 VSS.n277 0.367167
R751 VSS.n283 VSS.n279 0.367167
R752 VSS.n294 VSS.n293 0.367167
R753 VSS.n296 VSS.n295 0.367167
R754 VSS.n300 VSS.n192 0.367167
R755 VSS.n558 VSS.n557 0.367167
R756 VSS.n288 VSS.n287 0.3635
R757 VSS.n287 VSS.n286 0.3635
R758 VSS.n306 VSS.n305 0.3635
R759 VSS.n307 VSS.n306 0.3635
R760 VSS.n310 VSS.n309 0.3635
R761 VSS.n311 VSS.n310 0.3635
R762 VSS.n223 VSS.n222 0.3635
R763 VSS.n222 VSS.n221 0.3635
R764 VSS.n213 VSS.n212 0.3635
R765 VSS.n212 VSS.n211 0.3635
R766 VSS.n203 VSS.n202 0.3635
R767 VSS.n202 VSS.n201 0.3635
R768 VSS.n245 VSS.n244 0.3635
R769 VSS.n246 VSS.n245 0.3635
R770 VSS.n258 VSS.n257 0.3635
R771 VSS.n320 VSS.n317 0.3635
R772 VSS.n318 VSS.n317 0.3635
R773 VSS.n257 VSS.n256 0.3635
R774 VSS.n254 VSS.n253 0.3635
R775 VSS.n412 VSS.n411 0.346655
R776 VSS.n325 VSS.n319 0.338523
R777 VSS.n509 VSS.n508 0.337235
R778 VSS.n510 VSS.n509 0.337235
R779 VSS.n544 VSS.n206 0.31812
R780 VSS.n524 VSS.n226 0.31812
R781 VSS.n534 VSS.n216 0.31812
R782 VSS.n523 VSS.n227 0.31812
R783 VSS.n506 VSS.n505 0.318023
R784 VSS.n433 VSS.n432 0.315693
R785 VSS.n431 VSS.n430 0.307456
R786 VSS.n411 VSS.n410 0.303948
R787 VSS.n410 VSS.n409 0.303948
R788 VSS.n409 VSS.n408 0.303948
R789 VSS.n408 VSS.n404 0.303948
R790 VSS.n456 VSS.n453 0.302472
R791 VSS.n584 VSS.n68 0.302214
R792 VSS.n485 VSS.n474 0.291211
R793 VSS.n352 VSS.n351 0.288357
R794 VSS.n303 VSS.n302 0.276447
R795 VSS.n272 VSS.n271 0.276447
R796 VSS.n290 VSS.n289 0.276447
R797 VSS.n290 VSS.n288 0.276447
R798 VSS.n286 VSS.n285 0.276447
R799 VSS.n308 VSS.n307 0.276447
R800 VSS.n309 VSS.n308 0.276447
R801 VSS.n312 VSS.n311 0.276447
R802 VSS.n204 VSS.n203 0.276447
R803 VSS.n201 VSS.n200 0.276447
R804 VSS.n200 VSS.n199 0.276447
R805 VSS.n197 VSS.n196 0.276447
R806 VSS.n195 VSS.n194 0.276447
R807 VSS.n224 VSS.n223 0.276188
R808 VSS.n221 VSS.n220 0.276188
R809 VSS.n220 VSS.n219 0.276188
R810 VSS.n214 VSS.n213 0.276188
R811 VSS.n211 VSS.n210 0.276188
R812 VSS.n210 VSS.n209 0.276188
R813 VSS.n244 VSS.n239 0.276188
R814 VSS.n247 VSS.n246 0.276188
R815 VSS.n248 VSS.n247 0.276188
R816 VSS.n322 VSS.n320 0.276188
R817 VSS.n319 VSS.n318 0.276188
R818 VSS.n256 VSS.n255 0.276188
R819 VSS.n255 VSS.n254 0.276188
R820 VSS.n326 VSS.n315 0.2755
R821 VSS.n331 VSS.n330 0.2755
R822 VSS.n333 VSS.n332 0.2755
R823 VSS.n337 VSS.n252 0.2755
R824 VSS.n342 VSS.n341 0.2755
R825 VSS.n344 VSS.n343 0.2755
R826 VSS.n346 VSS.n241 0.2755
R827 VSS.n351 VSS.n350 0.2755
R828 VSS.n313 VSS.n312 0.271823
R829 VSS.n430 VSS.n429 0.267167
R830 VSS.n429 VSS.n428 0.267167
R831 VSS.n428 VSS.n427 0.267167
R832 VSS.n427 VSS.n426 0.267167
R833 VSS.n426 VSS.n418 0.267167
R834 VSS.n432 VSS.n418 0.267167
R835 VSS.n305 VSS.n304 0.2645
R836 VSS.n324 VSS.n258 0.2645
R837 VSS.n582 VSS.n3 0.239729
R838 VSS.n5 VSS.n69 0.239726
R839 VSS.n484 VSS.n116 0.24624
R840 VSS.n75 VSS.n73 0.243424
R841 VSS.n84 VSS.n82 0.243424
R842 VSS.n505 VSS.n503 0.243095
R843 VSS.n505 VSS.n495 0.243095
R844 VSS.n71 VSS.n70 0.24245
R845 VSS.n80 VSS.n79 0.24245
R846 VSS.n508 VSS.n357 0.241827
R847 VSS.n510 VSS.n356 0.241827
R848 VSS.n74 VSS.n72 0.240796
R849 VSS.n83 VSS.n81 0.240796
R850 VSS.n78 VSS.n76 0.239822
R851 VSS.n581 VSS.n579 0.239822
R852 VSS.n5 VSS.n82 0.225222
R853 VSS.n3 VSS.n73 0.22522
R854 VSS.n76 VSS.n70 0.227974
R855 VSS.n579 VSS.n79 0.227974
R856 VSS.n75 VSS.n74 0.227001
R857 VSS.n84 VSS.n83 0.227001
R858 VSS.n485 VSS.n384 0.22697
R859 VSS.n435 VSS.n414 0.226786
R860 VSS.n78 VSS.n77 0.225646
R861 VSS.n581 VSS.n580 0.225646
R862 VSS.n72 VSS.n71 0.224672
R863 VSS.n81 VSS.n80 0.224672
R864 VSS.n0 VSS.n79 0.218846
R865 VSS.n0 VSS.n84 0.218846
R866 VSS.n1 VSS.n70 0.218846
R867 VSS.n1 VSS.n75 0.218846
R868 VSS.n435 VSS.n434 0.214214
R869 VSS.n0 VSS.n581 0.208386
R870 VSS.n0 VSS.n81 0.208386
R871 VSS.n1 VSS.n78 0.208386
R872 VSS.n1 VSS.n72 0.208386
R873 VSS.n302 VSS.n271 0.199447
R874 VSS.n285 VSS.n270 0.199447
R875 VSS.n205 VSS.n204 0.199447
R876 VSS.n196 VSS.n195 0.199447
R877 VSS.n225 VSS.n224 0.199188
R878 VSS.n215 VSS.n214 0.199188
R879 VSS.n239 VSS.n238 0.199188
R880 VSS.n323 VSS.n322 0.199188
R881 VSS.n471 VSS.n11 0.251491
R882 VSS.n382 VSS.n381 0.189041
R883 VSS.n564 VSS.n559 0.183793
R884 VSS.n315 VSS.n314 0.165999
R885 VSS.n512 VSS.n354 0.161968
R886 VSS.n469 VSS.n27 0.220165
R887 VSS.n367 VSS.n33 0.189248
R888 VSS.n370 VSS.n37 0.220165
R889 VSS.n376 VSS.n39 0.220165
R890 VSS.n378 VSS.n44 0.220165
R891 VSS.n380 VSS.n46 0.220165
R892 VSS.n8 VSS.n26 0.344299
R893 VSS.n16 VSS.n8 0.405381
R894 VSS.n11 VSS.n470 0.219757
R895 VSS.n37 VSS.n369 0.219757
R896 VSS.n44 VSS.n41 0.282573
R897 VSS.n381 VSS.n380 0.157378
R898 VSS.n515 VSS.n514 0.1501
R899 VSS.n519 VSS.n518 0.1501
R900 VSS.n26 VSS.n17 0.406493
R901 VSS.n470 VSS.n469 0.126053
R902 VSS.n368 VSS.n367 0.126053
R903 VSS.n369 VSS.n368 0.126053
R904 VSS.n371 VSS.n370 0.126053
R905 VSS.n372 VSS.n371 0.126053
R906 VSS.n373 VSS.n372 0.126053
R907 VSS.n374 VSS.n373 0.126053
R908 VSS.n375 VSS.n374 0.126053
R909 VSS.n377 VSS.n376 0.126053
R910 VSS.n379 VSS.n378 0.126053
R911 VSS.n384 VSS.n33 1.01474
R912 VSS.n507 VSS.n355 0.121601
R913 VSS.n511 VSS.n355 0.121601
R914 VSS.n512 VSS.n511 0.121601
R915 VSS.n407 VSS.n402 0.103584
R916 VSS.n525 VSS.n524 0.102006
R917 VSS.n535 VSS.n534 0.102006
R918 VSS.n545 VSS.n544 0.102006
R919 VSS.n302 VSS.n301 0.101071
R920 VSS.n299 VSS.n271 0.101071
R921 VSS.n291 VSS.n290 0.101071
R922 VSS.n287 VSS.n280 0.101071
R923 VSS.n285 VSS.n284 0.101071
R924 VSS.n282 VSS.n270 0.101071
R925 VSS.n306 VSS.n268 0.101071
R926 VSS.n308 VSS.n266 0.101071
R927 VSS.n310 VSS.n264 0.101071
R928 VSS.n312 VSS.n262 0.101071
R929 VSS.n525 VSS.n225 0.101071
R930 VSS.n526 VSS.n224 0.101071
R931 VSS.n528 VSS.n222 0.101071
R932 VSS.n530 VSS.n220 0.101071
R933 VSS.n535 VSS.n215 0.101071
R934 VSS.n536 VSS.n214 0.101071
R935 VSS.n538 VSS.n212 0.101071
R936 VSS.n540 VSS.n210 0.101071
R937 VSS.n545 VSS.n205 0.101071
R938 VSS.n546 VSS.n204 0.101071
R939 VSS.n548 VSS.n202 0.101071
R940 VSS.n550 VSS.n200 0.101071
R941 VSS.n554 VSS.n196 0.101071
R942 VSS.n555 VSS.n195 0.101071
R943 VSS.n238 VSS.n228 0.101071
R944 VSS.n353 VSS.n239 0.101071
R945 VSS.n245 VSS.n243 0.101071
R946 VSS.n349 VSS.n247 0.101071
R947 VSS.n323 VSS.n259 0.101071
R948 VSS.n322 VSS.n321 0.101071
R949 VSS.n329 VSS.n317 0.101071
R950 VSS.n327 VSS.n319 0.101071
R951 VSS.n335 VSS.n257 0.101071
R952 VSS.n338 VSS.n255 0.101071
R953 VSS.n340 VSS.n253 0.101071
R954 VSS.n447 VSS.n446 0.0927224
R955 VSS.n448 VSS.n447 0.0891245
R956 VSS.n556 VSS.n555 0.0885
R957 VSS.n555 VSS.n554 0.0885
R958 VSS.n554 VSS.n553 0.0885
R959 VSS.n553 VSS.n552 0.0885
R960 VSS.n552 VSS.n551 0.0885
R961 VSS.n551 VSS.n550 0.0885
R962 VSS.n550 VSS.n549 0.0885
R963 VSS.n549 VSS.n548 0.0885
R964 VSS.n548 VSS.n547 0.0885
R965 VSS.n547 VSS.n546 0.0885
R966 VSS.n546 VSS.n545 0.0885
R967 VSS.n543 VSS.n542 0.0885
R968 VSS.n542 VSS.n541 0.0885
R969 VSS.n541 VSS.n540 0.0885
R970 VSS.n540 VSS.n539 0.0885
R971 VSS.n539 VSS.n538 0.0885
R972 VSS.n538 VSS.n537 0.0885
R973 VSS.n537 VSS.n536 0.0885
R974 VSS.n536 VSS.n535 0.0885
R975 VSS.n533 VSS.n532 0.0885
R976 VSS.n532 VSS.n531 0.0885
R977 VSS.n531 VSS.n530 0.0885
R978 VSS.n530 VSS.n529 0.0885
R979 VSS.n529 VSS.n528 0.0885
R980 VSS.n528 VSS.n527 0.0885
R981 VSS.n527 VSS.n526 0.0885
R982 VSS.n526 VSS.n525 0.0885
R983 VSS.n421 VSS.n420 0.0885
R984 VSS.n422 VSS.n421 0.0885
R985 VSS.n423 VSS.n422 0.0885
R986 VSS.n425 VSS.n423 0.0885
R987 VSS.n425 VSS.n424 0.0885
R988 VSS.n424 VSS.n417 0.0885
R989 VSS.n405 VSS.n403 0.0885
R990 VSS.n406 VSS.n405 0.0885
R991 VSS.n407 VSS.n406 0.0885
R992 VSS.n413 VSS.n412 0.0853311
R993 VSS.n500 VSS.n488 0.0846837
R994 VSS.n417 VSS.n416 0.0841
R995 VSS.n462 VSS.n453 0.0817061
R996 VSS.n461 VSS.n453 0.0817061
R997 VSS.n459 VSS.n453 0.0817061
R998 VSS.n458 VSS.n453 0.0817061
R999 VSS.n457 VSS.n453 0.0817061
R1000 VSS.n455 VSS.n453 0.0817061
R1001 VSS.n401 VSS.n400 0.0814472
R1002 VSS.n440 VSS.n439 0.0794206
R1003 VSS.n441 VSS.n399 0.0784641
R1004 VSS.n498 VSS.n89 0.0779076
R1005 VSS.n489 VSS.n86 0.0779076
R1006 VSS.n491 VSS.n99 0.0779076
R1007 VSS.n235 VSS.n104 0.0779076
R1008 VSS.n231 VSS.n101 0.0779076
R1009 VSS.n229 VSS.n114 0.0779076
R1010 VSS.n438 VSS.n437 0.0776211
R1011 VSS.n450 VSS.n448 0.0773061
R1012 VSS.n303 VSS.n193 0.0759286
R1013 VSS.n311 VSS.n263 0.0759286
R1014 VSS.n309 VSS.n265 0.0759286
R1015 VSS.n307 VSS.n267 0.0759286
R1016 VSS.n305 VSS.n269 0.0759286
R1017 VSS.n286 VSS.n281 0.0759286
R1018 VSS.n292 VSS.n288 0.0759286
R1019 VSS.n289 VSS.n274 0.0759286
R1020 VSS.n297 VSS.n273 0.0759286
R1021 VSS.n298 VSS.n272 0.0759286
R1022 VSS.n533 VSS.n217 0.0759286
R1023 VSS.n532 VSS.n218 0.0759286
R1024 VSS.n531 VSS.n219 0.0759286
R1025 VSS.n529 VSS.n221 0.0759286
R1026 VSS.n527 VSS.n223 0.0759286
R1027 VSS.n543 VSS.n207 0.0759286
R1028 VSS.n542 VSS.n208 0.0759286
R1029 VSS.n541 VSS.n209 0.0759286
R1030 VSS.n539 VSS.n211 0.0759286
R1031 VSS.n537 VSS.n213 0.0759286
R1032 VSS.n556 VSS.n194 0.0759286
R1033 VSS.n553 VSS.n197 0.0759286
R1034 VSS.n552 VSS.n198 0.0759286
R1035 VSS.n551 VSS.n199 0.0759286
R1036 VSS.n549 VSS.n201 0.0759286
R1037 VSS.n547 VSS.n203 0.0759286
R1038 VSS.n348 VSS.n248 0.0759286
R1039 VSS.n347 VSS.n249 0.0759286
R1040 VSS.n345 VSS.n250 0.0759286
R1041 VSS.n246 VSS.n242 0.0759286
R1042 VSS.n244 VSS.n240 0.0759286
R1043 VSS.n328 VSS.n318 0.0759286
R1044 VSS.n320 VSS.n316 0.0759286
R1045 VSS.n339 VSS.n254 0.0759286
R1046 VSS.n336 VSS.n256 0.0759286
R1047 VSS.n334 VSS.n258 0.0759286
R1048 VSS.n424 VSS.n418 0.0759286
R1049 VSS.n426 VSS.n425 0.0759286
R1050 VSS.n427 VSS.n423 0.0759286
R1051 VSS.n428 VSS.n422 0.0759286
R1052 VSS.n429 VSS.n421 0.0759286
R1053 VSS.n430 VSS.n420 0.0759286
R1054 VSS.n432 VSS.n417 0.0759286
R1055 VSS.n408 VSS.n407 0.0759286
R1056 VSS.n409 VSS.n406 0.0759286
R1057 VSS.n410 VSS.n405 0.0759286
R1058 VSS.n411 VSS.n403 0.0759286
R1059 VSS.n517 VSS.n515 0.0753
R1060 VSS.n518 VSS.n517 0.0753
R1061 VSS.n437 VSS.n436 0.0750054
R1062 VSS.n440 VSS.n438 0.0725235
R1063 VSS.n443 VSS.n441 0.0721359
R1064 VSS.n439 VSS.n401 0.0711793
R1065 VSS.n400 VSS.n399 0.0686974
R1066 VSS.n443 VSS.n442 0.0675776
R1067 VSS.n563 VSS.n561 0.0663537
R1068 VSS.n431 VSS.n419 0.064985
R1069 VSS.n450 VSS.n449 0.061725
R1070 VSS.n561 VSS.n67 0.0608659
R1071 VSS.n564 VSS.n563 0.0608659
R1072 VSS.n500 VSS.n92 0.0594056
R1073 VSS.n356 VSS.n107 0.0594056
R1074 VSS.n498 VSS.n92 0.0586497
R1075 VSS.n235 VSS.n107 0.0586497
R1076 VSS.n446 VSS.n445 0.0581825
R1077 VSS.n488 VSS.n487 0.0566224
R1078 VSS.n176 VSS.n132 0.0529665
R1079 VSS.n345 VSS.n344 0.0528809
R1080 VSS.n557 VSS.n193 0.0518333
R1081 VSS.n119 VSS.n118 0.0518066
R1082 VSS.n175 VSS.n172 0.0517609
R1083 VSS.n404 VSS.n402 0.0511625
R1084 VSS.n159 VSS.n144 0.0509482
R1085 VSS.n151 VSS.n150 0.050601
R1086 VSS.n191 VSS.n190 0.0497426
R1087 VSS.n150 VSS.n148 0.0490925
R1088 VSS.n420 VSS.n419 0.0489
R1089 VSS.n177 VSS.n175 0.0480833
R1090 VSS.n165 VSS.n164 0.0479206
R1091 VSS.n120 VSS.n119 0.0474161
R1092 VSS.n344 VSS.n251 0.0473412
R1093 VSS.n122 VSS.n120 0.0470742
R1094 VSS.n183 VSS.n128 0.0469115
R1095 VSS.n189 VSS.n128 0.0467151
R1096 VSS.n444 VSS.n396 0.0464192
R1097 VSS.n177 VSS.n176 0.0464069
R1098 VSS.n523 VSS.n522 0.046273
R1099 VSS.n452 VSS.n451 0.0460827
R1100 VSS.n168 VSS.n165 0.0457059
R1101 VSS.n156 VSS.n148 0.0453978
R1102 VSS VSS.n585 0.0444024
R1103 VSS.n190 VSS.n189 0.0438839
R1104 VSS.n164 VSS.n144 0.0426784
R1105 VSS.n172 VSS.n171 0.0418656
R1106 VSS.n180 VSS.n132 0.04066
R1107 VSS.n397 VSS.n396 0.0397236
R1108 VSS.n562 VSS.n184 0.0396708
R1109 VSS.n496 VSS.n89 0.039409
R1110 VSS.n491 VSS.n86 0.039409
R1111 VSS.n357 VSS.n99 0.039409
R1112 VSS.n233 VSS.n104 0.039409
R1113 VSS.n229 VSS.n101 0.039409
R1114 VSS.n521 VSS.n114 0.039409
R1115 VSS.n504 VSS.n96 0.0391419
R1116 VSS.n516 VSS.n111 0.0391419
R1117 VSS.n560 VSS.n169 0.0389181
R1118 VSS.n496 VSS.n94 0.0386633
R1119 VSS.n233 VSS.n109 0.0386633
R1120 VSS.n445 VSS.n444 0.037474
R1121 VSS.n169 VSS.n168 0.0356341
R1122 VSS.n157 VSS.n156 0.0354567
R1123 VSS.n559 VSS.n558 0.0353
R1124 VSS.n123 VSS.n122 0.0351224
R1125 VSS.n184 VSS.n183 0.0348814
R1126 VSS.n442 VSS.n398 0.0320652
R1127 VSS.n313 VSS.n261 0.0302645
R1128 VSS.n301 VSS.n193 0.0298333
R1129 VSS.n299 VSS.n298 0.0298333
R1130 VSS.n298 VSS.n297 0.0298333
R1131 VSS.n291 VSS.n274 0.0298333
R1132 VSS.n292 VSS.n291 0.0298333
R1133 VSS.n281 VSS.n280 0.0298333
R1134 VSS.n284 VSS.n281 0.0298333
R1135 VSS.n282 VSS.n269 0.0298333
R1136 VSS.n269 VSS.n268 0.0298333
R1137 VSS.n267 VSS.n266 0.0298333
R1138 VSS.n266 VSS.n265 0.0298333
R1139 VSS.n264 VSS.n263 0.0298333
R1140 VSS.n263 VSS.n262 0.0298333
R1141 VSS.n565 VSS.n123 0.0273833
R1142 VSS.n158 VSS.n157 0.027049
R1143 VSS.n413 VSS.n403 0.0269
R1144 VSS.n514 VSS.n513 0.0254333
R1145 VSS.n460 VSS.n453 0.022573
R1146 VSS.n300 VSS.n299 0.0225
R1147 VSS.n296 VSS.n274 0.0225
R1148 VSS.n293 VSS.n280 0.0225
R1149 VSS.n283 VSS.n282 0.0225
R1150 VSS.n277 VSS.n267 0.0225
R1151 VSS.n275 VSS.n264 0.0225
R1152 VSS.n449 VSS.n395 0.0215435
R1153 VSS.n328 VSS.n327 0.0214524
R1154 VSS.n329 VSS.n328 0.0214524
R1155 VSS.n321 VSS.n316 0.0214524
R1156 VSS.n321 VSS.n259 0.0214524
R1157 VSS.n335 VSS.n334 0.0214524
R1158 VSS.n336 VSS.n335 0.0214524
R1159 VSS.n339 VSS.n338 0.0214524
R1160 VSS.n340 VSS.n339 0.0214524
R1161 VSS.n348 VSS.n347 0.0214524
R1162 VSS.n349 VSS.n348 0.0214524
R1163 VSS.n243 VSS.n242 0.0214524
R1164 VSS.n243 VSS.n240 0.0214524
R1165 VSS.n433 VSS.n416 0.0213089
R1166 VSS.n451 VSS.n395 0.0210652
R1167 VSS.n489 VSS.n96 0.0200602
R1168 VSS.n231 VSS.n111 0.0200602
R1169 VSS.n504 VSS.n94 0.0195816
R1170 VSS.n516 VSS.n109 0.0195816
R1171 VSS.n558 VSS.n192 0.0185
R1172 VSS.n295 VSS.n192 0.0185
R1173 VSS.n295 VSS.n294 0.0185
R1174 VSS.n294 VSS.n279 0.0185
R1175 VSS.n279 VSS.n278 0.0185
R1176 VSS.n278 VSS.n276 0.0185
R1177 VSS.n276 VSS.n260 0.0185
R1178 VSS.n314 VSS.n260 0.0185
R1179 VSS.n160 VSS.n158 0.0181516
R1180 VSS.n566 VSS.n565 0.0181516
R1181 VSS.n341 VSS.n251 0.0159153
R1182 VSS.n326 VSS.n325 0.0156425
R1183 VSS.n354 VSS.n353 0.0143286
R1184 VSS.n331 VSS.n315 0.0133571
R1185 VSS.n332 VSS.n331 0.0133571
R1186 VSS.n332 VSS.n252 0.0133571
R1187 VSS.n342 VSS.n252 0.0133571
R1188 VSS.n343 VSS.n342 0.0133571
R1189 VSS.n343 VSS.n241 0.0133571
R1190 VSS.n351 VSS.n241 0.0133571
R1191 VSS.n171 VSS.n139 0.0131147
R1192 VSS.n181 VSS.n180 0.0131147
R1193 VSS.n160 VSS.n159 0.0131058
R1194 VSS.n566 VSS.n191 0.0131058
R1195 VSS.n304 VSS.n270 0.0124467
R1196 VSS.n206 VSS.n205 0.0124467
R1197 VSS.n226 VSS.n225 0.0121878
R1198 VSS.n216 VSS.n215 0.0121878
R1199 VSS.n238 VSS.n227 0.0121878
R1200 VSS.n324 VSS.n323 0.0121878
R1201 VSS.n327 VSS.n326 0.0109762
R1202 VSS.n330 VSS.n329 0.0109762
R1203 VSS.n330 VSS.n316 0.0109762
R1204 VSS.n333 VSS.n259 0.0109762
R1205 VSS.n334 VSS.n333 0.0109762
R1206 VSS.n337 VSS.n336 0.0109762
R1207 VSS.n338 VSS.n337 0.0109762
R1208 VSS.n341 VSS.n340 0.0109762
R1209 VSS.n346 VSS.n345 0.0109762
R1210 VSS.n347 VSS.n346 0.0109762
R1211 VSS.n350 VSS.n349 0.0109762
R1212 VSS.n350 VSS.n242 0.0109762
R1213 VSS.n352 VSS.n240 0.0109762
R1214 VSS.n353 VSS.n352 0.0109762
R1215 VSS.n398 VSS.n397 0.0105435
R1216 VSS.n301 VSS.n300 0.00783333
R1217 VSS.n297 VSS.n296 0.00783333
R1218 VSS.n293 VSS.n292 0.00783333
R1219 VSS.n284 VSS.n283 0.00783333
R1220 VSS.n277 VSS.n268 0.00783333
R1221 VSS.n275 VSS.n265 0.00783333
R1222 VSS.n262 VSS.n261 0.00783333
R1223 VSS.n354 VSS.n228 0.00762381
R1224 VSS.n486 VSS.n359 0.00691667
R1225 VSS.n13 VSS.n466 0.00649867
R1226 VSS.n25 VSS.n18 0.00490244
R1227 VSS.n560 VSS.n139 0.00605046
R1228 VSS.n562 VSS.n181 0.00605046
R1229 VSS.n522 VSS.n228 0.00594762
R1230 VSS.n51 VSS.n366 0.00592384
R1231 VSS.n15 VSS.n14 0.00474983
R1232 VSS.n23 VSS.n22 0.00449989
R1233 VSS.n21 VSS.n20 0.00299877
R1234 VSS.n20 VSS.n19 0.00449989
R1235 VSS.n19 VSS.n15 0.00449989
R1236 VSS.n25 VSS.n7 0.00399977
R1237 VSS.n31 VSS.n32 0.00399966
R1238 VSS.n14 VSS.n7 0.00374989
R1239 VSS.n47 VSS.n34 0.00343098
R1240 VSS.n61 VSS.n364 0.00283308
R1241 VSS.n65 VSS.n362 0.00249993
R1242 VSS.n468 VSS.n9 0.00166667
R1243 VSS.n366 VSS.n35 0.00166667
R1244 VSS.n57 VSS.n56 0.00169993
R1245 VSS.n364 VSS.n42 0.00166667
R1246 VSS.n63 VSS.n62 0.00169993
R1247 VSS.n362 VSS.n360 0.00166667
R1248 VSS.n363 VSS.n63 0.0015
R1249 VSS.n59 VSS.n40 0.00199997
R1250 VSS.n58 VSS.n365 0.00199997
R1251 VSS.n60 VSS.n45 0.00199997
R1252 VSS.n58 VSS.n40 0.00199997
R1253 VSS.n55 VSS.n38 0.00199997
R1254 VSS.n43 VSS.n42 0.00183332
R1255 VSS.n36 VSS.n35 0.00183332
R1256 VSS.n10 VSS.n9 0.00183332
R1257 VSS.t30 VSS.n1 7.4326
R1258 VSS.n0 VSS.n2 100.391
R1259 VSS.n365 VSS.n57 0.0015
R1260 VSS.n468 VSS.n466 0.00133332
R1261 VSS.n363 VSS.n360 0.00133332
R1262 VSS.n465 VSS.n1 774.803
R1263 VSS.n5 VSS.n0 0.280316
R1264 VSS.n3 VSS.n1 0.217607
R1265 a_19774_346.n0 a_19774_346.t0 4.85847
R1266 a_19774_346.t15 a_19774_346.n2 4.83761
R1267 a_19774_346.n2 a_19774_346.t14 4.83657
R1268 a_19774_346.n2 a_19774_346.t13 4.83657
R1269 a_19774_346.n2 a_19774_346.t12 4.83657
R1270 a_19774_346.n1 a_19774_346.t11 4.83657
R1271 a_19774_346.n1 a_19774_346.t10 4.83657
R1272 a_19774_346.n1 a_19774_346.t9 4.83657
R1273 a_19774_346.n1 a_19774_346.t8 4.83657
R1274 a_19774_346.n1 a_19774_346.t7 4.83657
R1275 a_19774_346.n1 a_19774_346.t6 4.83657
R1276 a_19774_346.n1 a_19774_346.t5 4.83657
R1277 a_19774_346.n1 a_19774_346.t4 4.83657
R1278 a_19774_346.n0 a_19774_346.t3 4.83657
R1279 a_19774_346.n0 a_19774_346.t2 4.83657
R1280 a_19774_346.n0 a_19774_346.t1 4.83657
R1281 a_19774_346.n2 a_19774_346.t16 0.895788
R1282 a_19774_346.n1 a_19774_346.n0 0.175641
R1283 a_19774_346.n2 a_19774_346.n1 0.131856
R1284 a_11798_1860.n4 a_11798_1860.t3 3.17076
R1285 a_11798_1860.n5 a_11798_1860.t25 3.17076
R1286 a_11798_1860.n27 a_11798_1860.t6 2.79558
R1287 a_11798_1860.n10 a_11798_1860.t22 2.79558
R1288 a_11798_1860.n14 a_11798_1860.t28 2.79558
R1289 a_11798_1860.n23 a_11798_1860.t0 2.79551
R1290 a_11798_1860.n32 a_11798_1860.t1 2.7955
R1291 a_11798_1860.n24 a_11798_1860.t2 2.7955
R1292 a_11798_1860.n25 a_11798_1860.t4 2.7955
R1293 a_11798_1860.n26 a_11798_1860.t5 2.7955
R1294 a_11798_1860.n19 a_11798_1860.t23 2.7955
R1295 a_11798_1860.n11 a_11798_1860.t24 2.7955
R1296 a_11798_1860.n12 a_11798_1860.t26 2.7955
R1297 a_11798_1860.n13 a_11798_1860.t27 2.7955
R1298 a_11798_1860.t21 a_11798_1860.n8 2.61386
R1299 a_11798_1860.n1 a_11798_1860.t7 2.61049
R1300 a_11798_1860.n1 a_11798_1860.t9 2.56233
R1301 a_11798_1860.n1 a_11798_1860.t10 2.56207
R1302 a_11798_1860.n8 a_11798_1860.t20 2.56173
R1303 a_11798_1860.n2 a_11798_1860.t14 2.56173
R1304 a_11798_1860.n8 a_11798_1860.t19 2.56159
R1305 a_11798_1860.n2 a_11798_1860.t16 2.56159
R1306 a_11798_1860.n1 a_11798_1860.t8 2.56159
R1307 a_11798_1860.n2 a_11798_1860.t15 2.56147
R1308 a_11798_1860.n7 a_11798_1860.t18 2.56146
R1309 a_11798_1860.n7 a_11798_1860.t17 2.56146
R1310 a_11798_1860.n2 a_11798_1860.t13 2.56146
R1311 a_11798_1860.n2 a_11798_1860.t12 2.56146
R1312 a_11798_1860.n2 a_11798_1860.t11 2.56128
R1313 a_11798_1860.n27 a_11798_1860.n21 2.36008
R1314 a_11798_1860.n20 a_11798_1860.n10 2.36008
R1315 a_11798_1860.n14 a_11798_1860.n0 2.36008
R1316 a_11798_1860.n33 a_11798_1860.n23 2.35957
R1317 a_11798_1860.n33 a_11798_1860.n32 2.3402
R1318 a_11798_1860.n26 a_11798_1860.n21 2.3402
R1319 a_11798_1860.n20 a_11798_1860.n19 2.3402
R1320 a_11798_1860.n13 a_11798_1860.n0 2.3402
R1321 a_11798_1860.n25 a_11798_1860.n3 2.3138
R1322 a_11798_1860.n12 a_11798_1860.n0 2.3138
R1323 a_11798_1860.n24 a_11798_1860.n22 2.3138
R1324 a_11798_1860.n11 a_11798_1860.n9 2.3138
R1325 a_11798_1860.n31 a_11798_1860.n23 0.748603
R1326 a_11798_1860.n28 a_11798_1860.n27 0.74808
R1327 a_11798_1860.n18 a_11798_1860.n10 0.74808
R1328 a_11798_1860.n15 a_11798_1860.n14 0.74808
R1329 a_11798_1860.n32 a_11798_1860.n31 0.561174
R1330 a_11798_1860.n30 a_11798_1860.n24 0.561174
R1331 a_11798_1860.n29 a_11798_1860.n25 0.561174
R1332 a_11798_1860.n28 a_11798_1860.n26 0.561174
R1333 a_11798_1860.n19 a_11798_1860.n18 0.561174
R1334 a_11798_1860.n17 a_11798_1860.n11 0.561174
R1335 a_11798_1860.n16 a_11798_1860.n12 0.561174
R1336 a_11798_1860.n15 a_11798_1860.n13 0.561174
R1337 a_11798_1860.n4 a_11798_1860.n3 0.402048
R1338 a_11798_1860.n5 a_11798_1860.n0 0.402048
R1339 a_11798_1860.n5 a_11798_1860.n16 0.284105
R1340 a_11798_1860.n4 a_11798_1860.n29 0.284105
R1341 a_11798_1860.n1 a_11798_1860.n33 0.25306
R1342 a_11798_1860.n6 a_11798_1860.n21 0.0449208
R1343 a_11798_1860.n2 a_11798_1860.n20 0.25306
R1344 a_11798_1860.n2 a_11798_1860.n6 0.203345
R1345 a_11798_1860.n2 a_11798_1860.n1 0.196551
R1346 a_11798_1860.n7 a_11798_1860.n0 0.194161
R1347 a_11798_1860.n31 a_11798_1860.n30 0.1875
R1348 a_11798_1860.n30 a_11798_1860.n4 0.1875
R1349 a_11798_1860.n29 a_11798_1860.n28 0.1875
R1350 a_11798_1860.n18 a_11798_1860.n17 0.1875
R1351 a_11798_1860.n17 a_11798_1860.n5 0.1875
R1352 a_11798_1860.n16 a_11798_1860.n15 0.1875
R1353 a_11798_1860.n9 a_11798_1860.n0 0.153033
R1354 a_11798_1860.n22 a_11798_1860.n3 0.153033
R1355 a_11798_1860.n8 a_11798_1860.n7 0.147538
R1356 a_11798_1860.n7 a_11798_1860.n2 0.147538
R1357 a_11798_1860.n33 a_11798_1860.n22 0.106833
R1358 a_11798_1860.n3 a_11798_1860.n6 0.0449208
R1359 a_11798_1860.n20 a_11798_1860.n9 0.106833
R1360 a_5060_3702.n0 a_5060_3702.t4 53.6901
R1361 a_5060_3702.n3 a_5060_3702.t1 29.2688
R1362 a_5060_3702.n2 a_5060_3702.t5 24.2693
R1363 a_5060_3702.n1 a_5060_3702.t2 24.2693
R1364 a_5060_3702.t0 a_5060_3702.n3 15.6064
R1365 a_5060_3702.n0 a_5060_3702.t3 9.21754
R1366 a_5060_3702.n3 a_5060_3702.n2 1.7693
R1367 a_5060_3702.n2 a_5060_3702.n1 0.543167
R1368 a_5060_3702.n1 a_5060_3702.n0 0.320233
R1369 a_5560_4622.n0 a_5560_4622.t0 27.72
R1370 a_5560_4622.n0 a_5560_4622.t1 24.1197
R1371 a_5560_4622.t2 a_5560_4622.n0 9.38813
R1372 a_5560_6408.n0 a_5560_6408.t0 55.3005
R1373 a_5560_6408.n0 a_5560_6408.t1 27.8842
R1374 a_5560_6408.t2 a_5560_6408.n0 7.50485
R1375 a_5060_6408.n0 a_5060_6408.t1 34.3045
R1376 a_5060_6408.t0 a_5060_6408.n0 5.85564
R1377 a_5060_6408.t0 a_5060_6408.n0 5.85498
R1378 a_6568_6836.n2 a_6568_6836.t1 19.9393
R1379 a_6568_6836.n0 a_6568_6836.t4 19.6783
R1380 a_6568_6836.n1 a_6568_6836.t0 17.974
R1381 a_6568_6836.n2 a_6568_6836.n1 5.04317
R1382 a_6568_6836.n0 a_6568_6836.t3 4.81727
R1383 a_6568_6836.n1 a_6568_6836.n0 4.76157
R1384 a_6568_6836.t2 a_6568_6836.n2 3.15445
R1385 a_5948_5116.n0 a_5948_5116.t2 30.2902
R1386 a_5948_5116.n0 a_5948_5116.t1 27.2706
R1387 a_5948_5116.t0 a_5948_5116.n0 11.5346
R1388 vco_feed_0.en_b.n0 vco_feed_0.en_b.t0 27.1774
R1389 vco_feed_0.en_b.n4 vco_feed_0.en_b.t6 24.9608
R1390 vco_feed_0.en_b.n3 vco_feed_0.en_b.t3 24.8442
R1391 vco_feed_0.en_b.n1 vco_feed_0.en_b.t7 20.7725
R1392 vco_feed_0.en_b.n1 vco_feed_0.en_b.t5 20.4909
R1393 vco_feed_0.en_b.n0 vco_feed_0.en_b.t4 20.4287
R1394 vco_feed_0.en_b.n0 vco_feed_0.en_b.t1 12.1418
R1395 vco_feed_0.en_b vco_feed_0.en_b.t2 5.74905
R1396 vco_feed_0.en_b.n2 vco_feed_0.en_b.n1 5.30277
R1397 vco_feed_0.en_b.n2 vco_feed_0.en_b.n0 4.5269
R1398 vco_feed_0.en_b vco_feed_0.en_b.n4 2.33103
R1399 vco_feed_0.en_b.n3 vco_feed_0.en_b.n2 0.562233
R1400 vco_feed_0.en_b.n4 vco_feed_0.en_b.n3 0.469833
R1401 vco_feed_0.vdd_core.n213 vco_feed_0.vdd_core.n7 9.0005
R1402 vco_feed_0.vdd_core.n205 vco_feed_0.vdd_core.t9 6.57599
R1403 vco_feed_0.vdd_core.n5 vco_feed_0.vdd_core.t12 6.57599
R1404 vco_feed_0.vdd_core.n216 vco_feed_0.vdd_core.t20 6.5301
R1405 vco_feed_0.vdd_core.n209 vco_feed_0.vdd_core.t5 6.52949
R1406 vco_feed_0.vdd_core.n209 vco_feed_0.vdd_core.t3 6.52949
R1407 vco_feed_0.vdd_core.n205 vco_feed_0.vdd_core.t7 6.52949
R1408 vco_feed_0.vdd_core.n209 vco_feed_0.vdd_core.t1 6.52949
R1409 vco_feed_0.vdd_core.n216 vco_feed_0.vdd_core.t18 6.52949
R1410 vco_feed_0.vdd_core.n216 vco_feed_0.vdd_core.t16 6.52949
R1411 vco_feed_0.vdd_core.n5 vco_feed_0.vdd_core.t14 6.52949
R1412 vco_feed_0.vdd_core.n20 vco_feed_0.vdd_core.n19 6.52948
R1413 vco_feed_0.vdd_core.n74 vco_feed_0.vdd_core.n54 6.52948
R1414 vco_feed_0.vdd_core.n35 vco_feed_0.vdd_core.n34 6.47038
R1415 vco_feed_0.vdd_core.n76 vco_feed_0.vdd_core.n53 6.47038
R1416 vco_feed_0.vdd_core.n110 vco_feed_0.vdd_core.n109 6.05177
R1417 vco_feed_0.vdd_core.n113 vco_feed_0.vdd_core.n112 6.00132
R1418 vco_feed_0.vdd_core.n210 vco_feed_0.vdd_core.t11 4.17215
R1419 vco_feed_0.vdd_core.n215 vco_feed_0.vdd_core.t0 4.00827
R1420 vco_feed_0.vdd_core.n206 vco_feed_0.vdd_core.t23 3.41873
R1421 vco_feed_0.vdd_core.n207 vco_feed_0.vdd_core.t25 3.41873
R1422 vco_feed_0.vdd_core.n208 vco_feed_0.vdd_core.t27 3.41873
R1423 vco_feed_0.vdd_core.n219 vco_feed_0.vdd_core.t24 3.39968
R1424 vco_feed_0.vdd_core.n218 vco_feed_0.vdd_core.t26 3.39968
R1425 vco_feed_0.vdd_core.n217 vco_feed_0.vdd_core.t28 3.39968
R1426 vco_feed_0.vdd_core.n214 vco_feed_0.vdd_core.n6 1.36338
R1427 vco_feed_0.vdd_core.n214 vco_feed_0.vdd_core.n213 1.30181
R1428 vco_feed_0.vdd_core.n213 vco_feed_0.vdd_core.n212 1.28621
R1429 vco_feed_0.vdd_core.n1 vco_feed_0.vdd_core.n0 0.0252705
R1430 vco_feed_0.vdd_core.n0 vco_feed_0.vdd_core.n211 0.793488
R1431 vco_feed_0.vdd_core.n122 vco_feed_0.vdd_core.t22 0.770099
R1432 vco_feed_0.vdd_core.n211 vco_feed_0.vdd_core 0.632687
R1433 vco_feed_0.vdd_core vco_feed_0.vdd_core.n122 0.627294
R1434 vco_feed_0.vdd_core.n204 vco_feed_0.vdd_core.n9 0.56175
R1435 vco_feed_0.vdd_core.n204 vco_feed_0.vdd_core.n203 0.5505
R1436 vco_feed_0.vdd_core.n177 vco_feed_0.vdd_core.n176 0.5505
R1437 vco_feed_0.vdd_core.n179 vco_feed_0.vdd_core.n178 0.5505
R1438 vco_feed_0.vdd_core.n182 vco_feed_0.vdd_core.n58 0.5505
R1439 vco_feed_0.vdd_core.n186 vco_feed_0.vdd_core.n185 0.5505
R1440 vco_feed_0.vdd_core.n188 vco_feed_0.vdd_core.n187 0.5505
R1441 vco_feed_0.vdd_core.n190 vco_feed_0.vdd_core.n44 0.5505
R1442 vco_feed_0.vdd_core.n195 vco_feed_0.vdd_core.n194 0.5505
R1443 vco_feed_0.vdd_core.n197 vco_feed_0.vdd_core.n196 0.5505
R1444 vco_feed_0.vdd_core.n200 vco_feed_0.vdd_core.n8 0.5505
R1445 vco_feed_0.vdd_core.n139 vco_feed_0.vdd_core.n123 0.5505
R1446 vco_feed_0.vdd_core.n144 vco_feed_0.vdd_core.n143 0.5505
R1447 vco_feed_0.vdd_core.n146 vco_feed_0.vdd_core.n145 0.5505
R1448 vco_feed_0.vdd_core.n150 vco_feed_0.vdd_core.n96 0.5505
R1449 vco_feed_0.vdd_core.n155 vco_feed_0.vdd_core.n154 0.5505
R1450 vco_feed_0.vdd_core.n157 vco_feed_0.vdd_core.n156 0.5505
R1451 vco_feed_0.vdd_core.n161 vco_feed_0.vdd_core.n81 0.5505
R1452 vco_feed_0.vdd_core.n166 vco_feed_0.vdd_core.n165 0.5505
R1453 vco_feed_0.vdd_core vco_feed_0.vdd_core.n214 0.504298
R1454 vco_feed_0.vdd_core.n138 vco_feed_0.vdd_core.n137 0.446709
R1455 vco_feed_0.vdd_core.n138 vco_feed_0.vdd_core.n136 0.445751
R1456 vco_feed_0.vdd_core.n92 vco_feed_0.vdd_core.n90 0.4405
R1457 vco_feed_0.vdd_core.n91 vco_feed_0.vdd_core.n89 0.4405
R1458 vco_feed_0.vdd_core.n30 vco_feed_0.vdd_core.n18 0.4405
R1459 vco_feed_0.vdd_core.n22 vco_feed_0.vdd_core.n21 0.4405
R1460 vco_feed_0.vdd_core.n63 vco_feed_0.vdd_core.n56 0.4405
R1461 vco_feed_0.vdd_core.n61 vco_feed_0.vdd_core.n55 0.4405
R1462 vco_feed_0.vdd_core.n90 vco_feed_0.vdd_core.n88 0.4405
R1463 vco_feed_0.vdd_core.n89 vco_feed_0.vdd_core.n87 0.4405
R1464 vco_feed_0.vdd_core.n34 vco_feed_0.vdd_core.n18 0.4405
R1465 vco_feed_0.vdd_core.n21 vco_feed_0.vdd_core.n20 0.4405
R1466 vco_feed_0.vdd_core.n56 vco_feed_0.vdd_core.n53 0.4405
R1467 vco_feed_0.vdd_core.n55 vco_feed_0.vdd_core.n54 0.4405
R1468 vco_feed_0.vdd_core.n104 vco_feed_0.vdd_core.n103 0.3635
R1469 vco_feed_0.vdd_core.n105 vco_feed_0.vdd_core.n104 0.3635
R1470 vco_feed_0.vdd_core.n116 vco_feed_0.vdd_core.n114 0.3635
R1471 vco_feed_0.vdd_core.n118 vco_feed_0.vdd_core.n116 0.3635
R1472 vco_feed_0.vdd_core.n131 vco_feed_0.vdd_core.n130 0.3635
R1473 vco_feed_0.vdd_core.n132 vco_feed_0.vdd_core.n131 0.3635
R1474 vco_feed_0.vdd_core.n87 vco_feed_0.vdd_core.n85 0.3635
R1475 vco_feed_0.vdd_core.n101 vco_feed_0.vdd_core.n100 0.3635
R1476 vco_feed_0.vdd_core.n101 vco_feed_0.vdd_core.n99 0.3635
R1477 vco_feed_0.vdd_core.n115 vco_feed_0.vdd_core.n111 0.3635
R1478 vco_feed_0.vdd_core.n117 vco_feed_0.vdd_core.n115 0.3635
R1479 vco_feed_0.vdd_core.n128 vco_feed_0.vdd_core.n127 0.3635
R1480 vco_feed_0.vdd_core.n128 vco_feed_0.vdd_core.n126 0.3635
R1481 vco_feed_0.vdd_core.n28 vco_feed_0.vdd_core.n27 0.3635
R1482 vco_feed_0.vdd_core.n27 vco_feed_0.vdd_core.n11 0.3635
R1483 vco_feed_0.vdd_core.n38 vco_feed_0.vdd_core.n36 0.3635
R1484 vco_feed_0.vdd_core.n40 vco_feed_0.vdd_core.n38 0.3635
R1485 vco_feed_0.vdd_core.n50 vco_feed_0.vdd_core.n49 0.3635
R1486 vco_feed_0.vdd_core.n50 vco_feed_0.vdd_core.n46 0.3635
R1487 vco_feed_0.vdd_core.n25 vco_feed_0.vdd_core.n24 0.3635
R1488 vco_feed_0.vdd_core.n24 vco_feed_0.vdd_core.n10 0.3635
R1489 vco_feed_0.vdd_core.n37 vco_feed_0.vdd_core.n17 0.3635
R1490 vco_feed_0.vdd_core.n39 vco_feed_0.vdd_core.n37 0.3635
R1491 vco_feed_0.vdd_core.n48 vco_feed_0.vdd_core.n47 0.3635
R1492 vco_feed_0.vdd_core.n48 vco_feed_0.vdd_core.n45 0.3635
R1493 vco_feed_0.vdd_core.n67 vco_feed_0.vdd_core.n60 0.3635
R1494 vco_feed_0.vdd_core.n69 vco_feed_0.vdd_core.n67 0.3635
R1495 vco_feed_0.vdd_core.n79 vco_feed_0.vdd_core.n77 0.3635
R1496 vco_feed_0.vdd_core.n171 vco_feed_0.vdd_core.n79 0.3635
R1497 vco_feed_0.vdd_core.n174 vco_feed_0.vdd_core.n168 0.3635
R1498 vco_feed_0.vdd_core.n2 vco_feed_0.vdd_core.n174 0.421153
R1499 vco_feed_0.vdd_core.n66 vco_feed_0.vdd_core.n59 0.3635
R1500 vco_feed_0.vdd_core.n68 vco_feed_0.vdd_core.n66 0.3635
R1501 vco_feed_0.vdd_core.n78 vco_feed_0.vdd_core.n75 0.3635
R1502 vco_feed_0.vdd_core.n169 vco_feed_0.vdd_core.n78 0.3635
R1503 vco_feed_0.vdd_core.n52 vco_feed_0.vdd_core.n45 0.345639
R1504 vco_feed_0.vdd_core.n209 vco_feed_0.vdd_core.n208 0.33314
R1505 vco_feed_0.vdd_core.n215 vco_feed_0.vdd_core 0.31895
R1506 vco_feed_0.vdd_core vco_feed_0.vdd_core.n210 0.306786
R1507 vco_feed_0.vdd_core.n192 vco_feed_0.vdd_core.n191 0.299759
R1508 vco_feed_0.vdd_core.n218 vco_feed_0.vdd_core.n217 0.29442
R1509 vco_feed_0.vdd_core.n208 vco_feed_0.vdd_core.n207 0.29442
R1510 vco_feed_0.vdd_core.n219 vco_feed_0.vdd_core.n218 0.29442
R1511 vco_feed_0.vdd_core.n207 vco_feed_0.vdd_core.n206 0.29442
R1512 vco_feed_0.vdd_core vco_feed_0.vdd_core.n204 0.2855
R1513 vco_feed_0.vdd_core.n112 vco_feed_0.vdd_core.n84 0.276447
R1514 vco_feed_0.vdd_core.n88 vco_feed_0.vdd_core.n86 0.276447
R1515 vco_feed_0.vdd_core.n94 vco_feed_0.vdd_core.n92 0.276447
R1516 vco_feed_0.vdd_core.n103 vco_feed_0.vdd_core.n94 0.276447
R1517 vco_feed_0.vdd_core.n106 vco_feed_0.vdd_core.n105 0.276447
R1518 vco_feed_0.vdd_core.n120 vco_feed_0.vdd_core.n118 0.276447
R1519 vco_feed_0.vdd_core.n130 vco_feed_0.vdd_core.n120 0.276447
R1520 vco_feed_0.vdd_core.n133 vco_feed_0.vdd_core.n132 0.276447
R1521 vco_feed_0.vdd_core.n137 vco_feed_0.vdd_core.n135 0.276447
R1522 vco_feed_0.vdd_core.n109 vco_feed_0.vdd_core.n83 0.276447
R1523 vco_feed_0.vdd_core.n93 vco_feed_0.vdd_core.n91 0.276447
R1524 vco_feed_0.vdd_core.n100 vco_feed_0.vdd_core.n93 0.276447
R1525 vco_feed_0.vdd_core.n99 vco_feed_0.vdd_core.n98 0.276447
R1526 vco_feed_0.vdd_core.n119 vco_feed_0.vdd_core.n117 0.276447
R1527 vco_feed_0.vdd_core.n127 vco_feed_0.vdd_core.n119 0.276447
R1528 vco_feed_0.vdd_core.n126 vco_feed_0.vdd_core.n125 0.276447
R1529 vco_feed_0.vdd_core.n136 vco_feed_0.vdd_core.n134 0.276447
R1530 vco_feed_0.vdd_core.n30 vco_feed_0.vdd_core.n29 0.276188
R1531 vco_feed_0.vdd_core.n29 vco_feed_0.vdd_core.n28 0.276188
R1532 vco_feed_0.vdd_core.n14 vco_feed_0.vdd_core.n11 0.276188
R1533 vco_feed_0.vdd_core.n42 vco_feed_0.vdd_core.n40 0.276188
R1534 vco_feed_0.vdd_core.n49 vco_feed_0.vdd_core.n42 0.276188
R1535 vco_feed_0.vdd_core.n192 vco_feed_0.vdd_core.n46 0.276188
R1536 vco_feed_0.vdd_core.n23 vco_feed_0.vdd_core.n22 0.276188
R1537 vco_feed_0.vdd_core.n25 vco_feed_0.vdd_core.n23 0.276188
R1538 vco_feed_0.vdd_core.n13 vco_feed_0.vdd_core.n10 0.276188
R1539 vco_feed_0.vdd_core.n41 vco_feed_0.vdd_core.n39 0.276188
R1540 vco_feed_0.vdd_core.n47 vco_feed_0.vdd_core.n41 0.276188
R1541 vco_feed_0.vdd_core.n64 vco_feed_0.vdd_core.n63 0.276188
R1542 vco_feed_0.vdd_core.n64 vco_feed_0.vdd_core.n60 0.276188
R1543 vco_feed_0.vdd_core.n71 vco_feed_0.vdd_core.n69 0.276188
R1544 vco_feed_0.vdd_core.n172 vco_feed_0.vdd_core.n171 0.276188
R1545 vco_feed_0.vdd_core.n172 vco_feed_0.vdd_core.n168 0.276188
R1546 vco_feed_0.vdd_core.n62 vco_feed_0.vdd_core.n61 0.276188
R1547 vco_feed_0.vdd_core.n62 vco_feed_0.vdd_core.n59 0.276188
R1548 vco_feed_0.vdd_core.n70 vco_feed_0.vdd_core.n68 0.276188
R1549 vco_feed_0.vdd_core.n170 vco_feed_0.vdd_core.n169 0.276188
R1550 vco_feed_0.vdd_core.n170 vco_feed_0.vdd_core.n167 0.276188
R1551 vco_feed_0.vdd_core.n114 vco_feed_0.vdd_core.n113 0.2645
R1552 vco_feed_0.vdd_core.n111 vco_feed_0.vdd_core.n110 0.2645
R1553 vco_feed_0.vdd_core.n36 vco_feed_0.vdd_core.n35 0.2645
R1554 vco_feed_0.vdd_core.n19 vco_feed_0.vdd_core.n17 0.2645
R1555 vco_feed_0.vdd_core.n77 vco_feed_0.vdd_core.n76 0.2645
R1556 vco_feed_0.vdd_core.n75 vco_feed_0.vdd_core.n74 0.2645
R1557 vco_feed_0.vdd_core.n86 vco_feed_0.vdd_core.n84 0.199447
R1558 vco_feed_0.vdd_core.n108 vco_feed_0.vdd_core.n106 0.199447
R1559 vco_feed_0.vdd_core.n135 vco_feed_0.vdd_core.n133 0.199447
R1560 vco_feed_0.vdd_core.n85 vco_feed_0.vdd_core.n83 0.199447
R1561 vco_feed_0.vdd_core.n107 vco_feed_0.vdd_core.n98 0.199447
R1562 vco_feed_0.vdd_core.n134 vco_feed_0.vdd_core.n125 0.199447
R1563 vco_feed_0.vdd_core.n16 vco_feed_0.vdd_core.n14 0.199188
R1564 vco_feed_0.vdd_core.n15 vco_feed_0.vdd_core.n13 0.199188
R1565 vco_feed_0.vdd_core.n73 vco_feed_0.vdd_core.n71 0.199188
R1566 vco_feed_0.vdd_core.n72 vco_feed_0.vdd_core.n70 0.199188
R1567 vco_feed_0.vdd_core.n217 vco_feed_0.vdd_core.n216 0.175092
R1568 vco_feed_0.vdd_core.n122 vco_feed_0.vdd_core 0.17474
R1569 vco_feed_0.vdd_core.n210 vco_feed_0.vdd_core.n209 0.102521
R1570 vco_feed_0.vdd_core.n4 vco_feed_0.vdd_core.n166 0.1019
R1571 vco_feed_0.vdd_core.n164 vco_feed_0.vdd_core.n84 0.101071
R1572 vco_feed_0.vdd_core.n163 vco_feed_0.vdd_core.n86 0.101071
R1573 vco_feed_0.vdd_core.n158 vco_feed_0.vdd_core.n94 0.101071
R1574 vco_feed_0.vdd_core.n104 vco_feed_0.vdd_core.n102 0.101071
R1575 vco_feed_0.vdd_core.n153 vco_feed_0.vdd_core.n106 0.101071
R1576 vco_feed_0.vdd_core.n152 vco_feed_0.vdd_core.n108 0.101071
R1577 vco_feed_0.vdd_core.n149 vco_feed_0.vdd_core.n116 0.101071
R1578 vco_feed_0.vdd_core.n147 vco_feed_0.vdd_core.n120 0.101071
R1579 vco_feed_0.vdd_core.n131 vco_feed_0.vdd_core.n129 0.101071
R1580 vco_feed_0.vdd_core.n142 vco_feed_0.vdd_core.n133 0.101071
R1581 vco_feed_0.vdd_core.n141 vco_feed_0.vdd_core.n135 0.101071
R1582 vco_feed_0.vdd_core.n164 vco_feed_0.vdd_core.n83 0.101071
R1583 vco_feed_0.vdd_core.n163 vco_feed_0.vdd_core.n85 0.101071
R1584 vco_feed_0.vdd_core.n158 vco_feed_0.vdd_core.n93 0.101071
R1585 vco_feed_0.vdd_core.n102 vco_feed_0.vdd_core.n101 0.101071
R1586 vco_feed_0.vdd_core.n153 vco_feed_0.vdd_core.n98 0.101071
R1587 vco_feed_0.vdd_core.n152 vco_feed_0.vdd_core.n107 0.101071
R1588 vco_feed_0.vdd_core.n149 vco_feed_0.vdd_core.n115 0.101071
R1589 vco_feed_0.vdd_core.n147 vco_feed_0.vdd_core.n119 0.101071
R1590 vco_feed_0.vdd_core.n129 vco_feed_0.vdd_core.n128 0.101071
R1591 vco_feed_0.vdd_core.n142 vco_feed_0.vdd_core.n125 0.101071
R1592 vco_feed_0.vdd_core.n141 vco_feed_0.vdd_core.n134 0.101071
R1593 vco_feed_0.vdd_core.n29 vco_feed_0.vdd_core.n9 0.101071
R1594 vco_feed_0.vdd_core.n27 vco_feed_0.vdd_core.n12 0.101071
R1595 vco_feed_0.vdd_core.n202 vco_feed_0.vdd_core.n14 0.101071
R1596 vco_feed_0.vdd_core.n201 vco_feed_0.vdd_core.n16 0.101071
R1597 vco_feed_0.vdd_core.n199 vco_feed_0.vdd_core.n38 0.101071
R1598 vco_feed_0.vdd_core.n197 vco_feed_0.vdd_core.n42 0.101071
R1599 vco_feed_0.vdd_core.n51 vco_feed_0.vdd_core.n50 0.101071
R1600 vco_feed_0.vdd_core.n193 vco_feed_0.vdd_core.n192 0.101071
R1601 vco_feed_0.vdd_core.n23 vco_feed_0.vdd_core.n9 0.101071
R1602 vco_feed_0.vdd_core.n24 vco_feed_0.vdd_core.n12 0.101071
R1603 vco_feed_0.vdd_core.n202 vco_feed_0.vdd_core.n13 0.101071
R1604 vco_feed_0.vdd_core.n201 vco_feed_0.vdd_core.n15 0.101071
R1605 vco_feed_0.vdd_core.n199 vco_feed_0.vdd_core.n37 0.101071
R1606 vco_feed_0.vdd_core.n197 vco_feed_0.vdd_core.n41 0.101071
R1607 vco_feed_0.vdd_core.n51 vco_feed_0.vdd_core.n48 0.101071
R1608 vco_feed_0.vdd_core.n65 vco_feed_0.vdd_core.n64 0.101071
R1609 vco_feed_0.vdd_core.n184 vco_feed_0.vdd_core.n67 0.101071
R1610 vco_feed_0.vdd_core.n182 vco_feed_0.vdd_core.n71 0.101071
R1611 vco_feed_0.vdd_core.n181 vco_feed_0.vdd_core.n73 0.101071
R1612 vco_feed_0.vdd_core.n179 vco_feed_0.vdd_core.n79 0.101071
R1613 vco_feed_0.vdd_core.n173 vco_feed_0.vdd_core.n172 0.101071
R1614 vco_feed_0.vdd_core.n175 vco_feed_0.vdd_core.n174 0.101071
R1615 vco_feed_0.vdd_core.n65 vco_feed_0.vdd_core.n62 0.101071
R1616 vco_feed_0.vdd_core.n184 vco_feed_0.vdd_core.n66 0.101071
R1617 vco_feed_0.vdd_core.n182 vco_feed_0.vdd_core.n70 0.101071
R1618 vco_feed_0.vdd_core.n181 vco_feed_0.vdd_core.n72 0.101071
R1619 vco_feed_0.vdd_core.n179 vco_feed_0.vdd_core.n78 0.101071
R1620 vco_feed_0.vdd_core.n173 vco_feed_0.vdd_core.n170 0.101071
R1621 vco_feed_0.vdd_core.n175 vco_feed_0.vdd_core.n3 0.00761283
R1622 vco_feed_0.vdd_core.n216 vco_feed_0.vdd_core.n215 0.0955774
R1623 vco_feed_0.vdd_core.n7 vco_feed_0.vdd_core.n6 0.0929
R1624 vco_feed_0.vdd_core.n109 vco_feed_0.vdd_core.n82 0.0759286
R1625 vco_feed_0.vdd_core.n112 vco_feed_0.vdd_core.n82 0.0759286
R1626 vco_feed_0.vdd_core.n140 vco_feed_0.vdd_core.n137 0.0759286
R1627 vco_feed_0.vdd_core.n132 vco_feed_0.vdd_core.n124 0.0759286
R1628 vco_feed_0.vdd_core.n130 vco_feed_0.vdd_core.n121 0.0759286
R1629 vco_feed_0.vdd_core.n148 vco_feed_0.vdd_core.n118 0.0759286
R1630 vco_feed_0.vdd_core.n151 vco_feed_0.vdd_core.n114 0.0759286
R1631 vco_feed_0.vdd_core.n105 vco_feed_0.vdd_core.n97 0.0759286
R1632 vco_feed_0.vdd_core.n103 vco_feed_0.vdd_core.n95 0.0759286
R1633 vco_feed_0.vdd_core.n159 vco_feed_0.vdd_core.n92 0.0759286
R1634 vco_feed_0.vdd_core.n160 vco_feed_0.vdd_core.n90 0.0759286
R1635 vco_feed_0.vdd_core.n162 vco_feed_0.vdd_core.n88 0.0759286
R1636 vco_feed_0.vdd_core.n140 vco_feed_0.vdd_core.n136 0.0759286
R1637 vco_feed_0.vdd_core.n126 vco_feed_0.vdd_core.n124 0.0759286
R1638 vco_feed_0.vdd_core.n127 vco_feed_0.vdd_core.n121 0.0759286
R1639 vco_feed_0.vdd_core.n148 vco_feed_0.vdd_core.n117 0.0759286
R1640 vco_feed_0.vdd_core.n151 vco_feed_0.vdd_core.n111 0.0759286
R1641 vco_feed_0.vdd_core.n99 vco_feed_0.vdd_core.n97 0.0759286
R1642 vco_feed_0.vdd_core.n100 vco_feed_0.vdd_core.n95 0.0759286
R1643 vco_feed_0.vdd_core.n162 vco_feed_0.vdd_core.n87 0.0759286
R1644 vco_feed_0.vdd_core.n160 vco_feed_0.vdd_core.n89 0.0759286
R1645 vco_feed_0.vdd_core.n159 vco_feed_0.vdd_core.n91 0.0759286
R1646 vco_feed_0.vdd_core.n33 vco_feed_0.vdd_core.n20 0.0759286
R1647 vco_feed_0.vdd_core.n34 vco_feed_0.vdd_core.n33 0.0759286
R1648 vco_feed_0.vdd_core.n194 vco_feed_0.vdd_core.n46 0.0759286
R1649 vco_feed_0.vdd_core.n49 vco_feed_0.vdd_core.n43 0.0759286
R1650 vco_feed_0.vdd_core.n198 vco_feed_0.vdd_core.n40 0.0759286
R1651 vco_feed_0.vdd_core.n200 vco_feed_0.vdd_core.n36 0.0759286
R1652 vco_feed_0.vdd_core.n203 vco_feed_0.vdd_core.n11 0.0759286
R1653 vco_feed_0.vdd_core.n28 vco_feed_0.vdd_core.n26 0.0759286
R1654 vco_feed_0.vdd_core.n31 vco_feed_0.vdd_core.n30 0.0759286
R1655 vco_feed_0.vdd_core.n32 vco_feed_0.vdd_core.n18 0.0759286
R1656 vco_feed_0.vdd_core.n194 vco_feed_0.vdd_core.n45 0.0759286
R1657 vco_feed_0.vdd_core.n47 vco_feed_0.vdd_core.n43 0.0759286
R1658 vco_feed_0.vdd_core.n198 vco_feed_0.vdd_core.n39 0.0759286
R1659 vco_feed_0.vdd_core.n200 vco_feed_0.vdd_core.n17 0.0759286
R1660 vco_feed_0.vdd_core.n203 vco_feed_0.vdd_core.n10 0.0759286
R1661 vco_feed_0.vdd_core.n26 vco_feed_0.vdd_core.n25 0.0759286
R1662 vco_feed_0.vdd_core.n32 vco_feed_0.vdd_core.n21 0.0759286
R1663 vco_feed_0.vdd_core.n31 vco_feed_0.vdd_core.n22 0.0759286
R1664 vco_feed_0.vdd_core.n189 vco_feed_0.vdd_core.n54 0.0759286
R1665 vco_feed_0.vdd_core.n189 vco_feed_0.vdd_core.n53 0.0759286
R1666 vco_feed_0.vdd_core.n176 vco_feed_0.vdd_core.n168 0.0759286
R1667 vco_feed_0.vdd_core.n171 vco_feed_0.vdd_core.n80 0.0759286
R1668 vco_feed_0.vdd_core.n180 vco_feed_0.vdd_core.n77 0.0759286
R1669 vco_feed_0.vdd_core.n183 vco_feed_0.vdd_core.n69 0.0759286
R1670 vco_feed_0.vdd_core.n185 vco_feed_0.vdd_core.n60 0.0759286
R1671 vco_feed_0.vdd_core.n63 vco_feed_0.vdd_core.n57 0.0759286
R1672 vco_feed_0.vdd_core.n188 vco_feed_0.vdd_core.n56 0.0759286
R1673 vco_feed_0.vdd_core.n3 vco_feed_0.vdd_core.n167 0.439821
R1674 vco_feed_0.vdd_core.n176 vco_feed_0.vdd_core.n167 0.0759286
R1675 vco_feed_0.vdd_core.n169 vco_feed_0.vdd_core.n80 0.0759286
R1676 vco_feed_0.vdd_core.n180 vco_feed_0.vdd_core.n75 0.0759286
R1677 vco_feed_0.vdd_core.n183 vco_feed_0.vdd_core.n68 0.0759286
R1678 vco_feed_0.vdd_core.n185 vco_feed_0.vdd_core.n59 0.0759286
R1679 vco_feed_0.vdd_core.n188 vco_feed_0.vdd_core.n55 0.0759286
R1680 vco_feed_0.vdd_core.n61 vco_feed_0.vdd_core.n57 0.0759286
R1681 vco_feed_0.vdd_core.n190 vco_feed_0.vdd_core.n189 0.0738333
R1682 vco_feed_0.vdd_core.n1 vco_feed_0.vdd_core.n7 1.45898
R1683 vco_feed_0.vdd_core.n123 vco_feed_0.vdd_core 0.038
R1684 vco_feed_0.vdd_core.n209 vco_feed_0.vdd_core.n205 0.0378886
R1685 vco_feed_0.vdd_core.n216 vco_feed_0.vdd_core.n5 0.0378886
R1686 vco_feed_0.vdd_core.n141 vco_feed_0.vdd_core.n140 0.0371667
R1687 vco_feed_0.vdd_core.n142 vco_feed_0.vdd_core.n141 0.0371667
R1688 vco_feed_0.vdd_core.n129 vco_feed_0.vdd_core.n124 0.0371667
R1689 vco_feed_0.vdd_core.n129 vco_feed_0.vdd_core.n121 0.0371667
R1690 vco_feed_0.vdd_core.n148 vco_feed_0.vdd_core.n147 0.0371667
R1691 vco_feed_0.vdd_core.n149 vco_feed_0.vdd_core.n148 0.0371667
R1692 vco_feed_0.vdd_core.n152 vco_feed_0.vdd_core.n151 0.0371667
R1693 vco_feed_0.vdd_core.n153 vco_feed_0.vdd_core.n152 0.0371667
R1694 vco_feed_0.vdd_core.n102 vco_feed_0.vdd_core.n97 0.0371667
R1695 vco_feed_0.vdd_core.n102 vco_feed_0.vdd_core.n95 0.0371667
R1696 vco_feed_0.vdd_core.n159 vco_feed_0.vdd_core.n158 0.0371667
R1697 vco_feed_0.vdd_core.n160 vco_feed_0.vdd_core.n159 0.0371667
R1698 vco_feed_0.vdd_core.n163 vco_feed_0.vdd_core.n162 0.0371667
R1699 vco_feed_0.vdd_core.n164 vco_feed_0.vdd_core.n163 0.0371667
R1700 vco_feed_0.vdd_core.n3 vco_feed_0.vdd_core.n2 0.0351511
R1701 vco_feed_0.vdd_core.n176 vco_feed_0.vdd_core.n175 0.0371667
R1702 vco_feed_0.vdd_core.n176 vco_feed_0.vdd_core.n173 0.0371667
R1703 vco_feed_0.vdd_core.n173 vco_feed_0.vdd_core.n80 0.0371667
R1704 vco_feed_0.vdd_core.n179 vco_feed_0.vdd_core.n80 0.0371667
R1705 vco_feed_0.vdd_core.n180 vco_feed_0.vdd_core.n179 0.0371667
R1706 vco_feed_0.vdd_core.n181 vco_feed_0.vdd_core.n180 0.0371667
R1707 vco_feed_0.vdd_core.n182 vco_feed_0.vdd_core.n181 0.0371667
R1708 vco_feed_0.vdd_core.n183 vco_feed_0.vdd_core.n182 0.0371667
R1709 vco_feed_0.vdd_core.n184 vco_feed_0.vdd_core.n183 0.0371667
R1710 vco_feed_0.vdd_core.n185 vco_feed_0.vdd_core.n184 0.0371667
R1711 vco_feed_0.vdd_core.n185 vco_feed_0.vdd_core.n65 0.0371667
R1712 vco_feed_0.vdd_core.n65 vco_feed_0.vdd_core.n57 0.0371667
R1713 vco_feed_0.vdd_core.n188 vco_feed_0.vdd_core.n57 0.0371667
R1714 vco_feed_0.vdd_core.n189 vco_feed_0.vdd_core.n188 0.0371667
R1715 vco_feed_0.vdd_core.n191 vco_feed_0.vdd_core.n190 0.0371667
R1716 vco_feed_0.vdd_core.n194 vco_feed_0.vdd_core.n193 0.0371667
R1717 vco_feed_0.vdd_core.n194 vco_feed_0.vdd_core.n51 0.0371667
R1718 vco_feed_0.vdd_core.n51 vco_feed_0.vdd_core.n43 0.0371667
R1719 vco_feed_0.vdd_core.n197 vco_feed_0.vdd_core.n43 0.0371667
R1720 vco_feed_0.vdd_core.n198 vco_feed_0.vdd_core.n197 0.0371667
R1721 vco_feed_0.vdd_core.n199 vco_feed_0.vdd_core.n198 0.0371667
R1722 vco_feed_0.vdd_core.n200 vco_feed_0.vdd_core.n199 0.0371667
R1723 vco_feed_0.vdd_core.n201 vco_feed_0.vdd_core.n200 0.0371667
R1724 vco_feed_0.vdd_core.n202 vco_feed_0.vdd_core.n201 0.0371667
R1725 vco_feed_0.vdd_core.n203 vco_feed_0.vdd_core.n202 0.0371667
R1726 vco_feed_0.vdd_core.n203 vco_feed_0.vdd_core.n12 0.0371667
R1727 vco_feed_0.vdd_core.n26 vco_feed_0.vdd_core.n12 0.0371667
R1728 vco_feed_0.vdd_core.n26 vco_feed_0.vdd_core.n9 0.0371667
R1729 vco_feed_0.vdd_core.n31 vco_feed_0.vdd_core.n9 0.0371667
R1730 vco_feed_0.vdd_core.n32 vco_feed_0.vdd_core.n31 0.0371667
R1731 vco_feed_0.vdd_core.n33 vco_feed_0.vdd_core.n32 0.0371667
R1732 vco_feed_0.vdd_core.n140 vco_feed_0.vdd_core.n139 0.028
R1733 vco_feed_0.vdd_core.n143 vco_feed_0.vdd_core.n124 0.028
R1734 vco_feed_0.vdd_core.n147 vco_feed_0.vdd_core.n146 0.028
R1735 vco_feed_0.vdd_core.n151 vco_feed_0.vdd_core.n150 0.028
R1736 vco_feed_0.vdd_core.n154 vco_feed_0.vdd_core.n97 0.028
R1737 vco_feed_0.vdd_core.n158 vco_feed_0.vdd_core.n157 0.028
R1738 vco_feed_0.vdd_core.n162 vco_feed_0.vdd_core.n161 0.028
R1739 vco_feed_0.vdd_core.n165 vco_feed_0.vdd_core.n82 0.028
R1740 vco_feed_0.vdd_core.n191 vco_feed_0.vdd_core.n52 0.0261384
R1741 vco_feed_0.vdd_core.n177 vco_feed_0.vdd_core.n4 0.023
R1742 vco_feed_0.vdd_core.n178 vco_feed_0.vdd_core.n177 0.023
R1743 vco_feed_0.vdd_core.n178 vco_feed_0.vdd_core.n58 0.023
R1744 vco_feed_0.vdd_core.n186 vco_feed_0.vdd_core.n58 0.023
R1745 vco_feed_0.vdd_core.n187 vco_feed_0.vdd_core.n186 0.023
R1746 vco_feed_0.vdd_core.n187 vco_feed_0.vdd_core.n44 0.023
R1747 vco_feed_0.vdd_core.n195 vco_feed_0.vdd_core.n44 0.023
R1748 vco_feed_0.vdd_core.n196 vco_feed_0.vdd_core.n195 0.023
R1749 vco_feed_0.vdd_core.n196 vco_feed_0.vdd_core.n8 0.023
R1750 vco_feed_0.vdd_core.n144 vco_feed_0.vdd_core.n123 0.023
R1751 vco_feed_0.vdd_core.n145 vco_feed_0.vdd_core.n144 0.023
R1752 vco_feed_0.vdd_core.n145 vco_feed_0.vdd_core.n96 0.023
R1753 vco_feed_0.vdd_core.n155 vco_feed_0.vdd_core.n96 0.023
R1754 vco_feed_0.vdd_core.n156 vco_feed_0.vdd_core.n155 0.023
R1755 vco_feed_0.vdd_core.n156 vco_feed_0.vdd_core.n81 0.023
R1756 vco_feed_0.vdd_core.n166 vco_feed_0.vdd_core.n81 0.023
R1757 vco_feed_0.vdd_core.n122 vco_feed_0.vdd_core 0.0227222
R1758 vco_feed_0.vdd_core.n212 vco_feed_0.vdd_core.n6 0.0201
R1759 vco_feed_0.vdd_core vco_feed_0.vdd_core.n219 0.0181
R1760 vco_feed_0.vdd_core.n206 vco_feed_0.vdd_core 0.0181
R1761 vco_feed_0.vdd_core.n212 vco_feed_0.vdd_core.n1 0.221956
R1762 vco_feed_0.vdd_core.n113 vco_feed_0.vdd_core.n108 0.0124467
R1763 vco_feed_0.vdd_core.n110 vco_feed_0.vdd_core.n107 0.0124467
R1764 vco_feed_0.vdd_core.n35 vco_feed_0.vdd_core.n16 0.0121878
R1765 vco_feed_0.vdd_core.n19 vco_feed_0.vdd_core.n15 0.0121878
R1766 vco_feed_0.vdd_core.n76 vco_feed_0.vdd_core.n73 0.0121878
R1767 vco_feed_0.vdd_core.n74 vco_feed_0.vdd_core.n72 0.0121878
R1768 vco_feed_0.vdd_core.n204 vco_feed_0.vdd_core.n8 0.01175
R1769 vco_feed_0.vdd_core.n139 vco_feed_0.vdd_core.n138 0.0113759
R1770 vco_feed_0.vdd_core.n213 vco_feed_0.vdd_core.n0 0.01106
R1771 vco_feed_0.vdd_core.n143 vco_feed_0.vdd_core.n142 0.00966667
R1772 vco_feed_0.vdd_core.n146 vco_feed_0.vdd_core.n121 0.00966667
R1773 vco_feed_0.vdd_core.n150 vco_feed_0.vdd_core.n149 0.00966667
R1774 vco_feed_0.vdd_core.n154 vco_feed_0.vdd_core.n153 0.00966667
R1775 vco_feed_0.vdd_core.n157 vco_feed_0.vdd_core.n95 0.00966667
R1776 vco_feed_0.vdd_core.n161 vco_feed_0.vdd_core.n160 0.00966667
R1777 vco_feed_0.vdd_core.n165 vco_feed_0.vdd_core.n164 0.00966667
R1778 vco_feed_0.vdd_core.n193 vco_feed_0.vdd_core.n52 0.00944821
R1779 vco_feed_0.vdd_core.n211 vco_feed_0.vdd_core 2.34256
R1780 vco_feed_0.vdd_core.n4 vco_feed_0.vdd_core.n2 0.578991
R1781 vco_bias_0.vbn_buf.n3 vco_bias_0.vbn_buf.t0 45.1624
R1782 vco_bias_0.vbn_buf.n2 vco_bias_0.vbn_buf.t4 34.2391
R1783 vco_bias_0.vbn_buf.n2 vco_bias_0.vbn_buf.t3 28.5544
R1784 vco_bias_0.vbn_buf.n1 vco_bias_0.vbn_buf.n0 22.8503
R1785 vco_bias_0.vbn_buf.n0 vco_bias_0.vbn_buf.t2 21.7736
R1786 vco_bias_0.vbn_buf.n4 vco_bias_0.vbn_buf.t1 17.3253
R1787 vco_bias_0.vbn_buf.n4 vco_bias_0.vbn_buf.n3 13.5293
R1788 vco_bias_0.vbn_buf.n3 vco_bias_0.vbn_buf.n2 6.81757
R1789 vco_bias_0.vbn_buf vco_bias_0.vbn_buf.n4 2.55837
R1790 vco_bias_0.vbn_buf vco_bias_0.vbn_buf.n1 0.2645
R1791 vco_bias_0.vbn_buf.n1 vco_bias_0.vbn_buf 0.208921
R1792 vco_bias_0.vbn_buf.n0 vco_bias_0.vbn_buf 0.1105
C0 VDD vco_feed_0.en_b 5.95879f
C1 vco_feed_0.en_b di_en 0.62558f
C2 vco_bias_0.vbg_buf a_5560_4708# 0.03933f
C3 VDD vco_feed_0.vdd_core 0.21537f
C4 VDD vco_bias_0.vbg_buf 3.98332f
C5 vco_bias_0.vbg_buf di_en 4.16619f
C6 VDD vco_bias_0.vbn_buf 1.75123f
C7 di_en vco_bias_0.vbn_buf 0.1413f
C8 vtune a_9400_4880# 0.23905f
C9 a_9400_4880# a_9400_4966# 0.04847f
C10 VDD a_10100_4160# 0.39117f
C11 vtune rf_out_p 0.03446f
C12 a_9400_4880# a_14668_3324# 0.12351f
C13 vtune rf_out_n 0.03446f
C14 a_5560_4708# a_5060_3788# 0.09924f
C15 a_14668_3324# rf_out_p 0.9832f
C16 a_16500_4160# a_14668_3324# 0.05715f
C17 vtune vco_feed_0.en_b 0.03157f
C18 vtune vco_feed_0.vdd_core 13.5168f
C19 vtune vco_bias_0.vbg_buf 0.07434f
C20 vtune vco_bias_0.vbn_buf 0.06626f
C21 a_9400_4966# vco_feed_0.vdd_core 0.0801f
C22 vco_bias_0.vbg_buf a_9400_4966# 0.03293f
C23 a_9400_4966# vco_bias_0.vbn_buf 0.01696f
C24 a_14668_3324# vco_feed_0.vdd_core 0.15264p
C25 vco_bias_0.vbg_buf a_14668_3324# 0.04293f
C26 VDD a_5560_4708# 0.03954f
C27 a_23460_164# vco_feed_0.vdd_core 1.12292f
C28 a_9400_4880# rf_out_n 0.9832f
C29 a_14668_3324# vco_bias_0.vbn_buf 0.05269f
C30 VDD di_en 0.60931f
C31 rf_out_n rf_out_p 0.02191f
C32 a_16500_4160# rf_out_p 0.69021f
C33 vco_bias_0.vbg_buf a_1160_2070# 0.04813f
C34 a_1160_2070# vco_bias_0.vbn_buf 0.02902f
C35 a_9400_4880# vco_feed_0.vdd_core 0.15264p
C36 vco_bias_0.vbg_buf a_9400_4880# 0.08032f
C37 a_9400_4880# vco_bias_0.vbn_buf 0.06582f
C38 vco_feed_0.en_b rf_out_p 0.07982f
C39 vco_feed_0.en_b rf_out_n 0.08032f
C40 a_9400_4880# a_10100_4160# 0.05715f
C41 a_19100_4966# a_14668_3324# 0.04847f
C42 rf_out_p vco_bias_0.vbn_buf 0.21953f
C43 rf_out_n vco_bias_0.vbn_buf 0.33134f
C44 a_1160_2070# a_1560_1770# 0.60592f
C45 vtune VDD 0.15487f
C46 VDD a_9400_4966# 0.01049f
C47 a_10100_4160# rf_out_n 0.69021f
C48 vco_feed_0.en_b vco_feed_0.vdd_core 0.01497f
C49 vco_bias_0.vbg_buf vco_feed_0.en_b 0.27386f
C50 VDD a_14668_3324# 1.57065f
C51 VDD a_23460_164# 0.04551f
C52 vco_bias_0.vbg_buf vco_feed_0.vdd_core 3.59919f
C53 vco_feed_0.en_b vco_bias_0.vbn_buf 1.18956f
C54 vco_bias_0.vbn_buf vco_feed_0.vdd_core 0.43987f
C55 vco_bias_0.vbg_buf vco_bias_0.vbn_buf 10.3424f
C56 VDD a_9400_4880# 1.57517f
C57 vco_bias_0.vbg_buf a_1560_1770# 0.03483f
C58 vco_bias_0.vbg_buf a_5060_3788# 0.27763f
C59 VDD rf_out_p 3.02587f
C60 VDD rf_out_n 3.00523f
C61 VDD a_16500_4160# 0.39117f
C62 a_19100_4966# vco_feed_0.vdd_core 0.08348f
C63 vco_bias_0.vbg_buf a_19100_4966# 0.03283f
C64 vtune a_14668_3324# 0.22943f
C65 vco_feed_0.en_b a_5560_4708# 0.05029f
C66 rf_out_p VSS 4.69306f
C67 rf_out_n VSS 4.55662f
C68 di_en VSS 3.9148f
C69 VDD VSS 31.0122f
C70 vtune VSS 3.99636f
C71 vco_feed_0.en_b VSS 14.64158f
C72 vco_feed_0.vdd_core VSS 3.85531p
C73 vco_bias_0.vbn_buf VSS 0.12752p
C74 vco_bias_0.vbn_buf.n0 VSS 0.16826f
C75 vco_bias_0.vbn_buf.n1 VSS 0.0949f
C76 vco_bias_0.vbn_buf.n2 VSS 0.17943f
C77 vco_bias_0.vbn_buf.t0 VSS 2.24078f
C78 vco_bias_0.vbn_buf.n3 VSS 0.2581f
C79 vco_bias_0.vbn_buf.t1 VSS 0.10582f
C80 vco_bias_0.vbn_buf.n4 VSS 0.1752f
C81 vco_feed_0.vdd_core.n0 VSS 9.75792f
C82 vco_feed_0.vdd_core.n1 VSS 0.35237f
C83 vco_feed_0.vdd_core.n2 VSS 1.99386f
C84 vco_feed_0.vdd_core.n3 VSS 0.40726f
C85 vco_feed_0.vdd_core.n4 VSS 1.05465f
C86 vco_feed_0.vdd_core.t12 VSS 0.05204f
C87 vco_feed_0.vdd_core.t14 VSS 0.0515f
C88 vco_feed_0.vdd_core.n5 VSS 0.18055f
C89 vco_feed_0.vdd_core.n6 VSS 2.96971f
C90 vco_feed_0.vdd_core.n7 VSS 0.12192f
C91 vco_feed_0.vdd_core.n8 VSS 0.2524f
C92 vco_feed_0.vdd_core.n9 VSS 0.12828f
C93 vco_feed_0.vdd_core.n10 VSS 0.22614f
C94 vco_feed_0.vdd_core.n11 VSS 0.22614f
C95 vco_feed_0.vdd_core.n12 VSS 0.11872f
C96 vco_feed_0.vdd_core.n13 VSS 0.35497f
C97 vco_feed_0.vdd_core.n14 VSS 0.35497f
C98 vco_feed_0.vdd_core.n15 VSS 0.16556f
C99 vco_feed_0.vdd_core.n16 VSS 0.16556f
C100 vco_feed_0.vdd_core.n17 VSS 0.21338f
C101 vco_feed_0.vdd_core.n18 VSS 0.31442f
C102 vco_feed_0.vdd_core.n19 VSS 12.6107f
C103 vco_feed_0.vdd_core.n20 VSS 5.46379f
C104 vco_feed_0.vdd_core.n21 VSS 0.31442f
C105 vco_feed_0.vdd_core.n22 VSS 0.24971f
C106 vco_feed_0.vdd_core.n23 VSS 0.38549f
C107 vco_feed_0.vdd_core.n24 VSS 0.35353f
C108 vco_feed_0.vdd_core.n25 VSS 0.22896f
C109 vco_feed_0.vdd_core.n26 VSS 0.11708f
C110 vco_feed_0.vdd_core.n27 VSS 0.35353f
C111 vco_feed_0.vdd_core.n28 VSS 0.22896f
C112 vco_feed_0.vdd_core.n29 VSS 0.38549f
C113 vco_feed_0.vdd_core.n30 VSS 0.24971f
C114 vco_feed_0.vdd_core.n31 VSS 0.11708f
C115 vco_feed_0.vdd_core.n32 VSS 0.11708f
C116 vco_feed_0.vdd_core.n33 VSS 0.11708f
C117 vco_feed_0.vdd_core.n34 VSS 5.50915f
C118 vco_feed_0.vdd_core.n35 VSS 12.5653f
C119 vco_feed_0.vdd_core.n36 VSS 0.21338f
C120 vco_feed_0.vdd_core.n37 VSS 0.35353f
C121 vco_feed_0.vdd_core.n38 VSS 0.35353f
C122 vco_feed_0.vdd_core.n39 VSS 0.23366f
C123 vco_feed_0.vdd_core.n40 VSS 0.23366f
C124 vco_feed_0.vdd_core.n41 VSS 0.38549f
C125 vco_feed_0.vdd_core.n42 VSS 0.38549f
C126 vco_feed_0.vdd_core.n43 VSS 0.11708f
C127 vco_feed_0.vdd_core.n44 VSS 0.33653f
C128 vco_feed_0.vdd_core.n45 VSS 0.31968f
C129 vco_feed_0.vdd_core.n46 VSS 0.22426f
C130 vco_feed_0.vdd_core.n47 VSS 0.23084f
C131 vco_feed_0.vdd_core.n48 VSS 0.35353f
C132 vco_feed_0.vdd_core.n49 VSS 0.23084f
C133 vco_feed_0.vdd_core.n50 VSS 0.35353f
C134 vco_feed_0.vdd_core.n51 VSS 0.11872f
C135 vco_feed_0.vdd_core.n52 VSS 0.37877f
C136 vco_feed_0.vdd_core.n53 VSS 5.50915f
C137 vco_feed_0.vdd_core.n54 VSS 5.46379f
C138 vco_feed_0.vdd_core.n55 VSS 0.31442f
C139 vco_feed_0.vdd_core.n56 VSS 0.31442f
C140 vco_feed_0.vdd_core.n57 VSS 0.11708f
C141 vco_feed_0.vdd_core.n58 VSS 0.33653f
C142 vco_feed_0.vdd_core.n59 VSS 0.22896f
C143 vco_feed_0.vdd_core.n60 VSS 0.22896f
C144 vco_feed_0.vdd_core.n61 VSS 0.24971f
C145 vco_feed_0.vdd_core.n62 VSS 0.38549f
C146 vco_feed_0.vdd_core.n63 VSS 0.24971f
C147 vco_feed_0.vdd_core.n64 VSS 0.38549f
C148 vco_feed_0.vdd_core.n65 VSS 0.11872f
C149 vco_feed_0.vdd_core.n66 VSS 0.35353f
C150 vco_feed_0.vdd_core.n67 VSS 0.35353f
C151 vco_feed_0.vdd_core.n68 VSS 0.22614f
C152 vco_feed_0.vdd_core.n69 VSS 0.22614f
C153 vco_feed_0.vdd_core.n70 VSS 0.35497f
C154 vco_feed_0.vdd_core.n71 VSS 0.35497f
C155 vco_feed_0.vdd_core.n72 VSS 0.16556f
C156 vco_feed_0.vdd_core.n73 VSS 0.16556f
C157 vco_feed_0.vdd_core.n74 VSS 12.6107f
C158 vco_feed_0.vdd_core.n75 VSS 0.21338f
C159 vco_feed_0.vdd_core.n76 VSS 12.5653f
C160 vco_feed_0.vdd_core.n77 VSS 0.21338f
C161 vco_feed_0.vdd_core.n78 VSS 0.35353f
C162 vco_feed_0.vdd_core.n79 VSS 0.35353f
C163 vco_feed_0.vdd_core.n80 VSS 0.11708f
C164 vco_feed_0.vdd_core.n81 VSS 0.33653f
C165 vco_feed_0.vdd_core.n82 VSS 0.13111f
C166 vco_feed_0.vdd_core.n83 VSS 0.26265f
C167 vco_feed_0.vdd_core.n84 VSS 0.26265f
C168 vco_feed_0.vdd_core.n85 VSS 0.23154f
C169 vco_feed_0.vdd_core.n86 VSS 0.253f
C170 vco_feed_0.vdd_core.n87 VSS 0.20201f
C171 vco_feed_0.vdd_core.n88 VSS 0.18055f
C172 vco_feed_0.vdd_core.n89 VSS 0.23099f
C173 vco_feed_0.vdd_core.n90 VSS 0.23099f
C174 vco_feed_0.vdd_core.n91 VSS 0.18381f
C175 vco_feed_0.vdd_core.n92 VSS 0.18381f
C176 vco_feed_0.vdd_core.n93 VSS 0.28289f
C177 vco_feed_0.vdd_core.n94 VSS 0.28289f
C178 vco_feed_0.vdd_core.n95 VSS 0.07502f
C179 vco_feed_0.vdd_core.n96 VSS 0.33653f
C180 vco_feed_0.vdd_core.n97 VSS 0.10306f
C181 vco_feed_0.vdd_core.n98 VSS 0.26051f
C182 vco_feed_0.vdd_core.n99 VSS 0.16646f
C183 vco_feed_0.vdd_core.n100 VSS 0.16852f
C184 vco_feed_0.vdd_core.n101 VSS 0.25954f
C185 vco_feed_0.vdd_core.n102 VSS 0.11872f
C186 vco_feed_0.vdd_core.n103 VSS 0.16852f
C187 vco_feed_0.vdd_core.n104 VSS 0.25954f
C188 vco_feed_0.vdd_core.n105 VSS 0.16646f
C189 vco_feed_0.vdd_core.n106 VSS 0.26051f
C190 vco_feed_0.vdd_core.n107 VSS 0.1233f
C191 vco_feed_0.vdd_core.n108 VSS 0.1233f
C192 vco_feed_0.vdd_core.n109 VSS 5.68255f
C193 vco_feed_0.vdd_core.n110 VSS 11.8843f
C194 vco_feed_0.vdd_core.n111 VSS 0.15706f
C195 vco_feed_0.vdd_core.n112 VSS 5.72614f
C196 vco_feed_0.vdd_core.n113 VSS 11.8407f
C197 vco_feed_0.vdd_core.n114 VSS 0.15706f
C198 vco_feed_0.vdd_core.n115 VSS 0.25954f
C199 vco_feed_0.vdd_core.n116 VSS 0.25954f
C200 vco_feed_0.vdd_core.n117 VSS 0.17196f
C201 vco_feed_0.vdd_core.n118 VSS 0.17196f
C202 vco_feed_0.vdd_core.n119 VSS 0.28289f
C203 vco_feed_0.vdd_core.n120 VSS 0.28289f
C204 vco_feed_0.vdd_core.n121 VSS 0.07502f
C205 vco_feed_0.vdd_core.t22 VSS 7.84017f
C206 vco_feed_0.vdd_core.n122 VSS 4.47496f
C207 vco_feed_0.vdd_core.n123 VSS 0.44871f
C208 vco_feed_0.vdd_core.n124 VSS 0.10306f
C209 vco_feed_0.vdd_core.n125 VSS 0.25836f
C210 vco_feed_0.vdd_core.n126 VSS 0.16509f
C211 vco_feed_0.vdd_core.n127 VSS 0.1699f
C212 vco_feed_0.vdd_core.n128 VSS 0.25954f
C213 vco_feed_0.vdd_core.n129 VSS 0.11872f
C214 vco_feed_0.vdd_core.n130 VSS 0.1699f
C215 vco_feed_0.vdd_core.n131 VSS 0.25954f
C216 vco_feed_0.vdd_core.n132 VSS 0.16509f
C217 vco_feed_0.vdd_core.n133 VSS 0.25836f
C218 vco_feed_0.vdd_core.n134 VSS 0.25729f
C219 vco_feed_0.vdd_core.n135 VSS 0.25729f
C220 vco_feed_0.vdd_core.n136 VSS 0.22959f
C221 vco_feed_0.vdd_core.n137 VSS 0.23121f
C222 vco_feed_0.vdd_core.n138 VSS 1.21631f
C223 vco_feed_0.vdd_core.n139 VSS 0.06814f
C224 vco_feed_0.vdd_core.n140 VSS 0.10306f
C225 vco_feed_0.vdd_core.n141 VSS 0.11872f
C226 vco_feed_0.vdd_core.n142 VSS 0.07665f
C227 vco_feed_0.vdd_core.n143 VSS 0.05609f
C228 vco_feed_0.vdd_core.n144 VSS 0.33653f
C229 vco_feed_0.vdd_core.n145 VSS 0.33653f
C230 vco_feed_0.vdd_core.n146 VSS 0.05609f
C231 vco_feed_0.vdd_core.n147 VSS 0.1047f
C232 vco_feed_0.vdd_core.n148 VSS 0.11708f
C233 vco_feed_0.vdd_core.n149 VSS 0.07665f
C234 vco_feed_0.vdd_core.n150 VSS 0.05609f
C235 vco_feed_0.vdd_core.n151 VSS 0.10306f
C236 vco_feed_0.vdd_core.n152 VSS 0.11872f
C237 vco_feed_0.vdd_core.n153 VSS 0.07665f
C238 vco_feed_0.vdd_core.n154 VSS 0.05609f
C239 vco_feed_0.vdd_core.n155 VSS 0.33653f
C240 vco_feed_0.vdd_core.n156 VSS 0.33653f
C241 vco_feed_0.vdd_core.n157 VSS 0.05609f
C242 vco_feed_0.vdd_core.n158 VSS 0.1047f
C243 vco_feed_0.vdd_core.n159 VSS 0.11708f
C244 vco_feed_0.vdd_core.n160 VSS 0.07502f
C245 vco_feed_0.vdd_core.n161 VSS 0.05609f
C246 vco_feed_0.vdd_core.n162 VSS 0.10306f
C247 vco_feed_0.vdd_core.n163 VSS 0.11872f
C248 vco_feed_0.vdd_core.n164 VSS 0.07665f
C249 vco_feed_0.vdd_core.n165 VSS 0.05609f
C250 vco_feed_0.vdd_core.n166 VSS 0.96074f
C251 vco_feed_0.vdd_core.n167 VSS 0.30029f
C252 vco_feed_0.vdd_core.n168 VSS 0.23084f
C253 vco_feed_0.vdd_core.n169 VSS 0.23366f
C254 vco_feed_0.vdd_core.n170 VSS 0.38549f
C255 vco_feed_0.vdd_core.n171 VSS 0.23366f
C256 vco_feed_0.vdd_core.n172 VSS 0.38549f
C257 vco_feed_0.vdd_core.n173 VSS 0.11872f
C258 vco_feed_0.vdd_core.n174 VSS 0.39968f
C259 vco_feed_0.vdd_core.n175 VSS 0.11872f
C260 vco_feed_0.vdd_core.n176 VSS 0.11708f
C261 vco_feed_0.vdd_core.n177 VSS 0.33653f
C262 vco_feed_0.vdd_core.n178 VSS 0.33653f
C263 vco_feed_0.vdd_core.n179 VSS 0.11872f
C264 vco_feed_0.vdd_core.n180 VSS 0.11708f
C265 vco_feed_0.vdd_core.n181 VSS 0.11872f
C266 vco_feed_0.vdd_core.n182 VSS 0.11872f
C267 vco_feed_0.vdd_core.n183 VSS 0.11708f
C268 vco_feed_0.vdd_core.n184 VSS 0.11872f
C269 vco_feed_0.vdd_core.n185 VSS 0.11708f
C270 vco_feed_0.vdd_core.n186 VSS 0.33653f
C271 vco_feed_0.vdd_core.n187 VSS 0.33653f
C272 vco_feed_0.vdd_core.n188 VSS 0.11708f
C273 vco_feed_0.vdd_core.n189 VSS 0.17317f
C274 vco_feed_0.vdd_core.n190 VSS 0.16826f
C275 vco_feed_0.vdd_core.n191 VSS 0.60148f
C276 vco_feed_0.vdd_core.n192 VSS 0.47419f
C277 vco_feed_0.vdd_core.n193 VSS 0.11872f
C278 vco_feed_0.vdd_core.n194 VSS 0.11708f
C279 vco_feed_0.vdd_core.n195 VSS 0.33653f
C280 vco_feed_0.vdd_core.n196 VSS 0.33653f
C281 vco_feed_0.vdd_core.n197 VSS 0.11872f
C282 vco_feed_0.vdd_core.n198 VSS 0.11708f
C283 vco_feed_0.vdd_core.n199 VSS 0.11872f
C284 vco_feed_0.vdd_core.n200 VSS 0.11708f
C285 vco_feed_0.vdd_core.n201 VSS 0.11872f
C286 vco_feed_0.vdd_core.n202 VSS 0.11872f
C287 vco_feed_0.vdd_core.n203 VSS 0.11708f
C288 vco_feed_0.vdd_core.n204 VSS 4.24281f
C289 vco_feed_0.vdd_core.t9 VSS 0.05204f
C290 vco_feed_0.vdd_core.t7 VSS 0.60103f
C291 vco_feed_0.vdd_core.n205 VSS 0.18055f
C292 vco_feed_0.vdd_core.t3 VSS 0.0515f
C293 vco_feed_0.vdd_core.n206 VSS 0.68099f
C294 vco_feed_0.vdd_core.n207 VSS 4.35588f
C295 vco_feed_0.vdd_core.n208 VSS 1.16443f
C296 vco_feed_0.vdd_core.t5 VSS 0.0515f
C297 vco_feed_0.vdd_core.t1 VSS 0.0515f
C298 vco_feed_0.vdd_core.n209 VSS 0.93204f
C299 vco_feed_0.vdd_core.n210 VSS 2.261f
C300 vco_feed_0.vdd_core.n211 VSS 40.1244f
C301 vco_feed_0.vdd_core.n212 VSS 0.554f
C302 vco_feed_0.vdd_core.n213 VSS 2.87927f
C303 vco_feed_0.vdd_core.n214 VSS 16f
C304 vco_feed_0.vdd_core.n215 VSS 2.07901f
C305 vco_feed_0.vdd_core.t16 VSS 0.0515f
C306 vco_feed_0.vdd_core.t18 VSS 0.43257f
C307 vco_feed_0.vdd_core.t20 VSS 0.0515f
C308 vco_feed_0.vdd_core.n216 VSS 0.63337f
C309 vco_feed_0.vdd_core.n217 VSS 0.89921f
C310 vco_feed_0.vdd_core.n218 VSS 2.40303f
C311 vco_feed_0.vdd_core.n219 VSS 2.23263f
C312 vco_feed_0.en_b.n0 VSS 0.93778f
C313 vco_feed_0.en_b.n1 VSS 0.74783f
C314 vco_feed_0.en_b.t0 VSS 0.16587f
C315 vco_feed_0.en_b.t1 VSS 0.22665f
C316 vco_feed_0.en_b.n2 VSS 0.25457f
C317 vco_feed_0.en_b.n3 VSS 0.379f
C318 vco_feed_0.en_b.n4 VSS 0.60337f
C319 a_5948_5116.t1 VSS 0.15472f
C320 a_5948_5116.n0 VSS 2.20174f
C321 a_5948_5116.t0 VSS 0.29401f
C322 a_6568_6836.t0 VSS 0.60931f
C323 a_6568_6836.t3 VSS 0.61066f
C324 a_6568_6836.n0 VSS 0.71873f
C325 a_6568_6836.n1 VSS 1.07763f
C326 a_6568_6836.n2 VSS 0.71926f
C327 a_6568_6836.t2 VSS 1.15117f
C328 a_5060_6408.t1 VSS 1.46499f
C329 a_5060_6408.n0 VSS 1.75426f
C330 a_5060_6408.t0 VSS 0.38225f
C331 a_5560_6408.t0 VSS 2.74401f
C332 a_5560_6408.t1 VSS 0.8042f
C333 a_5560_6408.n0 VSS 4.19226f
C334 a_5560_6408.t2 VSS 1.49836f
C335 a_5560_4622.t0 VSS 0.7582f
C336 a_5560_4622.n0 VSS 1.17868f
C337 a_5560_4622.t2 VSS 0.60336f
C338 a_5060_3702.t4 VSS 2.74475f
C339 a_5060_3702.t3 VSS 0.72508f
C340 a_5060_3702.n0 VSS 1.84097f
C341 a_5060_3702.n1 VSS 0.31854f
C342 a_5060_3702.n2 VSS 0.51373f
C343 a_5060_3702.t1 VSS 1.23857f
C344 a_5060_3702.n3 VSS 1.71705f
C345 a_5060_3702.t0 VSS 0.26564f
C346 a_11798_1860.n0 VSS 0.73632f
C347 a_11798_1860.n1 VSS 2.45117f
C348 a_11798_1860.n2 VSS 4.17642f
C349 a_11798_1860.n3 VSS 0.37897f
C350 a_11798_1860.n4 VSS 0.1145f
C351 a_11798_1860.n5 VSS 0.1145f
C352 a_11798_1860.n7 VSS 1.67631f
C353 a_11798_1860.n8 VSS 1.64655f
C354 a_11798_1860.n9 VSS 0.10122f
C355 a_11798_1860.t22 VSS 0.07276f
C356 a_11798_1860.n10 VSS 0.05853f
C357 a_11798_1860.t24 VSS 0.08124f
C358 a_11798_1860.n11 VSS 0.04391f
C359 a_11798_1860.t26 VSS 0.08124f
C360 a_11798_1860.n12 VSS 0.04391f
C361 a_11798_1860.t27 VSS 0.08124f
C362 a_11798_1860.n13 VSS 0.04479f
C363 a_11798_1860.t28 VSS 0.07276f
C364 a_11798_1860.n14 VSS 0.05853f
C365 a_11798_1860.n15 VSS 0.1141f
C366 a_11798_1860.n16 VSS 0.07502f
C367 a_11798_1860.t25 VSS 0.08654f
C368 a_11798_1860.n17 VSS 0.07502f
C369 a_11798_1860.n18 VSS 0.1141f
C370 a_11798_1860.t23 VSS 4.47348f
C371 a_11798_1860.n19 VSS 0.04479f
C372 a_11798_1860.n20 VSS 0.35735f
C373 a_11798_1860.n21 VSS 0.35735f
C374 a_11798_1860.n22 VSS 0.10122f
C375 a_11798_1860.t0 VSS 0.07276f
C376 a_11798_1860.n23 VSS 0.05853f
C377 a_11798_1860.t2 VSS 0.08124f
C378 a_11798_1860.n24 VSS 0.04391f
C379 a_11798_1860.t4 VSS 0.08124f
C380 a_11798_1860.n25 VSS 0.04391f
C381 a_11798_1860.t5 VSS 4.36811f
C382 a_11798_1860.n26 VSS 0.04479f
C383 a_11798_1860.t6 VSS 0.07276f
C384 a_11798_1860.n27 VSS 0.05853f
C385 a_11798_1860.n28 VSS 0.1141f
C386 a_11798_1860.n29 VSS 0.07502f
C387 a_11798_1860.t3 VSS 0.08654f
C388 a_11798_1860.n30 VSS 0.07502f
C389 a_11798_1860.n31 VSS 0.11411f
C390 a_11798_1860.t1 VSS 0.08124f
C391 a_11798_1860.n32 VSS 0.04479f
C392 a_11798_1860.n33 VSS 0.35734f
C393 a_11798_1860.t7 VSS 0.26135f
C394 a_11798_1860.t8 VSS 0.25427f
C395 a_11798_1860.t9 VSS 0.25427f
C396 a_11798_1860.t10 VSS 0.25427f
C397 a_11798_1860.t11 VSS 0.25427f
C398 a_11798_1860.t12 VSS 0.25427f
C399 a_11798_1860.t13 VSS 0.25427f
C400 a_11798_1860.t14 VSS 0.25427f
C401 a_11798_1860.t15 VSS 0.25427f
C402 a_11798_1860.t16 VSS 0.25427f
C403 a_11798_1860.t17 VSS 0.25427f
C404 a_11798_1860.t18 VSS 1.22161f
C405 a_11798_1860.t19 VSS 0.25427f
C406 a_11798_1860.t20 VSS 0.25427f
C407 a_11798_1860.t21 VSS 0.26131f
C408 a_19774_346.n0 VSS 2.24232f
C409 a_19774_346.n1 VSS 4.91328f
C410 a_19774_346.n2 VSS 16.605f
C411 a_19774_346.t16 VSS 16.90162f
C412 a_19774_346.t0 VSS 0.20805f
C413 a_19774_346.t1 VSS 0.20624f
C414 a_19774_346.t2 VSS 0.20624f
C415 a_19774_346.t3 VSS 0.20624f
C416 a_19774_346.t4 VSS 0.20624f
C417 a_19774_346.t5 VSS 0.20624f
C418 a_19774_346.t6 VSS 0.20624f
C419 a_19774_346.t7 VSS 0.20624f
C420 a_19774_346.t8 VSS 0.20624f
C421 a_19774_346.t9 VSS 0.20624f
C422 a_19774_346.t10 VSS 0.20624f
C423 a_19774_346.t11 VSS 0.20624f
C424 a_19774_346.t12 VSS 0.20624f
C425 a_19774_346.t13 VSS 0.20624f
C426 a_19774_346.t14 VSS 3.36341f
C427 a_19774_346.t15 VSS 0.20623f
C428 VSS.t117 VSS 0.99954f
C429 VSS.t127 VSS 0.3685p
C430 VSS.t122 VSS 0.28406f
C431 VSS.t132 VSS 0.25969f
C432 VSS.t118 VSS 0.99954f
C433 VSS.t128 VSS 0.3685p
C434 VSS.t130 VSS 0.25969f
C435 VSS.t124 VSS 0.28406f
C436 VSS.t165 VSS 4.31452f
C437 VSS.t167 VSS 4.31452f
C438 VSS.t100 VSS 0.96734f
C439 VSS.t46 VSS 0.38107f
C440 VSS.t1 VSS 0.07938f
C441 VSS.t139 VSS 0.04431f
C442 VSS.t154 VSS 0.11315f
C443 VSS.t20 VSS 0.05104f
C444 VSS.t114 VSS 0.21302f
C445 VSS.t3 VSS 0.25483f
C446 VSS.t116 VSS 0.25483f
C447 VSS.t60 VSS 0.54953f
C448 VSS.t29 VSS 4.30842f
C449 VSS.t31 VSS 4.30842f
C450 vtune.t5 VSS 7.2352f
C451 vtune.t3 VSS 7.2212f
C452 vtune.n0 VSS 0.4068f
C453 vtune.t0 VSS 7.2212f
C454 vtune.n1 VSS 1.10653f
C455 VDD.n0 VSS 0.33303f
C456 VDD.n2 VSS 0.14519f
C457 VDD.n3 VSS 0.17406f
C458 VDD.n4 VSS 0.1969f
C459 VDD.n5 VSS 0.1969f
C460 VDD.n6 VSS 0.1969f
C461 VDD.n7 VSS 1.53407f
C462 VDD.n8 VSS 0.03543f
C463 VDD.n9 VSS 0.03543f
C464 VDD.n10 VSS 0.1969f
C465 VDD.n11 VSS 0.03543f
C466 VDD.n12 VSS 0.03543f
C467 VDD.n13 VSS 0.1969f
C468 VDD.n14 VSS 0.03543f
C469 VDD.n15 VSS 0.03543f
C470 VDD.n16 VSS 0.27251f
C471 VDD.n17 VSS 0.36828f
C472 VDD.n18 VSS 0.06509f
C473 VDD.n19 VSS 0.10654f
C474 VDD.n20 VSS 0.01208f
C475 VDD.n21 VSS 0.11855f
C476 VDD.n22 VSS 0.10752f
C477 VDD.n23 VSS 0.08647f
C478 VDD.n24 VSS 1.00749f
C479 VDD.n25 VSS 0.13327f
C480 VDD.n26 VSS 0.03543f
C481 VDD.n27 VSS 0.09668f
C482 VDD.n29 VSS 0.54866f
C483 VDD.n31 VSS 0.06258f
C484 VDD.n32 VSS 0.08466f
C485 VDD.n33 VSS 0.08926f
C486 VDD.n34 VSS 0.06236f
C487 VDD.n35 VSS 0.03543f
C488 VDD.n36 VSS 0.06236f
C489 VDD.n38 VSS 0.03543f
C490 VDD.n39 VSS 0.06236f
C491 VDD.n40 VSS 0.03543f
C492 VDD.n41 VSS 0.06236f
C493 VDD.n43 VSS 0.03543f
C494 VDD.n44 VSS 0.03543f
C495 VDD.n45 VSS 0.03543f
C496 VDD.n46 VSS 0.06236f
C497 VDD.n47 VSS 0.06236f
C498 VDD.n49 VSS 0.06236f
C499 VDD.n50 VSS 0.06236f
C500 VDD.n52 VSS 0.06236f
C501 VDD.t17 VSS 0.0707f
C502 VDD.t20 VSS 0.06371f
C503 VDD.t16 VSS 0.06371f
C504 VDD.t14 VSS 0.06371f
C505 VDD.t12 VSS 0.06371f
C506 VDD.t10 VSS 0.06371f
C507 VDD.t8 VSS 0.06371f
C508 VDD.t6 VSS 0.06371f
C509 VDD.t5 VSS 0.05711f
C510 VDD.t4 VSS 4.76167f
C511 VDD.t22 VSS 0.06371f
C512 VDD.n53 VSS 0.03543f
C513 VDD.t24 VSS 0.06371f
C514 VDD.t28 VSS 0.06371f
C515 VDD.t27 VSS 0.06371f
C516 VDD.t26 VSS 0.06371f
C517 VDD.t32 VSS 0.06371f
C518 VDD.t34 VSS 3.22089f
C519 VDD.t36 VSS 0.05711f
C520 VDD.n54 VSS 0.0426f
C521 VDD.n55 VSS 0.04153f
C522 VDD.n56 VSS 8.31657f
C523 VDD.t37 VSS 1.03365f
C524 VDD.n57 VSS 3.56036f
C525 VDD.t40 VSS 1.0314f
C526 VDD.n58 VSS 3.56036f
C527 VDD.n59 VSS 8.52313f
C528 VDD.t3 VSS 0.07326f
C529 VDD.t41 VSS 0.11196f
C530 VDD.t1 VSS 0.28536f
C531 VDD.t38 VSS 0.55961f
C532 VDD.t49 VSS 0.20308f
C533 VDD.t50 VSS 0.19837f
C534 VDD.t39 VSS 0.55765f
C535 VDD.t46 VSS 0.19837f
C536 VDD.t47 VSS 0.19838f
C537 VDD.t2 VSS 0.13786f
C538 VDD.t43 VSS 0.02771f
C539 VDD.t44 VSS 0.02771f
C540 VDD.t0 VSS 5.92876f
C541 VDD.n60 VSS 0.48626f
C542 di_en.n0 VSS 3.0811f
C543 rf_out_n.n0 VSS 1.13169f
C544 rf_out_n.n1 VSS 1.77153f
C545 rf_out_n.t2 VSS 4.16972f
C546 rf_out_n.t5 VSS 0.40087f
C547 rf_out_n.t1 VSS 0.14118f
C548 rf_out_n.t0 VSS 0.14118f
C549 rf_out_n.t4 VSS 0.14118f
C550 rf_out_n.t3 VSS 0.14118f
C551 rf_out_n.t6 VSS 1.99529f
C552 rf_out_n.n2 VSS 5.58154f
C553 rf_out_p.n0 VSS 1.54578f
C554 rf_out_p.n1 VSS 1.33343f
C555 rf_out_p.t3 VSS 4.24954f
C556 rf_out_p.t4 VSS 0.42408f
C557 rf_out_p.t1 VSS 0.14002f
C558 rf_out_p.t2 VSS 0.14002f
C559 rf_out_p.t6 VSS 0.14002f
C560 rf_out_p.t5 VSS 0.14002f
C561 rf_out_p.t0 VSS 1.98761f
C562 rf_out_p.n2 VSS 5.53538f
.ends
