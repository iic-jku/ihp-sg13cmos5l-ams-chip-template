* PEX produced on Sat Nov  7 09:42:57 PM CET 2026 using /foss/tools/sak/sak-pex.sh with m=3 and s=1 (extresist threshold=1000 mOhm, minres=100 mOhm, mindelay=0 ps)
* NGSPICE file created from vco_top_pex.ext - technology: ihp-sg13cmos5l

.subckt vco_top_pex di_en VDD VSS vtune rf_out_p rf_out_n
X0 a_5060_3702.t0 vco_feed_0.en_b.t4 VSS.t27 VSS.t26 sg13_lv_nmos ad=0.34p pd=2.68u as=0.34p ps=2.68u w=1u l=0.13u
X1 VSS.t112 vco_feed_0.vdd_core.t11 vco_feed_0.vdd_core.t18 VSS.t111 sg13_lv_nmos ad=0.38p pd=2.38u as=0.38p ps=2.38u w=2u l=0.13u
X2 a_11798_1860.t11 vco_bias_0.vbn_buf.t2 VSS.t61 VSS.t62 sg13_lv_nmos ad=0.95p pd=5.38u as=0.95p ps=5.38u w=5u l=0.5u
X3 rf_out_n.t5 a_9400_4880# a_11798_1860.t20 VSS.t124 sg13_lv_nmos ad=0.38p pd=2.38u as=0.38p ps=2.38u w=2u l=0.13u
X4 VSS.t89 vco_bias_0.vbg_buf VSS.t88 VSS.t2 sg13_lv_nmos ad=2.72p pd=16.68u as=0 ps=0 w=8u l=10u
X5 vco_feed_0.en_b.t0 di_en.t0 VSS.t129 VSS.t128 sg13_lv_nmos ad=0.17p pd=1.68u as=0.17p ps=1.68u w=0.5u l=0.13u
X6 rf_out_n.t3 a_9400_4880# a_11798_1860.t18 VSS.t120 sg13_lv_nmos ad=0.38p pd=2.38u as=0.38p ps=2.38u w=2u l=0.13u
X7 VSS.t171 vco_feed_0.vdd_core.t0 vco_feed_0.vdd_core.t7 VSS.t170 sg13_lv_nmos ad=0.38p pd=2.38u as=0.38p ps=2.38u w=2u l=0.13u
X8 a_11798_1860.t12 vco_bias_0.vbn_buf.t2 VSS.t64 VSS.t69 sg13_lv_nmos ad=0.95p pd=5.38u as=0.95p ps=5.38u w=5u l=0.5u
X9 VDD.t26 vco_feed_0.en_b.t2 a_19774_346.t14 VDD.t4 sg13_lv_pmos ad=0.57p pd=3.38u as=0.57p ps=3.38u w=3u l=0.13u
X10 a_19774_346.t2 vco_feed_0.en_b.t2 VDD.t8 VDD.t4 sg13_lv_pmos ad=0.57p pd=3.38u as=0.57p ps=3.38u w=3u l=0.13u
X11 VSS.t12 vco_bias_0.vbn_buf.t3 VSS.t10 VSS.t11 sg13_lv_nmos ad=1.52p pd=8.38u as=0 ps=0 w=8u l=10u
X12 a_5560_6408.t0 a_5560_4622.t2 VSS.t141 rppd l=8.5u w=0.5u
X13 a_19774_346.t15 vco_feed_0.en_b.t2 VDD.t26 VDD.t4 sg13_lv_pmos ad=0.57p pd=3.38u as=0.57p ps=3.38u w=3u l=0.13u
X14 VDD.t10 vco_feed_0.en_b.t2 a_19774_346.t2 VDD.t4 sg13_lv_pmos ad=0.57p pd=3.38u as=0.57p ps=3.38u w=3u l=0.13u
X15 a_11798_1860.t23 a_14668_3324# rf_out_p.t1 VSS.t147 sg13_lv_nmos ad=0.38p pd=2.38u as=0.38p ps=2.38u w=2u l=0.13u
X16 a_11798_1860.t1 vco_bias_0.vbn_buf.t2 VSS.t31 VSS.t32 sg13_lv_nmos ad=0.95p pd=5.38u as=0.95p ps=5.38u w=5u l=0.5u
X17 VDD.t36 vco_feed_0.en_b.t2 a_19774_346.t15 VDD.t4 sg13_lv_pmos ad=1.02p pd=6.68u as=0.57p ps=3.38u w=3u l=0.13u
X18 a_19774_346.t3 vco_feed_0.en_b.t2 VDD.t10 VDD.t4 sg13_lv_pmos ad=0.57p pd=3.38u as=0.57p ps=3.38u w=3u l=0.13u
X19 VSS.t36 vco_bias_0.vbn_buf.t2 a_11798_1860.t4 VSS.t46 sg13_lv_nmos ad=0.95p pd=5.38u as=0.95p ps=5.38u w=5u l=0.5u
X20 a_11798_1860.t2 vco_bias_0.vbn_buf.t2 VSS.t34 VSS.t37 sg13_lv_nmos ad=0.95p pd=5.38u as=0.95p ps=5.38u w=5u l=0.5u
X21 vco_feed_0.vdd_core.t5 vco_feed_0.vdd_core.t0 VSS.t165 VSS.t166 sg13_lv_nmos ad=0.38p pd=2.38u as=0.38p ps=2.38u w=2u l=0.13u
X22 VSS.t48 vco_bias_0.vbn_buf.t2 a_11798_1860.t5 VSS.t47 sg13_lv_nmos ad=0.95p pd=5.38u as=0.95p ps=5.38u w=5u l=0.5u
X23 vco_feed_0.vdd_core.t1 vco_feed_0.vdd_core.t0 VSS.t160 VSS.t159 sg13_lv_nmos ad=0.38p pd=2.38u as=0.68p ps=4.68u w=2u l=0.13u
X24 VSS.t106 vco_feed_0.vdd_core.t11 vco_feed_0.vdd_core.t14 VSS.t105 sg13_lv_nmos ad=0.38p pd=2.38u as=0.38p ps=2.38u w=2u l=0.13u
X25 a_11798_1860.t9 vco_bias_0.vbn_buf.t2 VSS.t41 VSS.t56 sg13_lv_nmos ad=0.95p pd=5.38u as=0.95p ps=5.38u w=5u l=0.5u
X26 a_11798_1860.t26 a_14668_3324# rf_out_p.t3 VSS.t153 sg13_lv_nmos ad=0.38p pd=2.38u as=0.38p ps=2.38u w=2u l=0.13u
X27 rf_out_p.t2 a_14668_3324# a_11798_1860.t24 VSS.t150 sg13_lv_nmos ad=0.38p pd=2.38u as=0.38p ps=2.38u w=2u l=0.13u
X28 VDD.t12 vco_feed_0.en_b.t2 a_19774_346.t3 VDD.t4 sg13_lv_pmos ad=0.57p pd=3.38u as=0.57p ps=3.38u w=3u l=0.13u
X29 VSS.t162 vco_feed_0.vdd_core.t0 vco_feed_0.vdd_core.t1 VSS.t161 sg13_lv_nmos ad=0.38p pd=2.38u as=0.38p ps=2.38u w=2u l=0.13u
X30 VDD.t43 VDD.t41 VDD.t42 VDD.t0 sg13_lv_pmos ad=0.34p pd=2.68u as=0 ps=0 w=1u l=0.13u
X31 VDD.t46 VDD.t44 VDD.t45 VDD.t0 sg13_lv_pmos ad=1.7p pd=10.68u as=0 ps=0 w=5u l=0.5u
X32 a_11798_1860.t16 a_9400_4880# rf_out_n.t0 VSS.t115 sg13_lv_nmos ad=0.38p pd=2.38u as=0.38p ps=2.38u w=2u l=0.13u
X33 VSS.t91 vco_bias_0.vbg_buf VSS.t89 VSS.t5 sg13_lv_nmos ad=1.52p pd=8.38u as=0 ps=0 w=8u l=10u
X34 a_6568_6836.t0 a_5948_5116.t2 VDD.t1 VDD.t0 sg13_lv_pmos ad=0.34p pd=2.68u as=0.34p ps=2.68u w=1u l=0.13u
X35 VDD.t19 vco_feed_0.en_b.t2 a_19774_346.t6 VDD.t4 sg13_lv_pmos ad=0.57p pd=3.38u as=0.57p ps=3.38u w=3u l=0.13u
X36 a_19774_346.t4 vco_feed_0.en_b.t2 VDD.t12 VDD.t4 sg13_lv_pmos ad=0.57p pd=3.38u as=0.57p ps=3.38u w=3u l=0.13u
X37 vco_feed_0.en_b.t1 di_en.t1 VDD.t38 VDD.t0 sg13_lv_pmos ad=0.34p pd=2.68u as=0.34p ps=2.68u w=1u l=0.13u
X38 VSS.t39 vco_bias_0.vbn_buf.t2 a_11798_1860.t2 VSS.t38 sg13_lv_nmos ad=0.95p pd=5.38u as=0.95p ps=5.38u w=5u l=0.5u
X39 a_11798_1860.t21 a_9400_4880# rf_out_n.t5 VSS.t125 sg13_lv_nmos ad=0.68p pd=4.68u as=0.38p ps=2.38u w=2u l=0.13u
X40 VSS.t41 vco_bias_0.vbn_buf.t2 a_11798_1860.t8 VSS.t40 sg13_lv_nmos ad=0.95p pd=5.38u as=0.95p ps=5.38u w=5u l=0.5u
X41 a_11798_1860.t6 vco_bias_0.vbn_buf.t2 VSS.t48 VSS.t49 sg13_lv_nmos ad=0.95p pd=5.38u as=0.95p ps=5.38u w=5u l=0.5u
X42 a_11798_1860.t19 a_9400_4880# rf_out_n.t3 VSS.t121 sg13_lv_nmos ad=0.38p pd=2.38u as=0.38p ps=2.38u w=2u l=0.13u
X43 a_19774_346.t7 vco_feed_0.en_b.t2 VDD.t19 VDD.t4 sg13_lv_pmos ad=0.57p pd=3.38u as=0.57p ps=3.38u w=3u l=0.13u
X44 VDD.t14 vco_feed_0.en_b.t2 a_19774_346.t4 VDD.t4 sg13_lv_pmos ad=0.57p pd=3.38u as=0.57p ps=3.38u w=3u l=0.13u
X45 a_11798_1860.t17 a_9400_4880# rf_out_n.t1 VSS.t117 sg13_lv_nmos ad=0.38p pd=2.38u as=0.38p ps=2.38u w=2u l=0.13u
X46 vco_bias_0.vbg_buf a_14668_3324# VSS.t144 rhigh l=8u w=0.5u
X47 a_19774_346.t16 vco_feed_0.vdd_core.t22 VSS.t158 rppd l=8.8u w=17.3u
X48 vco_feed_0.vdd_core.t20 vco_feed_0.vdd_core.t11 VSS.t112 VSS.t113 sg13_lv_nmos ad=0.38p pd=2.38u as=0.38p ps=2.38u w=2u l=0.13u
X49 VSS.t19 vco_bias_0.vbn_buf.t4 VSS.t17 VSS.t18 sg13_lv_nmos ad=1.52p pd=8.38u as=0 ps=0 w=8u l=10u
X50 VSS.t23 vco_bias_0.vbn_buf.t4 VSS.t21 VSS.t22 sg13_lv_nmos ad=1.52p pd=8.38u as=0 ps=0 w=8u l=10u
X51 vco_feed_0.vdd_core.t9 vco_feed_0.vdd_core.t0 VSS.t171 VSS.t172 sg13_lv_nmos ad=0.38p pd=2.38u as=0.38p ps=2.38u w=2u l=0.13u
X52 rf_out_p.t4 a_14668_3324# a_11798_1860.t23 VSS.t148 sg13_lv_nmos ad=0.38p pd=2.38u as=0.38p ps=2.38u w=2u l=0.13u
X53 VDD.t15 vco_feed_0.en_b.t2 a_19774_346.t7 VDD.t4 sg13_lv_pmos ad=0.57p pd=3.38u as=0.57p ps=3.38u w=3u l=0.13u
X54 a_19774_346.t5 vco_feed_0.en_b.t2 VDD.t14 VDD.t4 sg13_lv_pmos ad=0.57p pd=3.38u as=0.57p ps=3.38u w=3u l=0.13u
X55 a_19774_346.t8 vco_feed_0.en_b.t2 VDD.t15 VDD.t4 sg13_lv_pmos ad=0.57p pd=3.38u as=0.57p ps=3.38u w=3u l=0.13u
X56 VDD.t16 vco_feed_0.en_b.t2 a_19774_346.t5 VDD.t4 sg13_lv_pmos ad=0.57p pd=3.38u as=0.57p ps=3.38u w=3u l=0.13u
X57 VSS.t85 vco_bias_0.vbg_buf VSS.t83 VSS.t9 sg13_lv_nmos ad=1.52p pd=8.38u as=0 ps=0 w=8u l=10u
X58 a_5560_6408.t2 a_6568_6836.t4 VDD.t50 VDD.t0 sg13_lv_pmos ad=1.7p pd=10.68u as=1.7p ps=10.68u w=5u l=0.5u
X59 a_11798_1860.t3 vco_bias_0.vbn_buf.t2 VSS.t39 VSS.t42 sg13_lv_nmos ad=0.95p pd=5.38u as=0.95p ps=5.38u w=5u l=0.5u
X60 VSS.t51 vco_bias_0.vbn_buf.t2 a_11798_1860.t6 VSS.t50 sg13_lv_nmos ad=0.95p pd=5.38u as=0.95p ps=5.38u w=5u l=0.5u
N61 vco_feed_0.vdd_core.t27 vtune.t2 sg13_hv_svaricap l=0.3u w=30.08u
X62 a_11798_1860.t28 a_14668_3324# rf_out_p.t6 VSS.t157 sg13_lv_nmos ad=0.68p pd=4.68u as=0.38p ps=2.38u w=2u l=0.13u
X63 rf_out_p.t5 a_14668_3324# a_11798_1860.t26 VSS.t154 sg13_lv_nmos ad=0.38p pd=2.38u as=0.38p ps=2.38u w=2u l=0.13u
X64 a_5060_6408.t0 vco_feed_0.en_b.t6 VDD.t2 VDD.t0 sg13_lv_pmos ad=0.68p pd=4.68u as=0.68p ps=4.68u w=2u l=0.13u
X65 VDD.t22 vco_feed_0.en_b.t2 a_19774_346.t8 VDD.t4 sg13_lv_pmos ad=0.57p pd=3.38u as=0.57p ps=3.38u w=3u l=0.13u
X66 a_11798_1860.t25 a_14668_3324# rf_out_p.t2 VSS.t151 sg13_lv_nmos ad=0.38p pd=2.38u as=0.38p ps=2.38u w=2u l=0.13u
X67 a_19774_346.t6 vco_feed_0.en_b.t2 VDD.t16 VDD.t4 sg13_lv_pmos ad=0.57p pd=3.38u as=0.57p ps=3.38u w=3u l=0.13u
X68 VSS.t168 vco_feed_0.vdd_core.t0 vco_feed_0.vdd_core.t5 VSS.t167 sg13_lv_nmos ad=0.38p pd=2.38u as=0.38p ps=2.38u w=2u l=0.13u
X69 VSS.t83 vco_bias_0.vbg_buf VSS.t81 VSS.t7 sg13_lv_nmos ad=1.52p pd=8.38u as=0 ps=0 w=8u l=10u
X70 vco_feed_0.vdd_core.t16 vco_feed_0.vdd_core.t11 VSS.t106 VSS.t107 sg13_lv_nmos ad=0.38p pd=2.38u as=0.38p ps=2.38u w=2u l=0.13u
X71 rf_out_n.t1 a_9400_4880# a_11798_1860.t16 VSS.t116 sg13_lv_nmos ad=0.38p pd=2.38u as=0.38p ps=2.38u w=2u l=0.13u
X72 vco_feed_0.vdd_core.t12 vco_feed_0.vdd_core.t11 VSS.t103 VSS.t102 sg13_lv_nmos ad=0.38p pd=2.38u as=0.68p ps=4.68u w=2u l=0.13u
X73 VDD.t29 vco_feed_0.en_b.t2 a_19774_346.t11 VDD.t4 sg13_lv_pmos ad=0.57p pd=3.38u as=0.57p ps=3.38u w=3u l=0.13u
X74 a_19774_346.t9 vco_feed_0.en_b.t2 VDD.t22 VDD.t4 sg13_lv_pmos ad=0.57p pd=3.38u as=0.57p ps=3.38u w=3u l=0.13u
N75 vco_feed_0.vdd_core.t23 vtune.t0 sg13_hv_svaricap l=0.3u w=30.08u
X76 VSS.t66 vco_bias_0.vbn_buf.t2 a_11798_1860.t12 VSS.t70 sg13_lv_nmos ad=0.95p pd=5.38u as=0.95p ps=5.38u w=5u l=0.5u
X77 a_11798_1860.t10 vco_bias_0.vbn_buf.t2 VSS.t58 VSS.t59 sg13_lv_nmos ad=0.95p pd=5.38u as=0.95p ps=5.38u w=5u l=0.5u
X78 a_11798_1860.t0 vco_bias_0.vbn_buf.t2 VSS.t29 VSS.t28 sg13_lv_nmos ad=0.95p pd=5.38u as=1.7p ps=10.68u w=5u l=0.5u
X79 vco_feed_0.vdd_core.t3 vco_feed_0.vdd_core.t0 VSS.t162 VSS.t163 sg13_lv_nmos ad=0.38p pd=2.38u as=0.38p ps=2.38u w=2u l=0.13u
X80 VSS.t6 vco_bias_0.vbn_buf.t3 VSS.t4 VSS.t5 sg13_lv_nmos ad=1.52p pd=8.38u as=0 ps=0 w=8u l=10u
X81 VSS.t133 VSS.t130 VSS.t132 VSS.t131 sg13_lv_nmos ad=0.85p pd=5.68u as=0 ps=0 w=2.5u l=0.5u
X82 VDD.t39 rf_out_n.t6 VSS.t139 rppd l=1.65u w=10u
X83 VSS.t99 vco_feed_0.vdd_core.t11 vco_feed_0.vdd_core.t12 VSS.t104 sg13_lv_nmos ad=0.38p pd=2.38u as=0.38p ps=2.38u w=2u l=0.13u
X84 VSS.t10 vco_bias_0.vbn_buf.t3 VSS.t8 VSS.t9 sg13_lv_nmos ad=1.52p pd=8.38u as=0 ps=0 w=8u l=10u
X85 VSS.t44 vco_bias_0.vbn_buf.t2 a_11798_1860.t3 VSS.t45 sg13_lv_nmos ad=0.95p pd=5.38u as=0.95p ps=5.38u w=5u l=0.5u
X86 rf_out_n.t4 a_9400_4880# a_11798_1860.t19 VSS.t122 sg13_lv_nmos ad=0.38p pd=2.38u as=0.38p ps=2.38u w=2u l=0.13u
X87 a_19774_346.t12 vco_feed_0.en_b.t2 VDD.t29 VDD.t4 sg13_lv_pmos ad=0.57p pd=3.38u as=0.57p ps=3.38u w=3u l=0.13u
X88 VDD.t24 vco_feed_0.en_b.t2 a_19774_346.t9 VDD.t4 sg13_lv_pmos ad=0.57p pd=3.38u as=0.57p ps=3.38u w=3u l=0.13u
X89 rf_out_n.t2 a_9400_4880# a_11798_1860.t17 VSS.t118 sg13_lv_nmos ad=0.38p pd=2.38u as=0.38p ps=2.38u w=2u l=0.13u
X90 VSS.t21 vco_bias_0.vbn_buf.t4 VSS.t19 VSS.t20 sg13_lv_nmos ad=1.52p pd=8.38u as=0 ps=0 w=8u l=10u
X91 VSS.t87 vco_bias_0.vbg_buf VSS.t85 VSS.t11 sg13_lv_nmos ad=1.52p pd=8.38u as=0 ps=0 w=8u l=10u
X92 VDD.t49 VDD.t47 VDD.t48 VDD.t0 sg13_lv_pmos ad=1.7p pd=10.68u as=0 ps=0 w=5u l=0.5u
X93 a_5560_4622.t1 a_5560_4622.t0 VSS.t14 VSS.t13 sg13_lv_nmos ad=0.85p pd=5.68u as=0.85p ps=5.68u w=2.5u l=0.5u
X94 VDD.t31 vco_feed_0.en_b.t2 a_19774_346.t12 VDD.t4 sg13_lv_pmos ad=0.57p pd=3.38u as=0.57p ps=3.38u w=3u l=0.13u
X95 a_11798_1860.t24 a_14668_3324# rf_out_p.t4 VSS.t149 sg13_lv_nmos ad=0.38p pd=2.38u as=0.38p ps=2.38u w=2u l=0.13u
X96 rf_out_p.t1 a_14668_3324# a_11798_1860.t22 VSS.t146 sg13_lv_nmos ad=0.38p pd=2.38u as=0.68p ps=4.68u w=2u l=0.13u
X97 a_19774_346.t10 vco_feed_0.en_b.t2 VDD.t24 VDD.t4 sg13_lv_pmos ad=0.57p pd=3.38u as=0.57p ps=3.38u w=3u l=0.13u
X98 VSS.t95 vco_bias_0.vbg_buf VSS.t93 VSS.t9 sg13_lv_nmos ad=1.52p pd=8.38u as=0 ps=0 w=8u l=10u
X99 VDD.t27 vco_feed_0.en_b.t2 a_19774_346.t10 VDD.t4 sg13_lv_pmos ad=0.57p pd=3.38u as=0.57p ps=3.38u w=3u l=0.13u
X100 VSS.t58 vco_bias_0.vbn_buf.t2 a_11798_1860.t9 VSS.t57 sg13_lv_nmos ad=0.95p pd=5.38u as=0.95p ps=5.38u w=5u l=0.5u
N101 vco_feed_0.vdd_core.t25 vtune.t5 sg13_hv_svaricap l=0.3u w=30.08u
X102 VSS.t31 vco_bias_0.vbn_buf.t2 a_11798_1860.t0 VSS.t30 sg13_lv_nmos ad=0.95p pd=5.38u as=0.95p ps=5.38u w=5u l=0.5u
X103 a_6568_6836.t3 a_6568_6836.t2 VDD.t3 VDD.t0 sg13_lv_pmos ad=1.7p pd=10.68u as=1.7p ps=10.68u w=5u l=0.5u
X104 a_11798_1860.t13 vco_bias_0.vbn_buf.t2 VSS.t66 VSS.t65 sg13_lv_nmos ad=0.95p pd=5.38u as=0.95p ps=5.38u w=5u l=0.5u
X105 VSS.t101 vco_feed_0.vdd_core.t11 vco_feed_0.vdd_core.t20 VSS.t100 sg13_lv_nmos ad=0.68p pd=4.68u as=0.38p ps=2.38u w=2u l=0.13u
X106 a_11798_1860.t14 vco_bias_0.vbn_buf.t2 VSS.t68 VSS.t71 sg13_lv_nmos ad=0.95p pd=5.38u as=0.95p ps=5.38u w=5u l=0.5u
X107 VSS.t174 vco_feed_0.vdd_core.t0 vco_feed_0.vdd_core.t9 VSS.t173 sg13_lv_nmos ad=0.68p pd=4.68u as=0.38p ps=2.38u w=2u l=0.13u
X108 a_11798_1860.t27 a_14668_3324# rf_out_p.t5 VSS.t155 sg13_lv_nmos ad=0.38p pd=2.38u as=0.38p ps=2.38u w=2u l=0.13u
X109 vco_bias_0.vbg_buf a_9400_4880# VSS.t140 rhigh l=8u w=0.5u
X110 VSS.t93 vco_bias_0.vbg_buf VSS.t91 VSS.t7 sg13_lv_nmos ad=1.52p pd=8.38u as=0 ps=0 w=8u l=10u
X111 a_19774_346.t11 vco_feed_0.en_b.t2 VDD.t27 VDD.t4 sg13_lv_pmos ad=0.57p pd=3.38u as=0.57p ps=3.38u w=3u l=0.13u
X112 a_6568_6836.t1 a_5060_3702.t5 VSS.t127 VSS.t126 sg13_lv_nmos ad=0.85p pd=5.68u as=0.85p ps=5.68u w=2.5u l=0.5u
X113 VSS.t8 vco_bias_0.vbn_buf.t3 VSS.t6 VSS.t7 sg13_lv_nmos ad=1.52p pd=8.38u as=0 ps=0 w=8u l=10u
X114 a_5948_5116.t0 vco_feed_0.en_b.t5 VSS.t75 VSS.t74 sg13_lv_nmos ad=0.17p pd=1.68u as=0.17p ps=1.68u w=0.5u l=0.13u
X115 a_11798_1860.t4 vco_bias_0.vbn_buf.t2 VSS.t44 VSS.t43 sg13_lv_nmos ad=0.95p pd=5.38u as=0.95p ps=5.38u w=5u l=0.5u
X116 vco_bias_0.vbg_buf a_5560_6408.t1 VSS.t142 rhigh l=32u w=0.5u
X117 VSS.t53 vco_bias_0.vbn_buf.t2 a_11798_1860.t7 VSS.t55 sg13_lv_nmos ad=0.95p pd=5.38u as=0.95p ps=5.38u w=5u l=0.5u
X118 VSS.t109 vco_feed_0.vdd_core.t11 vco_feed_0.vdd_core.t16 VSS.t108 sg13_lv_nmos ad=0.38p pd=2.38u as=0.38p ps=2.38u w=2u l=0.13u
X119 a_19774_346.t0 vco_feed_0.en_b.t2 VDD.t5 VDD.t4 sg13_lv_pmos ad=0.57p pd=3.38u as=1.02p ps=6.68u w=3u l=0.13u
X120 VSS.t68 vco_bias_0.vbn_buf.t2 a_11798_1860.t13 VSS.t67 sg13_lv_nmos ad=0.95p pd=5.38u as=0.95p ps=5.38u w=5u l=0.5u
X121 a_11798_1860.t20 a_9400_4880# rf_out_n.t4 VSS.t123 sg13_lv_nmos ad=0.38p pd=2.38u as=0.38p ps=2.38u w=2u l=0.13u
X122 a_11798_1860.t18 a_9400_4880# rf_out_n.t2 VSS.t119 sg13_lv_nmos ad=0.38p pd=2.38u as=0.38p ps=2.38u w=2u l=0.13u
X123 VDD.t6 vco_feed_0.en_b.t2 a_19774_346.t0 VDD.t4 sg13_lv_pmos ad=0.57p pd=3.38u as=0.57p ps=3.38u w=3u l=0.13u
X124 VSS.t73 vco_bias_0.vbn_buf.t2 a_11798_1860.t14 VSS.t72 sg13_lv_nmos ad=1.7p pd=10.68u as=0.95p ps=5.38u w=5u l=0.5u
X125 VSS.t17 vco_bias_0.vbn_buf.t4 VSS.t16 VSS.t15 sg13_lv_nmos ad=2.72p pd=16.68u as=0 ps=0 w=8u l=10u
X126 VSS.t79 vco_bias_0.vbg_buf VSS.t78 VSS.t2 sg13_lv_nmos ad=2.72p pd=16.68u as=0 ps=0 w=8u l=10u
X127 VSS.t97 vco_bias_0.vbg_buf VSS.t95 VSS.t11 sg13_lv_nmos ad=1.52p pd=8.38u as=0 ps=0 w=8u l=10u
X128 VSS.t165 vco_feed_0.vdd_core.t0 vco_feed_0.vdd_core.t3 VSS.t164 sg13_lv_nmos ad=0.38p pd=2.38u as=0.38p ps=2.38u w=2u l=0.13u
X129 vco_feed_0.vdd_core.t18 vco_feed_0.vdd_core.t11 VSS.t109 VSS.t110 sg13_lv_nmos ad=0.38p pd=2.38u as=0.38p ps=2.38u w=2u l=0.13u
X130 vco_bias_0.vbn_buf.t1 a_5060_3702.t4 VSS.t143 rhigh l=32u w=0.5u
X131 vco_feed_0.vdd_core.t7 vco_feed_0.vdd_core.t0 VSS.t168 VSS.t169 sg13_lv_nmos ad=0.38p pd=2.38u as=0.38p ps=2.38u w=2u l=0.13u
X132 vco_feed_0.vdd_core.t14 vco_feed_0.vdd_core.t11 VSS.t99 VSS.t98 sg13_lv_nmos ad=0.38p pd=2.38u as=0.38p ps=2.38u w=2u l=0.13u
N133 vco_feed_0.vdd_core.t24 vtune.t0 sg13_hv_svaricap l=0.3u w=30.08u
X134 a_19774_346.t1 vco_feed_0.en_b.t2 VDD.t6 VDD.t4 sg13_lv_pmos ad=0.57p pd=3.38u as=0.57p ps=3.38u w=3u l=0.13u
X135 a_19774_346.t13 vco_feed_0.en_b.t2 VDD.t31 VDD.t4 sg13_lv_pmos ad=0.57p pd=3.38u as=0.57p ps=3.38u w=3u l=0.13u
X136 a_11798_1860.t7 vco_bias_0.vbn_buf.t2 VSS.t51 VSS.t54 sg13_lv_nmos ad=0.95p pd=5.38u as=0.95p ps=5.38u w=5u l=0.5u
X137 VSS.t137 VSS.t134 VSS.t136 VSS.t135 sg13_lv_nmos ad=0.85p pd=5.68u as=0 ps=0 w=2.5u l=0.5u
X138 VSS.t25 vco_bias_0.vbn_buf.t4 VSS.t23 VSS.t24 sg13_lv_nmos ad=1.52p pd=8.38u as=0 ps=0 w=8u l=10u
X139 a_5060_6408.t1 a_5060_3702.t3 VSS.t138 rppd l=13.1u w=0.5u
X140 VSS.t61 vco_bias_0.vbn_buf.t2 a_11798_1860.t10 VSS.t60 sg13_lv_nmos ad=0.95p pd=5.38u as=0.95p ps=5.38u w=5u l=0.5u
X141 a_11798_1860.t8 vco_bias_0.vbn_buf.t2 VSS.t53 VSS.t52 sg13_lv_nmos ad=0.95p pd=5.38u as=0.95p ps=5.38u w=5u l=0.5u
X142 VSS.t64 vco_bias_0.vbn_buf.t2 a_11798_1860.t11 VSS.t63 sg13_lv_nmos ad=0.95p pd=5.38u as=0.95p ps=5.38u w=5u l=0.5u
X143 rf_out_p.t6 a_14668_3324# a_11798_1860.t27 VSS.t156 sg13_lv_nmos ad=0.38p pd=2.38u as=0.38p ps=2.38u w=2u l=0.13u
X144 rf_out_p.t3 a_14668_3324# a_11798_1860.t25 VSS.t152 sg13_lv_nmos ad=0.38p pd=2.38u as=0.38p ps=2.38u w=2u l=0.13u
X145 VDD.t33 vco_feed_0.en_b.t2 a_19774_346.t13 VDD.t4 sg13_lv_pmos ad=0.57p pd=3.38u as=0.57p ps=3.38u w=3u l=0.13u
N146 vco_feed_0.vdd_core.t26 vtune.t5 sg13_hv_svaricap l=0.3u w=30.08u
X147 a_5948_5116.t1 vco_feed_0.en_b.t7 VDD.t37 VDD.t0 sg13_lv_pmos ad=0.34p pd=2.68u as=0.34p ps=2.68u w=1u l=0.13u
N148 vco_feed_0.vdd_core.t28 vtune.t2 sg13_hv_svaricap l=0.3u w=30.08u
X149 a_5060_3702.t2 a_5060_3702.t1 VSS.t1 VSS.t0 sg13_lv_nmos ad=0.85p pd=5.68u as=0.85p ps=5.68u w=2.5u l=0.5u
X150 rf_out_n.t0 a_9400_4880# a_11798_1860.t15 VSS.t114 sg13_lv_nmos ad=0.38p pd=2.38u as=0.68p ps=4.68u w=2u l=0.13u
X151 VSS.t4 vco_bias_0.vbn_buf.t3 VSS.t3 VSS.t2 sg13_lv_nmos ad=2.72p pd=16.68u as=0 ps=0 w=8u l=10u
X152 vco_bias_0.vbn_buf.t0 vco_feed_0.en_b.t3 VSS.t77 VSS.t76 sg13_lv_nmos ad=0.34p pd=2.68u as=0.34p ps=2.68u w=1u l=0.13u
X153 a_19774_346.t14 vco_feed_0.en_b.t2 VDD.t33 VDD.t4 sg13_lv_pmos ad=0.57p pd=3.38u as=0.57p ps=3.38u w=3u l=0.13u
X154 VSS.t34 vco_bias_0.vbn_buf.t2 a_11798_1860.t1 VSS.t33 sg13_lv_nmos ad=0.95p pd=5.38u as=0.95p ps=5.38u w=5u l=0.5u
X155 VSS.t81 vco_bias_0.vbg_buf VSS.t79 VSS.t5 sg13_lv_nmos ad=1.52p pd=8.38u as=0 ps=0 w=8u l=10u
X156 VDD.t8 vco_feed_0.en_b.t2 a_19774_346.t1 VDD.t4 sg13_lv_pmos ad=0.57p pd=3.38u as=0.57p ps=3.38u w=3u l=0.13u
X157 a_11798_1860.t5 vco_bias_0.vbn_buf.t2 VSS.t36 VSS.t35 sg13_lv_nmos ad=0.95p pd=5.38u as=0.95p ps=5.38u w=5u l=0.5u
X158 VDD.t40 rf_out_p.t0 VSS.t145 rppd l=1.65u w=10u
R0 rf_out_p.n0 rf_out_p.t1 6.56137
R1 rf_out_p.n1 rf_out_p.t6 6.52949
R2 rf_out_p.n1 rf_out_p.t5 6.52949
R3 rf_out_p.n0 rf_out_p.t3 6.52949
R4 rf_out_p.n0 rf_out_p.t2 6.52949
R5 rf_out_p.n0 rf_out_p.t4 6.52949
R6 rf_out_p rf_out_p.n2 2.38105
R7 rf_out_p.n2 rf_out_p.t0 1.62005
R8 rf_out_p.n1 rf_out_p.n0 0.128045
R9 rf_out_p.n2 rf_out_p.n1 0.117417
R10 rf_out_n.n0 rf_out_n.t5 6.56137
R11 rf_out_n.n0 rf_out_n.t4 6.52949
R12 rf_out_n.n0 rf_out_n.t3 6.52949
R13 rf_out_n.n1 rf_out_n.t2 6.52949
R14 rf_out_n.n1 rf_out_n.t1 6.52949
R15 rf_out_n.n1 rf_out_n.t0 6.52949
R16 rf_out_n rf_out_n.n2 2.38105
R17 rf_out_n.n2 rf_out_n.t6 1.62005
R18 rf_out_n.n1 rf_out_n.n0 0.128045
R19 rf_out_n.n2 rf_out_n.n1 0.117417
R20 di_en.n0 di_en.t0 21.6583
R21 di_en.n0 di_en.t1 19.605
R22 di_en di_en.n0 14.2289
R23 VDD VDD.n24 24.0135
R24 VDD.n17 VDD.t47 17.5809
R25 VDD.n0 VDD.t44 17.5809
R26 VDD.n60 VDD.n1 1.2602
R27 VDD.n18 VDD.t48 2.54502
R28 VDD.n2 VDD.t41 15.8062
R29 VDD.n20 VDD.n29 3.37066
R30 VDD.n25 VDD.t42 6.07554
R31 VDD.n2 VDD.t43 6.07554
R32 VDD.n19 VDD.t1 6.07554
R33 VDD.n23 VDD.t38 6.07554
R34 VDD.n24 VDD.t37 6.07554
R35 VDD.n1 VDD.n19 0.0656783
R36 VDD.n54 VDD.n22 0.830556
R37 VDD.n22 VDD.n29 2.80696
R38 VDD.n52 VDD.n51 0.0585658
R39 VDD.n51 VDD.n29 2.7974
R40 VDD.n50 VDD.n48 0.0585658
R41 VDD.n48 VDD.n29 2.7974
R42 VDD.n47 VDD.n30 0.066765
R43 VDD.n21 VDD.n42 0.0585658
R44 VDD.n42 VDD.n29 2.7974
R45 VDD.n41 VDD.n37 0.0585658
R46 VDD.n37 VDD.n29 2.7974
R47 VDD.n28 VDD.n29 2.37707
R48 VDD.n19 VDD.n23 0.1061
R49 VDD.n30 VDD.n29 2.3909
R50 VDD.n27 VDD.n28 0.0743661
R51 VDD.n58 VDD.n57 3.7073
R52 VDD.n25 VDD.t2 3.45404
R53 VDD.n24 VDD.n60 3.37539
R54 VDD.n60 VDD.n0 1.51113
R55 VDD.n60 VDD.n18 1.16155
R56 VDD.n32 VDD.t15 2.57245
R57 VDD.n17 VDD.t49 2.36416
R58 VDD.n0 VDD.t45 2.36389
R59 VDD.n33 VDD.t50 2.36338
R60 VDD.n0 VDD.t46 2.36338
R61 VDD.n17 VDD.t3 2.36316
R62 VDD.n3 VDD.n55 2.10932
R63 VDD.n54 VDD.n16 2.10932
R64 VDD.n55 VDD.t5 2.06537
R65 VDD.n54 VDD.t36 2.06537
R66 VDD.n26 VDD.t6 2.06506
R67 VDD.n35 VDD.t8 2.06506
R68 VDD.n38 VDD.t10 2.06506
R69 VDD.n40 VDD.t12 2.06506
R70 VDD.n43 VDD.t14 2.06506
R71 VDD.n44 VDD.t16 2.06506
R72 VDD.n45 VDD.t19 2.06506
R73 VDD.n53 VDD.t22 2.06506
R74 VDD.n9 VDD.t24 2.06506
R75 VDD.n8 VDD.t27 2.06506
R76 VDD.n12 VDD.t29 2.06506
R77 VDD.n11 VDD.t31 2.06506
R78 VDD.n15 VDD.t33 2.06506
R79 VDD.n14 VDD.t26 2.06506
R80 VDD.n3 VDD.n26 2.01733
R81 VDD.n4 VDD.n35 2.01733
R82 VDD.n4 VDD.n38 2.01733
R83 VDD.n5 VDD.n40 2.01733
R84 VDD.n5 VDD.n43 2.01733
R85 VDD.n6 VDD.n44 2.01733
R86 VDD.n6 VDD.n45 2.01733
R87 VDD.n53 VDD.n7 2.01733
R88 VDD.n10 VDD.n9 2.01733
R89 VDD.n10 VDD.n8 2.01733
R90 VDD.n13 VDD.n12 2.01733
R91 VDD.n13 VDD.n11 2.01733
R92 VDD.n16 VDD.n15 2.01733
R93 VDD.n16 VDD.n14 2.01733
R94 VDD.n57 VDD.n56 1.88605
R95 VDD.n59 VDD.n58 1.88605
R96 VDD.n55 VDD.n27 0.811613
R97 VDD.n27 VDD.n26 0.75308
R98 VDD.n36 VDD.n35 0.75308
R99 VDD.n34 VDD.n38 0.75308
R100 VDD.n41 VDD.n40 0.75308
R101 VDD.n39 VDD.n43 0.75308
R102 VDD.n21 VDD.n44 0.75308
R103 VDD.n21 VDD.n45 0.75308
R104 VDD.n31 VDD.n53 0.75308
R105 VDD.n47 VDD.n9 0.75308
R106 VDD.n46 VDD.n8 0.75308
R107 VDD.n50 VDD.n12 0.75308
R108 VDD.n49 VDD.n11 0.75308
R109 VDD.n52 VDD.n15 0.75308
R110 VDD.n22 VDD.n14 0.75308
R111 VDD.n56 VDD.n7 0.656341
R112 VDD VDD.n59 0.597573
R113 VDD.n57 VDD.t40 0.517741
R114 VDD.n58 VDD.t39 0.517741
R115 VDD.n60 VDD.t0 0.395849
R116 VDD.n59 VDD.n56 0.35172
R117 VDD.n29 VDD.t4 0.347439
R118 VDD.n0 VDD.n33 0.222999
R119 VDD.n2 VDD.n25 0.199822
R120 VDD.n16 VDD.n13 0.183684
R121 VDD.n13 VDD.n10 0.183684
R122 VDD.n10 VDD.n7 0.183684
R123 VDD.n7 VDD.n6 0.183684
R124 VDD.n6 VDD.n5 0.183684
R125 VDD.n5 VDD.n4 0.183684
R126 VDD.n4 VDD.n3 0.183684
R127 VDD.n33 VDD.n17 0.181347
R128 VDD.n28 VDD.n36 0.099072
R129 VDD.n32 VDD.n31 0.174604
R130 VDD.n52 VDD.n22 0.155757
R131 VDD.n7 VDD.n32 0.152545
R132 VDD.n24 VDD.n23 0.152127
R133 VDD.n18 VDD.n17 0.0814646
R134 VDD.n2 VDD.n1 0.0766266
R135 VDD.n0 VDD.n25 0.139213
R136 VDD.n49 VDD.n51 0.0585658
R137 VDD.n50 VDD.n49 0.116817
R138 VDD.n46 VDD.n48 0.0585658
R139 VDD.n47 VDD.n46 0.116817
R140 VDD.n31 VDD.n30 0.0501977
R141 VDD.n39 VDD.n42 0.0585658
R142 VDD.n41 VDD.n39 0.116817
R143 VDD.n34 VDD.n37 0.0585658
R144 VDD.n36 VDD.n34 0.116817
R145 VDD.n21 VDD.n20 0.116756
R146 VDD.n20 VDD.n32 0.116351
R147 vtune vtune.n1 16.693
R148 vtune.n0 vtune.t2 16.1774
R149 vtune.n0 vtune.t5 14.7078
R150 vtune.n1 vtune.t0 14.7078
R151 vtune.n1 vtune.n0 1.4701
R152 VSS.n630 VSS.t158 2.59877e+06
R153 VSS.n630 VSS.n133 6446.43
R154 VSS.n530 VSS.n133 4127.1
R155 VSS.t158 VSS.n132 1913.69
R156 VSS.n11 VSS.t143 1472.93
R157 VSS.n631 VSS.n132 956.177
R158 VSS.n504 VSS.n503 774.799
R159 VSS.n632 VSS.n631 756.904
R160 VSS.n631 VSS.t144 686.107
R161 VSS.n502 VSS.t140 666.034
R162 VSS.t144 VSS.t145 405.473
R163 VSS.t140 VSS.n501 301.341
R164 VSS.n635 VSS.n634 278.832
R165 VSS.t141 VSS.t138 251.089
R166 VSS.t139 VSS.n168 236.65
R167 VSS.t142 VSS.t143 200.87
R168 VSS.t138 VSS.t142 175.762
R169 VSS.n492 VSS.t141 145.13
R170 VSS.n630 VSS.n629 130.981
R171 VSS.n7 VSS.n637 100.389
R172 VSS.n499 VSS.t126 45.0201
R173 VSS.t135 VSS.n500 44.0139
R174 VSS.n531 VSS.n529 43.5761
R175 VSS.n494 VSS.t128 43.2932
R176 VSS.n497 VSS.t13 41.0027
R177 VSS.n432 VSS.t11 39.9626
R178 VSS.n643 VSS.t2 39.9596
R179 VSS.n496 VSS.t76 39.4961
R180 VSS.n642 VSS.n2 7.74209
R181 VSS.t26 VSS.n494 34.254
R182 VSS.n503 VSS.n502 33.7949
R183 VSS.t131 VSS.n497 32.966
R184 VSS.n163 VSS.t38 32.8355
R185 VSS.n170 VSS.t32 31.2091
R186 VSS.n500 VSS.t0 29.9548
R187 VSS.t0 VSS.n499 28.9486
R188 VSS.n493 VSS.t74 28.4482
R189 VSS.t33 VSS.n170 27.9562
R190 VSS.t28 VSS.n168 26.837
R191 VSS.t37 VSS.n163 26.3297
R192 VSS.n498 VSS.t131 25.9964
R193 VSS.n169 VSS.t30 25.9797
R194 VSS.n12 VSS.t7 42.0171
R195 VSS.n1 VSS.n0 0.00126806
R196 VSS.n177 VSS.t115 24.804
R197 VSS.t117 VSS.n159 24.804
R198 VSS.n179 VSS.t119 24.804
R199 VSS.n495 VSS.t26 24.4308
R200 VSS.n1 VSS.t9 12.2527
R201 VSS.n12 VSS.t5 12.2528
R202 VSS.t30 VSS.n165 22.7276
R203 VSS.n530 VSS.n182 22.5291
R204 VSS.t114 VSS.n162 21.507
R205 VSS.t69 VSS.n141 20.8388
R206 VSS.t67 VSS.n626 19.8559
R207 VSS.t125 VSS.t49 19.8391
R208 VSS.t146 VSS.t40 19.8391
R209 VSS.t35 VSS.n156 19.5029
R210 VSS.t57 VSS.n202 19.5029
R211 VSS.n171 VSS.t37 19.4739
R212 VSS.t76 VSS.n495 19.4073
R213 VSS.n178 VSS.t43 18.7048
R214 VSS.t54 VSS.n428 18.1579
R215 VSS.n537 VSS.t55 18.1579
R216 VSS.t74 VSS.n492 18.0788
R217 VSS.t13 VSS.n496 17.9008
R218 VSS.n626 VSS.t65 17.89
R219 VSS.n171 VSS.t33 17.8483
R220 VSS.t71 VSS.n134 17.7669
R221 VSS.n474 VSS.t75 17.3443
R222 VSS.n476 VSS.t129 17.3443
R223 VSS.n636 VSS.n635 17.0005
R224 VSS.n636 VSS.n102 17.0005
R225 VSS.n636 VSS.n114 17.0005
R226 VSS.n636 VSS.n111 17.0005
R227 VSS.n636 VSS.n105 17.0005
R228 VSS.n636 VSS.n110 17.0005
R229 VSS.n637 VSS.n636 17.0005
R230 VSS.n633 VSS.n632 17.0005
R231 VSS.n633 VSS.n117 17.0005
R232 VSS.n633 VSS.n129 17.0005
R233 VSS.n633 VSS.n126 17.0005
R234 VSS.n633 VSS.n120 17.0005
R235 VSS.n633 VSS.n125 17.0005
R236 VSS.n634 VSS.n633 17.0005
R237 VSS.n543 VSS.n205 17.0005
R238 VSS.n543 VSS.n144 17.0005
R239 VSS.n543 VSS.n204 17.0005
R240 VSS.n543 VSS.n423 17.0005
R241 VSS.n543 VSS.n542 17.0005
R242 VSS.n543 VSS.n146 17.0005
R243 VSS.n543 VSS.n202 17.0005
R244 VSS.n543 VSS.n424 17.0005
R245 VSS.n543 VSS.n541 17.0005
R246 VSS.n543 VSS.n148 17.0005
R247 VSS.n543 VSS.n540 17.0005
R248 VSS.n543 VSS.n425 17.0005
R249 VSS.n543 VSS.n196 17.0005
R250 VSS.n543 VSS.n426 17.0005
R251 VSS.n543 VSS.n539 17.0005
R252 VSS.n543 VSS.n427 17.0005
R253 VSS.n543 VSS.n537 17.0005
R254 VSS.n543 VSS.n428 17.0005
R255 VSS.n543 VSS.n536 17.0005
R256 VSS.n543 VSS.n429 17.0005
R257 VSS.n543 VSS.n534 17.0005
R258 VSS.n543 VSS.n153 17.0005
R259 VSS.n543 VSS.n533 17.0005
R260 VSS.n543 VSS.n430 17.0005
R261 VSS.n543 VSS.n186 17.0005
R262 VSS.n543 VSS.n431 17.0005
R263 VSS.n543 VSS.n532 17.0005
R264 VSS.n543 VSS.n156 17.0005
R265 VSS.n543 VSS.n182 17.0005
R266 VSS.n543 VSS.n504 17.0005
R267 VSS.n544 VSS.n543 17.0005
R268 VSS.n629 VSS.n628 17.0005
R269 VSS.n628 VSS.n142 17.0005
R270 VSS.n628 VSS.n205 17.0005
R271 VSS.n628 VSS.n144 17.0005
R272 VSS.n628 VSS.n204 17.0005
R273 VSS.n628 VSS.n146 17.0005
R274 VSS.n628 VSS.n202 17.0005
R275 VSS.n628 VSS.n148 17.0005
R276 VSS.n628 VSS.n198 17.0005
R277 VSS.n628 VSS.n196 17.0005
R278 VSS.n628 VSS.n151 17.0005
R279 VSS.n628 VSS.n190 17.0005
R280 VSS.n628 VSS.n153 17.0005
R281 VSS.n628 VSS.n155 17.0005
R282 VSS.n628 VSS.n186 17.0005
R283 VSS.n628 VSS.n156 17.0005
R284 VSS.n628 VSS.n182 17.0005
R285 VSS.n628 VSS.n157 17.0005
R286 VSS.n628 VSS.n179 17.0005
R287 VSS.n628 VSS.n158 17.0005
R288 VSS.n628 VSS.n178 17.0005
R289 VSS.n628 VSS.n159 17.0005
R290 VSS.n628 VSS.n177 17.0005
R291 VSS.n628 VSS.n168 17.0005
R292 VSS.n491 VSS.n433 17.0005
R293 VSS.n491 VSS.n436 17.0005
R294 VSS.n492 VSS.n491 17.0005
R295 VSS.n141 VSS.t70 16.907
R296 VSS.n146 VSS.t59 16.8129
R297 VSS.t116 VSS.n159 16.6717
R298 VSS.n179 VSS.t118 16.6717
R299 VSS.n480 VSS.t130 16.4809
R300 VSS.n487 VSS.t134 16.4809
R301 VSS.n629 VSS.t72 16.2194
R302 VSS.n627 VSS.t71 15.8002
R303 VSS.t128 VSS.n493 15.3899
R304 VSS.n11 VSS.n0 0.00115685
R305 VSS.n502 VSS.n432 15.2936
R306 VSS.n625 VSS.t157 15.0637
R307 VSS.t156 VSS.n142 14.9907
R308 VSS.t32 VSS.n165 14.5945
R309 VSS.n452 VSS.n440 14.3477
R310 VSS.n641 VSS.t20 14.2139
R311 VSS.n429 VSS.t50 14.1229
R312 VSS.n539 VSS.t52 14.1229
R313 VSS.n472 VSS.n471 14.0949
R314 VSS.t15 VSS.n5 4.1605
R315 VSS.n7 VSS.t24 14.0333
R316 VSS.t126 VSS.n498 13.9432
R317 VSS.n642 VSS.n3 13.8978
R318 VSS.t70 VSS.n138 13.835
R319 VSS.n177 VSS.t42 13.8254
R320 VSS.t120 VSS.n156 13.7866
R321 VSS.t122 VSS.n186 13.7866
R322 VSS.t124 VSS.n153 13.7866
R323 VSS.t147 VSS.n196 13.7866
R324 VSS.t149 VSS.n148 13.7866
R325 VSS.n202 VSS.t151 13.7866
R326 VSS.n535 VSS.n191 13.6726
R327 VSS.n538 VSS.n152 13.6726
R328 VSS.n454 VSS.n453 13.5948
R329 VSS.n457 VSS.n75 13.5948
R330 VSS.n452 VSS.n451 13.5948
R331 VSS.n419 VSS.t154 13.2705
R332 VSS.t38 VSS.n162 12.9689
R333 VSS.t65 VSS.n138 12.8513
R334 VSS.n531 VSS.n530 12.7436
R335 VSS.n379 VSS.n6 12.409
R336 VSS.t145 VSS.n630 12.0418
R337 VSS.n169 VSS.t28 11.3424
R338 VSS.t60 VSS.n144 11.3046
R339 VSS.n501 VSS.t135 11.0303
R340 VSS.t118 VSS.n158 10.9791
R341 VSS.n627 VSS.t67 10.8861
R342 VSS.t115 VSS.n161 10.4718
R343 VSS.t123 VSS.t47 10.4242
R344 VSS.t148 VSS.t56 10.4242
R345 VSS.t18 VSS.n4 10.2484
R346 VSS.t47 VSS.n186 10.0879
R347 VSS.t56 VSS.n148 10.0879
R348 VSS.n423 VSS.t153 10.0759
R349 VSS.n205 VSS.t155 10.0759
R350 VSS.n161 VSS.t45 10.0651
R351 VSS.n625 VSS.t69 9.90241
R352 VSS.n647 VSS.n646 9.76416
R353 VSS.t2 VSS.n11 9.13099
R354 VSS.n182 VSS.t120 9.07918
R355 VSS.n431 VSS.t122 9.07918
R356 VSS.n533 VSS.t124 9.07918
R357 VSS.n425 VSS.t147 9.07918
R358 VSS.n541 VSS.t149 9.07918
R359 VSS.t151 VSS.n146 9.07918
R360 VSS.t43 VSS.n158 8.94601
R361 VSS.n134 VSS.t72 8.91945
R362 VSS.t50 VSS.n190 8.74293
R363 VSS.t52 VSS.n151 8.74293
R364 VSS.n648 VSS.n647 8.5413
R365 VSS.t45 VSS.t116 8.5394
R366 VSS.n14 VSS.n13 5.64592
R367 VSS.n529 VSS.n14 1.06274
R368 VSS.n27 VSS.n28 0.00173273
R369 VSS.n28 VSS.n29 0.00172462
R370 VSS.n29 VSS.n30 0.00170812
R371 VSS.n30 VSS.n31 0.00166658
R372 VSS.n529 VSS.n33 2.12569
R373 VSS.n33 VSS.n32 0.00170812
R374 VSS.n32 VSS.n34 0.00166658
R375 VSS.n34 VSS.n18 0.00149997
R376 VSS.n529 VSS.n36 1.70056
R377 VSS.n36 VSS.n35 0.00172462
R378 VSS.n35 VSS.n37 0.00170812
R379 VSS.n37 VSS.n38 0.00166658
R380 VSS.n529 VSS.n39 3.40102
R381 VSS.n42 VSS.n41 0.00216959
R382 VSS.n41 VSS.n43 0.00170812
R383 VSS.n43 VSS.n44 0.00166658
R384 VSS.n44 VSS.n23 0.00149997
R385 VSS.n26 VSS.n25 0.00372261
R386 VSS.n419 VSS.n59 4.251
R387 VSS.n419 VSS.n60 4.251
R388 VSS.n419 VSS.n61 3.40102
R389 VSS.n419 VSS.n63 4.251
R390 VSS.n419 VSS.n64 3.40102
R391 VSS.n419 VSS.n67 2.83428
R392 VSS.n67 VSS.n53 0.00249992
R393 VSS.n419 VSS.n68 4.251
R394 VSS.n419 VSS.n70 2.12569
R395 VSS.n70 VSS.n69 0.00170812
R396 VSS.n69 VSS.n71 0.00166658
R397 VSS.n419 VSS.n72 3.40102
R398 VSS.n45 VSS.n506 8.5005
R399 VSS.n8 VSS.n87 8.5005
R400 VSS.n8 VSS.n101 8.5005
R401 VSS.n8 VSS.n88 8.5005
R402 VSS.n8 VSS.n100 8.5005
R403 VSS.n8 VSS.n89 8.5005
R404 VSS.n8 VSS.n99 8.5005
R405 VSS.n8 VSS.n90 8.5005
R406 VSS.n8 VSS.n98 8.5005
R407 VSS.n8 VSS.n91 8.5005
R408 VSS.n8 VSS.n97 8.5005
R409 VSS.n395 VSS.n394 8.5005
R410 VSS.n628 VSS.n624 8.49671
R411 VSS.n628 VSS.n176 8.49671
R412 VSS.n491 VSS.n434 8.49288
R413 VSS.n636 VSS.n113 8.49147
R414 VSS.n633 VSS.n128 8.49147
R415 VSS.n421 VSS.n420 8.48628
R416 VSS.n511 VSS.n27 8.48544
R417 VSS.n512 VSS.n28 8.48544
R418 VSS.n513 VSS.n29 8.48544
R419 VSS.n514 VSS.n30 8.48544
R420 VSS.n515 VSS.n31 8.48544
R421 VSS.n515 VSS.n16 0.188868
R422 VSS.n16 VSS.n15 4.21231
R423 VSS.n516 VSS.n32 8.48544
R424 VSS.n517 VSS.n34 8.48544
R425 VSS.n19 VSS.n18 3.35165
R426 VSS.n518 VSS.n510 8.48544
R427 VSS.n519 VSS.n35 8.48544
R428 VSS.n520 VSS.n37 8.48544
R429 VSS.n521 VSS.n38 8.48544
R430 VSS.n521 VSS.n21 0.219757
R431 VSS.n522 VSS.n40 8.48544
R432 VSS.n525 VSS.n41 8.48544
R433 VSS.n526 VSS.n43 8.48544
R434 VSS.n527 VSS.n44 8.48544
R435 VSS.n24 VSS.n23 3.35165
R436 VSS.n528 VSS.n25 2.38652
R437 VSS.n45 VSS.n25 0.00227693
R438 VSS.n389 VSS.n388 8.48544
R439 VSS.n388 VSS.n47 0.188868
R440 VSS.n47 VSS.n46 4.21231
R441 VSS.n47 VSS.n49 0.282573
R442 VSS.n403 VSS.n62 8.48544
R443 VSS.n404 VSS.n402 8.48544
R444 VSS.n404 VSS.n51 0.219757
R445 VSS.n405 VSS.n65 8.48544
R446 VSS.n407 VSS.n400 8.48544
R447 VSS.n408 VSS.n66 8.48544
R448 VSS.n54 VSS.n53 3.35165
R449 VSS.n411 VSS.n397 8.48544
R450 VSS.n411 VSS.n56 0.188868
R451 VSS.n56 VSS.n55 4.21231
R452 VSS.n412 VSS.n69 8.48544
R453 VSS.n413 VSS.n71 8.48544
R454 VSS.n413 VSS.n58 0.219757
R455 VSS.n414 VSS.n73 8.48544
R456 VSS.t63 VSS.n142 8.35568
R457 VSS.n646 VSS.n76 7.76695
R458 VSS.n384 VSS.n3 7.53845
R459 VSS.n143 VSS.t156 7.32312
R460 VSS.t62 VSS.n143 7.07738
R461 VSS.t7 VSS.n2 7.06786
R462 VSS.n384 VSS.n97 7.03894
R463 VSS.n385 VSS.n91 7.03894
R464 VSS.n375 VSS.n98 7.03894
R465 VSS.n383 VSS.n90 7.03894
R466 VSS.n376 VSS.n99 7.03894
R467 VSS.n382 VSS.n89 7.03894
R468 VSS.n377 VSS.n100 7.03894
R469 VSS.n378 VSS.n101 7.03894
R470 VSS.n380 VSS.n87 7.03894
R471 VSS.n530 VSS.t46 6.91294
R472 VSS.n637 VSS.t159 6.90359
R473 VSS.n110 VSS.t161 6.90359
R474 VSS.n110 VSS.t163 6.90359
R475 VSS.t164 VSS.n105 6.90359
R476 VSS.t166 VSS.n105 6.90359
R477 VSS.n114 VSS.t167 6.90359
R478 VSS.n114 VSS.t169 6.90359
R479 VSS.t172 VSS.n102 6.90359
R480 VSS.n635 VSS.t173 6.90359
R481 VSS.n634 VSS.t102 6.90359
R482 VSS.n125 VSS.t104 6.90359
R483 VSS.t105 VSS.n120 6.90359
R484 VSS.t107 VSS.n120 6.90359
R485 VSS.n129 VSS.t108 6.90359
R486 VSS.n129 VSS.t110 6.90359
R487 VSS.t111 VSS.n117 6.90359
R488 VSS.t113 VSS.n117 6.90359
R489 VSS.n632 VSS.t100 6.90359
R490 VSS.n538 VSS.n151 6.83654
R491 VSS.n541 VSS.n147 6.83654
R492 VSS.n425 VSS.n199 6.83654
R493 VSS.n539 VSS.n150 6.83654
R494 VSS.n428 VSS.n192 6.83654
R495 VSS.n429 VSS.n187 6.83654
R496 VSS.n533 VSS.n154 6.83654
R497 VSS.n431 VSS.n183 6.83654
R498 VSS.n532 VSS.n183 6.83654
R499 VSS.n430 VSS.n154 6.83654
R500 VSS.n534 VSS.n187 6.83654
R501 VSS.n535 VSS.n190 6.83654
R502 VSS.n536 VSS.n191 6.83654
R503 VSS.n537 VSS.n192 6.83654
R504 VSS.n427 VSS.n152 6.83654
R505 VSS.n426 VSS.n150 6.83654
R506 VSS.n540 VSS.n199 6.83654
R507 VSS.n424 VSS.n147 6.83654
R508 VSS.n470 VSS.n469 6.75595
R509 VSS.n636 VSS.n115 6.69018
R510 VSS.n636 VSS.n104 6.69018
R511 VSS.n636 VSS.n112 6.69018
R512 VSS.n636 VSS.n107 6.69018
R513 VSS.n636 VSS.n108 6.69018
R514 VSS.n633 VSS.n130 6.69018
R515 VSS.n633 VSS.n119 6.69018
R516 VSS.n633 VSS.n127 6.69018
R517 VSS.n633 VSS.n122 6.69018
R518 VSS.n633 VSS.n123 6.69018
R519 VSS.t153 VSS.n204 6.63549
R520 VSS.n342 VSS.n341 6.61367
R521 VSS.n267 VSS.n244 6.51503
R522 VSS.n243 VSS.n234 6.5067
R523 VSS.n233 VSS.n224 6.5067
R524 VSS.n582 VSS.n581 6.34066
R525 VSS.n321 VSS.n320 6.09818
R526 VSS.n477 VSS.t27 6.07511
R527 VSS.n438 VSS.t77 6.07511
R528 VSS.n223 VSS.n211 6.04071
R529 VSS.n108 VSS.t159 5.92367
R530 VSS.t161 VSS.n108 5.92367
R531 VSS.t163 VSS.n107 5.92367
R532 VSS.n107 VSS.t164 5.92367
R533 VSS.n112 VSS.t166 5.92367
R534 VSS.t167 VSS.n112 5.92367
R535 VSS.t169 VSS.n104 5.92367
R536 VSS.t170 VSS.n104 5.92367
R537 VSS.n115 VSS.t172 5.92367
R538 VSS.t173 VSS.n115 5.92367
R539 VSS.n123 VSS.t102 5.92367
R540 VSS.t104 VSS.n123 5.92367
R541 VSS.t98 VSS.n122 5.92367
R542 VSS.n122 VSS.t105 5.92367
R543 VSS.n127 VSS.t107 5.92367
R544 VSS.t108 VSS.n127 5.92367
R545 VSS.t110 VSS.n119 5.92367
R546 VSS.n119 VSS.t111 5.92367
R547 VSS.n130 VSS.t113 5.92367
R548 VSS.t100 VSS.n130 5.92367
R549 VSS.t24 VSS.n6 5.91285
R550 VSS.t18 VSS.n5 9.70453
R551 VSS.t59 VSS.n133 5.71671
R552 VSS.n628 VSS.n626 5.70003
R553 VSS.n628 VSS.n141 5.70003
R554 VSS.n628 VSS.n143 5.70003
R555 VSS.n628 VSS.n203 5.70003
R556 VSS.n642 VSS.n641 5.68575
R557 VSS.n529 VSS.n17 5.66778
R558 VSS.n39 VSS.n20 0.00229996
R559 VSS.n529 VSS.n505 5.66778
R560 VSS.n529 VSS.n42 1.54575
R561 VSS.n529 VSS.n22 5.66778
R562 VSS.n529 VSS.n26 3.4009
R563 VSS.n420 VSS.n419 5.66778
R564 VSS.n61 VSS.n48 0.00229996
R565 VSS.n64 VSS.n50 0.00229996
R566 VSS.n419 VSS.n392 5.66778
R567 VSS.n419 VSS.n52 5.66778
R568 VSS.n419 VSS.n393 5.66778
R569 VSS.n419 VSS.n391 5.66778
R570 VSS.n72 VSS.n57 0.00229996
R571 VSS.n419 VSS.n390 5.66778
R572 VSS.n529 VSS.n45 5.66767
R573 VSS.n386 VSS.n384 5.66717
R574 VSS.n386 VSS.n385 5.66717
R575 VSS.n386 VSS.n375 5.66717
R576 VSS.n386 VSS.n383 5.66717
R577 VSS.n386 VSS.n376 5.66717
R578 VSS.n386 VSS.n382 5.66717
R579 VSS.n386 VSS.n377 5.66717
R580 VSS.n386 VSS.n381 5.66717
R581 VSS.n386 VSS.n378 5.66717
R582 VSS.n386 VSS.n380 5.66717
R583 VSS.n386 VSS.n379 5.66717
R584 VSS.n628 VSS.n140 5.66016
R585 VSS.n628 VSS.n173 5.66016
R586 VSS.n491 VSS.n490 5.65335
R587 VSS.n491 VSS.n483 5.65335
R588 VSS.n636 VSS.n116 5.65086
R589 VSS.n636 VSS.n103 5.65086
R590 VSS.n636 VSS.n106 5.65086
R591 VSS.n633 VSS.n131 5.65086
R592 VSS.n633 VSS.n118 5.65086
R593 VSS.n633 VSS.n121 5.65086
R594 VSS.n21 VSS.n20 3.35165
R595 VSS.n523 VSS.n509 5.64018
R596 VSS.n524 VSS.n508 5.64018
R597 VSS.n528 VSS.n507 5.64018
R598 VSS.n49 VSS.n48 3.35165
R599 VSS.n51 VSS.n50 3.35165
R600 VSS.n406 VSS.n401 5.64018
R601 VSS.n409 VSS.n399 5.64018
R602 VSS.n410 VSS.n398 5.64018
R603 VSS.n58 VSS.n57 3.35165
R604 VSS.n415 VSS.n396 5.64018
R605 VSS.n417 VSS.n416 5.64018
R606 VSS.n423 VSS.n203 5.60293
R607 VSS.n542 VSS.n203 5.60293
R608 VSS.n204 VSS.t60 5.40679
R609 VSS.n4 VSS.t20 5.37151
R610 VSS.t155 VSS.t62 5.16105
R611 VSS.n543 VSS.n538 5.08323
R612 VSS.n543 VSS.n535 5.08323
R613 VSS.n628 VSS.n147 5.08323
R614 VSS.n628 VSS.n199 5.08323
R615 VSS.n628 VSS.n150 5.08323
R616 VSS.n628 VSS.n152 5.08323
R617 VSS.n628 VSS.n192 5.08323
R618 VSS.n628 VSS.n191 5.08323
R619 VSS.n628 VSS.n187 5.08323
R620 VSS.n628 VSS.n154 5.08323
R621 VSS.n628 VSS.n183 5.08323
R622 VSS.n502 VSS.t139 4.87987
R623 VSS.n536 VSS.t54 4.70796
R624 VSS.t55 VSS.n427 4.70796
R625 VSS.n628 VSS.n161 4.68877
R626 VSS.n628 VSS.n163 4.68877
R627 VSS.n628 VSS.n170 4.68877
R628 VSS.n646 VSS.n645 4.67815
R629 VSS.n506 VSS.t170 4.60256
R630 VSS.n394 VSS.t98 4.60256
R631 VSS.n416 VSS.n395 4.43191
R632 VSS.n450 VSS.n442 4.3831
R633 VSS.t22 VSS.n88 4.33185
R634 VSS.n644 VSS.n643 4.25154
R635 VSS.n419 VSS.n418 4.25112
R636 VSS.n9 VSS.n8 0.207269
R637 VSS.n501 VSS.n491 4.24177
R638 VSS.n628 VSS.n201 4.24049
R639 VSS.n628 VSS.n185 4.24049
R640 VSS.n491 VSS.n488 4.23094
R641 VSS.n491 VSS.n437 4.23094
R642 VSS.n491 VSS.n478 4.23094
R643 VSS.n636 VSS.n109 4.22744
R644 VSS.n633 VSS.n124 4.22744
R645 VSS.n615 VSS.n614 3.93263
R646 VSS.n545 VSS.n386 3.89224
R647 VSS.n545 VSS.n544 3.88607
R648 VSS.n529 VSS.n504 3.59762
R649 VSS.n580 VSS.n579 3.57193
R650 VSS.n628 VSS.n135 3.38773
R651 VSS.n628 VSS.n167 3.38773
R652 VSS.n628 VSS.n207 3.38758
R653 VSS.n628 VSS.n145 3.38758
R654 VSS.n628 VSS.n149 3.38758
R655 VSS.n628 VSS.n189 3.38758
R656 VSS.n628 VSS.n181 3.38758
R657 VSS.n628 VSS.n160 3.38758
R658 VSS.n569 VSS.n568 3.3755
R659 VSS.n567 VSS.n372 3.3755
R660 VSS.n566 VSS.n565 3.3755
R661 VSS.n491 VSS.n481 3.37539
R662 VSS.n491 VSS.n439 3.37539
R663 VSS.n491 VSS.n475 3.37539
R664 VSS.n490 VSS.t137 3.18948
R665 VSS.n479 VSS.t14 3.14902
R666 VSS.n435 VSS.t132 3.14902
R667 VSS.n482 VSS.t133 3.14902
R668 VSS.n484 VSS.t127 3.14902
R669 VSS.n486 VSS.t1 3.14902
R670 VSS.n489 VSS.t136 3.14902
R671 VSS.n174 VSS.n74 3.09542
R672 VSS.n619 VSS.n618 3.09542
R673 VSS.n621 VSS.n620 3.09542
R674 VSS.n623 VSS.n622 3.09542
R675 VSS.t42 VSS.t114 2.8468
R676 VSS.n178 VSS.t117 2.8468
R677 VSS.t119 VSS.n157 2.8468
R678 VSS.n628 VSS.n137 2.81806
R679 VSS.n628 VSS.n195 2.81806
R680 VSS.n628 VSS.n164 2.81806
R681 VSS.n491 VSS.n485 2.80331
R682 VSS.n560 VSS.n559 2.79907
R683 VSS.n552 VSS.n551 2.79907
R684 VSS.n578 VSS.t101 2.79558
R685 VSS.n559 VSS.t160 2.79558
R686 VSS.n551 VSS.t174 2.79558
R687 VSS.n253 VSS.t99 2.7955
R688 VSS.n251 VSS.t106 2.7955
R689 VSS.n249 VSS.t109 2.7955
R690 VSS.n247 VSS.t112 2.7955
R691 VSS.n557 VSS.t162 2.7955
R692 VSS.n555 VSS.t165 2.7955
R693 VSS.n548 VSS.t168 2.7955
R694 VSS.n550 VSS.t171 2.7955
R695 VSS.n254 VSS.t103 2.79532
R696 VSS.n474 VSS.n473 2.71772
R697 VSS.n381 VSS.t22 2.70759
R698 VSS.n133 VSS.t152 2.69048
R699 VSS.n578 VSS.n577 2.46348
R700 VSS.n571 VSS.n254 2.4382
R701 VSS.n532 VSS.t121 2.35423
R702 VSS.n430 VSS.t123 2.35423
R703 VSS.n534 VSS.t125 2.35423
R704 VSS.n426 VSS.t146 2.35423
R705 VSS.n540 VSS.t148 2.35423
R706 VSS.n424 VSS.t150 2.35423
R707 VSS.n572 VSS.n253 2.3138
R708 VSS.n573 VSS.n251 2.3138
R709 VSS.n576 VSS.n249 2.3138
R710 VSS.n577 VSS.n247 2.3138
R711 VSS.n560 VSS.n557 2.3138
R712 VSS.n561 VSS.n555 2.3138
R713 VSS.n553 VSS.n548 2.3138
R714 VSS.n552 VSS.n550 2.3138
R715 VSS.n506 VSS.n102 2.30153
R716 VSS.n394 VSS.n125 2.30153
R717 VSS.n571 VSS.n570 2.2505
R718 VSS.n78 VSS.t93 2.21127
R719 VSS.n92 VSS.t8 2.21111
R720 VSS.n84 VSS.t97 2.21099
R721 VSS.n83 VSS.t95 2.21095
R722 VSS.n81 VSS.t91 2.21061
R723 VSS.n645 VSS.t88 2.21057
R724 VSS.n95 VSS.t6 2.21049
R725 VSS.n76 VSS.t3 2.21047
R726 VSS.n80 VSS.t89 2.21005
R727 VSS.n94 VSS.t4 2.21
R728 VSS.n639 VSS.t12 2.21
R729 VSS.n638 VSS.t10 2.20994
R730 VSS.n94 VSS.t17 2.20308
R731 VSS.n76 VSS.t16 2.20306
R732 VSS.n80 VSS.t79 2.20274
R733 VSS.n92 VSS.t21 2.20189
R734 VSS.n78 VSS.t83 2.20187
R735 VSS.n84 VSS.t87 2.20182
R736 VSS.n83 VSS.t85 2.20146
R737 VSS.n638 VSS.t23 2.20133
R738 VSS.n81 VSS.t81 2.20132
R739 VSS.n645 VSS.t78 2.20131
R740 VSS.n639 VSS.t25 2.2012
R741 VSS.n95 VSS.t19 2.20116
R742 VSS.n132 VSS.n617 318.474
R743 VSS.n385 VSS.n97 2.16617
R744 VSS.n375 VSS.n91 2.16617
R745 VSS.n383 VSS.n98 2.16617
R746 VSS.n376 VSS.n90 2.16617
R747 VSS.n382 VSS.n99 2.16617
R748 VSS.n377 VSS.n89 2.16617
R749 VSS.n381 VSS.n100 2.16617
R750 VSS.n378 VSS.n88 2.16617
R751 VSS.n380 VSS.n101 2.16617
R752 VSS.n379 VSS.n87 2.16617
R753 VSS.n628 VSS.n134 2.15357
R754 VSS.n628 VSS.n627 2.15357
R755 VSS.n628 VSS.n138 2.15357
R756 VSS.n628 VSS.n625 2.15357
R757 VSS.t154 VSS.n144 1.72068
R758 VSS.n419 VSS.n205 1.72068
R759 VSS.t157 VSS.t63 1.72068
R760 VSS.n167 VSS.t29 1.61894
R761 VSS.n135 VSS.t73 1.61831
R762 VSS.n193 VSS.t51 1.47429
R763 VSS.n166 VSS.t31 1.4742
R764 VSS.n197 VSS.t41 1.4742
R765 VSS.n194 VSS.t53 1.47409
R766 VSS.n200 VSS.t58 1.47378
R767 VSS.n208 VSS.t64 1.47354
R768 VSS.n136 VSS.t68 1.47343
R769 VSS.n172 VSS.t34 1.47335
R770 VSS.n206 VSS.t61 1.47335
R771 VSS.n139 VSS.t66 1.47328
R772 VSS.n175 VSS.t39 1.47305
R773 VSS.n180 VSS.t44 1.47305
R774 VSS.n184 VSS.t36 1.4729
R775 VSS.n188 VSS.t48 1.4729
R776 VSS.n564 VSS.n546 1.42376
R777 VSS.n628 VSS.n162 1.40016
R778 VSS.n628 VSS.n171 1.40016
R779 VSS.n628 VSS.n165 1.40016
R780 VSS.n628 VSS.n169 1.40016
R781 VSS.n602 VSS.n601 1.30527
R782 VSS.n565 VSS.n564 1.23289
R783 VSS.t121 VSS.t35 1.00924
R784 VSS.t150 VSS.t57 1.00924
R785 VSS.n422 VSS.n421 0.952305
R786 VSS.n422 VSS.n387 0.882565
R787 VSS.n592 VSS.n591 0.812182
R788 VSS.n563 VSS.n562 0.7505
R789 VSS.n575 VSS.n574 0.7505
R790 VSS.t49 VSS.n153 0.672995
R791 VSS.t40 VSS.n196 0.672995
R792 VSS.n648 VSS.n74 0.648061
R793 VSS.n373 VSS.n254 0.561425
R794 VSS.n253 VSS.n252 0.561174
R795 VSS.n251 VSS.n250 0.561174
R796 VSS.n249 VSS.n248 0.561174
R797 VSS.n247 VSS.n246 0.561174
R798 VSS.n557 VSS.n556 0.561174
R799 VSS.n555 VSS.n554 0.561174
R800 VSS.n548 VSS.n547 0.561174
R801 VSS.n550 VSS.n549 0.561174
R802 VSS.n579 VSS.n578 0.56108
R803 VSS.n559 VSS.n558 0.56108
R804 VSS.n551 VSS.n374 0.56108
R805 VSS.n561 VSS.n560 0.485689
R806 VSS.n553 VSS.n552 0.485689
R807 VSS.n453 VSS.n75 0.471929
R808 VSS.n472 VSS.n453 0.471929
R809 VSS.n306 VSS.n290 0.4405
R810 VSS.n236 VSS.n235 0.4405
R811 VSS.n226 VSS.n225 0.4405
R812 VSS.n216 VSS.n215 0.4405
R813 VSS.n266 VSS.n265 0.4405
R814 VSS.n290 VSS.n289 0.4405
R815 VSS.n235 VSS.n234 0.4405
R816 VSS.n225 VSS.n224 0.4405
R817 VSS.n215 VSS.n214 0.4405
R818 VSS.n267 VSS.n266 0.4405
R819 VSS.n331 VSS.n330 0.424088
R820 VSS.n270 VSS.n268 0.422335
R821 VSS.n530 VSS.n157 0.407114
R822 VSS.n641 VSS.n8 0.368641
R823 VSS.n278 VSS.n277 0.367167
R824 VSS.n293 VSS.n292 0.367167
R825 VSS.n295 VSS.n294 0.367167
R826 VSS.n300 VSS.n296 0.367167
R827 VSS.n311 VSS.n310 0.367167
R828 VSS.n313 VSS.n312 0.367167
R829 VSS.n317 VSS.n209 0.367167
R830 VSS.n616 VSS.n615 0.367167
R831 VSS.n305 VSS.n304 0.3635
R832 VSS.n304 VSS.n303 0.3635
R833 VSS.n323 VSS.n322 0.3635
R834 VSS.n324 VSS.n323 0.3635
R835 VSS.n327 VSS.n326 0.3635
R836 VSS.n328 VSS.n327 0.3635
R837 VSS.n240 VSS.n239 0.3635
R838 VSS.n239 VSS.n238 0.3635
R839 VSS.n230 VSS.n229 0.3635
R840 VSS.n229 VSS.n228 0.3635
R841 VSS.n220 VSS.n219 0.3635
R842 VSS.n219 VSS.n218 0.3635
R843 VSS.n262 VSS.n261 0.3635
R844 VSS.n263 VSS.n262 0.3635
R845 VSS.n275 VSS.n274 0.3635
R846 VSS.n337 VSS.n334 0.3635
R847 VSS.n335 VSS.n334 0.3635
R848 VSS.n274 VSS.n273 0.3635
R849 VSS.n271 VSS.n270 0.3635
R850 VSS.n450 VSS.n449 0.346655
R851 VSS.n342 VSS.n336 0.338523
R852 VSS.n567 VSS.n566 0.337235
R853 VSS.n568 VSS.n567 0.337235
R854 VSS.n602 VSS.n223 0.31812
R855 VSS.n582 VSS.n243 0.31812
R856 VSS.n592 VSS.n233 0.31812
R857 VSS.n581 VSS.n244 0.31812
R858 VSS.n564 VSS.n563 0.318023
R859 VSS.n471 VSS.n470 0.315693
R860 VSS.n469 VSS.n468 0.307456
R861 VSS.n449 VSS.n448 0.303948
R862 VSS.n448 VSS.n447 0.303948
R863 VSS.n447 VSS.n446 0.303948
R864 VSS.n446 VSS.n442 0.303948
R865 VSS.n494 VSS.n491 0.302472
R866 VSS.n647 VSS.n75 0.302214
R867 VSS.n543 VSS.n531 0.291211
R868 VSS.n369 VSS.n368 0.288357
R869 VSS.n320 VSS.n319 0.276447
R870 VSS.n289 VSS.n288 0.276447
R871 VSS.n307 VSS.n306 0.276447
R872 VSS.n307 VSS.n305 0.276447
R873 VSS.n303 VSS.n302 0.276447
R874 VSS.n325 VSS.n324 0.276447
R875 VSS.n326 VSS.n325 0.276447
R876 VSS.n329 VSS.n328 0.276447
R877 VSS.n221 VSS.n220 0.276447
R878 VSS.n218 VSS.n217 0.276447
R879 VSS.n217 VSS.n216 0.276447
R880 VSS.n214 VSS.n213 0.276447
R881 VSS.n212 VSS.n211 0.276447
R882 VSS.n241 VSS.n240 0.276188
R883 VSS.n238 VSS.n237 0.276188
R884 VSS.n237 VSS.n236 0.276188
R885 VSS.n231 VSS.n230 0.276188
R886 VSS.n228 VSS.n227 0.276188
R887 VSS.n227 VSS.n226 0.276188
R888 VSS.n261 VSS.n256 0.276188
R889 VSS.n264 VSS.n263 0.276188
R890 VSS.n265 VSS.n264 0.276188
R891 VSS.n339 VSS.n337 0.276188
R892 VSS.n336 VSS.n335 0.276188
R893 VSS.n273 VSS.n272 0.276188
R894 VSS.n272 VSS.n271 0.276188
R895 VSS.n343 VSS.n332 0.2755
R896 VSS.n348 VSS.n347 0.2755
R897 VSS.n350 VSS.n349 0.2755
R898 VSS.n354 VSS.n269 0.2755
R899 VSS.n359 VSS.n358 0.2755
R900 VSS.n361 VSS.n360 0.2755
R901 VSS.n363 VSS.n258 0.2755
R902 VSS.n368 VSS.n367 0.2755
R903 VSS.n330 VSS.n329 0.271823
R904 VSS.n468 VSS.n467 0.267167
R905 VSS.n467 VSS.n466 0.267167
R906 VSS.n466 VSS.n465 0.267167
R907 VSS.n465 VSS.n464 0.267167
R908 VSS.n464 VSS.n456 0.267167
R909 VSS.n470 VSS.n456 0.267167
R910 VSS.n322 VSS.n321 0.2645
R911 VSS.n341 VSS.n275 0.2645
R912 VSS.n644 VSS.n10 0.249698
R913 VSS.n9 VSS.n76 0.239717
R914 VSS.n542 VSS.n133 0.24624
R915 VSS.n82 VSS.n80 0.243424
R916 VSS.n96 VSS.n94 0.243424
R917 VSS.n563 VSS.n561 0.243095
R918 VSS.n563 VSS.n553 0.243095
R919 VSS.n78 VSS.n77 0.24245
R920 VSS.n92 VSS.n86 0.24245
R921 VSS.n566 VSS.n374 0.241827
R922 VSS.n568 VSS.n373 0.241827
R923 VSS.n81 VSS.n79 0.240796
R924 VSS.n95 VSS.n93 0.240796
R925 VSS.n85 VSS.n83 0.239822
R926 VSS.n640 VSS.n638 0.239822
R927 VSS.n9 VSS.n94 0.225226
R928 VSS.n0 VSS.n10 0.230002
R929 VSS.n83 VSS.n77 0.227974
R930 VSS.n638 VSS.n86 0.227974
R931 VSS.n82 VSS.n81 0.227001
R932 VSS.n96 VSS.n95 0.227001
R933 VSS.n543 VSS.n422 0.22697
R934 VSS.n473 VSS.n452 0.226786
R935 VSS.n85 VSS.n84 0.225646
R936 VSS.n640 VSS.n639 0.225646
R937 VSS.n79 VSS.n78 0.224672
R938 VSS.n93 VSS.n92 0.224672
R939 VSS.n8 VSS.n86 0.218846
R940 VSS.n8 VSS.n96 0.218846
R941 VSS.n0 VSS.n77 0.218846
R942 VSS.n0 VSS.n82 0.218846
R943 VSS.n473 VSS.n472 0.214214
R944 VSS.n80 VSS.n10 0.212632
R945 VSS.n8 VSS.n640 0.208386
R946 VSS.n8 VSS.n93 0.208386
R947 VSS.n0 VSS.n85 0.208386
R948 VSS.n0 VSS.n79 0.208386
R949 VSS.n319 VSS.n288 0.199447
R950 VSS.n302 VSS.n287 0.199447
R951 VSS.n222 VSS.n221 0.199447
R952 VSS.n213 VSS.n212 0.199447
R953 VSS.n242 VSS.n241 0.199188
R954 VSS.n232 VSS.n231 0.199188
R955 VSS.n256 VSS.n255 0.199188
R956 VSS.n340 VSS.n339 0.199188
R957 VSS.n524 VSS.n523 0.189041
R958 VSS.n528 VSS.n24 0.251491
R959 VSS.n409 VSS.n54 0.251491
R960 VSS.n410 VSS.n409 0.189041
R961 VSS.n416 VSS.n415 0.189041
R962 VSS.n622 VSS.n617 0.183793
R963 VSS.n332 VSS.n331 0.165999
R964 VSS.n570 VSS.n371 0.161968
R965 VSS.n518 VSS.n19 0.220165
R966 VSS.n522 VSS.n21 0.220165
R967 VSS.n525 VSS.n524 0.157715
R968 VSS.n403 VSS.n49 0.220165
R969 VSS.n405 VSS.n51 0.220165
R970 VSS.n407 VSS.n406 0.157715
R971 VSS.n411 VSS.n410 0.157715
R972 VSS.n414 VSS.n58 0.220165
R973 VSS.n19 VSS.n517 0.219757
R974 VSS.n523 VSS.n522 0.157378
R975 VSS.n24 VSS.n527 0.219757
R976 VSS.n406 VSS.n405 0.157378
R977 VSS.n54 VSS.n408 0.219757
R978 VSS.n415 VSS.n414 0.157378
R979 VSS.n573 VSS.n572 0.1501
R980 VSS.n577 VSS.n576 0.1501
R981 VSS.n511 VSS.n13 0.157714
R982 VSS.n512 VSS.n511 0.126053
R983 VSS.n513 VSS.n512 0.126053
R984 VSS.n514 VSS.n513 0.126053
R985 VSS.n515 VSS.n514 0.126053
R986 VSS.n516 VSS.n16 0.188868
R987 VSS.n517 VSS.n516 0.126053
R988 VSS.n519 VSS.n518 0.126053
R989 VSS.n520 VSS.n519 0.126053
R990 VSS.n521 VSS.n520 0.126053
R991 VSS.n526 VSS.n525 0.126053
R992 VSS.n527 VSS.n526 0.126053
R993 VSS.n421 VSS.n388 0.126053
R994 VSS.n404 VSS.n403 0.126053
R995 VSS.n408 VSS.n407 0.126053
R996 VSS.n412 VSS.n56 0.188868
R997 VSS.n413 VSS.n412 0.126053
R998 VSS.n565 VSS.n372 0.121601
R999 VSS.n569 VSS.n372 0.121601
R1000 VSS.n570 VSS.n569 0.121601
R1001 VSS.n445 VSS.n440 0.103584
R1002 VSS.n583 VSS.n582 0.102006
R1003 VSS.n593 VSS.n592 0.102006
R1004 VSS.n603 VSS.n602 0.102006
R1005 VSS.n319 VSS.n318 0.101071
R1006 VSS.n316 VSS.n288 0.101071
R1007 VSS.n308 VSS.n307 0.101071
R1008 VSS.n304 VSS.n297 0.101071
R1009 VSS.n302 VSS.n301 0.101071
R1010 VSS.n299 VSS.n287 0.101071
R1011 VSS.n323 VSS.n285 0.101071
R1012 VSS.n325 VSS.n283 0.101071
R1013 VSS.n327 VSS.n281 0.101071
R1014 VSS.n329 VSS.n279 0.101071
R1015 VSS.n583 VSS.n242 0.101071
R1016 VSS.n584 VSS.n241 0.101071
R1017 VSS.n586 VSS.n239 0.101071
R1018 VSS.n588 VSS.n237 0.101071
R1019 VSS.n593 VSS.n232 0.101071
R1020 VSS.n594 VSS.n231 0.101071
R1021 VSS.n596 VSS.n229 0.101071
R1022 VSS.n598 VSS.n227 0.101071
R1023 VSS.n603 VSS.n222 0.101071
R1024 VSS.n604 VSS.n221 0.101071
R1025 VSS.n606 VSS.n219 0.101071
R1026 VSS.n608 VSS.n217 0.101071
R1027 VSS.n612 VSS.n213 0.101071
R1028 VSS.n613 VSS.n212 0.101071
R1029 VSS.n255 VSS.n245 0.101071
R1030 VSS.n370 VSS.n256 0.101071
R1031 VSS.n262 VSS.n260 0.101071
R1032 VSS.n366 VSS.n264 0.101071
R1033 VSS.n340 VSS.n276 0.101071
R1034 VSS.n339 VSS.n338 0.101071
R1035 VSS.n346 VSS.n334 0.101071
R1036 VSS.n344 VSS.n336 0.101071
R1037 VSS.n352 VSS.n274 0.101071
R1038 VSS.n355 VSS.n272 0.101071
R1039 VSS.n357 VSS.n270 0.101071
R1040 VSS.n13 VSS.n387 0.185353
R1041 VSS.n485 VSS.n484 0.0927224
R1042 VSS.n486 VSS.n485 0.0891245
R1043 VSS.n614 VSS.n613 0.0885
R1044 VSS.n613 VSS.n612 0.0885
R1045 VSS.n612 VSS.n611 0.0885
R1046 VSS.n611 VSS.n610 0.0885
R1047 VSS.n610 VSS.n609 0.0885
R1048 VSS.n609 VSS.n608 0.0885
R1049 VSS.n608 VSS.n607 0.0885
R1050 VSS.n607 VSS.n606 0.0885
R1051 VSS.n606 VSS.n605 0.0885
R1052 VSS.n605 VSS.n604 0.0885
R1053 VSS.n604 VSS.n603 0.0885
R1054 VSS.n601 VSS.n600 0.0885
R1055 VSS.n600 VSS.n599 0.0885
R1056 VSS.n599 VSS.n598 0.0885
R1057 VSS.n598 VSS.n597 0.0885
R1058 VSS.n597 VSS.n596 0.0885
R1059 VSS.n596 VSS.n595 0.0885
R1060 VSS.n595 VSS.n594 0.0885
R1061 VSS.n594 VSS.n593 0.0885
R1062 VSS.n591 VSS.n590 0.0885
R1063 VSS.n590 VSS.n589 0.0885
R1064 VSS.n589 VSS.n588 0.0885
R1065 VSS.n588 VSS.n587 0.0885
R1066 VSS.n587 VSS.n586 0.0885
R1067 VSS.n586 VSS.n585 0.0885
R1068 VSS.n585 VSS.n584 0.0885
R1069 VSS.n584 VSS.n583 0.0885
R1070 VSS.n459 VSS.n458 0.0885
R1071 VSS.n460 VSS.n459 0.0885
R1072 VSS.n461 VSS.n460 0.0885
R1073 VSS.n463 VSS.n461 0.0885
R1074 VSS.n463 VSS.n462 0.0885
R1075 VSS.n462 VSS.n455 0.0885
R1076 VSS.n443 VSS.n441 0.0885
R1077 VSS.n444 VSS.n443 0.0885
R1078 VSS.n445 VSS.n444 0.0885
R1079 VSS.n451 VSS.n450 0.0853311
R1080 VSS.n558 VSS.n546 0.0846837
R1081 VSS.n455 VSS.n454 0.0841
R1082 VSS.n500 VSS.n491 0.0817061
R1083 VSS.n499 VSS.n491 0.0817061
R1084 VSS.n497 VSS.n491 0.0817061
R1085 VSS.n496 VSS.n491 0.0817061
R1086 VSS.n495 VSS.n491 0.0817061
R1087 VSS.n493 VSS.n491 0.0817061
R1088 VSS.n439 VSS.n438 0.0814472
R1089 VSS.n478 VSS.n477 0.0794206
R1090 VSS.n479 VSS.n437 0.0784641
R1091 VSS.n556 VSS.n106 0.0779076
R1092 VSS.n547 VSS.n103 0.0779076
R1093 VSS.n549 VSS.n116 0.0779076
R1094 VSS.n252 VSS.n121 0.0779076
R1095 VSS.n248 VSS.n118 0.0779076
R1096 VSS.n246 VSS.n131 0.0779076
R1097 VSS.n476 VSS.n475 0.0776211
R1098 VSS.n488 VSS.n486 0.0773061
R1099 VSS.n320 VSS.n210 0.0759286
R1100 VSS.n328 VSS.n280 0.0759286
R1101 VSS.n326 VSS.n282 0.0759286
R1102 VSS.n324 VSS.n284 0.0759286
R1103 VSS.n322 VSS.n286 0.0759286
R1104 VSS.n303 VSS.n298 0.0759286
R1105 VSS.n309 VSS.n305 0.0759286
R1106 VSS.n306 VSS.n291 0.0759286
R1107 VSS.n314 VSS.n290 0.0759286
R1108 VSS.n315 VSS.n289 0.0759286
R1109 VSS.n591 VSS.n234 0.0759286
R1110 VSS.n590 VSS.n235 0.0759286
R1111 VSS.n589 VSS.n236 0.0759286
R1112 VSS.n587 VSS.n238 0.0759286
R1113 VSS.n585 VSS.n240 0.0759286
R1114 VSS.n601 VSS.n224 0.0759286
R1115 VSS.n600 VSS.n225 0.0759286
R1116 VSS.n599 VSS.n226 0.0759286
R1117 VSS.n597 VSS.n228 0.0759286
R1118 VSS.n595 VSS.n230 0.0759286
R1119 VSS.n614 VSS.n211 0.0759286
R1120 VSS.n611 VSS.n214 0.0759286
R1121 VSS.n610 VSS.n215 0.0759286
R1122 VSS.n609 VSS.n216 0.0759286
R1123 VSS.n607 VSS.n218 0.0759286
R1124 VSS.n605 VSS.n220 0.0759286
R1125 VSS.n365 VSS.n265 0.0759286
R1126 VSS.n364 VSS.n266 0.0759286
R1127 VSS.n362 VSS.n267 0.0759286
R1128 VSS.n263 VSS.n259 0.0759286
R1129 VSS.n261 VSS.n257 0.0759286
R1130 VSS.n345 VSS.n335 0.0759286
R1131 VSS.n337 VSS.n333 0.0759286
R1132 VSS.n356 VSS.n271 0.0759286
R1133 VSS.n353 VSS.n273 0.0759286
R1134 VSS.n351 VSS.n275 0.0759286
R1135 VSS.n462 VSS.n456 0.0759286
R1136 VSS.n464 VSS.n463 0.0759286
R1137 VSS.n465 VSS.n461 0.0759286
R1138 VSS.n466 VSS.n460 0.0759286
R1139 VSS.n467 VSS.n459 0.0759286
R1140 VSS.n468 VSS.n458 0.0759286
R1141 VSS.n470 VSS.n455 0.0759286
R1142 VSS.n446 VSS.n445 0.0759286
R1143 VSS.n447 VSS.n444 0.0759286
R1144 VSS.n448 VSS.n443 0.0759286
R1145 VSS.n449 VSS.n441 0.0759286
R1146 VSS.n575 VSS.n573 0.0753
R1147 VSS.n576 VSS.n575 0.0753
R1148 VSS.n475 VSS.n474 0.0750054
R1149 VSS.n478 VSS.n476 0.0725235
R1150 VSS.n481 VSS.n479 0.0721359
R1151 VSS.n477 VSS.n439 0.0711793
R1152 VSS.n438 VSS.n437 0.0686974
R1153 VSS.n481 VSS.n480 0.0675776
R1154 VSS.n621 VSS.n619 0.0663537
R1155 VSS.n469 VSS.n457 0.064985
R1156 VSS.n488 VSS.n487 0.061725
R1157 VSS.n619 VSS.n74 0.0608659
R1158 VSS.n622 VSS.n621 0.0608659
R1159 VSS.n558 VSS.n109 0.0594056
R1160 VSS.n373 VSS.n124 0.0594056
R1161 VSS.n556 VSS.n109 0.0586497
R1162 VSS.n252 VSS.n124 0.0586497
R1163 VSS.n484 VSS.n483 0.0581825
R1164 VSS.n546 VSS.n545 0.0566224
R1165 VSS.n194 VSS.n149 0.0529665
R1166 VSS.n362 VSS.n361 0.0528809
R1167 VSS.n615 VSS.n210 0.0518333
R1168 VSS.n136 VSS.n135 0.0518066
R1169 VSS.n193 VSS.n189 0.0517609
R1170 VSS.n442 VSS.n440 0.0511625
R1171 VSS.n175 VSS.n160 0.0509482
R1172 VSS.n167 VSS.n166 0.050601
R1173 VSS.n208 VSS.n207 0.0497426
R1174 VSS.n166 VSS.n164 0.0490925
R1175 VSS.n458 VSS.n457 0.0489
R1176 VSS.n195 VSS.n193 0.0480833
R1177 VSS.n181 VSS.n180 0.0479206
R1178 VSS.n137 VSS.n136 0.0474161
R1179 VSS.n361 VSS.n268 0.0473412
R1180 VSS.n139 VSS.n137 0.0470742
R1181 VSS.n200 VSS.n145 0.0469115
R1182 VSS.n206 VSS.n145 0.0467151
R1183 VSS.n482 VSS.n434 0.0464192
R1184 VSS.n195 VSS.n194 0.0464069
R1185 VSS.n581 VSS.n580 0.046273
R1186 VSS.n490 VSS.n489 0.0460827
R1187 VSS.n184 VSS.n181 0.0457059
R1188 VSS.n172 VSS.n164 0.0453978
R1189 VSS VSS.n648 0.0444024
R1190 VSS.n207 VSS.n206 0.0438839
R1191 VSS.n180 VSS.n160 0.0426784
R1192 VSS.n189 VSS.n188 0.0418656
R1193 VSS.n197 VSS.n149 0.04066
R1194 VSS.n435 VSS.n434 0.0397236
R1195 VSS.n620 VSS.n201 0.0396708
R1196 VSS.n554 VSS.n106 0.039409
R1197 VSS.n549 VSS.n103 0.039409
R1198 VSS.n374 VSS.n116 0.039409
R1199 VSS.n250 VSS.n121 0.039409
R1200 VSS.n246 VSS.n118 0.039409
R1201 VSS.n579 VSS.n131 0.039409
R1202 VSS.n562 VSS.n113 0.0391419
R1203 VSS.n574 VSS.n128 0.0391419
R1204 VSS.n618 VSS.n185 0.0389181
R1205 VSS.n554 VSS.n111 0.0386633
R1206 VSS.n250 VSS.n126 0.0386633
R1207 VSS.n483 VSS.n482 0.037474
R1208 VSS.n185 VSS.n184 0.0356341
R1209 VSS.n173 VSS.n172 0.0354567
R1210 VSS.n617 VSS.n616 0.0353
R1211 VSS.n140 VSS.n139 0.0351224
R1212 VSS.n201 VSS.n200 0.0348814
R1213 VSS.n480 VSS.n436 0.0320652
R1214 VSS.n330 VSS.n278 0.0302645
R1215 VSS.n318 VSS.n210 0.0298333
R1216 VSS.n316 VSS.n315 0.0298333
R1217 VSS.n315 VSS.n314 0.0298333
R1218 VSS.n308 VSS.n291 0.0298333
R1219 VSS.n309 VSS.n308 0.0298333
R1220 VSS.n298 VSS.n297 0.0298333
R1221 VSS.n301 VSS.n298 0.0298333
R1222 VSS.n299 VSS.n286 0.0298333
R1223 VSS.n286 VSS.n285 0.0298333
R1224 VSS.n284 VSS.n283 0.0298333
R1225 VSS.n283 VSS.n282 0.0298333
R1226 VSS.n281 VSS.n280 0.0298333
R1227 VSS.n280 VSS.n279 0.0298333
R1228 VSS.n623 VSS.n140 0.0273833
R1229 VSS.n174 VSS.n173 0.027049
R1230 VSS.n451 VSS.n441 0.0269
R1231 VSS.n572 VSS.n571 0.0254333
R1232 VSS.n498 VSS.n491 0.022573
R1233 VSS.n317 VSS.n316 0.0225
R1234 VSS.n313 VSS.n291 0.0225
R1235 VSS.n310 VSS.n297 0.0225
R1236 VSS.n300 VSS.n299 0.0225
R1237 VSS.n294 VSS.n284 0.0225
R1238 VSS.n292 VSS.n281 0.0225
R1239 VSS.n487 VSS.n433 0.0215435
R1240 VSS.n345 VSS.n344 0.0214524
R1241 VSS.n346 VSS.n345 0.0214524
R1242 VSS.n338 VSS.n333 0.0214524
R1243 VSS.n338 VSS.n276 0.0214524
R1244 VSS.n352 VSS.n351 0.0214524
R1245 VSS.n353 VSS.n352 0.0214524
R1246 VSS.n356 VSS.n355 0.0214524
R1247 VSS.n357 VSS.n356 0.0214524
R1248 VSS.n365 VSS.n364 0.0214524
R1249 VSS.n366 VSS.n365 0.0214524
R1250 VSS.n260 VSS.n259 0.0214524
R1251 VSS.n260 VSS.n257 0.0214524
R1252 VSS.n471 VSS.n454 0.0213089
R1253 VSS.n489 VSS.n433 0.0210652
R1254 VSS.n547 VSS.n113 0.0200602
R1255 VSS.n248 VSS.n128 0.0200602
R1256 VSS.n562 VSS.n111 0.0195816
R1257 VSS.n574 VSS.n126 0.0195816
R1258 VSS.n616 VSS.n209 0.0185
R1259 VSS.n312 VSS.n209 0.0185
R1260 VSS.n312 VSS.n311 0.0185
R1261 VSS.n311 VSS.n296 0.0185
R1262 VSS.n296 VSS.n295 0.0185
R1263 VSS.n295 VSS.n293 0.0185
R1264 VSS.n293 VSS.n277 0.0185
R1265 VSS.n331 VSS.n277 0.0185
R1266 VSS.n176 VSS.n174 0.0181516
R1267 VSS.n624 VSS.n623 0.0181516
R1268 VSS.n358 VSS.n268 0.0159153
R1269 VSS.n343 VSS.n342 0.0156425
R1270 VSS.n645 VSS.n644 0.0152453
R1271 VSS.n371 VSS.n370 0.0143286
R1272 VSS.n348 VSS.n332 0.0133571
R1273 VSS.n349 VSS.n348 0.0133571
R1274 VSS.n349 VSS.n269 0.0133571
R1275 VSS.n359 VSS.n269 0.0133571
R1276 VSS.n360 VSS.n359 0.0133571
R1277 VSS.n360 VSS.n258 0.0133571
R1278 VSS.n368 VSS.n258 0.0133571
R1279 VSS.n188 VSS.n155 0.0131147
R1280 VSS.n198 VSS.n197 0.0131147
R1281 VSS.n176 VSS.n175 0.0131058
R1282 VSS.n624 VSS.n208 0.0131058
R1283 VSS.n321 VSS.n287 0.0124467
R1284 VSS.n223 VSS.n222 0.0124467
R1285 VSS.n243 VSS.n242 0.0121878
R1286 VSS.n233 VSS.n232 0.0121878
R1287 VSS.n255 VSS.n244 0.0121878
R1288 VSS.n341 VSS.n340 0.0121878
R1289 VSS.n344 VSS.n343 0.0109762
R1290 VSS.n347 VSS.n346 0.0109762
R1291 VSS.n347 VSS.n333 0.0109762
R1292 VSS.n350 VSS.n276 0.0109762
R1293 VSS.n351 VSS.n350 0.0109762
R1294 VSS.n354 VSS.n353 0.0109762
R1295 VSS.n355 VSS.n354 0.0109762
R1296 VSS.n358 VSS.n357 0.0109762
R1297 VSS.n363 VSS.n362 0.0109762
R1298 VSS.n364 VSS.n363 0.0109762
R1299 VSS.n367 VSS.n366 0.0109762
R1300 VSS.n367 VSS.n259 0.0109762
R1301 VSS.n369 VSS.n257 0.0109762
R1302 VSS.n370 VSS.n369 0.0109762
R1303 VSS.n436 VSS.n435 0.0105435
R1304 VSS.n318 VSS.n317 0.00783333
R1305 VSS.n314 VSS.n313 0.00783333
R1306 VSS.n310 VSS.n309 0.00783333
R1307 VSS.n301 VSS.n300 0.00783333
R1308 VSS.n294 VSS.n285 0.00783333
R1309 VSS.n292 VSS.n282 0.00783333
R1310 VSS.n279 VSS.n278 0.00783333
R1311 VSS.n2 VSS.n0 0.00679447
R1312 VSS.n371 VSS.n245 0.00762381
R1313 VSS.n544 VSS.n387 0.00691667
R1314 VSS.n27 VSS.n14 0.00297714
R1315 VSS.n618 VSS.n155 0.00605046
R1316 VSS.n620 VSS.n198 0.00605046
R1317 VSS.n580 VSS.n245 0.00594762
R1318 VSS.n42 VSS.n508 0.00495229
R1319 VSS.n36 VSS.n510 0.00439839
R1320 VSS.n70 VSS.n55 0.00362425
R1321 VSS.n33 VSS.n15 0.00362425
R1322 VSS.n26 VSS.n507 0.00249993
R1323 VSS.n418 VSS.n417 0.002125
R1324 VSS.n418 VSS.n395 0.00187493
R1325 VSS.n510 VSS.n17 0.00166667
R1326 VSS.n40 VSS.n39 0.00169993
R1327 VSS.n508 VSS.n505 0.00166667
R1328 VSS.n507 VSS.n22 0.00166667
R1329 VSS.n420 VSS.n389 0.00166667
R1330 VSS.n62 VSS.n61 0.00169993
R1331 VSS.n65 VSS.n64 0.00169993
R1332 VSS.n400 VSS.n392 0.00166667
R1333 VSS.n399 VSS.n52 0.00166667
R1334 VSS.n398 VSS.n393 0.00166667
R1335 VSS.n397 VSS.n391 0.00166667
R1336 VSS.n73 VSS.n72 0.00169993
R1337 VSS.n417 VSS.n390 0.00166667
R1338 VSS.n396 VSS.n73 0.0015
R1339 VSS.n68 VSS.n397 0.00199997
R1340 VSS.n67 VSS.n66 0.00199984
R1341 VSS.n400 VSS.n66 0.0015
R1342 VSS.n401 VSS.n65 0.0015
R1343 VSS.n63 VSS.n402 0.00199997
R1344 VSS.n402 VSS.n62 0.0015
R1345 VSS.n60 VSS.n46 0.00199997
R1346 VSS.n59 VSS.n389 0.00199997
R1347 VSS.n71 VSS.n57 0.00199997
R1348 VSS.n68 VSS.n55 0.00199997
R1349 VSS.n63 VSS.n50 0.00199997
R1350 VSS.n60 VSS.n48 0.00199997
R1351 VSS.n59 VSS.n46 0.00199997
R1352 VSS.n38 VSS.n20 0.00199997
R1353 VSS.n31 VSS.n15 0.00199997
R1354 VSS.n53 VSS.n52 0.00183332
R1355 VSS.n23 VSS.n22 0.00183332
R1356 VSS.n18 VSS.n17 0.00183332
R1357 VSS.n643 VSS.n0 0.00151498
R1358 VSS.n8 VSS.n4 0.00150153
R1359 VSS.n12 VSS.n0 0.00147905
R1360 VSS.n509 VSS.n40 0.0015
R1361 VSS.n509 VSS.n505 0.00133332
R1362 VSS.n401 VSS.n392 0.00133332
R1363 VSS.n399 VSS.n393 0.00133332
R1364 VSS.n398 VSS.n391 0.00133332
R1365 VSS.n396 VSS.n390 0.00133332
R1366 VSS.n503 VSS.n0 0.0012742
R1367 VSS.n8 VSS.n6 0.00107833
R1368 VSS.n8 VSS.n3 0.00106804
R1369 VSS.n432 VSS.n0 0.0010482
R1370 VSS.n8 VSS.n7 0.00104178
R1371 VSS.n8 VSS.n5 0.00136978
R1372 VSS.t11 VSS.n1 9.12788
R1373 a_19774_346.n0 a_19774_346.t0 4.85847
R1374 a_19774_346.t15 a_19774_346.n2 4.83761
R1375 a_19774_346.n2 a_19774_346.t14 4.83657
R1376 a_19774_346.n2 a_19774_346.t13 4.83657
R1377 a_19774_346.n2 a_19774_346.t12 4.83657
R1378 a_19774_346.n1 a_19774_346.t11 4.83657
R1379 a_19774_346.n1 a_19774_346.t10 4.83657
R1380 a_19774_346.n1 a_19774_346.t9 4.83657
R1381 a_19774_346.n1 a_19774_346.t8 4.83657
R1382 a_19774_346.n1 a_19774_346.t7 4.83657
R1383 a_19774_346.n1 a_19774_346.t6 4.83657
R1384 a_19774_346.n1 a_19774_346.t5 4.83657
R1385 a_19774_346.n1 a_19774_346.t4 4.83657
R1386 a_19774_346.n0 a_19774_346.t3 4.83657
R1387 a_19774_346.n0 a_19774_346.t2 4.83657
R1388 a_19774_346.n0 a_19774_346.t1 4.83657
R1389 a_19774_346.n2 a_19774_346.t16 0.895788
R1390 a_19774_346.n1 a_19774_346.n0 0.175641
R1391 a_19774_346.n2 a_19774_346.n1 0.131856
R1392 a_11798_1860.n4 a_11798_1860.t18 3.17076
R1393 a_11798_1860.n5 a_11798_1860.t25 3.17076
R1394 a_11798_1860.n27 a_11798_1860.t21 2.79558
R1395 a_11798_1860.n10 a_11798_1860.t22 2.79558
R1396 a_11798_1860.n14 a_11798_1860.t28 2.79558
R1397 a_11798_1860.n23 a_11798_1860.t15 2.79551
R1398 a_11798_1860.n32 a_11798_1860.t16 2.7955
R1399 a_11798_1860.n24 a_11798_1860.t17 2.7955
R1400 a_11798_1860.n25 a_11798_1860.t19 2.7955
R1401 a_11798_1860.n26 a_11798_1860.t20 2.7955
R1402 a_11798_1860.n19 a_11798_1860.t23 2.7955
R1403 a_11798_1860.n11 a_11798_1860.t24 2.7955
R1404 a_11798_1860.n12 a_11798_1860.t26 2.7955
R1405 a_11798_1860.n13 a_11798_1860.t27 2.7955
R1406 a_11798_1860.t14 a_11798_1860.n8 2.61386
R1407 a_11798_1860.n1 a_11798_1860.t0 2.61074
R1408 a_11798_1860.n2 a_11798_1860.t9 2.56233
R1409 a_11798_1860.n2 a_11798_1860.t8 2.56233
R1410 a_11798_1860.n2 a_11798_1860.t6 2.5622
R1411 a_11798_1860.n1 a_11798_1860.t3 2.5622
R1412 a_11798_1860.n2 a_11798_1860.t7 2.56214
R1413 a_11798_1860.n8 a_11798_1860.t12 2.56207
R1414 a_11798_1860.n7 a_11798_1860.t10 2.56174
R1415 a_11798_1860.n7 a_11798_1860.t11 2.56173
R1416 a_11798_1860.n2 a_11798_1860.t5 2.56173
R1417 a_11798_1860.n1 a_11798_1860.t2 2.56173
R1418 a_11798_1860.n8 a_11798_1860.t13 2.56161
R1419 a_11798_1860.n2 a_11798_1860.t4 2.56161
R1420 a_11798_1860.n1 a_11798_1860.t1 2.56161
R1421 a_11798_1860.n27 a_11798_1860.n21 2.36008
R1422 a_11798_1860.n20 a_11798_1860.n10 2.36008
R1423 a_11798_1860.n14 a_11798_1860.n0 2.36008
R1424 a_11798_1860.n33 a_11798_1860.n23 2.35957
R1425 a_11798_1860.n33 a_11798_1860.n32 2.3402
R1426 a_11798_1860.n26 a_11798_1860.n21 2.3402
R1427 a_11798_1860.n20 a_11798_1860.n19 2.3402
R1428 a_11798_1860.n13 a_11798_1860.n0 2.3402
R1429 a_11798_1860.n25 a_11798_1860.n3 2.3138
R1430 a_11798_1860.n12 a_11798_1860.n0 2.3138
R1431 a_11798_1860.n24 a_11798_1860.n22 2.3138
R1432 a_11798_1860.n11 a_11798_1860.n9 2.3138
R1433 a_11798_1860.n31 a_11798_1860.n23 0.748603
R1434 a_11798_1860.n28 a_11798_1860.n27 0.74808
R1435 a_11798_1860.n18 a_11798_1860.n10 0.74808
R1436 a_11798_1860.n15 a_11798_1860.n14 0.74808
R1437 a_11798_1860.n32 a_11798_1860.n31 0.561174
R1438 a_11798_1860.n30 a_11798_1860.n24 0.561174
R1439 a_11798_1860.n29 a_11798_1860.n25 0.561174
R1440 a_11798_1860.n28 a_11798_1860.n26 0.561174
R1441 a_11798_1860.n19 a_11798_1860.n18 0.561174
R1442 a_11798_1860.n17 a_11798_1860.n11 0.561174
R1443 a_11798_1860.n16 a_11798_1860.n12 0.561174
R1444 a_11798_1860.n15 a_11798_1860.n13 0.561174
R1445 a_11798_1860.n4 a_11798_1860.n3 0.402048
R1446 a_11798_1860.n5 a_11798_1860.n0 0.402048
R1447 a_11798_1860.n5 a_11798_1860.n16 0.284105
R1448 a_11798_1860.n4 a_11798_1860.n29 0.284105
R1449 a_11798_1860.n1 a_11798_1860.n33 0.25306
R1450 a_11798_1860.n6 a_11798_1860.n21 0.0449208
R1451 a_11798_1860.n2 a_11798_1860.n20 0.25306
R1452 a_11798_1860.n2 a_11798_1860.n6 0.203345
R1453 a_11798_1860.n2 a_11798_1860.n1 0.196551
R1454 a_11798_1860.n7 a_11798_1860.n0 0.194161
R1455 a_11798_1860.n31 a_11798_1860.n30 0.1875
R1456 a_11798_1860.n30 a_11798_1860.n4 0.1875
R1457 a_11798_1860.n29 a_11798_1860.n28 0.1875
R1458 a_11798_1860.n18 a_11798_1860.n17 0.1875
R1459 a_11798_1860.n17 a_11798_1860.n5 0.1875
R1460 a_11798_1860.n16 a_11798_1860.n15 0.1875
R1461 a_11798_1860.n9 a_11798_1860.n0 0.153033
R1462 a_11798_1860.n22 a_11798_1860.n3 0.153033
R1463 a_11798_1860.n8 a_11798_1860.n7 0.147538
R1464 a_11798_1860.n7 a_11798_1860.n2 0.147538
R1465 a_11798_1860.n33 a_11798_1860.n22 0.106833
R1466 a_11798_1860.n3 a_11798_1860.n6 0.0449208
R1467 a_11798_1860.n20 a_11798_1860.n9 0.106833
R1468 a_5060_3702.n0 a_5060_3702.t4 53.6901
R1469 a_5060_3702.n3 a_5060_3702.t3 29.2688
R1470 a_5060_3702.n2 a_5060_3702.t5 24.2693
R1471 a_5060_3702.n1 a_5060_3702.t1 24.2693
R1472 a_5060_3702.t0 a_5060_3702.n3 15.6064
R1473 a_5060_3702.n0 a_5060_3702.t2 9.21754
R1474 a_5060_3702.n3 a_5060_3702.n2 1.7693
R1475 a_5060_3702.n2 a_5060_3702.n1 0.543167
R1476 a_5060_3702.n1 a_5060_3702.n0 0.320233
R1477 a_5560_4622.n0 a_5560_4622.t2 27.72
R1478 a_5560_4622.n0 a_5560_4622.t0 24.1197
R1479 a_5560_4622.t1 a_5560_4622.n0 9.38813
R1480 a_5560_6408.n0 a_5560_6408.t1 55.3005
R1481 a_5560_6408.n0 a_5560_6408.t0 27.8842
R1482 a_5560_6408.t2 a_5560_6408.n0 7.50485
R1483 a_5060_6408.n0 a_5060_6408.t1 34.3045
R1484 a_5060_6408.t0 a_5060_6408.n0 5.85564
R1485 a_5060_6408.t0 a_5060_6408.n0 5.85498
R1486 a_6568_6836.n2 a_6568_6836.t2 19.9393
R1487 a_6568_6836.n0 a_6568_6836.t4 19.6783
R1488 a_6568_6836.n1 a_6568_6836.t0 17.974
R1489 a_6568_6836.n2 a_6568_6836.n1 5.04317
R1490 a_6568_6836.n0 a_6568_6836.t1 4.81727
R1491 a_6568_6836.n1 a_6568_6836.n0 4.76157
R1492 a_6568_6836.t3 a_6568_6836.n2 3.15445
R1493 a_5948_5116.n0 a_5948_5116.t2 30.2902
R1494 a_5948_5116.n0 a_5948_5116.t0 27.2706
R1495 a_5948_5116.t1 a_5948_5116.n0 11.5346
R1496 vco_feed_0.en_b.n0 vco_feed_0.en_b.t0 27.1774
R1497 vco_feed_0.en_b.n4 vco_feed_0.en_b.t6 24.9608
R1498 vco_feed_0.en_b.n3 vco_feed_0.en_b.t3 24.8442
R1499 vco_feed_0.en_b.n1 vco_feed_0.en_b.t7 20.7725
R1500 vco_feed_0.en_b.n1 vco_feed_0.en_b.t5 20.4909
R1501 vco_feed_0.en_b.n0 vco_feed_0.en_b.t4 20.4287
R1502 vco_feed_0.en_b.n0 vco_feed_0.en_b.t1 12.1418
R1503 vco_feed_0.en_b vco_feed_0.en_b.t2 5.74905
R1504 vco_feed_0.en_b.n2 vco_feed_0.en_b.n1 5.30277
R1505 vco_feed_0.en_b.n2 vco_feed_0.en_b.n0 4.5269
R1506 vco_feed_0.en_b vco_feed_0.en_b.n4 2.33103
R1507 vco_feed_0.en_b.n3 vco_feed_0.en_b.n2 0.562233
R1508 vco_feed_0.en_b.n4 vco_feed_0.en_b.n3 0.469833
R1509 vco_feed_0.vdd_core.n213 vco_feed_0.vdd_core.n7 9.0005
R1510 vco_feed_0.vdd_core.n205 vco_feed_0.vdd_core.t9 6.57599
R1511 vco_feed_0.vdd_core.n5 vco_feed_0.vdd_core.t12 6.57599
R1512 vco_feed_0.vdd_core.n216 vco_feed_0.vdd_core.t20 6.5301
R1513 vco_feed_0.vdd_core.n209 vco_feed_0.vdd_core.t5 6.52949
R1514 vco_feed_0.vdd_core.n209 vco_feed_0.vdd_core.t3 6.52949
R1515 vco_feed_0.vdd_core.n205 vco_feed_0.vdd_core.t7 6.52949
R1516 vco_feed_0.vdd_core.n209 vco_feed_0.vdd_core.t1 6.52949
R1517 vco_feed_0.vdd_core.n216 vco_feed_0.vdd_core.t18 6.52949
R1518 vco_feed_0.vdd_core.n216 vco_feed_0.vdd_core.t16 6.52949
R1519 vco_feed_0.vdd_core.n5 vco_feed_0.vdd_core.t14 6.52949
R1520 vco_feed_0.vdd_core.n20 vco_feed_0.vdd_core.n19 6.52948
R1521 vco_feed_0.vdd_core.n74 vco_feed_0.vdd_core.n54 6.52948
R1522 vco_feed_0.vdd_core.n35 vco_feed_0.vdd_core.n34 6.47038
R1523 vco_feed_0.vdd_core.n76 vco_feed_0.vdd_core.n53 6.47038
R1524 vco_feed_0.vdd_core.n110 vco_feed_0.vdd_core.n109 6.05177
R1525 vco_feed_0.vdd_core.n113 vco_feed_0.vdd_core.n112 6.00132
R1526 vco_feed_0.vdd_core.n210 vco_feed_0.vdd_core.t11 4.17215
R1527 vco_feed_0.vdd_core.n215 vco_feed_0.vdd_core.t0 4.00827
R1528 vco_feed_0.vdd_core.n206 vco_feed_0.vdd_core.t23 3.41873
R1529 vco_feed_0.vdd_core.n207 vco_feed_0.vdd_core.t25 3.41873
R1530 vco_feed_0.vdd_core.n208 vco_feed_0.vdd_core.t27 3.41873
R1531 vco_feed_0.vdd_core.n219 vco_feed_0.vdd_core.t24 3.39968
R1532 vco_feed_0.vdd_core.n218 vco_feed_0.vdd_core.t26 3.39968
R1533 vco_feed_0.vdd_core.n217 vco_feed_0.vdd_core.t28 3.39968
R1534 vco_feed_0.vdd_core.n214 vco_feed_0.vdd_core.n6 1.36338
R1535 vco_feed_0.vdd_core.n214 vco_feed_0.vdd_core.n213 1.30181
R1536 vco_feed_0.vdd_core.n213 vco_feed_0.vdd_core.n212 1.28621
R1537 vco_feed_0.vdd_core.n1 vco_feed_0.vdd_core.n0 0.0252705
R1538 vco_feed_0.vdd_core.n0 vco_feed_0.vdd_core.n211 0.793488
R1539 vco_feed_0.vdd_core.n122 vco_feed_0.vdd_core.t22 0.770099
R1540 vco_feed_0.vdd_core.n211 vco_feed_0.vdd_core 0.632687
R1541 vco_feed_0.vdd_core vco_feed_0.vdd_core.n122 0.627294
R1542 vco_feed_0.vdd_core.n204 vco_feed_0.vdd_core.n9 0.56175
R1543 vco_feed_0.vdd_core.n204 vco_feed_0.vdd_core.n203 0.5505
R1544 vco_feed_0.vdd_core.n177 vco_feed_0.vdd_core.n176 0.5505
R1545 vco_feed_0.vdd_core.n179 vco_feed_0.vdd_core.n178 0.5505
R1546 vco_feed_0.vdd_core.n182 vco_feed_0.vdd_core.n58 0.5505
R1547 vco_feed_0.vdd_core.n186 vco_feed_0.vdd_core.n185 0.5505
R1548 vco_feed_0.vdd_core.n188 vco_feed_0.vdd_core.n187 0.5505
R1549 vco_feed_0.vdd_core.n190 vco_feed_0.vdd_core.n44 0.5505
R1550 vco_feed_0.vdd_core.n195 vco_feed_0.vdd_core.n194 0.5505
R1551 vco_feed_0.vdd_core.n197 vco_feed_0.vdd_core.n196 0.5505
R1552 vco_feed_0.vdd_core.n200 vco_feed_0.vdd_core.n8 0.5505
R1553 vco_feed_0.vdd_core.n139 vco_feed_0.vdd_core.n123 0.5505
R1554 vco_feed_0.vdd_core.n144 vco_feed_0.vdd_core.n143 0.5505
R1555 vco_feed_0.vdd_core.n146 vco_feed_0.vdd_core.n145 0.5505
R1556 vco_feed_0.vdd_core.n150 vco_feed_0.vdd_core.n96 0.5505
R1557 vco_feed_0.vdd_core.n155 vco_feed_0.vdd_core.n154 0.5505
R1558 vco_feed_0.vdd_core.n157 vco_feed_0.vdd_core.n156 0.5505
R1559 vco_feed_0.vdd_core.n161 vco_feed_0.vdd_core.n81 0.5505
R1560 vco_feed_0.vdd_core.n166 vco_feed_0.vdd_core.n165 0.5505
R1561 vco_feed_0.vdd_core vco_feed_0.vdd_core.n214 0.504298
R1562 vco_feed_0.vdd_core.n138 vco_feed_0.vdd_core.n137 0.446709
R1563 vco_feed_0.vdd_core.n138 vco_feed_0.vdd_core.n136 0.445751
R1564 vco_feed_0.vdd_core.n92 vco_feed_0.vdd_core.n90 0.4405
R1565 vco_feed_0.vdd_core.n91 vco_feed_0.vdd_core.n89 0.4405
R1566 vco_feed_0.vdd_core.n30 vco_feed_0.vdd_core.n18 0.4405
R1567 vco_feed_0.vdd_core.n22 vco_feed_0.vdd_core.n21 0.4405
R1568 vco_feed_0.vdd_core.n63 vco_feed_0.vdd_core.n56 0.4405
R1569 vco_feed_0.vdd_core.n61 vco_feed_0.vdd_core.n55 0.4405
R1570 vco_feed_0.vdd_core.n90 vco_feed_0.vdd_core.n88 0.4405
R1571 vco_feed_0.vdd_core.n89 vco_feed_0.vdd_core.n87 0.4405
R1572 vco_feed_0.vdd_core.n34 vco_feed_0.vdd_core.n18 0.4405
R1573 vco_feed_0.vdd_core.n21 vco_feed_0.vdd_core.n20 0.4405
R1574 vco_feed_0.vdd_core.n56 vco_feed_0.vdd_core.n53 0.4405
R1575 vco_feed_0.vdd_core.n55 vco_feed_0.vdd_core.n54 0.4405
R1576 vco_feed_0.vdd_core.n104 vco_feed_0.vdd_core.n103 0.3635
R1577 vco_feed_0.vdd_core.n105 vco_feed_0.vdd_core.n104 0.3635
R1578 vco_feed_0.vdd_core.n116 vco_feed_0.vdd_core.n114 0.3635
R1579 vco_feed_0.vdd_core.n118 vco_feed_0.vdd_core.n116 0.3635
R1580 vco_feed_0.vdd_core.n131 vco_feed_0.vdd_core.n130 0.3635
R1581 vco_feed_0.vdd_core.n132 vco_feed_0.vdd_core.n131 0.3635
R1582 vco_feed_0.vdd_core.n87 vco_feed_0.vdd_core.n85 0.3635
R1583 vco_feed_0.vdd_core.n101 vco_feed_0.vdd_core.n100 0.3635
R1584 vco_feed_0.vdd_core.n101 vco_feed_0.vdd_core.n99 0.3635
R1585 vco_feed_0.vdd_core.n115 vco_feed_0.vdd_core.n111 0.3635
R1586 vco_feed_0.vdd_core.n117 vco_feed_0.vdd_core.n115 0.3635
R1587 vco_feed_0.vdd_core.n128 vco_feed_0.vdd_core.n127 0.3635
R1588 vco_feed_0.vdd_core.n128 vco_feed_0.vdd_core.n126 0.3635
R1589 vco_feed_0.vdd_core.n28 vco_feed_0.vdd_core.n27 0.3635
R1590 vco_feed_0.vdd_core.n27 vco_feed_0.vdd_core.n11 0.3635
R1591 vco_feed_0.vdd_core.n38 vco_feed_0.vdd_core.n36 0.3635
R1592 vco_feed_0.vdd_core.n40 vco_feed_0.vdd_core.n38 0.3635
R1593 vco_feed_0.vdd_core.n50 vco_feed_0.vdd_core.n49 0.3635
R1594 vco_feed_0.vdd_core.n50 vco_feed_0.vdd_core.n46 0.3635
R1595 vco_feed_0.vdd_core.n25 vco_feed_0.vdd_core.n24 0.3635
R1596 vco_feed_0.vdd_core.n24 vco_feed_0.vdd_core.n10 0.3635
R1597 vco_feed_0.vdd_core.n37 vco_feed_0.vdd_core.n17 0.3635
R1598 vco_feed_0.vdd_core.n39 vco_feed_0.vdd_core.n37 0.3635
R1599 vco_feed_0.vdd_core.n48 vco_feed_0.vdd_core.n47 0.3635
R1600 vco_feed_0.vdd_core.n48 vco_feed_0.vdd_core.n45 0.3635
R1601 vco_feed_0.vdd_core.n67 vco_feed_0.vdd_core.n60 0.3635
R1602 vco_feed_0.vdd_core.n69 vco_feed_0.vdd_core.n67 0.3635
R1603 vco_feed_0.vdd_core.n79 vco_feed_0.vdd_core.n77 0.3635
R1604 vco_feed_0.vdd_core.n171 vco_feed_0.vdd_core.n79 0.3635
R1605 vco_feed_0.vdd_core.n174 vco_feed_0.vdd_core.n168 0.3635
R1606 vco_feed_0.vdd_core.n2 vco_feed_0.vdd_core.n174 0.421153
R1607 vco_feed_0.vdd_core.n66 vco_feed_0.vdd_core.n59 0.3635
R1608 vco_feed_0.vdd_core.n68 vco_feed_0.vdd_core.n66 0.3635
R1609 vco_feed_0.vdd_core.n78 vco_feed_0.vdd_core.n75 0.3635
R1610 vco_feed_0.vdd_core.n169 vco_feed_0.vdd_core.n78 0.3635
R1611 vco_feed_0.vdd_core.n52 vco_feed_0.vdd_core.n45 0.345639
R1612 vco_feed_0.vdd_core.n209 vco_feed_0.vdd_core.n208 0.33314
R1613 vco_feed_0.vdd_core.n215 vco_feed_0.vdd_core 0.31895
R1614 vco_feed_0.vdd_core vco_feed_0.vdd_core.n210 0.306786
R1615 vco_feed_0.vdd_core.n192 vco_feed_0.vdd_core.n191 0.299759
R1616 vco_feed_0.vdd_core.n218 vco_feed_0.vdd_core.n217 0.29442
R1617 vco_feed_0.vdd_core.n208 vco_feed_0.vdd_core.n207 0.29442
R1618 vco_feed_0.vdd_core.n219 vco_feed_0.vdd_core.n218 0.29442
R1619 vco_feed_0.vdd_core.n207 vco_feed_0.vdd_core.n206 0.29442
R1620 vco_feed_0.vdd_core vco_feed_0.vdd_core.n204 0.2855
R1621 vco_feed_0.vdd_core.n112 vco_feed_0.vdd_core.n84 0.276447
R1622 vco_feed_0.vdd_core.n88 vco_feed_0.vdd_core.n86 0.276447
R1623 vco_feed_0.vdd_core.n94 vco_feed_0.vdd_core.n92 0.276447
R1624 vco_feed_0.vdd_core.n103 vco_feed_0.vdd_core.n94 0.276447
R1625 vco_feed_0.vdd_core.n106 vco_feed_0.vdd_core.n105 0.276447
R1626 vco_feed_0.vdd_core.n120 vco_feed_0.vdd_core.n118 0.276447
R1627 vco_feed_0.vdd_core.n130 vco_feed_0.vdd_core.n120 0.276447
R1628 vco_feed_0.vdd_core.n133 vco_feed_0.vdd_core.n132 0.276447
R1629 vco_feed_0.vdd_core.n137 vco_feed_0.vdd_core.n135 0.276447
R1630 vco_feed_0.vdd_core.n109 vco_feed_0.vdd_core.n83 0.276447
R1631 vco_feed_0.vdd_core.n93 vco_feed_0.vdd_core.n91 0.276447
R1632 vco_feed_0.vdd_core.n100 vco_feed_0.vdd_core.n93 0.276447
R1633 vco_feed_0.vdd_core.n99 vco_feed_0.vdd_core.n98 0.276447
R1634 vco_feed_0.vdd_core.n119 vco_feed_0.vdd_core.n117 0.276447
R1635 vco_feed_0.vdd_core.n127 vco_feed_0.vdd_core.n119 0.276447
R1636 vco_feed_0.vdd_core.n126 vco_feed_0.vdd_core.n125 0.276447
R1637 vco_feed_0.vdd_core.n136 vco_feed_0.vdd_core.n134 0.276447
R1638 vco_feed_0.vdd_core.n30 vco_feed_0.vdd_core.n29 0.276188
R1639 vco_feed_0.vdd_core.n29 vco_feed_0.vdd_core.n28 0.276188
R1640 vco_feed_0.vdd_core.n14 vco_feed_0.vdd_core.n11 0.276188
R1641 vco_feed_0.vdd_core.n42 vco_feed_0.vdd_core.n40 0.276188
R1642 vco_feed_0.vdd_core.n49 vco_feed_0.vdd_core.n42 0.276188
R1643 vco_feed_0.vdd_core.n192 vco_feed_0.vdd_core.n46 0.276188
R1644 vco_feed_0.vdd_core.n23 vco_feed_0.vdd_core.n22 0.276188
R1645 vco_feed_0.vdd_core.n25 vco_feed_0.vdd_core.n23 0.276188
R1646 vco_feed_0.vdd_core.n13 vco_feed_0.vdd_core.n10 0.276188
R1647 vco_feed_0.vdd_core.n41 vco_feed_0.vdd_core.n39 0.276188
R1648 vco_feed_0.vdd_core.n47 vco_feed_0.vdd_core.n41 0.276188
R1649 vco_feed_0.vdd_core.n64 vco_feed_0.vdd_core.n63 0.276188
R1650 vco_feed_0.vdd_core.n64 vco_feed_0.vdd_core.n60 0.276188
R1651 vco_feed_0.vdd_core.n71 vco_feed_0.vdd_core.n69 0.276188
R1652 vco_feed_0.vdd_core.n172 vco_feed_0.vdd_core.n171 0.276188
R1653 vco_feed_0.vdd_core.n172 vco_feed_0.vdd_core.n168 0.276188
R1654 vco_feed_0.vdd_core.n62 vco_feed_0.vdd_core.n61 0.276188
R1655 vco_feed_0.vdd_core.n62 vco_feed_0.vdd_core.n59 0.276188
R1656 vco_feed_0.vdd_core.n70 vco_feed_0.vdd_core.n68 0.276188
R1657 vco_feed_0.vdd_core.n170 vco_feed_0.vdd_core.n169 0.276188
R1658 vco_feed_0.vdd_core.n170 vco_feed_0.vdd_core.n167 0.276188
R1659 vco_feed_0.vdd_core.n114 vco_feed_0.vdd_core.n113 0.2645
R1660 vco_feed_0.vdd_core.n111 vco_feed_0.vdd_core.n110 0.2645
R1661 vco_feed_0.vdd_core.n36 vco_feed_0.vdd_core.n35 0.2645
R1662 vco_feed_0.vdd_core.n19 vco_feed_0.vdd_core.n17 0.2645
R1663 vco_feed_0.vdd_core.n77 vco_feed_0.vdd_core.n76 0.2645
R1664 vco_feed_0.vdd_core.n75 vco_feed_0.vdd_core.n74 0.2645
R1665 vco_feed_0.vdd_core.n86 vco_feed_0.vdd_core.n84 0.199447
R1666 vco_feed_0.vdd_core.n108 vco_feed_0.vdd_core.n106 0.199447
R1667 vco_feed_0.vdd_core.n135 vco_feed_0.vdd_core.n133 0.199447
R1668 vco_feed_0.vdd_core.n85 vco_feed_0.vdd_core.n83 0.199447
R1669 vco_feed_0.vdd_core.n107 vco_feed_0.vdd_core.n98 0.199447
R1670 vco_feed_0.vdd_core.n134 vco_feed_0.vdd_core.n125 0.199447
R1671 vco_feed_0.vdd_core.n16 vco_feed_0.vdd_core.n14 0.199188
R1672 vco_feed_0.vdd_core.n15 vco_feed_0.vdd_core.n13 0.199188
R1673 vco_feed_0.vdd_core.n73 vco_feed_0.vdd_core.n71 0.199188
R1674 vco_feed_0.vdd_core.n72 vco_feed_0.vdd_core.n70 0.199188
R1675 vco_feed_0.vdd_core.n217 vco_feed_0.vdd_core.n216 0.175092
R1676 vco_feed_0.vdd_core.n122 vco_feed_0.vdd_core 0.17474
R1677 vco_feed_0.vdd_core.n210 vco_feed_0.vdd_core.n209 0.102521
R1678 vco_feed_0.vdd_core.n4 vco_feed_0.vdd_core.n166 0.1019
R1679 vco_feed_0.vdd_core.n164 vco_feed_0.vdd_core.n84 0.101071
R1680 vco_feed_0.vdd_core.n163 vco_feed_0.vdd_core.n86 0.101071
R1681 vco_feed_0.vdd_core.n158 vco_feed_0.vdd_core.n94 0.101071
R1682 vco_feed_0.vdd_core.n104 vco_feed_0.vdd_core.n102 0.101071
R1683 vco_feed_0.vdd_core.n153 vco_feed_0.vdd_core.n106 0.101071
R1684 vco_feed_0.vdd_core.n152 vco_feed_0.vdd_core.n108 0.101071
R1685 vco_feed_0.vdd_core.n149 vco_feed_0.vdd_core.n116 0.101071
R1686 vco_feed_0.vdd_core.n147 vco_feed_0.vdd_core.n120 0.101071
R1687 vco_feed_0.vdd_core.n131 vco_feed_0.vdd_core.n129 0.101071
R1688 vco_feed_0.vdd_core.n142 vco_feed_0.vdd_core.n133 0.101071
R1689 vco_feed_0.vdd_core.n141 vco_feed_0.vdd_core.n135 0.101071
R1690 vco_feed_0.vdd_core.n164 vco_feed_0.vdd_core.n83 0.101071
R1691 vco_feed_0.vdd_core.n163 vco_feed_0.vdd_core.n85 0.101071
R1692 vco_feed_0.vdd_core.n158 vco_feed_0.vdd_core.n93 0.101071
R1693 vco_feed_0.vdd_core.n102 vco_feed_0.vdd_core.n101 0.101071
R1694 vco_feed_0.vdd_core.n153 vco_feed_0.vdd_core.n98 0.101071
R1695 vco_feed_0.vdd_core.n152 vco_feed_0.vdd_core.n107 0.101071
R1696 vco_feed_0.vdd_core.n149 vco_feed_0.vdd_core.n115 0.101071
R1697 vco_feed_0.vdd_core.n147 vco_feed_0.vdd_core.n119 0.101071
R1698 vco_feed_0.vdd_core.n129 vco_feed_0.vdd_core.n128 0.101071
R1699 vco_feed_0.vdd_core.n142 vco_feed_0.vdd_core.n125 0.101071
R1700 vco_feed_0.vdd_core.n141 vco_feed_0.vdd_core.n134 0.101071
R1701 vco_feed_0.vdd_core.n29 vco_feed_0.vdd_core.n9 0.101071
R1702 vco_feed_0.vdd_core.n27 vco_feed_0.vdd_core.n12 0.101071
R1703 vco_feed_0.vdd_core.n202 vco_feed_0.vdd_core.n14 0.101071
R1704 vco_feed_0.vdd_core.n201 vco_feed_0.vdd_core.n16 0.101071
R1705 vco_feed_0.vdd_core.n199 vco_feed_0.vdd_core.n38 0.101071
R1706 vco_feed_0.vdd_core.n197 vco_feed_0.vdd_core.n42 0.101071
R1707 vco_feed_0.vdd_core.n51 vco_feed_0.vdd_core.n50 0.101071
R1708 vco_feed_0.vdd_core.n193 vco_feed_0.vdd_core.n192 0.101071
R1709 vco_feed_0.vdd_core.n23 vco_feed_0.vdd_core.n9 0.101071
R1710 vco_feed_0.vdd_core.n24 vco_feed_0.vdd_core.n12 0.101071
R1711 vco_feed_0.vdd_core.n202 vco_feed_0.vdd_core.n13 0.101071
R1712 vco_feed_0.vdd_core.n201 vco_feed_0.vdd_core.n15 0.101071
R1713 vco_feed_0.vdd_core.n199 vco_feed_0.vdd_core.n37 0.101071
R1714 vco_feed_0.vdd_core.n197 vco_feed_0.vdd_core.n41 0.101071
R1715 vco_feed_0.vdd_core.n51 vco_feed_0.vdd_core.n48 0.101071
R1716 vco_feed_0.vdd_core.n65 vco_feed_0.vdd_core.n64 0.101071
R1717 vco_feed_0.vdd_core.n184 vco_feed_0.vdd_core.n67 0.101071
R1718 vco_feed_0.vdd_core.n182 vco_feed_0.vdd_core.n71 0.101071
R1719 vco_feed_0.vdd_core.n181 vco_feed_0.vdd_core.n73 0.101071
R1720 vco_feed_0.vdd_core.n179 vco_feed_0.vdd_core.n79 0.101071
R1721 vco_feed_0.vdd_core.n173 vco_feed_0.vdd_core.n172 0.101071
R1722 vco_feed_0.vdd_core.n175 vco_feed_0.vdd_core.n174 0.101071
R1723 vco_feed_0.vdd_core.n65 vco_feed_0.vdd_core.n62 0.101071
R1724 vco_feed_0.vdd_core.n184 vco_feed_0.vdd_core.n66 0.101071
R1725 vco_feed_0.vdd_core.n182 vco_feed_0.vdd_core.n70 0.101071
R1726 vco_feed_0.vdd_core.n181 vco_feed_0.vdd_core.n72 0.101071
R1727 vco_feed_0.vdd_core.n179 vco_feed_0.vdd_core.n78 0.101071
R1728 vco_feed_0.vdd_core.n173 vco_feed_0.vdd_core.n170 0.101071
R1729 vco_feed_0.vdd_core.n175 vco_feed_0.vdd_core.n3 0.00761283
R1730 vco_feed_0.vdd_core.n216 vco_feed_0.vdd_core.n215 0.0955774
R1731 vco_feed_0.vdd_core.n7 vco_feed_0.vdd_core.n6 0.0929
R1732 vco_feed_0.vdd_core.n109 vco_feed_0.vdd_core.n82 0.0759286
R1733 vco_feed_0.vdd_core.n112 vco_feed_0.vdd_core.n82 0.0759286
R1734 vco_feed_0.vdd_core.n140 vco_feed_0.vdd_core.n137 0.0759286
R1735 vco_feed_0.vdd_core.n132 vco_feed_0.vdd_core.n124 0.0759286
R1736 vco_feed_0.vdd_core.n130 vco_feed_0.vdd_core.n121 0.0759286
R1737 vco_feed_0.vdd_core.n148 vco_feed_0.vdd_core.n118 0.0759286
R1738 vco_feed_0.vdd_core.n151 vco_feed_0.vdd_core.n114 0.0759286
R1739 vco_feed_0.vdd_core.n105 vco_feed_0.vdd_core.n97 0.0759286
R1740 vco_feed_0.vdd_core.n103 vco_feed_0.vdd_core.n95 0.0759286
R1741 vco_feed_0.vdd_core.n159 vco_feed_0.vdd_core.n92 0.0759286
R1742 vco_feed_0.vdd_core.n160 vco_feed_0.vdd_core.n90 0.0759286
R1743 vco_feed_0.vdd_core.n162 vco_feed_0.vdd_core.n88 0.0759286
R1744 vco_feed_0.vdd_core.n140 vco_feed_0.vdd_core.n136 0.0759286
R1745 vco_feed_0.vdd_core.n126 vco_feed_0.vdd_core.n124 0.0759286
R1746 vco_feed_0.vdd_core.n127 vco_feed_0.vdd_core.n121 0.0759286
R1747 vco_feed_0.vdd_core.n148 vco_feed_0.vdd_core.n117 0.0759286
R1748 vco_feed_0.vdd_core.n151 vco_feed_0.vdd_core.n111 0.0759286
R1749 vco_feed_0.vdd_core.n99 vco_feed_0.vdd_core.n97 0.0759286
R1750 vco_feed_0.vdd_core.n100 vco_feed_0.vdd_core.n95 0.0759286
R1751 vco_feed_0.vdd_core.n162 vco_feed_0.vdd_core.n87 0.0759286
R1752 vco_feed_0.vdd_core.n160 vco_feed_0.vdd_core.n89 0.0759286
R1753 vco_feed_0.vdd_core.n159 vco_feed_0.vdd_core.n91 0.0759286
R1754 vco_feed_0.vdd_core.n33 vco_feed_0.vdd_core.n20 0.0759286
R1755 vco_feed_0.vdd_core.n34 vco_feed_0.vdd_core.n33 0.0759286
R1756 vco_feed_0.vdd_core.n194 vco_feed_0.vdd_core.n46 0.0759286
R1757 vco_feed_0.vdd_core.n49 vco_feed_0.vdd_core.n43 0.0759286
R1758 vco_feed_0.vdd_core.n198 vco_feed_0.vdd_core.n40 0.0759286
R1759 vco_feed_0.vdd_core.n200 vco_feed_0.vdd_core.n36 0.0759286
R1760 vco_feed_0.vdd_core.n203 vco_feed_0.vdd_core.n11 0.0759286
R1761 vco_feed_0.vdd_core.n28 vco_feed_0.vdd_core.n26 0.0759286
R1762 vco_feed_0.vdd_core.n31 vco_feed_0.vdd_core.n30 0.0759286
R1763 vco_feed_0.vdd_core.n32 vco_feed_0.vdd_core.n18 0.0759286
R1764 vco_feed_0.vdd_core.n194 vco_feed_0.vdd_core.n45 0.0759286
R1765 vco_feed_0.vdd_core.n47 vco_feed_0.vdd_core.n43 0.0759286
R1766 vco_feed_0.vdd_core.n198 vco_feed_0.vdd_core.n39 0.0759286
R1767 vco_feed_0.vdd_core.n200 vco_feed_0.vdd_core.n17 0.0759286
R1768 vco_feed_0.vdd_core.n203 vco_feed_0.vdd_core.n10 0.0759286
R1769 vco_feed_0.vdd_core.n26 vco_feed_0.vdd_core.n25 0.0759286
R1770 vco_feed_0.vdd_core.n32 vco_feed_0.vdd_core.n21 0.0759286
R1771 vco_feed_0.vdd_core.n31 vco_feed_0.vdd_core.n22 0.0759286
R1772 vco_feed_0.vdd_core.n189 vco_feed_0.vdd_core.n54 0.0759286
R1773 vco_feed_0.vdd_core.n189 vco_feed_0.vdd_core.n53 0.0759286
R1774 vco_feed_0.vdd_core.n176 vco_feed_0.vdd_core.n168 0.0759286
R1775 vco_feed_0.vdd_core.n171 vco_feed_0.vdd_core.n80 0.0759286
R1776 vco_feed_0.vdd_core.n180 vco_feed_0.vdd_core.n77 0.0759286
R1777 vco_feed_0.vdd_core.n183 vco_feed_0.vdd_core.n69 0.0759286
R1778 vco_feed_0.vdd_core.n185 vco_feed_0.vdd_core.n60 0.0759286
R1779 vco_feed_0.vdd_core.n63 vco_feed_0.vdd_core.n57 0.0759286
R1780 vco_feed_0.vdd_core.n188 vco_feed_0.vdd_core.n56 0.0759286
R1781 vco_feed_0.vdd_core.n3 vco_feed_0.vdd_core.n167 0.439821
R1782 vco_feed_0.vdd_core.n176 vco_feed_0.vdd_core.n167 0.0759286
R1783 vco_feed_0.vdd_core.n169 vco_feed_0.vdd_core.n80 0.0759286
R1784 vco_feed_0.vdd_core.n180 vco_feed_0.vdd_core.n75 0.0759286
R1785 vco_feed_0.vdd_core.n183 vco_feed_0.vdd_core.n68 0.0759286
R1786 vco_feed_0.vdd_core.n185 vco_feed_0.vdd_core.n59 0.0759286
R1787 vco_feed_0.vdd_core.n188 vco_feed_0.vdd_core.n55 0.0759286
R1788 vco_feed_0.vdd_core.n61 vco_feed_0.vdd_core.n57 0.0759286
R1789 vco_feed_0.vdd_core.n190 vco_feed_0.vdd_core.n189 0.0738333
R1790 vco_feed_0.vdd_core.n1 vco_feed_0.vdd_core.n7 1.45898
R1791 vco_feed_0.vdd_core.n123 vco_feed_0.vdd_core 0.038
R1792 vco_feed_0.vdd_core.n209 vco_feed_0.vdd_core.n205 0.0378886
R1793 vco_feed_0.vdd_core.n216 vco_feed_0.vdd_core.n5 0.0378886
R1794 vco_feed_0.vdd_core.n141 vco_feed_0.vdd_core.n140 0.0371667
R1795 vco_feed_0.vdd_core.n142 vco_feed_0.vdd_core.n141 0.0371667
R1796 vco_feed_0.vdd_core.n129 vco_feed_0.vdd_core.n124 0.0371667
R1797 vco_feed_0.vdd_core.n129 vco_feed_0.vdd_core.n121 0.0371667
R1798 vco_feed_0.vdd_core.n148 vco_feed_0.vdd_core.n147 0.0371667
R1799 vco_feed_0.vdd_core.n149 vco_feed_0.vdd_core.n148 0.0371667
R1800 vco_feed_0.vdd_core.n152 vco_feed_0.vdd_core.n151 0.0371667
R1801 vco_feed_0.vdd_core.n153 vco_feed_0.vdd_core.n152 0.0371667
R1802 vco_feed_0.vdd_core.n102 vco_feed_0.vdd_core.n97 0.0371667
R1803 vco_feed_0.vdd_core.n102 vco_feed_0.vdd_core.n95 0.0371667
R1804 vco_feed_0.vdd_core.n159 vco_feed_0.vdd_core.n158 0.0371667
R1805 vco_feed_0.vdd_core.n160 vco_feed_0.vdd_core.n159 0.0371667
R1806 vco_feed_0.vdd_core.n163 vco_feed_0.vdd_core.n162 0.0371667
R1807 vco_feed_0.vdd_core.n164 vco_feed_0.vdd_core.n163 0.0371667
R1808 vco_feed_0.vdd_core.n3 vco_feed_0.vdd_core.n2 0.0351511
R1809 vco_feed_0.vdd_core.n176 vco_feed_0.vdd_core.n175 0.0371667
R1810 vco_feed_0.vdd_core.n176 vco_feed_0.vdd_core.n173 0.0371667
R1811 vco_feed_0.vdd_core.n173 vco_feed_0.vdd_core.n80 0.0371667
R1812 vco_feed_0.vdd_core.n179 vco_feed_0.vdd_core.n80 0.0371667
R1813 vco_feed_0.vdd_core.n180 vco_feed_0.vdd_core.n179 0.0371667
R1814 vco_feed_0.vdd_core.n181 vco_feed_0.vdd_core.n180 0.0371667
R1815 vco_feed_0.vdd_core.n182 vco_feed_0.vdd_core.n181 0.0371667
R1816 vco_feed_0.vdd_core.n183 vco_feed_0.vdd_core.n182 0.0371667
R1817 vco_feed_0.vdd_core.n184 vco_feed_0.vdd_core.n183 0.0371667
R1818 vco_feed_0.vdd_core.n185 vco_feed_0.vdd_core.n184 0.0371667
R1819 vco_feed_0.vdd_core.n185 vco_feed_0.vdd_core.n65 0.0371667
R1820 vco_feed_0.vdd_core.n65 vco_feed_0.vdd_core.n57 0.0371667
R1821 vco_feed_0.vdd_core.n188 vco_feed_0.vdd_core.n57 0.0371667
R1822 vco_feed_0.vdd_core.n189 vco_feed_0.vdd_core.n188 0.0371667
R1823 vco_feed_0.vdd_core.n191 vco_feed_0.vdd_core.n190 0.0371667
R1824 vco_feed_0.vdd_core.n194 vco_feed_0.vdd_core.n193 0.0371667
R1825 vco_feed_0.vdd_core.n194 vco_feed_0.vdd_core.n51 0.0371667
R1826 vco_feed_0.vdd_core.n51 vco_feed_0.vdd_core.n43 0.0371667
R1827 vco_feed_0.vdd_core.n197 vco_feed_0.vdd_core.n43 0.0371667
R1828 vco_feed_0.vdd_core.n198 vco_feed_0.vdd_core.n197 0.0371667
R1829 vco_feed_0.vdd_core.n199 vco_feed_0.vdd_core.n198 0.0371667
R1830 vco_feed_0.vdd_core.n200 vco_feed_0.vdd_core.n199 0.0371667
R1831 vco_feed_0.vdd_core.n201 vco_feed_0.vdd_core.n200 0.0371667
R1832 vco_feed_0.vdd_core.n202 vco_feed_0.vdd_core.n201 0.0371667
R1833 vco_feed_0.vdd_core.n203 vco_feed_0.vdd_core.n202 0.0371667
R1834 vco_feed_0.vdd_core.n203 vco_feed_0.vdd_core.n12 0.0371667
R1835 vco_feed_0.vdd_core.n26 vco_feed_0.vdd_core.n12 0.0371667
R1836 vco_feed_0.vdd_core.n26 vco_feed_0.vdd_core.n9 0.0371667
R1837 vco_feed_0.vdd_core.n31 vco_feed_0.vdd_core.n9 0.0371667
R1838 vco_feed_0.vdd_core.n32 vco_feed_0.vdd_core.n31 0.0371667
R1839 vco_feed_0.vdd_core.n33 vco_feed_0.vdd_core.n32 0.0371667
R1840 vco_feed_0.vdd_core.n140 vco_feed_0.vdd_core.n139 0.028
R1841 vco_feed_0.vdd_core.n143 vco_feed_0.vdd_core.n124 0.028
R1842 vco_feed_0.vdd_core.n147 vco_feed_0.vdd_core.n146 0.028
R1843 vco_feed_0.vdd_core.n151 vco_feed_0.vdd_core.n150 0.028
R1844 vco_feed_0.vdd_core.n154 vco_feed_0.vdd_core.n97 0.028
R1845 vco_feed_0.vdd_core.n158 vco_feed_0.vdd_core.n157 0.028
R1846 vco_feed_0.vdd_core.n162 vco_feed_0.vdd_core.n161 0.028
R1847 vco_feed_0.vdd_core.n165 vco_feed_0.vdd_core.n82 0.028
R1848 vco_feed_0.vdd_core.n191 vco_feed_0.vdd_core.n52 0.0261384
R1849 vco_feed_0.vdd_core.n177 vco_feed_0.vdd_core.n4 0.023
R1850 vco_feed_0.vdd_core.n178 vco_feed_0.vdd_core.n177 0.023
R1851 vco_feed_0.vdd_core.n178 vco_feed_0.vdd_core.n58 0.023
R1852 vco_feed_0.vdd_core.n186 vco_feed_0.vdd_core.n58 0.023
R1853 vco_feed_0.vdd_core.n187 vco_feed_0.vdd_core.n186 0.023
R1854 vco_feed_0.vdd_core.n187 vco_feed_0.vdd_core.n44 0.023
R1855 vco_feed_0.vdd_core.n195 vco_feed_0.vdd_core.n44 0.023
R1856 vco_feed_0.vdd_core.n196 vco_feed_0.vdd_core.n195 0.023
R1857 vco_feed_0.vdd_core.n196 vco_feed_0.vdd_core.n8 0.023
R1858 vco_feed_0.vdd_core.n144 vco_feed_0.vdd_core.n123 0.023
R1859 vco_feed_0.vdd_core.n145 vco_feed_0.vdd_core.n144 0.023
R1860 vco_feed_0.vdd_core.n145 vco_feed_0.vdd_core.n96 0.023
R1861 vco_feed_0.vdd_core.n155 vco_feed_0.vdd_core.n96 0.023
R1862 vco_feed_0.vdd_core.n156 vco_feed_0.vdd_core.n155 0.023
R1863 vco_feed_0.vdd_core.n156 vco_feed_0.vdd_core.n81 0.023
R1864 vco_feed_0.vdd_core.n166 vco_feed_0.vdd_core.n81 0.023
R1865 vco_feed_0.vdd_core.n122 vco_feed_0.vdd_core 0.0227222
R1866 vco_feed_0.vdd_core.n212 vco_feed_0.vdd_core.n6 0.0201
R1867 vco_feed_0.vdd_core vco_feed_0.vdd_core.n219 0.0181
R1868 vco_feed_0.vdd_core.n206 vco_feed_0.vdd_core 0.0181
R1869 vco_feed_0.vdd_core.n212 vco_feed_0.vdd_core.n1 0.221956
R1870 vco_feed_0.vdd_core.n113 vco_feed_0.vdd_core.n108 0.0124467
R1871 vco_feed_0.vdd_core.n110 vco_feed_0.vdd_core.n107 0.0124467
R1872 vco_feed_0.vdd_core.n35 vco_feed_0.vdd_core.n16 0.0121878
R1873 vco_feed_0.vdd_core.n19 vco_feed_0.vdd_core.n15 0.0121878
R1874 vco_feed_0.vdd_core.n76 vco_feed_0.vdd_core.n73 0.0121878
R1875 vco_feed_0.vdd_core.n74 vco_feed_0.vdd_core.n72 0.0121878
R1876 vco_feed_0.vdd_core.n204 vco_feed_0.vdd_core.n8 0.01175
R1877 vco_feed_0.vdd_core.n139 vco_feed_0.vdd_core.n138 0.0113759
R1878 vco_feed_0.vdd_core.n213 vco_feed_0.vdd_core.n0 0.01106
R1879 vco_feed_0.vdd_core.n143 vco_feed_0.vdd_core.n142 0.00966667
R1880 vco_feed_0.vdd_core.n146 vco_feed_0.vdd_core.n121 0.00966667
R1881 vco_feed_0.vdd_core.n150 vco_feed_0.vdd_core.n149 0.00966667
R1882 vco_feed_0.vdd_core.n154 vco_feed_0.vdd_core.n153 0.00966667
R1883 vco_feed_0.vdd_core.n157 vco_feed_0.vdd_core.n95 0.00966667
R1884 vco_feed_0.vdd_core.n161 vco_feed_0.vdd_core.n160 0.00966667
R1885 vco_feed_0.vdd_core.n165 vco_feed_0.vdd_core.n164 0.00966667
R1886 vco_feed_0.vdd_core.n193 vco_feed_0.vdd_core.n52 0.00944821
R1887 vco_feed_0.vdd_core.n211 vco_feed_0.vdd_core 2.34256
R1888 vco_feed_0.vdd_core.n4 vco_feed_0.vdd_core.n2 0.578991
R1889 vco_bias_0.vbn_buf.n3 vco_bias_0.vbn_buf.t1 45.1624
R1890 vco_bias_0.vbn_buf.n2 vco_bias_0.vbn_buf.t4 34.2391
R1891 vco_bias_0.vbn_buf.n2 vco_bias_0.vbn_buf.t3 28.5544
R1892 vco_bias_0.vbn_buf.n1 vco_bias_0.vbn_buf.n0 22.8503
R1893 vco_bias_0.vbn_buf.n0 vco_bias_0.vbn_buf.t2 21.7736
R1894 vco_bias_0.vbn_buf.n4 vco_bias_0.vbn_buf.t0 17.3253
R1895 vco_bias_0.vbn_buf.n4 vco_bias_0.vbn_buf.n3 13.5293
R1896 vco_bias_0.vbn_buf.n3 vco_bias_0.vbn_buf.n2 6.81757
R1897 vco_bias_0.vbn_buf vco_bias_0.vbn_buf.n4 2.55837
R1898 vco_bias_0.vbn_buf vco_bias_0.vbn_buf.n1 0.2645
R1899 vco_bias_0.vbn_buf.n1 vco_bias_0.vbn_buf 0.208921
R1900 vco_bias_0.vbn_buf.n0 vco_bias_0.vbn_buf 0.1105
C0 VDD a_16500_4160# 0.39117f
C1 vco_feed_0.vdd_core a_19100_4966# 0.08348f
C2 vco_feed_0.en_b di_en 0.62558f
C3 vco_bias_0.vbg_buf a_9400_4880# 0.08032f
C4 vco_bias_0.vbg_buf vco_feed_0.en_b 0.27386f
C5 vco_bias_0.vbg_buf di_en 4.16619f
C6 vco_bias_0.vbn_buf a_1160_2070# 0.02902f
C7 rf_out_n a_10100_4160# 0.69021f
C8 vco_feed_0.vdd_core a_9400_4966# 0.0801f
C9 vco_bias_0.vbn_buf vco_feed_0.vdd_core 0.43987f
C10 vco_bias_0.vbn_buf a_9400_4966# 0.01696f
C11 a_9400_4880# a_10100_4160# 0.05715f
C12 vco_feed_0.en_b a_5560_4708# 0.05029f
C13 vtune VDD 0.15487f
C14 vco_bias_0.vbg_buf a_5560_4708# 0.03933f
C15 a_14668_3324# VDD 1.57065f
C16 rf_out_p VDD 3.02587f
C17 a_19100_4966# a_14668_3324# 0.04847f
C18 rf_out_n VDD 3.00523f
C19 a_1160_2070# a_1560_1770# 0.60592f
C20 vco_bias_0.vbg_buf a_5060_3788# 0.27763f
C21 a_9400_4880# VDD 1.57517f
C22 a_23460_164# VDD 0.04551f
C23 vco_feed_0.en_b VDD 5.95879f
C24 VDD di_en 0.60931f
C25 vco_bias_0.vbg_buf VDD 3.98332f
C26 vco_feed_0.vdd_core vtune 13.5168f
C27 vco_feed_0.vdd_core a_14668_3324# 0.15264p
C28 vco_bias_0.vbn_buf vtune 0.06626f
C29 vco_bias_0.vbn_buf a_14668_3324# 0.05269f
C30 vco_bias_0.vbg_buf a_19100_4966# 0.03283f
C31 a_14668_3324# a_16500_4160# 0.05715f
C32 rf_out_p vco_bias_0.vbn_buf 0.21953f
C33 vco_bias_0.vbg_buf a_1160_2070# 0.04813f
C34 rf_out_n vco_bias_0.vbn_buf 0.33134f
C35 rf_out_p a_16500_4160# 0.69021f
C36 a_5060_3788# a_5560_4708# 0.09924f
C37 VDD a_10100_4160# 0.39117f
C38 vco_feed_0.vdd_core a_9400_4880# 0.15264p
C39 vco_feed_0.vdd_core a_23460_164# 1.12292f
C40 vco_feed_0.en_b vco_feed_0.vdd_core 0.01497f
C41 a_9400_4966# a_9400_4880# 0.04847f
C42 a_5560_4708# VDD 0.03954f
C43 vco_bias_0.vbn_buf a_9400_4880# 0.06582f
C44 vco_feed_0.en_b vco_bias_0.vbn_buf 1.18956f
C45 vco_bias_0.vbg_buf vco_feed_0.vdd_core 3.59919f
C46 vco_bias_0.vbn_buf di_en 0.1413f
C47 vco_bias_0.vbg_buf a_9400_4966# 0.03293f
C48 vco_bias_0.vbg_buf vco_bias_0.vbn_buf 10.3424f
C49 a_14668_3324# vtune 0.22943f
C50 rf_out_p vtune 0.03446f
C51 rf_out_p a_14668_3324# 0.9832f
C52 rf_out_n vtune 0.03446f
C53 rf_out_n rf_out_p 0.02191f
C54 a_9400_4880# vtune 0.23905f
C55 vco_feed_0.en_b vtune 0.03157f
C56 a_9400_4880# a_14668_3324# 0.12351f
C57 vco_bias_0.vbg_buf vtune 0.07434f
C58 vco_bias_0.vbg_buf a_14668_3324# 0.04293f
C59 rf_out_p vco_feed_0.en_b 0.07982f
C60 rf_out_n a_9400_4880# 0.9832f
C61 vco_bias_0.vbg_buf a_1560_1770# 0.03483f
C62 rf_out_n vco_feed_0.en_b 0.08032f
C63 vco_feed_0.vdd_core VDD 0.21537f
C64 a_9400_4966# VDD 0.01049f
C65 vco_bias_0.vbn_buf VDD 1.75123f
C66 rf_out_p VSS 4.69306f
C67 rf_out_n VSS 4.55662f
C68 di_en VSS 3.9148f
C69 VDD VSS 31.0122f
C70 vtune VSS 3.99636f
C71 vco_feed_0.en_b VSS 14.64158f
C72 vco_feed_0.vdd_core VSS 3.85531p
C73 vco_bias_0.vbn_buf VSS 0.12752p
C74 vco_bias_0.vbn_buf.n0 VSS 0.16826f
C75 vco_bias_0.vbn_buf.n1 VSS 0.0949f
C76 vco_bias_0.vbn_buf.n2 VSS 0.17943f
C77 vco_bias_0.vbn_buf.t1 VSS 2.24078f
C78 vco_bias_0.vbn_buf.n3 VSS 0.2581f
C79 vco_bias_0.vbn_buf.t0 VSS 0.10582f
C80 vco_bias_0.vbn_buf.n4 VSS 0.1752f
C81 vco_feed_0.vdd_core.n0 VSS 9.75792f
C82 vco_feed_0.vdd_core.n1 VSS 0.35237f
C83 vco_feed_0.vdd_core.n2 VSS 1.99386f
C84 vco_feed_0.vdd_core.n3 VSS 0.40726f
C85 vco_feed_0.vdd_core.n4 VSS 1.05465f
C86 vco_feed_0.vdd_core.t12 VSS 0.05204f
C87 vco_feed_0.vdd_core.t14 VSS 0.0515f
C88 vco_feed_0.vdd_core.n5 VSS 0.18055f
C89 vco_feed_0.vdd_core.n6 VSS 2.96971f
C90 vco_feed_0.vdd_core.n7 VSS 0.12192f
C91 vco_feed_0.vdd_core.n8 VSS 0.2524f
C92 vco_feed_0.vdd_core.n9 VSS 0.12828f
C93 vco_feed_0.vdd_core.n10 VSS 0.22614f
C94 vco_feed_0.vdd_core.n11 VSS 0.22614f
C95 vco_feed_0.vdd_core.n12 VSS 0.11872f
C96 vco_feed_0.vdd_core.n13 VSS 0.35497f
C97 vco_feed_0.vdd_core.n14 VSS 0.35497f
C98 vco_feed_0.vdd_core.n15 VSS 0.16556f
C99 vco_feed_0.vdd_core.n16 VSS 0.16556f
C100 vco_feed_0.vdd_core.n17 VSS 0.21338f
C101 vco_feed_0.vdd_core.n18 VSS 0.31442f
C102 vco_feed_0.vdd_core.n19 VSS 12.6107f
C103 vco_feed_0.vdd_core.n20 VSS 5.46379f
C104 vco_feed_0.vdd_core.n21 VSS 0.31442f
C105 vco_feed_0.vdd_core.n22 VSS 0.24971f
C106 vco_feed_0.vdd_core.n23 VSS 0.38549f
C107 vco_feed_0.vdd_core.n24 VSS 0.35353f
C108 vco_feed_0.vdd_core.n25 VSS 0.22896f
C109 vco_feed_0.vdd_core.n26 VSS 0.11708f
C110 vco_feed_0.vdd_core.n27 VSS 0.35353f
C111 vco_feed_0.vdd_core.n28 VSS 0.22896f
C112 vco_feed_0.vdd_core.n29 VSS 0.38549f
C113 vco_feed_0.vdd_core.n30 VSS 0.24971f
C114 vco_feed_0.vdd_core.n31 VSS 0.11708f
C115 vco_feed_0.vdd_core.n32 VSS 0.11708f
C116 vco_feed_0.vdd_core.n33 VSS 0.11708f
C117 vco_feed_0.vdd_core.n34 VSS 5.50915f
C118 vco_feed_0.vdd_core.n35 VSS 12.5653f
C119 vco_feed_0.vdd_core.n36 VSS 0.21338f
C120 vco_feed_0.vdd_core.n37 VSS 0.35353f
C121 vco_feed_0.vdd_core.n38 VSS 0.35353f
C122 vco_feed_0.vdd_core.n39 VSS 0.23366f
C123 vco_feed_0.vdd_core.n40 VSS 0.23366f
C124 vco_feed_0.vdd_core.n41 VSS 0.38549f
C125 vco_feed_0.vdd_core.n42 VSS 0.38549f
C126 vco_feed_0.vdd_core.n43 VSS 0.11708f
C127 vco_feed_0.vdd_core.n44 VSS 0.33653f
C128 vco_feed_0.vdd_core.n45 VSS 0.31968f
C129 vco_feed_0.vdd_core.n46 VSS 0.22426f
C130 vco_feed_0.vdd_core.n47 VSS 0.23084f
C131 vco_feed_0.vdd_core.n48 VSS 0.35353f
C132 vco_feed_0.vdd_core.n49 VSS 0.23084f
C133 vco_feed_0.vdd_core.n50 VSS 0.35353f
C134 vco_feed_0.vdd_core.n51 VSS 0.11872f
C135 vco_feed_0.vdd_core.n52 VSS 0.37877f
C136 vco_feed_0.vdd_core.n53 VSS 5.50915f
C137 vco_feed_0.vdd_core.n54 VSS 5.46379f
C138 vco_feed_0.vdd_core.n55 VSS 0.31442f
C139 vco_feed_0.vdd_core.n56 VSS 0.31442f
C140 vco_feed_0.vdd_core.n57 VSS 0.11708f
C141 vco_feed_0.vdd_core.n58 VSS 0.33653f
C142 vco_feed_0.vdd_core.n59 VSS 0.22896f
C143 vco_feed_0.vdd_core.n60 VSS 0.22896f
C144 vco_feed_0.vdd_core.n61 VSS 0.24971f
C145 vco_feed_0.vdd_core.n62 VSS 0.38549f
C146 vco_feed_0.vdd_core.n63 VSS 0.24971f
C147 vco_feed_0.vdd_core.n64 VSS 0.38549f
C148 vco_feed_0.vdd_core.n65 VSS 0.11872f
C149 vco_feed_0.vdd_core.n66 VSS 0.35353f
C150 vco_feed_0.vdd_core.n67 VSS 0.35353f
C151 vco_feed_0.vdd_core.n68 VSS 0.22614f
C152 vco_feed_0.vdd_core.n69 VSS 0.22614f
C153 vco_feed_0.vdd_core.n70 VSS 0.35497f
C154 vco_feed_0.vdd_core.n71 VSS 0.35497f
C155 vco_feed_0.vdd_core.n72 VSS 0.16556f
C156 vco_feed_0.vdd_core.n73 VSS 0.16556f
C157 vco_feed_0.vdd_core.n74 VSS 12.6107f
C158 vco_feed_0.vdd_core.n75 VSS 0.21338f
C159 vco_feed_0.vdd_core.n76 VSS 12.5653f
C160 vco_feed_0.vdd_core.n77 VSS 0.21338f
C161 vco_feed_0.vdd_core.n78 VSS 0.35353f
C162 vco_feed_0.vdd_core.n79 VSS 0.35353f
C163 vco_feed_0.vdd_core.n80 VSS 0.11708f
C164 vco_feed_0.vdd_core.n81 VSS 0.33653f
C165 vco_feed_0.vdd_core.n82 VSS 0.13111f
C166 vco_feed_0.vdd_core.n83 VSS 0.26265f
C167 vco_feed_0.vdd_core.n84 VSS 0.26265f
C168 vco_feed_0.vdd_core.n85 VSS 0.23154f
C169 vco_feed_0.vdd_core.n86 VSS 0.253f
C170 vco_feed_0.vdd_core.n87 VSS 0.20201f
C171 vco_feed_0.vdd_core.n88 VSS 0.18055f
C172 vco_feed_0.vdd_core.n89 VSS 0.23099f
C173 vco_feed_0.vdd_core.n90 VSS 0.23099f
C174 vco_feed_0.vdd_core.n91 VSS 0.18381f
C175 vco_feed_0.vdd_core.n92 VSS 0.18381f
C176 vco_feed_0.vdd_core.n93 VSS 0.28289f
C177 vco_feed_0.vdd_core.n94 VSS 0.28289f
C178 vco_feed_0.vdd_core.n95 VSS 0.07502f
C179 vco_feed_0.vdd_core.n96 VSS 0.33653f
C180 vco_feed_0.vdd_core.n97 VSS 0.10306f
C181 vco_feed_0.vdd_core.n98 VSS 0.26051f
C182 vco_feed_0.vdd_core.n99 VSS 0.16646f
C183 vco_feed_0.vdd_core.n100 VSS 0.16852f
C184 vco_feed_0.vdd_core.n101 VSS 0.25954f
C185 vco_feed_0.vdd_core.n102 VSS 0.11872f
C186 vco_feed_0.vdd_core.n103 VSS 0.16852f
C187 vco_feed_0.vdd_core.n104 VSS 0.25954f
C188 vco_feed_0.vdd_core.n105 VSS 0.16646f
C189 vco_feed_0.vdd_core.n106 VSS 0.26051f
C190 vco_feed_0.vdd_core.n107 VSS 0.1233f
C191 vco_feed_0.vdd_core.n108 VSS 0.1233f
C192 vco_feed_0.vdd_core.n109 VSS 5.68255f
C193 vco_feed_0.vdd_core.n110 VSS 11.8843f
C194 vco_feed_0.vdd_core.n111 VSS 0.15706f
C195 vco_feed_0.vdd_core.n112 VSS 5.72614f
C196 vco_feed_0.vdd_core.n113 VSS 11.8407f
C197 vco_feed_0.vdd_core.n114 VSS 0.15706f
C198 vco_feed_0.vdd_core.n115 VSS 0.25954f
C199 vco_feed_0.vdd_core.n116 VSS 0.25954f
C200 vco_feed_0.vdd_core.n117 VSS 0.17196f
C201 vco_feed_0.vdd_core.n118 VSS 0.17196f
C202 vco_feed_0.vdd_core.n119 VSS 0.28289f
C203 vco_feed_0.vdd_core.n120 VSS 0.28289f
C204 vco_feed_0.vdd_core.n121 VSS 0.07502f
C205 vco_feed_0.vdd_core.t22 VSS 7.84017f
C206 vco_feed_0.vdd_core.n122 VSS 4.47496f
C207 vco_feed_0.vdd_core.n123 VSS 0.44871f
C208 vco_feed_0.vdd_core.n124 VSS 0.10306f
C209 vco_feed_0.vdd_core.n125 VSS 0.25836f
C210 vco_feed_0.vdd_core.n126 VSS 0.16509f
C211 vco_feed_0.vdd_core.n127 VSS 0.1699f
C212 vco_feed_0.vdd_core.n128 VSS 0.25954f
C213 vco_feed_0.vdd_core.n129 VSS 0.11872f
C214 vco_feed_0.vdd_core.n130 VSS 0.1699f
C215 vco_feed_0.vdd_core.n131 VSS 0.25954f
C216 vco_feed_0.vdd_core.n132 VSS 0.16509f
C217 vco_feed_0.vdd_core.n133 VSS 0.25836f
C218 vco_feed_0.vdd_core.n134 VSS 0.25729f
C219 vco_feed_0.vdd_core.n135 VSS 0.25729f
C220 vco_feed_0.vdd_core.n136 VSS 0.22959f
C221 vco_feed_0.vdd_core.n137 VSS 0.23121f
C222 vco_feed_0.vdd_core.n138 VSS 1.21631f
C223 vco_feed_0.vdd_core.n139 VSS 0.06814f
C224 vco_feed_0.vdd_core.n140 VSS 0.10306f
C225 vco_feed_0.vdd_core.n141 VSS 0.11872f
C226 vco_feed_0.vdd_core.n142 VSS 0.07665f
C227 vco_feed_0.vdd_core.n143 VSS 0.05609f
C228 vco_feed_0.vdd_core.n144 VSS 0.33653f
C229 vco_feed_0.vdd_core.n145 VSS 0.33653f
C230 vco_feed_0.vdd_core.n146 VSS 0.05609f
C231 vco_feed_0.vdd_core.n147 VSS 0.1047f
C232 vco_feed_0.vdd_core.n148 VSS 0.11708f
C233 vco_feed_0.vdd_core.n149 VSS 0.07665f
C234 vco_feed_0.vdd_core.n150 VSS 0.05609f
C235 vco_feed_0.vdd_core.n151 VSS 0.10306f
C236 vco_feed_0.vdd_core.n152 VSS 0.11872f
C237 vco_feed_0.vdd_core.n153 VSS 0.07665f
C238 vco_feed_0.vdd_core.n154 VSS 0.05609f
C239 vco_feed_0.vdd_core.n155 VSS 0.33653f
C240 vco_feed_0.vdd_core.n156 VSS 0.33653f
C241 vco_feed_0.vdd_core.n157 VSS 0.05609f
C242 vco_feed_0.vdd_core.n158 VSS 0.1047f
C243 vco_feed_0.vdd_core.n159 VSS 0.11708f
C244 vco_feed_0.vdd_core.n160 VSS 0.07502f
C245 vco_feed_0.vdd_core.n161 VSS 0.05609f
C246 vco_feed_0.vdd_core.n162 VSS 0.10306f
C247 vco_feed_0.vdd_core.n163 VSS 0.11872f
C248 vco_feed_0.vdd_core.n164 VSS 0.07665f
C249 vco_feed_0.vdd_core.n165 VSS 0.05609f
C250 vco_feed_0.vdd_core.n166 VSS 0.96074f
C251 vco_feed_0.vdd_core.n167 VSS 0.30029f
C252 vco_feed_0.vdd_core.n168 VSS 0.23084f
C253 vco_feed_0.vdd_core.n169 VSS 0.23366f
C254 vco_feed_0.vdd_core.n170 VSS 0.38549f
C255 vco_feed_0.vdd_core.n171 VSS 0.23366f
C256 vco_feed_0.vdd_core.n172 VSS 0.38549f
C257 vco_feed_0.vdd_core.n173 VSS 0.11872f
C258 vco_feed_0.vdd_core.n174 VSS 0.39968f
C259 vco_feed_0.vdd_core.n175 VSS 0.11872f
C260 vco_feed_0.vdd_core.n176 VSS 0.11708f
C261 vco_feed_0.vdd_core.n177 VSS 0.33653f
C262 vco_feed_0.vdd_core.n178 VSS 0.33653f
C263 vco_feed_0.vdd_core.n179 VSS 0.11872f
C264 vco_feed_0.vdd_core.n180 VSS 0.11708f
C265 vco_feed_0.vdd_core.n181 VSS 0.11872f
C266 vco_feed_0.vdd_core.n182 VSS 0.11872f
C267 vco_feed_0.vdd_core.n183 VSS 0.11708f
C268 vco_feed_0.vdd_core.n184 VSS 0.11872f
C269 vco_feed_0.vdd_core.n185 VSS 0.11708f
C270 vco_feed_0.vdd_core.n186 VSS 0.33653f
C271 vco_feed_0.vdd_core.n187 VSS 0.33653f
C272 vco_feed_0.vdd_core.n188 VSS 0.11708f
C273 vco_feed_0.vdd_core.n189 VSS 0.17317f
C274 vco_feed_0.vdd_core.n190 VSS 0.16826f
C275 vco_feed_0.vdd_core.n191 VSS 0.60148f
C276 vco_feed_0.vdd_core.n192 VSS 0.47419f
C277 vco_feed_0.vdd_core.n193 VSS 0.11872f
C278 vco_feed_0.vdd_core.n194 VSS 0.11708f
C279 vco_feed_0.vdd_core.n195 VSS 0.33653f
C280 vco_feed_0.vdd_core.n196 VSS 0.33653f
C281 vco_feed_0.vdd_core.n197 VSS 0.11872f
C282 vco_feed_0.vdd_core.n198 VSS 0.11708f
C283 vco_feed_0.vdd_core.n199 VSS 0.11872f
C284 vco_feed_0.vdd_core.n200 VSS 0.11708f
C285 vco_feed_0.vdd_core.n201 VSS 0.11872f
C286 vco_feed_0.vdd_core.n202 VSS 0.11872f
C287 vco_feed_0.vdd_core.n203 VSS 0.11708f
C288 vco_feed_0.vdd_core.n204 VSS 4.24281f
C289 vco_feed_0.vdd_core.t9 VSS 0.05204f
C290 vco_feed_0.vdd_core.t7 VSS 0.60103f
C291 vco_feed_0.vdd_core.n205 VSS 0.18055f
C292 vco_feed_0.vdd_core.t3 VSS 0.0515f
C293 vco_feed_0.vdd_core.n206 VSS 0.68099f
C294 vco_feed_0.vdd_core.n207 VSS 4.35588f
C295 vco_feed_0.vdd_core.n208 VSS 1.16443f
C296 vco_feed_0.vdd_core.t5 VSS 0.0515f
C297 vco_feed_0.vdd_core.t1 VSS 0.0515f
C298 vco_feed_0.vdd_core.n209 VSS 0.93204f
C299 vco_feed_0.vdd_core.n210 VSS 2.261f
C300 vco_feed_0.vdd_core.n211 VSS 40.1244f
C301 vco_feed_0.vdd_core.n212 VSS 0.554f
C302 vco_feed_0.vdd_core.n213 VSS 2.87927f
C303 vco_feed_0.vdd_core.n214 VSS 16f
C304 vco_feed_0.vdd_core.n215 VSS 2.07901f
C305 vco_feed_0.vdd_core.t16 VSS 0.0515f
C306 vco_feed_0.vdd_core.t18 VSS 0.43257f
C307 vco_feed_0.vdd_core.t20 VSS 0.0515f
C308 vco_feed_0.vdd_core.n216 VSS 0.63337f
C309 vco_feed_0.vdd_core.n217 VSS 0.89921f
C310 vco_feed_0.vdd_core.n218 VSS 2.40303f
C311 vco_feed_0.vdd_core.n219 VSS 2.23263f
C312 vco_feed_0.en_b.n0 VSS 0.93778f
C313 vco_feed_0.en_b.n1 VSS 0.74783f
C314 vco_feed_0.en_b.t0 VSS 0.16587f
C315 vco_feed_0.en_b.t1 VSS 0.22665f
C316 vco_feed_0.en_b.n2 VSS 0.25457f
C317 vco_feed_0.en_b.n3 VSS 0.379f
C318 vco_feed_0.en_b.n4 VSS 0.60337f
C319 a_5948_5116.t0 VSS 0.15472f
C320 a_5948_5116.n0 VSS 2.20174f
C321 a_5948_5116.t1 VSS 0.29401f
C322 a_6568_6836.t0 VSS 0.60931f
C323 a_6568_6836.t1 VSS 0.61066f
C324 a_6568_6836.n0 VSS 0.71873f
C325 a_6568_6836.n1 VSS 1.07763f
C326 a_6568_6836.n2 VSS 0.71926f
C327 a_6568_6836.t3 VSS 1.15117f
C328 a_5060_6408.t1 VSS 1.46499f
C329 a_5060_6408.n0 VSS 1.75426f
C330 a_5060_6408.t0 VSS 0.38225f
C331 a_5560_6408.t1 VSS 2.74401f
C332 a_5560_6408.t0 VSS 0.8042f
C333 a_5560_6408.n0 VSS 4.19226f
C334 a_5560_6408.t2 VSS 1.49836f
C335 a_5560_4622.t2 VSS 0.7582f
C336 a_5560_4622.n0 VSS 1.17868f
C337 a_5560_4622.t1 VSS 0.60336f
C338 a_5060_3702.t4 VSS 2.74475f
C339 a_5060_3702.t2 VSS 0.72508f
C340 a_5060_3702.n0 VSS 1.84097f
C341 a_5060_3702.n1 VSS 0.31854f
C342 a_5060_3702.n2 VSS 0.51373f
C343 a_5060_3702.t3 VSS 1.23857f
C344 a_5060_3702.n3 VSS 1.71705f
C345 a_5060_3702.t0 VSS 0.26564f
C346 a_11798_1860.n0 VSS 0.73632f
C347 a_11798_1860.n1 VSS 2.45116f
C348 a_11798_1860.n2 VSS 4.17643f
C349 a_11798_1860.n3 VSS 0.37897f
C350 a_11798_1860.n4 VSS 0.1145f
C351 a_11798_1860.n5 VSS 0.1145f
C352 a_11798_1860.n7 VSS 1.67631f
C353 a_11798_1860.n8 VSS 1.64655f
C354 a_11798_1860.n9 VSS 0.10122f
C355 a_11798_1860.t22 VSS 0.07276f
C356 a_11798_1860.n10 VSS 0.05853f
C357 a_11798_1860.t24 VSS 0.08124f
C358 a_11798_1860.n11 VSS 0.04391f
C359 a_11798_1860.t26 VSS 0.08124f
C360 a_11798_1860.n12 VSS 0.04391f
C361 a_11798_1860.t27 VSS 0.08124f
C362 a_11798_1860.n13 VSS 0.04479f
C363 a_11798_1860.t28 VSS 0.07276f
C364 a_11798_1860.n14 VSS 0.05853f
C365 a_11798_1860.n15 VSS 0.1141f
C366 a_11798_1860.n16 VSS 0.07502f
C367 a_11798_1860.t25 VSS 0.08654f
C368 a_11798_1860.n17 VSS 0.07502f
C369 a_11798_1860.n18 VSS 0.1141f
C370 a_11798_1860.t23 VSS 4.47348f
C371 a_11798_1860.n19 VSS 0.04479f
C372 a_11798_1860.n20 VSS 0.35735f
C373 a_11798_1860.n21 VSS 0.35735f
C374 a_11798_1860.n22 VSS 0.10122f
C375 a_11798_1860.t15 VSS 0.07276f
C376 a_11798_1860.n23 VSS 0.05853f
C377 a_11798_1860.t17 VSS 0.08124f
C378 a_11798_1860.n24 VSS 0.04391f
C379 a_11798_1860.t19 VSS 0.08124f
C380 a_11798_1860.n25 VSS 0.04391f
C381 a_11798_1860.t20 VSS 4.36811f
C382 a_11798_1860.n26 VSS 0.04479f
C383 a_11798_1860.t21 VSS 0.07276f
C384 a_11798_1860.n27 VSS 0.05853f
C385 a_11798_1860.n28 VSS 0.1141f
C386 a_11798_1860.n29 VSS 0.07502f
C387 a_11798_1860.t18 VSS 0.08654f
C388 a_11798_1860.n30 VSS 0.07502f
C389 a_11798_1860.n31 VSS 0.11411f
C390 a_11798_1860.t16 VSS 0.08124f
C391 a_11798_1860.n32 VSS 0.04479f
C392 a_11798_1860.n33 VSS 0.35734f
C393 a_11798_1860.t0 VSS 0.26135f
C394 a_11798_1860.t1 VSS 0.25427f
C395 a_11798_1860.t2 VSS 0.25427f
C396 a_11798_1860.t3 VSS 0.25427f
C397 a_11798_1860.t4 VSS 0.25427f
C398 a_11798_1860.t5 VSS 0.25427f
C399 a_11798_1860.t6 VSS 0.25427f
C400 a_11798_1860.t7 VSS 0.25427f
C401 a_11798_1860.t8 VSS 0.25427f
C402 a_11798_1860.t9 VSS 0.25427f
C403 a_11798_1860.t10 VSS 0.25427f
C404 a_11798_1860.t11 VSS 1.22161f
C405 a_11798_1860.t12 VSS 0.25427f
C406 a_11798_1860.t13 VSS 0.25427f
C407 a_11798_1860.t14 VSS 0.26131f
C408 a_19774_346.n0 VSS 2.24232f
C409 a_19774_346.n1 VSS 4.91328f
C410 a_19774_346.n2 VSS 16.605f
C411 a_19774_346.t16 VSS 16.90162f
C412 a_19774_346.t0 VSS 0.20805f
C413 a_19774_346.t1 VSS 0.20624f
C414 a_19774_346.t2 VSS 0.20624f
C415 a_19774_346.t3 VSS 0.20624f
C416 a_19774_346.t4 VSS 0.20624f
C417 a_19774_346.t5 VSS 0.20624f
C418 a_19774_346.t6 VSS 0.20624f
C419 a_19774_346.t7 VSS 0.20624f
C420 a_19774_346.t8 VSS 0.20624f
C421 a_19774_346.t9 VSS 0.20624f
C422 a_19774_346.t10 VSS 0.20624f
C423 a_19774_346.t11 VSS 0.20624f
C424 a_19774_346.t12 VSS 0.20624f
C425 a_19774_346.t13 VSS 0.20624f
C426 a_19774_346.t14 VSS 3.36341f
C427 a_19774_346.t15 VSS 0.20623f
C428 VSS.t78 VSS 0.99954f
C429 VSS.t88 VSS 0.3685p
C430 VSS.t83 VSS 0.28406f
C431 VSS.t93 VSS 0.25969f
C432 VSS.t79 VSS 0.99954f
C433 VSS.t89 VSS 0.3685p
C434 VSS.t91 VSS 0.25969f
C435 VSS.t85 VSS 0.28406f
C436 VSS.t17 VSS 4.31452f
C437 VSS.t19 VSS 4.31452f
C438 VSS.t61 VSS 0.96734f
C439 VSS.t112 VSS 0.38107f
C440 VSS.t77 VSS 0.07938f
C441 VSS.t75 VSS 0.04431f
C442 VSS.t129 VSS 0.11315f
C443 VSS.t27 VSS 0.05104f
C444 VSS.t14 VSS 0.21302f
C445 VSS.t127 VSS 0.25483f
C446 VSS.t1 VSS 0.25483f
C447 VSS.t171 VSS 0.54953f
C448 VSS.t10 VSS 4.30842f
C449 VSS.t12 VSS 4.30842f
C450 vtune.t2 VSS 7.2352f
C451 vtune.t5 VSS 7.2212f
C452 vtune.n0 VSS 0.4068f
C453 vtune.t0 VSS 7.2212f
C454 vtune.n1 VSS 1.10653f
C455 VDD.n0 VSS 0.33303f
C456 VDD.n2 VSS 0.14519f
C457 VDD.n3 VSS 0.17406f
C458 VDD.n4 VSS 0.1969f
C459 VDD.n5 VSS 0.1969f
C460 VDD.n6 VSS 0.1969f
C461 VDD.n7 VSS 1.53407f
C462 VDD.n8 VSS 0.03543f
C463 VDD.n9 VSS 0.03543f
C464 VDD.n10 VSS 0.1969f
C465 VDD.n11 VSS 0.03543f
C466 VDD.n12 VSS 0.03543f
C467 VDD.n13 VSS 0.1969f
C468 VDD.n14 VSS 0.03543f
C469 VDD.n15 VSS 0.03543f
C470 VDD.n16 VSS 0.27251f
C471 VDD.n17 VSS 0.36828f
C472 VDD.n18 VSS 0.06509f
C473 VDD.n19 VSS 0.10654f
C474 VDD.n20 VSS 0.01208f
C475 VDD.n21 VSS 0.11855f
C476 VDD.n22 VSS 0.10752f
C477 VDD.n23 VSS 0.08647f
C478 VDD.n24 VSS 1.00749f
C479 VDD.n25 VSS 0.13327f
C480 VDD.n26 VSS 0.03543f
C481 VDD.n27 VSS 0.09668f
C482 VDD.n29 VSS 0.54866f
C483 VDD.n31 VSS 0.06258f
C484 VDD.n32 VSS 0.08466f
C485 VDD.n33 VSS 0.08926f
C486 VDD.n34 VSS 0.06236f
C487 VDD.n35 VSS 0.03543f
C488 VDD.n36 VSS 0.06236f
C489 VDD.n38 VSS 0.03543f
C490 VDD.n39 VSS 0.06236f
C491 VDD.n40 VSS 0.03543f
C492 VDD.n41 VSS 0.06236f
C493 VDD.n43 VSS 0.03543f
C494 VDD.n44 VSS 0.03543f
C495 VDD.n45 VSS 0.03543f
C496 VDD.n46 VSS 0.06236f
C497 VDD.n47 VSS 0.06236f
C498 VDD.n49 VSS 0.06236f
C499 VDD.n50 VSS 0.06236f
C500 VDD.n52 VSS 0.06236f
C501 VDD.t15 VSS 0.0707f
C502 VDD.t19 VSS 0.06371f
C503 VDD.t16 VSS 0.06371f
C504 VDD.t14 VSS 0.06371f
C505 VDD.t12 VSS 0.06371f
C506 VDD.t10 VSS 0.06371f
C507 VDD.t8 VSS 0.06371f
C508 VDD.t6 VSS 0.06371f
C509 VDD.t5 VSS 0.05711f
C510 VDD.t4 VSS 4.76167f
C511 VDD.t22 VSS 0.06371f
C512 VDD.n53 VSS 0.03543f
C513 VDD.t24 VSS 0.06371f
C514 VDD.t27 VSS 0.06371f
C515 VDD.t29 VSS 0.06371f
C516 VDD.t31 VSS 0.06371f
C517 VDD.t33 VSS 0.06371f
C518 VDD.t26 VSS 3.22089f
C519 VDD.t36 VSS 0.05711f
C520 VDD.n54 VSS 0.0426f
C521 VDD.n55 VSS 0.04153f
C522 VDD.n56 VSS 8.31657f
C523 VDD.t40 VSS 1.03365f
C524 VDD.n57 VSS 3.56036f
C525 VDD.t39 VSS 1.0314f
C526 VDD.n58 VSS 3.56036f
C527 VDD.n59 VSS 8.52313f
C528 VDD.t37 VSS 0.07326f
C529 VDD.t38 VSS 0.11196f
C530 VDD.t1 VSS 0.28536f
C531 VDD.t3 VSS 0.55961f
C532 VDD.t48 VSS 0.20308f
C533 VDD.t49 VSS 0.19837f
C534 VDD.t50 VSS 0.55765f
C535 VDD.t45 VSS 0.19837f
C536 VDD.t46 VSS 0.19837f
C537 VDD.t2 VSS 0.13786f
C538 VDD.t42 VSS 0.02771f
C539 VDD.t43 VSS 0.02771f
C540 VDD.t0 VSS 5.92876f
C541 VDD.n60 VSS 0.48626f
C542 di_en.n0 VSS 3.0811f
C543 rf_out_n.n0 VSS 1.13169f
C544 rf_out_n.n1 VSS 1.77153f
C545 rf_out_n.t5 VSS 4.16972f
C546 rf_out_n.t4 VSS 0.40087f
C547 rf_out_n.t3 VSS 0.14118f
C548 rf_out_n.t2 VSS 0.14118f
C549 rf_out_n.t1 VSS 0.14118f
C550 rf_out_n.t0 VSS 0.14118f
C551 rf_out_n.t6 VSS 1.99529f
C552 rf_out_n.n2 VSS 5.58154f
C553 rf_out_p.n0 VSS 1.54578f
C554 rf_out_p.n1 VSS 1.33343f
C555 rf_out_p.t1 VSS 4.24954f
C556 rf_out_p.t4 VSS 0.42408f
C557 rf_out_p.t2 VSS 0.14002f
C558 rf_out_p.t3 VSS 0.14002f
C559 rf_out_p.t5 VSS 0.14002f
C560 rf_out_p.t6 VSS 0.14002f
C561 rf_out_p.t0 VSS 1.98761f
C562 rf_out_p.n2 VSS 5.53538f
.ends
