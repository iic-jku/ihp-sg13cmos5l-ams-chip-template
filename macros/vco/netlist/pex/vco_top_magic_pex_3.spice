* PEX produced on Fri Nov  6 11:37:35 PM CET 2026 using /foss/tools/sak/sak-pex.sh with m=3 and s=1 (extresist threshold=1000 mOhm, minres=100 mOhm, mindelay=0 ps)
* NGSPICE file created from vco_top_pex.ext - technology: ihp-sg13cmos5l

.subckt vco_top_pex ibias_100u di_en VDD VSS vdd_core vtune rf_out_p rf_out_n
X0 ibias_100u.t0 a_5905_5252.t3 VSS.t71 VSS.t70 sg13_lv_nmos ad=0.34p pd=2.68u as=0.34p ps=2.68u w=1u l=0.13u
X1 VSS.t165 vdd_core.t0 vdd_core.t14 VSS.t164 sg13_lv_nmos ad=0.38p pd=2.38u as=0.38p ps=2.38u w=2u l=0.13u
X2 a_11798_1860.t11 vco_bias_0.vbn_buf.t2 VSS.t46 VSS.t47 sg13_lv_nmos ad=0.95p pd=5.38u as=0.95p ps=5.38u w=5u l=0.5u
X3 rf_out_n.t3 a_9400_4880# a_11798_1860.t20 VSS.t102 sg13_lv_nmos ad=0.38p pd=2.38u as=0.38p ps=2.38u w=2u l=0.13u
X4 rf_out_n.t5 a_9400_4880# a_11798_1860.t18 VSS.t98 sg13_lv_nmos ad=0.38p pd=2.38u as=0.38p ps=2.38u w=2u l=0.13u
X5 a_5905_5252.t1 di_en.t0 VSS.t136 VSS.t135 sg13_lv_nmos ad=0.17p pd=1.68u as=0.17p ps=1.68u w=0.5u l=0.13u
X6 VSS.t83 vco_bias_0.vbg_buf VSS.t82 VSS.t59 sg13_lv_nmos ad=2.72p pd=16.68u as=0 ps=0 w=8u l=10u
X7 VSS.t149 vdd_core.t4 vdd_core.t5 VSS.t148 sg13_lv_nmos ad=0.38p pd=2.38u as=0.38p ps=2.38u w=2u l=0.13u
X8 a_11798_1860.t12 vco_bias_0.vbn_buf.t2 VSS.t40 VSS.t48 sg13_lv_nmos ad=0.95p pd=5.38u as=0.95p ps=5.38u w=5u l=0.5u
X9 VSS.t69 vco_bias_0.vbn_buf.t3 VSS.t67 VSS.t68 sg13_lv_nmos ad=1.52p pd=8.38u as=0 ps=0 w=8u l=10u
X10 a_11798_1860.t23 a_14668_3324# rf_out_p.t3 VSS.t124 sg13_lv_nmos ad=0.38p pd=2.38u as=0.38p ps=2.38u w=2u l=0.13u
X11 a_5560_6408.t1 a_5560_4622.t2 VSS.t110 rppd l=8.5u w=0.5u
X12 a_11798_1860.t1 vco_bias_0.vbn_buf.t2 VSS.t12 VSS.t11 sg13_lv_nmos ad=0.95p pd=5.38u as=0.95p ps=5.38u w=5u l=0.5u
X13 VSS.t26 vco_bias_0.vbn_buf.t2 a_11798_1860.t4 VSS.t25 sg13_lv_nmos ad=0.95p pd=5.38u as=0.95p ps=5.38u w=5u l=0.5u
X14 a_11798_1860.t2 vco_bias_0.vbn_buf.t2 VSS.t14 VSS.t18 sg13_lv_nmos ad=0.95p pd=5.38u as=0.95p ps=5.38u w=5u l=0.5u
X15 vdd_core.t8 vdd_core.t4 VSS.t143 VSS.t144 sg13_lv_nmos ad=0.38p pd=2.38u as=0.38p ps=2.38u w=2u l=0.13u
X16 VSS.t28 vco_bias_0.vbn_buf.t2 a_11798_1860.t5 VSS.t32 sg13_lv_nmos ad=0.95p pd=5.38u as=0.95p ps=5.38u w=5u l=0.5u
X17 vdd_core.t9 vdd_core.t4 VSS.t138 VSS.t137 sg13_lv_nmos ad=0.38p pd=2.38u as=0.68p ps=4.68u w=2u l=0.13u
X18 VSS.t159 vdd_core.t0 vdd_core.t3 VSS.t158 sg13_lv_nmos ad=0.38p pd=2.38u as=0.38p ps=2.38u w=2u l=0.13u
X19 a_11798_1860.t9 vco_bias_0.vbn_buf.t2 VSS.t38 VSS.t41 sg13_lv_nmos ad=0.95p pd=5.38u as=0.95p ps=5.38u w=5u l=0.5u
X20 a_11798_1860.t26 a_14668_3324# rf_out_p.t2 VSS.t130 sg13_lv_nmos ad=0.38p pd=2.38u as=0.38p ps=2.38u w=2u l=0.13u
X21 rf_out_p.t1 a_14668_3324# a_11798_1860.t24 VSS.t127 sg13_lv_nmos ad=0.38p pd=2.38u as=0.38p ps=2.38u w=2u l=0.13u
X22 VSS.t140 vdd_core.t4 vdd_core.t9 VSS.t139 sg13_lv_nmos ad=0.38p pd=2.38u as=0.38p ps=2.38u w=2u l=0.13u
X23 VDD.t6 VDD.t4 VDD.t5 VDD.t0 sg13_lv_pmos ad=0.34p pd=2.68u as=0 ps=0 w=1u l=0.13u
X24 a_11798_1860.t16 a_9400_4880# rf_out_n.t2 VSS.t93 sg13_lv_nmos ad=0.38p pd=2.38u as=0.38p ps=2.38u w=2u l=0.13u
X25 VDD.t12 VDD.t10 VDD.t11 VDD.t0 sg13_lv_pmos ad=1.7p pd=10.68u as=0 ps=0 w=5u l=0.5u
X26 a_6568_6836.t3 a_5948_5116.t2 VDD.t19 VDD.t0 sg13_lv_pmos ad=0.34p pd=2.68u as=0.34p ps=2.68u w=1u l=0.13u
X27 VSS.t85 vco_bias_0.vbg_buf VSS.t83 VSS.t62 sg13_lv_nmos ad=1.52p pd=8.38u as=0 ps=0 w=8u l=10u
X28 VSS.t20 vco_bias_0.vbn_buf.t2 a_11798_1860.t2 VSS.t19 sg13_lv_nmos ad=0.95p pd=5.38u as=0.95p ps=5.38u w=5u l=0.5u
X29 a_5905_5252.t0 di_en.t1 VDD.t18 VDD.t0 sg13_lv_pmos ad=0.34p pd=2.68u as=0.34p ps=2.68u w=1u l=0.13u
X30 a_11798_1860.t21 a_9400_4880# rf_out_n.t3 VSS.t103 sg13_lv_nmos ad=0.68p pd=4.68u as=0.38p ps=2.38u w=2u l=0.13u
X31 VSS.t38 vco_bias_0.vbn_buf.t2 a_11798_1860.t8 VSS.t37 sg13_lv_nmos ad=0.95p pd=5.38u as=0.95p ps=5.38u w=5u l=0.5u
X32 a_11798_1860.t6 vco_bias_0.vbn_buf.t2 VSS.t28 VSS.t27 sg13_lv_nmos ad=0.95p pd=5.38u as=0.95p ps=5.38u w=5u l=0.5u
X33 a_11798_1860.t19 a_9400_4880# rf_out_n.t5 VSS.t99 sg13_lv_nmos ad=0.38p pd=2.38u as=0.38p ps=2.38u w=2u l=0.13u
X34 VDD.t9 VDD.t7 VDD.t8 VDD.t0 sg13_lv_pmos ad=1.7p pd=10.68u as=0 ps=0 w=5u l=0.5u
X35 a_11798_1860.t17 a_9400_4880# rf_out_n.t0 VSS.t95 sg13_lv_nmos ad=0.38p pd=2.38u as=0.38p ps=2.38u w=2u l=0.13u
X36 vco_bias_0.vbg_buf a_14668_3324# VSS.t113 rhigh l=8u w=0.5u
X37 vdd_core.t1 vdd_core.t0 VSS.t165 VSS.t166 sg13_lv_nmos ad=0.38p pd=2.38u as=0.38p ps=2.38u w=2u l=0.13u
X38 VSS.t4 vco_bias_0.vbn_buf.t4 VSS.t2 VSS.t3 sg13_lv_nmos ad=1.52p pd=8.38u as=0 ps=0 w=8u l=10u
X39 VSS.t8 vco_bias_0.vbn_buf.t4 VSS.t6 VSS.t7 sg13_lv_nmos ad=1.52p pd=8.38u as=0 ps=0 w=8u l=10u
X40 vdd_core.t6 vdd_core.t4 VSS.t149 VSS.t150 sg13_lv_nmos ad=0.38p pd=2.38u as=0.38p ps=2.38u w=2u l=0.13u
X41 rf_out_p.t6 a_14668_3324# a_11798_1860.t23 VSS.t125 sg13_lv_nmos ad=0.38p pd=2.38u as=0.38p ps=2.38u w=2u l=0.13u
X42 a_5560_6408.t0 a_6568_6836.t4 VDD.t1 VDD.t0 sg13_lv_pmos ad=1.7p pd=10.68u as=1.7p ps=10.68u w=5u l=0.5u
X43 VSS.t79 vco_bias_0.vbg_buf VSS.t77 VSS.t66 sg13_lv_nmos ad=1.52p pd=8.38u as=0 ps=0 w=8u l=10u
X44 a_11798_1860.t3 vco_bias_0.vbn_buf.t2 VSS.t20 VSS.t21 sg13_lv_nmos ad=0.95p pd=5.38u as=0.95p ps=5.38u w=5u l=0.5u
X45 VSS.t30 vco_bias_0.vbn_buf.t2 a_11798_1860.t6 VSS.t29 sg13_lv_nmos ad=0.95p pd=5.38u as=0.95p ps=5.38u w=5u l=0.5u
N46 vdd_core.t26 vtune.t0 sg13_hv_svaricap l=0.3u w=30.08u
X47 a_11798_1860.t28 a_14668_3324# rf_out_p.t5 VSS.t134 sg13_lv_nmos ad=0.68p pd=4.68u as=0.38p ps=2.38u w=2u l=0.13u
X48 rf_out_p.t4 a_14668_3324# a_11798_1860.t26 VSS.t131 sg13_lv_nmos ad=0.38p pd=2.38u as=0.38p ps=2.38u w=2u l=0.13u
X49 a_11798_1860.t25 a_14668_3324# rf_out_p.t1 VSS.t128 sg13_lv_nmos ad=0.38p pd=2.38u as=0.38p ps=2.38u w=2u l=0.13u
X50 VSS.t146 vdd_core.t4 vdd_core.t8 VSS.t145 sg13_lv_nmos ad=0.38p pd=2.38u as=0.38p ps=2.38u w=2u l=0.13u
X51 VSS.t77 vco_bias_0.vbg_buf VSS.t75 VSS.t64 sg13_lv_nmos ad=1.52p pd=8.38u as=0 ps=0 w=8u l=10u
X52 vdd_core.t12 vdd_core.t0 VSS.t159 VSS.t160 sg13_lv_nmos ad=0.38p pd=2.38u as=0.38p ps=2.38u w=2u l=0.13u
X53 rf_out_n.t0 a_9400_4880# a_11798_1860.t16 VSS.t94 sg13_lv_nmos ad=0.38p pd=2.38u as=0.38p ps=2.38u w=2u l=0.13u
X54 vdd_core.t2 vdd_core.t0 VSS.t154 VSS.t153 sg13_lv_nmos ad=0.38p pd=2.38u as=0.68p ps=4.68u w=2u l=0.13u
N55 vdd_core.t22 vtune.t6 sg13_hv_svaricap l=0.3u w=30.08u
X56 VSS.t50 vco_bias_0.vbn_buf.t2 a_11798_1860.t12 VSS.t49 sg13_lv_nmos ad=0.95p pd=5.38u as=0.95p ps=5.38u w=5u l=0.5u
X57 a_11798_1860.t10 vco_bias_0.vbn_buf.t2 VSS.t43 VSS.t44 sg13_lv_nmos ad=0.95p pd=5.38u as=0.95p ps=5.38u w=5u l=0.5u
X58 a_11798_1860.t0 vco_bias_0.vbn_buf.t2 VSS.t16 VSS.t15 sg13_lv_nmos ad=0.95p pd=5.38u as=1.7p ps=10.68u w=5u l=0.5u
X59 vdd_core.t7 vdd_core.t4 VSS.t140 VSS.t141 sg13_lv_nmos ad=0.38p pd=2.38u as=0.38p ps=2.38u w=2u l=0.13u
X60 VSS.t63 vco_bias_0.vbn_buf.t3 VSS.t61 VSS.t62 sg13_lv_nmos ad=1.52p pd=8.38u as=0 ps=0 w=8u l=10u
X61 VDD.t16 rf_out_n.t6 VSS.t108 rppd l=1.65u w=10u
X62 VSS.t117 VSS.t114 VSS.t116 VSS.t115 sg13_lv_nmos ad=0.85p pd=5.68u as=0 ps=0 w=2.5u l=0.5u
X63 VSS.t156 vdd_core.t0 vdd_core.t2 VSS.t155 sg13_lv_nmos ad=0.38p pd=2.38u as=0.38p ps=2.38u w=2u l=0.13u
X64 VSS.t67 vco_bias_0.vbn_buf.t3 VSS.t65 VSS.t66 sg13_lv_nmos ad=1.52p pd=8.38u as=0 ps=0 w=8u l=10u
X65 VSS.t23 vco_bias_0.vbn_buf.t2 a_11798_1860.t3 VSS.t22 sg13_lv_nmos ad=0.95p pd=5.38u as=0.95p ps=5.38u w=5u l=0.5u
X66 rf_out_n.t4 a_9400_4880# a_11798_1860.t19 VSS.t100 sg13_lv_nmos ad=0.38p pd=2.38u as=0.38p ps=2.38u w=2u l=0.13u
X67 rf_out_n.t1 a_9400_4880# a_11798_1860.t17 VSS.t96 sg13_lv_nmos ad=0.38p pd=2.38u as=0.38p ps=2.38u w=2u l=0.13u
X68 VSS.t6 vco_bias_0.vbn_buf.t4 VSS.t4 VSS.t5 sg13_lv_nmos ad=1.52p pd=8.38u as=0 ps=0 w=8u l=10u
X69 VDD.t15 VDD.t13 VDD.t14 VDD.t0 sg13_lv_pmos ad=1.7p pd=10.68u as=0 ps=0 w=5u l=0.5u
X70 VSS.t81 vco_bias_0.vbg_buf VSS.t79 VSS.t68 sg13_lv_nmos ad=1.52p pd=8.38u as=0 ps=0 w=8u l=10u
X71 a_5560_4622.t1 a_5560_4622.t0 VSS.t58 VSS.t57 sg13_lv_nmos ad=0.85p pd=5.68u as=0.85p ps=5.68u w=2.5u l=0.5u
X72 a_11798_1860.t24 a_14668_3324# rf_out_p.t6 VSS.t126 sg13_lv_nmos ad=0.38p pd=2.38u as=0.38p ps=2.38u w=2u l=0.13u
X73 rf_out_p.t3 a_14668_3324# a_11798_1860.t22 VSS.t123 sg13_lv_nmos ad=0.38p pd=2.38u as=0.68p ps=4.68u w=2u l=0.13u
X74 VSS.t89 vco_bias_0.vbg_buf VSS.t87 VSS.t66 sg13_lv_nmos ad=1.52p pd=8.38u as=0 ps=0 w=8u l=10u
X75 VSS.t43 vco_bias_0.vbn_buf.t2 a_11798_1860.t9 VSS.t42 sg13_lv_nmos ad=0.95p pd=5.38u as=0.95p ps=5.38u w=5u l=0.5u
X76 VSS.t12 vco_bias_0.vbn_buf.t2 a_11798_1860.t0 VSS.t17 sg13_lv_nmos ad=0.95p pd=5.38u as=0.95p ps=5.38u w=5u l=0.5u
N77 vdd_core.t24 vtune.t3 sg13_hv_svaricap l=0.3u w=30.08u
X78 a_11798_1860.t13 vco_bias_0.vbn_buf.t2 VSS.t50 VSS.t51 sg13_lv_nmos ad=0.95p pd=5.38u as=0.95p ps=5.38u w=5u l=0.5u
X79 a_6568_6836.t2 a_6568_6836.t1 VDD.t2 VDD.t0 sg13_lv_pmos ad=1.7p pd=10.68u as=1.7p ps=10.68u w=5u l=0.5u
X80 VSS.t168 vdd_core.t0 vdd_core.t1 VSS.t167 sg13_lv_nmos ad=0.68p pd=4.68u as=0.38p ps=2.38u w=2u l=0.13u
X81 a_11798_1860.t14 vco_bias_0.vbn_buf.t2 VSS.t53 VSS.t52 sg13_lv_nmos ad=0.95p pd=5.38u as=0.95p ps=5.38u w=5u l=0.5u
X82 VSS.t152 vdd_core.t4 vdd_core.t6 VSS.t151 sg13_lv_nmos ad=0.68p pd=4.68u as=0.38p ps=2.38u w=2u l=0.13u
X83 a_11798_1860.t27 a_14668_3324# rf_out_p.t4 VSS.t132 sg13_lv_nmos ad=0.38p pd=2.38u as=0.38p ps=2.38u w=2u l=0.13u
X84 vco_bias_0.vbg_buf a_9400_4880# VSS.t109 rhigh l=8u w=0.5u
X85 VSS.t87 vco_bias_0.vbg_buf VSS.t85 VSS.t64 sg13_lv_nmos ad=1.52p pd=8.38u as=0 ps=0 w=8u l=10u
X86 a_6568_6836.t0 ibias_100u.t4 VSS.t105 VSS.t104 sg13_lv_nmos ad=0.85p pd=5.68u as=0.85p ps=5.68u w=2.5u l=0.5u
X87 VSS.t65 vco_bias_0.vbn_buf.t3 VSS.t63 VSS.t64 sg13_lv_nmos ad=1.52p pd=8.38u as=0 ps=0 w=8u l=10u
X88 a_5948_5116.t1 a_5905_5252.t4 VSS.t170 VSS.t169 sg13_lv_nmos ad=0.17p pd=1.68u as=0.17p ps=1.68u w=0.5u l=0.13u
X89 a_11798_1860.t4 vco_bias_0.vbn_buf.t2 VSS.t23 VSS.t24 sg13_lv_nmos ad=0.95p pd=5.38u as=0.95p ps=5.38u w=5u l=0.5u
X90 vco_bias_0.vbg_buf a_5560_6408.t2 VSS.t111 rhigh l=32u w=0.5u
X91 VSS.t35 vco_bias_0.vbn_buf.t2 a_11798_1860.t7 VSS.t34 sg13_lv_nmos ad=0.95p pd=5.38u as=0.95p ps=5.38u w=5u l=0.5u
X92 VSS.t162 vdd_core.t0 vdd_core.t12 VSS.t161 sg13_lv_nmos ad=0.38p pd=2.38u as=0.38p ps=2.38u w=2u l=0.13u
X93 VSS.t53 vco_bias_0.vbn_buf.t2 a_11798_1860.t13 VSS.t54 sg13_lv_nmos ad=0.95p pd=5.38u as=0.95p ps=5.38u w=5u l=0.5u
X94 a_11798_1860.t20 a_9400_4880# rf_out_n.t4 VSS.t101 sg13_lv_nmos ad=0.38p pd=2.38u as=0.38p ps=2.38u w=2u l=0.13u
X95 a_11798_1860.t18 a_9400_4880# rf_out_n.t1 VSS.t97 sg13_lv_nmos ad=0.38p pd=2.38u as=0.38p ps=2.38u w=2u l=0.13u
X96 VSS.t56 vco_bias_0.vbn_buf.t2 a_11798_1860.t14 VSS.t55 sg13_lv_nmos ad=1.7p pd=10.68u as=0.95p ps=5.38u w=5u l=0.5u
X97 VSS.t2 vco_bias_0.vbn_buf.t4 VSS.t1 VSS.t0 sg13_lv_nmos ad=2.72p pd=16.68u as=0 ps=0 w=8u l=10u
X98 VSS.t73 vco_bias_0.vbg_buf VSS.t72 VSS.t59 sg13_lv_nmos ad=2.72p pd=16.68u as=0 ps=0 w=8u l=10u
X99 VSS.t91 vco_bias_0.vbg_buf VSS.t89 VSS.t68 sg13_lv_nmos ad=1.52p pd=8.38u as=0 ps=0 w=8u l=10u
X100 VSS.t143 vdd_core.t4 vdd_core.t7 VSS.t142 sg13_lv_nmos ad=0.38p pd=2.38u as=0.38p ps=2.38u w=2u l=0.13u
X101 vdd_core.t14 vdd_core.t0 VSS.t162 VSS.t163 sg13_lv_nmos ad=0.38p pd=2.38u as=0.38p ps=2.38u w=2u l=0.13u
X102 vco_bias_0.vbn_buf.t1 ibias_100u.t3 VSS.t112 rhigh l=32u w=0.5u
X103 vdd_core.t5 vdd_core.t4 VSS.t146 VSS.t147 sg13_lv_nmos ad=0.38p pd=2.38u as=0.38p ps=2.38u w=2u l=0.13u
X104 vdd_core.t3 vdd_core.t0 VSS.t156 VSS.t157 sg13_lv_nmos ad=0.38p pd=2.38u as=0.38p ps=2.38u w=2u l=0.13u
N105 vdd_core.t23 vtune.t6 sg13_hv_svaricap l=0.3u w=30.08u
X106 a_11798_1860.t7 vco_bias_0.vbn_buf.t2 VSS.t30 VSS.t33 sg13_lv_nmos ad=0.95p pd=5.38u as=0.95p ps=5.38u w=5u l=0.5u
X107 VSS.t121 VSS.t118 VSS.t120 VSS.t119 sg13_lv_nmos ad=0.85p pd=5.68u as=0 ps=0 w=2.5u l=0.5u
X108 VSS.t10 vco_bias_0.vbn_buf.t4 VSS.t8 VSS.t9 sg13_lv_nmos ad=1.52p pd=8.38u as=0 ps=0 w=8u l=10u
X109 VSS.t46 vco_bias_0.vbn_buf.t2 a_11798_1860.t10 VSS.t45 sg13_lv_nmos ad=0.95p pd=5.38u as=0.95p ps=5.38u w=5u l=0.5u
X110 a_11798_1860.t8 vco_bias_0.vbn_buf.t2 VSS.t35 VSS.t36 sg13_lv_nmos ad=0.95p pd=5.38u as=0.95p ps=5.38u w=5u l=0.5u
X111 VSS.t40 vco_bias_0.vbn_buf.t2 a_11798_1860.t11 VSS.t39 sg13_lv_nmos ad=0.95p pd=5.38u as=0.95p ps=5.38u w=5u l=0.5u
X112 rf_out_p.t5 a_14668_3324# a_11798_1860.t27 VSS.t133 sg13_lv_nmos ad=0.38p pd=2.38u as=0.38p ps=2.38u w=2u l=0.13u
X113 rf_out_p.t2 a_14668_3324# a_11798_1860.t25 VSS.t129 sg13_lv_nmos ad=0.38p pd=2.38u as=0.38p ps=2.38u w=2u l=0.13u
N114 vdd_core.t25 vtune.t3 sg13_hv_svaricap l=0.3u w=30.08u
X115 a_5948_5116.t0 a_5905_5252.t5 VDD.t3 VDD.t0 sg13_lv_pmos ad=0.34p pd=2.68u as=0.34p ps=2.68u w=1u l=0.13u
X116 ibias_100u.t2 ibias_100u.t1 VSS.t107 VSS.t106 sg13_lv_nmos ad=0.85p pd=5.68u as=0.85p ps=5.68u w=2.5u l=0.5u
N117 vdd_core.t27 vtune.t0 sg13_hv_svaricap l=0.3u w=30.08u
X118 rf_out_n.t2 a_9400_4880# a_11798_1860.t15 VSS.t92 sg13_lv_nmos ad=0.38p pd=2.38u as=0.68p ps=4.68u w=2u l=0.13u
X119 VSS.t61 vco_bias_0.vbn_buf.t3 VSS.t60 VSS.t59 sg13_lv_nmos ad=2.72p pd=16.68u as=0 ps=0 w=8u l=10u
X120 vco_bias_0.vbn_buf.t0 a_5905_5252.t2 VSS.t172 VSS.t171 sg13_lv_nmos ad=0.34p pd=2.68u as=0.34p ps=2.68u w=1u l=0.13u
X121 VSS.t14 vco_bias_0.vbn_buf.t2 a_11798_1860.t1 VSS.t13 sg13_lv_nmos ad=0.95p pd=5.38u as=0.95p ps=5.38u w=5u l=0.5u
X122 VSS.t75 vco_bias_0.vbg_buf VSS.t73 VSS.t62 sg13_lv_nmos ad=1.52p pd=8.38u as=0 ps=0 w=8u l=10u
X123 a_11798_1860.t5 vco_bias_0.vbn_buf.t2 VSS.t26 VSS.t31 sg13_lv_nmos ad=0.95p pd=5.38u as=0.95p ps=5.38u w=5u l=0.5u
X124 VDD.t17 rf_out_p.t0 VSS.t122 rppd l=1.65u w=10u
R0 rf_out_p rf_out_p.n2 7.11117
R1 rf_out_p.n0 rf_out_p.t3 4.77599
R2 rf_out_p.n1 rf_out_p.t5 4.72949
R3 rf_out_p.n1 rf_out_p.t4 4.72949
R4 rf_out_p.n0 rf_out_p.t2 4.72949
R5 rf_out_p.n0 rf_out_p.t1 4.72949
R6 rf_out_p.n0 rf_out_p.t6 4.72949
R7 rf_out_p.n2 rf_out_p.t0 2.40801
R8 rf_out_p.n2 rf_out_p.n1 0.685593
R9 rf_out_p.n1 rf_out_p.n0 0.186531
R10 rf_out_n rf_out_n.n2 7.11117
R11 rf_out_n.n0 rf_out_n.t3 4.77599
R12 rf_out_n.n0 rf_out_n.t4 4.72949
R13 rf_out_n.n0 rf_out_n.t5 4.72949
R14 rf_out_n.n1 rf_out_n.t1 4.72949
R15 rf_out_n.n1 rf_out_n.t0 4.72949
R16 rf_out_n.n1 rf_out_n.t2 4.72949
R17 rf_out_n.n2 rf_out_n.t6 2.40801
R18 rf_out_n.n2 rf_out_n.n1 0.685593
R19 rf_out_n.n1 rf_out_n.n0 0.186531
R20 ibias_100u.n3 ibias_100u.t3 48.9114
R21 ibias_100u.n0 ibias_100u.t4 24.2693
R22 ibias_100u.n1 ibias_100u.t1 24.2693
R23 ibias_100u ibias_100u.n3 19.3021
R24 ibias_100u.n0 ibias_100u.t0 17.3756
R25 ibias_100u.n2 ibias_100u.t2 9.21754
R26 ibias_100u.n3 ibias_100u.n2 4.77917
R27 ibias_100u.n1 ibias_100u.n0 0.543167
R28 ibias_100u.n2 ibias_100u.n1 0.320233
R29 di_en.n0 di_en.t0 21.6583
R30 di_en.n0 di_en.t1 19.605
R31 di_en di_en.n0 14.2289
R32 vdd_core.n87 vdd_core.n86 6.52948
R33 vdd_core.n46 vdd_core.n45 6.52948
R34 vdd_core.n102 vdd_core.n101 6.47038
R35 vdd_core.n169 vdd_core.n168 6.47038
R36 vdd_core.n235 vdd_core.n234 6.05177
R37 vdd_core.n212 vdd_core.n24 6.00132
R38 vdd_core.n3 vdd_core.t6 4.76919
R39 vdd_core.n0 vdd_core.t2 4.76919
R40 vdd_core.n107 vdd_core.t9 4.74635
R41 vdd_core.n126 vdd_core.t1 4.74635
R42 vdd_core.n4 vdd_core.t5 4.72949
R43 vdd_core.n110 vdd_core.t8 4.72949
R44 vdd_core.n111 vdd_core.t7 4.72949
R45 vdd_core.n125 vdd_core.t14 4.72949
R46 vdd_core.n121 vdd_core.t12 4.72949
R47 vdd_core.n1 vdd_core.t3 4.72949
R48 vdd_core.n113 vdd_core.t0 4.17215
R49 vdd_core.n128 vdd_core.t4 4.00826
R50 vdd_core.n108 vdd_core.t22 3.71265
R51 vdd_core.n123 vdd_core.t23 3.6936
R52 vdd_core.n143 vdd_core.n142 3.55422
R53 vdd_core.n108 vdd_core.t24 3.41873
R54 vdd_core.n109 vdd_core.t26 3.41873
R55 vdd_core.n123 vdd_core.t25 3.39968
R56 vdd_core.n124 vdd_core.t27 3.39968
R57 vdd_core.n147 vdd_core.n117 3.34302
R58 vdd_core.n136 vdd_core.n115 3.13182
R59 vdd_core.n134 vdd_core.n120 2.4579
R60 vdd_core.n141 vdd_core.n140 2.3523
R61 vdd_core.n145 vdd_core.n116 2.3523
R62 vdd_core.n4 vdd_core.n3 0.0338961
R63 vdd_core.n1 vdd_core.n0 0.0338961
R64 vdd_core.n148 vdd_core.n114 2.2467
R65 vdd_core.n138 vdd_core.n137 2.2467
R66 vdd_core.n7 vdd_core.n115 0.0886235
R67 vdd_core.n130 vdd_core.n129 1.94587
R68 vdd_core.n149 vdd_core.n148 1.86783
R69 vdd_core.n133 vdd_core.n132 1.79979
R70 vdd_core.n142 vdd_core.n135 1.72436
R71 vdd_core.n144 vdd_core.n143 1.72436
R72 vdd_core.n147 vdd_core.n146 1.64893
R73 vdd_core.n139 vdd_core.n117 1.64893
R74 vdd_core.n136 vdd_core.n8 0.134007
R75 vdd_core.n129 vdd_core.n118 1.44601
R76 vdd_core.n131 vdd_core.n119 1.16033
R77 vdd_core.n2 vdd_core.n107 1.12056
R78 vdd_core.n127 vdd_core.n126 1.12056
R79 vdd_core vdd_core.n248 0.9603
R80 vdd_core.n150 vdd_core.n149 0.917955
R81 vdd_core.n129 vdd_core.n128 0.833239
R82 vdd_core.n2 vdd_core.n112 0.741487
R83 vdd_core.n127 vdd_core.n122 0.741487
R84 vdd_core.n150 vdd_core.n79 0.56175
R85 vdd_core.n248 vdd_core.n247 0.5505
R86 vdd_core.n14 vdd_core.n9 0.5505
R87 vdd_core.n217 vdd_core.n216 0.5505
R88 vdd_core.n219 vdd_core.n218 0.5505
R89 vdd_core.n221 vdd_core.n220 0.5505
R90 vdd_core.n225 vdd_core.n181 0.5505
R91 vdd_core.n230 vdd_core.n229 0.5505
R92 vdd_core.n232 vdd_core.n231 0.5505
R93 vdd_core.n178 vdd_core.n26 0.5505
R94 vdd_core.n175 vdd_core.n174 0.5505
R95 vdd_core.n173 vdd_core.n172 0.5505
R96 vdd_core.n60 vdd_core.n37 0.5505
R97 vdd_core.n166 vdd_core.n165 0.5505
R98 vdd_core.n164 vdd_core.n47 0.5505
R99 vdd_core.n163 vdd_core.n162 0.5505
R100 vdd_core.n155 vdd_core.n63 0.5505
R101 vdd_core.n152 vdd_core.n151 0.5505
R102 vdd_core.n150 vdd_core.n106 0.5505
R103 vdd_core.n246 vdd_core.n11 0.446709
R104 vdd_core.n246 vdd_core.n245 0.445751
R105 vdd_core.n97 vdd_core.n84 0.4405
R106 vdd_core.n89 vdd_core.n88 0.4405
R107 vdd_core.n50 vdd_core.n43 0.4405
R108 vdd_core.n49 vdd_core.n48 0.4405
R109 vdd_core.n192 vdd_core.n190 0.4405
R110 vdd_core.n191 vdd_core.n183 0.4405
R111 vdd_core.n101 vdd_core.n84 0.4405
R112 vdd_core.n88 vdd_core.n87 0.4405
R113 vdd_core.n168 vdd_core.n43 0.4405
R114 vdd_core.n48 vdd_core.n46 0.4405
R115 vdd_core.n190 vdd_core.n189 0.4405
R116 vdd_core.n184 vdd_core.n183 0.4405
R117 vdd_core.n131 vdd_core.n130 0.421631
R118 vdd_core.n95 vdd_core.n94 0.3635
R119 vdd_core.n94 vdd_core.n81 0.3635
R120 vdd_core.n77 vdd_core.n75 0.3635
R121 vdd_core.n75 vdd_core.n73 0.3635
R122 vdd_core.n69 vdd_core.n67 0.3635
R123 vdd_core.n67 vdd_core.n65 0.3635
R124 vdd_core.n92 vdd_core.n91 0.3635
R125 vdd_core.n91 vdd_core.n80 0.3635
R126 vdd_core.n76 vdd_core.n74 0.3635
R127 vdd_core.n74 vdd_core.n72 0.3635
R128 vdd_core.n68 vdd_core.n66 0.3635
R129 vdd_core.n66 vdd_core.n64 0.3635
R130 vdd_core.n58 vdd_core.n54 0.3635
R131 vdd_core.n58 vdd_core.n57 0.3635
R132 vdd_core.n42 vdd_core.n35 0.3635
R133 vdd_core.n35 vdd_core.n33 0.3635
R134 vdd_core.n29 vdd_core.n27 0.3635
R135 vdd_core.n27 vdd_core.n5 0.421153
R136 vdd_core.n56 vdd_core.n53 0.3635
R137 vdd_core.n56 vdd_core.n55 0.3635
R138 vdd_core.n44 vdd_core.n34 0.3635
R139 vdd_core.n34 vdd_core.n32 0.3635
R140 vdd_core.n198 vdd_core.n196 0.3635
R141 vdd_core.n200 vdd_core.n198 0.3635
R142 vdd_core.n211 vdd_core.n210 0.3635
R143 vdd_core.n210 vdd_core.n209 0.3635
R144 vdd_core.n207 vdd_core.n206 0.3635
R145 vdd_core.n206 vdd_core.n205 0.3635
R146 vdd_core.n185 vdd_core.n184 0.3635
R147 vdd_core.n197 vdd_core.n195 0.3635
R148 vdd_core.n199 vdd_core.n197 0.3635
R149 vdd_core.n237 vdd_core.n236 0.3635
R150 vdd_core.n238 vdd_core.n237 0.3635
R151 vdd_core.n241 vdd_core.n240 0.3635
R152 vdd_core.n242 vdd_core.n241 0.3635
R153 vdd_core.n158 vdd_core.n64 0.345639
R154 vdd_core.n2 vdd_core.n109 0.33314
R155 vdd_core.n160 vdd_core.n159 0.299759
R156 vdd_core.n109 vdd_core.n108 0.29442
R157 vdd_core.n124 vdd_core.n123 0.29442
R158 vdd_core.n187 vdd_core.n24 0.276447
R159 vdd_core.n189 vdd_core.n188 0.276447
R160 vdd_core.n194 vdd_core.n192 0.276447
R161 vdd_core.n196 vdd_core.n194 0.276447
R162 vdd_core.n202 vdd_core.n200 0.276447
R163 vdd_core.n209 vdd_core.n208 0.276447
R164 vdd_core.n208 vdd_core.n207 0.276447
R165 vdd_core.n205 vdd_core.n204 0.276447
R166 vdd_core.n203 vdd_core.n11 0.276447
R167 vdd_core.n234 vdd_core.n23 0.276447
R168 vdd_core.n193 vdd_core.n191 0.276447
R169 vdd_core.n195 vdd_core.n193 0.276447
R170 vdd_core.n201 vdd_core.n199 0.276447
R171 vdd_core.n239 vdd_core.n238 0.276447
R172 vdd_core.n240 vdd_core.n239 0.276447
R173 vdd_core.n243 vdd_core.n242 0.276447
R174 vdd_core.n245 vdd_core.n244 0.276447
R175 vdd_core.n97 vdd_core.n96 0.276188
R176 vdd_core.n96 vdd_core.n95 0.276188
R177 vdd_core.n104 vdd_core.n81 0.276188
R178 vdd_core.n73 vdd_core.n71 0.276188
R179 vdd_core.n71 vdd_core.n69 0.276188
R180 vdd_core.n160 vdd_core.n65 0.276188
R181 vdd_core.n90 vdd_core.n89 0.276188
R182 vdd_core.n92 vdd_core.n90 0.276188
R183 vdd_core.n83 vdd_core.n80 0.276188
R184 vdd_core.n72 vdd_core.n70 0.276188
R185 vdd_core.n70 vdd_core.n68 0.276188
R186 vdd_core.n52 vdd_core.n50 0.276188
R187 vdd_core.n54 vdd_core.n52 0.276188
R188 vdd_core.n57 vdd_core.n39 0.276188
R189 vdd_core.n33 vdd_core.n31 0.276188
R190 vdd_core.n31 vdd_core.n29 0.276188
R191 vdd_core.n51 vdd_core.n49 0.276188
R192 vdd_core.n53 vdd_core.n51 0.276188
R193 vdd_core.n55 vdd_core.n38 0.276188
R194 vdd_core.n32 vdd_core.n30 0.276188
R195 vdd_core.n30 vdd_core.n28 0.276188
R196 vdd_core.n144 vdd_core.n118 0.264545
R197 vdd_core.n102 vdd_core.n77 0.2645
R198 vdd_core.n86 vdd_core.n76 0.2645
R199 vdd_core.n169 vdd_core.n42 0.2645
R200 vdd_core.n45 vdd_core.n44 0.2645
R201 vdd_core.n212 vdd_core.n211 0.2645
R202 vdd_core.n236 vdd_core.n235 0.2645
R203 vdd_core.n8 vdd_core.n138 0.449962
R204 vdd_core.n119 vdd_core.n118 0.249794
R205 vdd_core.n188 vdd_core.n187 0.199447
R206 vdd_core.n213 vdd_core.n202 0.199447
R207 vdd_core.n204 vdd_core.n203 0.199447
R208 vdd_core.n185 vdd_core.n23 0.199447
R209 vdd_core.n201 vdd_core.n22 0.199447
R210 vdd_core.n244 vdd_core.n243 0.199447
R211 vdd_core.n104 vdd_core.n103 0.199188
R212 vdd_core.n85 vdd_core.n83 0.199188
R213 vdd_core.n170 vdd_core.n39 0.199188
R214 vdd_core.n41 vdd_core.n38 0.199188
R215 vdd_core.n133 vdd_core.n130 0.195018
R216 vdd_core.n127 vdd_core.n124 0.175092
R217 vdd_core.n146 vdd_core.n114 0.1061
R218 vdd_core.n139 vdd_core.n138 0.1061
R219 vdd_core.n140 vdd_core.n135 0.1061
R220 vdd_core.n134 vdd_core.n133 0.1061
R221 vdd_core.n145 vdd_core.n144 0.1061
R222 vdd_core.n113 vdd_core.n2 0.102521
R223 vdd_core.n231 vdd_core.n180 0.1019
R224 vdd_core.n96 vdd_core.n79 0.101071
R225 vdd_core.n94 vdd_core.n82 0.101071
R226 vdd_core.n105 vdd_core.n104 0.101071
R227 vdd_core.n103 vdd_core.n78 0.101071
R228 vdd_core.n153 vdd_core.n75 0.101071
R229 vdd_core.n155 vdd_core.n71 0.101071
R230 vdd_core.n157 vdd_core.n67 0.101071
R231 vdd_core.n161 vdd_core.n160 0.101071
R232 vdd_core.n90 vdd_core.n79 0.101071
R233 vdd_core.n91 vdd_core.n82 0.101071
R234 vdd_core.n105 vdd_core.n83 0.101071
R235 vdd_core.n85 vdd_core.n78 0.101071
R236 vdd_core.n153 vdd_core.n74 0.101071
R237 vdd_core.n155 vdd_core.n70 0.101071
R238 vdd_core.n157 vdd_core.n66 0.101071
R239 vdd_core.n61 vdd_core.n52 0.101071
R240 vdd_core.n59 vdd_core.n58 0.101071
R241 vdd_core.n172 vdd_core.n39 0.101071
R242 vdd_core.n171 vdd_core.n170 0.101071
R243 vdd_core.n175 vdd_core.n35 0.101071
R244 vdd_core.n177 vdd_core.n31 0.101071
R245 vdd_core.n179 vdd_core.n27 0.101071
R246 vdd_core.n61 vdd_core.n51 0.101071
R247 vdd_core.n59 vdd_core.n56 0.101071
R248 vdd_core.n172 vdd_core.n38 0.101071
R249 vdd_core.n171 vdd_core.n41 0.101071
R250 vdd_core.n175 vdd_core.n34 0.101071
R251 vdd_core.n177 vdd_core.n30 0.101071
R252 vdd_core.n179 vdd_core.n6 0.00761283
R253 vdd_core.n187 vdd_core.n25 0.101071
R254 vdd_core.n188 vdd_core.n186 0.101071
R255 vdd_core.n226 vdd_core.n194 0.101071
R256 vdd_core.n223 vdd_core.n198 0.101071
R257 vdd_core.n215 vdd_core.n202 0.101071
R258 vdd_core.n214 vdd_core.n213 0.101071
R259 vdd_core.n210 vdd_core.n20 0.101071
R260 vdd_core.n208 vdd_core.n18 0.101071
R261 vdd_core.n206 vdd_core.n16 0.101071
R262 vdd_core.n204 vdd_core.n13 0.101071
R263 vdd_core.n203 vdd_core.n12 0.101071
R264 vdd_core.n25 vdd_core.n23 0.101071
R265 vdd_core.n186 vdd_core.n185 0.101071
R266 vdd_core.n226 vdd_core.n193 0.101071
R267 vdd_core.n223 vdd_core.n197 0.101071
R268 vdd_core.n215 vdd_core.n201 0.101071
R269 vdd_core.n214 vdd_core.n22 0.101071
R270 vdd_core.n237 vdd_core.n20 0.101071
R271 vdd_core.n239 vdd_core.n18 0.101071
R272 vdd_core.n241 vdd_core.n16 0.101071
R273 vdd_core.n243 vdd_core.n13 0.101071
R274 vdd_core.n244 vdd_core.n12 0.101071
R275 vdd_core.n128 vdd_core.n127 0.0955821
R276 vdd_core.n7 vdd_core.n8 0.872565
R277 vdd_core.n7 vdd_core.n114 0.433741
R278 vdd_core.n140 vdd_core.n139 0.0759286
R279 vdd_core.n135 vdd_core.n134 0.0759286
R280 vdd_core.n146 vdd_core.n145 0.0759286
R281 vdd_core.n100 vdd_core.n87 0.0759286
R282 vdd_core.n101 vdd_core.n100 0.0759286
R283 vdd_core.n162 vdd_core.n65 0.0759286
R284 vdd_core.n156 vdd_core.n69 0.0759286
R285 vdd_core.n154 vdd_core.n73 0.0759286
R286 vdd_core.n152 vdd_core.n77 0.0759286
R287 vdd_core.n106 vdd_core.n81 0.0759286
R288 vdd_core.n95 vdd_core.n93 0.0759286
R289 vdd_core.n98 vdd_core.n97 0.0759286
R290 vdd_core.n99 vdd_core.n84 0.0759286
R291 vdd_core.n162 vdd_core.n64 0.0759286
R292 vdd_core.n156 vdd_core.n68 0.0759286
R293 vdd_core.n154 vdd_core.n72 0.0759286
R294 vdd_core.n152 vdd_core.n76 0.0759286
R295 vdd_core.n106 vdd_core.n80 0.0759286
R296 vdd_core.n93 vdd_core.n92 0.0759286
R297 vdd_core.n99 vdd_core.n88 0.0759286
R298 vdd_core.n98 vdd_core.n89 0.0759286
R299 vdd_core.n167 vdd_core.n46 0.0759286
R300 vdd_core.n168 vdd_core.n167 0.0759286
R301 vdd_core.n178 vdd_core.n29 0.0759286
R302 vdd_core.n176 vdd_core.n33 0.0759286
R303 vdd_core.n42 vdd_core.n36 0.0759286
R304 vdd_core.n57 vdd_core.n40 0.0759286
R305 vdd_core.n60 vdd_core.n54 0.0759286
R306 vdd_core.n62 vdd_core.n50 0.0759286
R307 vdd_core.n166 vdd_core.n43 0.0759286
R308 vdd_core.n6 vdd_core.n28 0.439821
R309 vdd_core.n178 vdd_core.n28 0.0759286
R310 vdd_core.n176 vdd_core.n32 0.0759286
R311 vdd_core.n44 vdd_core.n36 0.0759286
R312 vdd_core.n55 vdd_core.n40 0.0759286
R313 vdd_core.n60 vdd_core.n53 0.0759286
R314 vdd_core.n166 vdd_core.n48 0.0759286
R315 vdd_core.n62 vdd_core.n49 0.0759286
R316 vdd_core.n234 vdd_core.n233 0.0759286
R317 vdd_core.n233 vdd_core.n24 0.0759286
R318 vdd_core.n11 vdd_core.n10 0.0759286
R319 vdd_core.n205 vdd_core.n15 0.0759286
R320 vdd_core.n207 vdd_core.n17 0.0759286
R321 vdd_core.n209 vdd_core.n19 0.0759286
R322 vdd_core.n211 vdd_core.n21 0.0759286
R323 vdd_core.n222 vdd_core.n200 0.0759286
R324 vdd_core.n224 vdd_core.n196 0.0759286
R325 vdd_core.n227 vdd_core.n192 0.0759286
R326 vdd_core.n228 vdd_core.n190 0.0759286
R327 vdd_core.n189 vdd_core.n182 0.0759286
R328 vdd_core.n245 vdd_core.n10 0.0759286
R329 vdd_core.n242 vdd_core.n15 0.0759286
R330 vdd_core.n240 vdd_core.n17 0.0759286
R331 vdd_core.n238 vdd_core.n19 0.0759286
R332 vdd_core.n236 vdd_core.n21 0.0759286
R333 vdd_core.n222 vdd_core.n199 0.0759286
R334 vdd_core.n224 vdd_core.n195 0.0759286
R335 vdd_core.n184 vdd_core.n182 0.0759286
R336 vdd_core.n228 vdd_core.n183 0.0759286
R337 vdd_core.n227 vdd_core.n191 0.0759286
R338 vdd_core.n167 vdd_core.n47 0.0738333
R339 vdd_core.n148 vdd_core.n115 0.0621
R340 vdd_core.n137 vdd_core.n136 0.0621
R341 vdd_core.n141 vdd_core.n117 0.0621
R342 vdd_core.n142 vdd_core.n120 0.0621
R343 vdd_core.n143 vdd_core.n119 0.0621
R344 vdd_core.n147 vdd_core.n116 0.0621
R345 vdd_core.n132 vdd_core.n131 0.0383489
R346 vdd_core.n5 vdd_core.n6 0.0351511
R347 vdd_core.n179 vdd_core.n178 0.0371667
R348 vdd_core.n178 vdd_core.n177 0.0371667
R349 vdd_core.n177 vdd_core.n176 0.0371667
R350 vdd_core.n176 vdd_core.n175 0.0371667
R351 vdd_core.n175 vdd_core.n36 0.0371667
R352 vdd_core.n171 vdd_core.n36 0.0371667
R353 vdd_core.n172 vdd_core.n171 0.0371667
R354 vdd_core.n172 vdd_core.n40 0.0371667
R355 vdd_core.n59 vdd_core.n40 0.0371667
R356 vdd_core.n60 vdd_core.n59 0.0371667
R357 vdd_core.n61 vdd_core.n60 0.0371667
R358 vdd_core.n62 vdd_core.n61 0.0371667
R359 vdd_core.n166 vdd_core.n62 0.0371667
R360 vdd_core.n167 vdd_core.n166 0.0371667
R361 vdd_core.n159 vdd_core.n47 0.0371667
R362 vdd_core.n162 vdd_core.n161 0.0371667
R363 vdd_core.n162 vdd_core.n157 0.0371667
R364 vdd_core.n157 vdd_core.n156 0.0371667
R365 vdd_core.n156 vdd_core.n155 0.0371667
R366 vdd_core.n155 vdd_core.n154 0.0371667
R367 vdd_core.n154 vdd_core.n153 0.0371667
R368 vdd_core.n153 vdd_core.n152 0.0371667
R369 vdd_core.n152 vdd_core.n78 0.0371667
R370 vdd_core.n105 vdd_core.n78 0.0371667
R371 vdd_core.n106 vdd_core.n105 0.0371667
R372 vdd_core.n106 vdd_core.n82 0.0371667
R373 vdd_core.n93 vdd_core.n82 0.0371667
R374 vdd_core.n93 vdd_core.n79 0.0371667
R375 vdd_core.n98 vdd_core.n79 0.0371667
R376 vdd_core.n99 vdd_core.n98 0.0371667
R377 vdd_core.n100 vdd_core.n99 0.0371667
R378 vdd_core.n12 vdd_core.n10 0.0371667
R379 vdd_core.n13 vdd_core.n12 0.0371667
R380 vdd_core.n16 vdd_core.n15 0.0371667
R381 vdd_core.n17 vdd_core.n16 0.0371667
R382 vdd_core.n19 vdd_core.n18 0.0371667
R383 vdd_core.n20 vdd_core.n19 0.0371667
R384 vdd_core.n214 vdd_core.n21 0.0371667
R385 vdd_core.n215 vdd_core.n214 0.0371667
R386 vdd_core.n223 vdd_core.n222 0.0371667
R387 vdd_core.n224 vdd_core.n223 0.0371667
R388 vdd_core.n227 vdd_core.n226 0.0371667
R389 vdd_core.n228 vdd_core.n227 0.0371667
R390 vdd_core.n186 vdd_core.n182 0.0371667
R391 vdd_core.n186 vdd_core.n25 0.0371667
R392 vdd_core.n148 vdd_core.n147 0.0319286
R393 vdd_core.n137 vdd_core.n117 0.0319286
R394 vdd_core.n142 vdd_core.n141 0.0319286
R395 vdd_core.n132 vdd_core.n120 0.0319286
R396 vdd_core.n143 vdd_core.n116 0.0319286
R397 vdd_core.n111 vdd_core.n107 0.0310403
R398 vdd_core.n126 vdd_core.n125 0.0310403
R399 vdd_core.n3 vdd_core.n2 0.59294
R400 vdd_core.n247 vdd_core.n10 0.028
R401 vdd_core.n15 vdd_core.n14 0.028
R402 vdd_core.n216 vdd_core.n18 0.028
R403 vdd_core.n218 vdd_core.n21 0.028
R404 vdd_core.n222 vdd_core.n221 0.028
R405 vdd_core.n226 vdd_core.n225 0.028
R406 vdd_core.n229 vdd_core.n182 0.028
R407 vdd_core.n233 vdd_core.n232 0.028
R408 vdd_core.n159 vdd_core.n158 0.0261384
R409 vdd_core.n125 vdd_core.n122 0.0260771
R410 vdd_core.n112 vdd_core.n111 0.0257351
R411 vdd_core.n112 vdd_core.n110 0.0233414
R412 vdd_core.n248 vdd_core.n9 0.023
R413 vdd_core.n217 vdd_core.n9 0.023
R414 vdd_core.n219 vdd_core.n217 0.023
R415 vdd_core.n220 vdd_core.n219 0.023
R416 vdd_core.n220 vdd_core.n181 0.023
R417 vdd_core.n230 vdd_core.n181 0.023
R418 vdd_core.n231 vdd_core.n230 0.023
R419 vdd_core.n180 vdd_core.n26 0.023
R420 vdd_core.n174 vdd_core.n26 0.023
R421 vdd_core.n174 vdd_core.n173 0.023
R422 vdd_core.n173 vdd_core.n37 0.023
R423 vdd_core.n165 vdd_core.n37 0.023
R424 vdd_core.n165 vdd_core.n164 0.023
R425 vdd_core.n164 vdd_core.n163 0.023
R426 vdd_core.n163 vdd_core.n63 0.023
R427 vdd_core.n151 vdd_core.n63 0.023
R428 vdd_core.n122 vdd_core.n121 0.0229994
R429 vdd_core.n110 vdd_core.n4 0.022386
R430 vdd_core.n121 vdd_core.n1 0.022386
R431 vdd_core.n127 vdd_core.n0 0.59294
R432 vdd_core.n213 vdd_core.n212 0.0124467
R433 vdd_core.n235 vdd_core.n22 0.0124467
R434 vdd_core.n103 vdd_core.n102 0.0121878
R435 vdd_core.n86 vdd_core.n85 0.0121878
R436 vdd_core.n170 vdd_core.n169 0.0121878
R437 vdd_core.n45 vdd_core.n41 0.0121878
R438 vdd_core.n151 vdd_core.n150 0.01175
R439 vdd_core.n247 vdd_core.n246 0.0113759
R440 vdd_core.n14 vdd_core.n13 0.00966667
R441 vdd_core.n216 vdd_core.n17 0.00966667
R442 vdd_core.n218 vdd_core.n20 0.00966667
R443 vdd_core.n221 vdd_core.n215 0.00966667
R444 vdd_core.n225 vdd_core.n224 0.00966667
R445 vdd_core.n229 vdd_core.n228 0.00966667
R446 vdd_core.n232 vdd_core.n25 0.00966667
R447 vdd_core.n161 vdd_core.n158 0.00944821
R448 vdd_core.n113 vdd_core.n149 1.16529
R449 vdd_core.n5 vdd_core.n180 0.578991
R450 VDD VDD.n6 22.8096
R451 VDD VDD.n12 17.9801
R452 VDD.n0 VDD.t13 17.5809
R453 VDD.n2 VDD.t10 17.5809
R454 VDD.n8 VDD.t7 17.5809
R455 VDD.n7 VDD.n8 0.0636783
R456 VDD.n11 VDD.n7 1.85672
R457 VDD.n3 VDD.t14 2.54491
R458 VDD.n10 VDD.t4 15.8062
R459 VDD.n11 VDD.n9 2.10335
R460 VDD.n8 VDD.t5 6.07554
R461 VDD.n8 VDD.t6 6.07554
R462 VDD.n4 VDD.t19 6.07554
R463 VDD.n5 VDD.t18 6.07554
R464 VDD.n6 VDD.t3 6.07554
R465 VDD.n11 VDD.n4 2.40129
R466 VDD.n4 VDD.n5 0.1061
R467 VDD.n12 VDD.t17 4.22454
R468 VDD.n6 VDD.n11 3.37539
R469 VDD.n11 VDD.n3 1.16155
R470 VDD.n2 VDD.t8 2.36482
R471 VDD.n2 VDD.t12 2.36408
R472 VDD.n0 VDD.t15 2.36375
R473 VDD.n1 VDD.t1 2.3637
R474 VDD.n1 VDD.t11 2.36357
R475 VDD.n0 VDD.t2 2.36327
R476 VDD.n2 VDD.t9 2.36322
R477 VDD.n12 VDD.t16 0.517741
R478 VDD.n11 VDD.t0 0.395849
R479 VDD.n1 VDD.n0 0.181347
R480 VDD.n6 VDD.n5 0.152127
R481 VDD.n3 VDD.n0 0.0814646
R482 VDD.n10 VDD.n4 0.144689
R483 VDD.n9 VDD.n1 0.139765
R484 VDD.n9 VDD.n2 0.137132
R485 VDD.n2 VDD.n7 0.120382
R486 VDD.n8 VDD.n10 0.102865
R487 vtune vtune.n1 16.693
R488 vtune.n0 vtune.t0 16.1774
R489 vtune.n0 vtune.t3 14.7078
R490 vtune.n1 vtune.t6 14.7078
R491 vtune.n1 vtune.n0 1.4701
R492 VSS.n383 VSS.n382 4127.1
R493 VSS.n576 VSS.t112 1462.4
R494 VSS.n567 VSS.t113 1390.68
R495 VSS.n347 VSS.n346 774.801
R496 VSS.n345 VSS.t109 666.034
R497 VSS.t110 VSS.t111 426.851
R498 VSS.t113 VSS.t122 374.546
R499 VSS.t109 VSS.n342 301.341
R500 VSS.n570 VSS.n569 278.832
R501 VSS.t108 VSS.n165 236.65
R502 VSS.t111 VSS.t112 200.87
R503 VSS.n333 VSS.t110 145.13
R504 VSS.t122 VSS.n566 132.113
R505 VSS.n340 VSS.t104 45.0201
R506 VSS.t119 VSS.n341 44.0139
R507 VSS.n372 VSS.n371 43.5761
R508 VSS.n335 VSS.t135 43.2932
R509 VSS.t64 VSS.n8 6.0485
R510 VSS.n338 VSS.t57 41.0027
R511 VSS.n5 VSS.n7 0.00141935
R512 VSS.n344 VSS.t68 39.9596
R513 VSS.n337 VSS.t171 39.4961
R514 VSS.n575 VSS.n91 39.4498
R515 VSS.t70 VSS.n335 34.254
R516 VSS.n346 VSS.n345 33.7949
R517 VSS.t115 VSS.n338 32.966
R518 VSS.n160 VSS.t19 32.8355
R519 VSS.n167 VSS.t11 31.2091
R520 VSS.n341 VSS.t106 29.9548
R521 VSS.t106 VSS.n340 28.9486
R522 VSS.n334 VSS.t169 28.4482
R523 VSS.t13 VSS.n167 27.9562
R524 VSS.t15 VSS.n165 26.837
R525 VSS.t18 VSS.n160 26.3297
R526 VSS.n339 VSS.t115 25.9964
R527 VSS.n166 VSS.t17 25.9797
R528 VSS.n9 VSS.n5 0.00126047
R529 VSS.t66 VSS.n91 25.5721
R530 VSS.n172 VSS.t93 24.804
R531 VSS.t95 VSS.n156 24.804
R532 VSS.n174 VSS.t97 24.804
R533 VSS.n336 VSS.t70 24.4308
R534 VSS.n9 VSS.t62 12.2521
R535 VSS.n343 VSS.t66 23.5166
R536 VSS.t17 VSS.n162 22.7276
R537 VSS.n382 VSS.n179 22.5291
R538 VSS.t92 VSS.n159 21.507
R539 VSS.t103 VSS.t27 19.8391
R540 VSS.t123 VSS.t37 19.8391
R541 VSS.t31 VSS.n153 19.5029
R542 VSS.t42 VSS.n195 19.5029
R543 VSS.n168 VSS.t18 19.4739
R544 VSS.t171 VSS.n336 19.4073
R545 VSS.t48 VSS.n137 19.3829
R546 VSS.n173 VSS.t24 18.7048
R547 VSS.t54 VSS.n561 18.4749
R548 VSS.n268 VSS.t33 18.1579
R549 VSS.n377 VSS.t34 18.1579
R550 VSS.t169 VSS.n333 18.0788
R551 VSS.t57 VSS.n337 17.9008
R552 VSS.n168 VSS.t13 17.8483
R553 VSS.n315 VSS.t170 17.3443
R554 VSS.n317 VSS.t136 17.3443
R555 VSS.n571 VSS.n570 17.0005
R556 VSS.n571 VSS.n98 17.0005
R557 VSS.n571 VSS.n112 17.0005
R558 VSS.n571 VSS.n101 17.0005
R559 VSS.n571 VSS.n107 17.0005
R560 VSS.n2 VSS.n571 17.0005
R561 VSS.n568 VSS.n567 17.0005
R562 VSS.n568 VSS.n115 17.0005
R563 VSS.n568 VSS.n128 17.0005
R564 VSS.n568 VSS.n118 17.0005
R565 VSS.n568 VSS.n123 17.0005
R566 VSS.n569 VSS.n568 17.0005
R567 VSS.n385 VSS.n198 17.0005
R568 VSS.n385 VSS.n140 17.0005
R569 VSS.n385 VSS.n197 17.0005
R570 VSS.n385 VSS.n263 17.0005
R571 VSS.n385 VSS.n384 17.0005
R572 VSS.n385 VSS.n142 17.0005
R573 VSS.n385 VSS.n195 17.0005
R574 VSS.n385 VSS.n264 17.0005
R575 VSS.n385 VSS.n381 17.0005
R576 VSS.n385 VSS.n144 17.0005
R577 VSS.n385 VSS.n380 17.0005
R578 VSS.n385 VSS.n265 17.0005
R579 VSS.n385 VSS.n191 17.0005
R580 VSS.n385 VSS.n266 17.0005
R581 VSS.n385 VSS.n379 17.0005
R582 VSS.n385 VSS.n267 17.0005
R583 VSS.n385 VSS.n377 17.0005
R584 VSS.n385 VSS.n268 17.0005
R585 VSS.n385 VSS.n376 17.0005
R586 VSS.n385 VSS.n270 17.0005
R587 VSS.n385 VSS.n375 17.0005
R588 VSS.n385 VSS.n150 17.0005
R589 VSS.n385 VSS.n374 17.0005
R590 VSS.n385 VSS.n271 17.0005
R591 VSS.n385 VSS.n180 17.0005
R592 VSS.n385 VSS.n272 17.0005
R593 VSS.n385 VSS.n373 17.0005
R594 VSS.n385 VSS.n153 17.0005
R595 VSS.n385 VSS.n179 17.0005
R596 VSS.n385 VSS.n347 17.0005
R597 VSS.n386 VSS.n385 17.0005
R598 VSS.n566 VSS.n565 17.0005
R599 VSS.n565 VSS.n138 17.0005
R600 VSS.n565 VSS.n198 17.0005
R601 VSS.n565 VSS.n140 17.0005
R602 VSS.n565 VSS.n197 17.0005
R603 VSS.n565 VSS.n142 17.0005
R604 VSS.n565 VSS.n195 17.0005
R605 VSS.n565 VSS.n144 17.0005
R606 VSS.n565 VSS.n191 17.0005
R607 VSS.n565 VSS.n148 17.0005
R608 VSS.n565 VSS.n186 17.0005
R609 VSS.n565 VSS.n150 17.0005
R610 VSS.n565 VSS.n180 17.0005
R611 VSS.n565 VSS.n153 17.0005
R612 VSS.n565 VSS.n179 17.0005
R613 VSS.n565 VSS.n154 17.0005
R614 VSS.n565 VSS.n174 17.0005
R615 VSS.n565 VSS.n155 17.0005
R616 VSS.n565 VSS.n173 17.0005
R617 VSS.n565 VSS.n156 17.0005
R618 VSS.n565 VSS.n172 17.0005
R619 VSS.n565 VSS.n165 17.0005
R620 VSS.n332 VSS.n273 17.0005
R621 VSS.n332 VSS.n276 17.0005
R622 VSS.n333 VSS.n332 17.0005
R623 VSS.t44 VSS.n142 16.8129
R624 VSS.t52 VSS.n132 16.7178
R625 VSS.t94 VSS.n156 16.6717
R626 VSS.n174 VSS.t96 16.6717
R627 VSS.n561 VSS.t51 16.659
R628 VSS.n321 VSS.t114 16.4809
R629 VSS.n328 VSS.t118 16.4809
R630 VSS.n137 VSS.t49 15.751
R631 VSS.t135 VSS.n334 15.3899
R632 VSS.n576 VSS.n9 15.2964
R633 VSS.n345 VSS.n344 15.2946
R634 VSS.n566 VSS.t55 14.9823
R635 VSS.n562 VSS.t52 14.901
R636 VSS.t11 VSS.n162 14.5945
R637 VSS.n292 VSS.n280 14.3477
R638 VSS.n560 VSS.t134 14.2208
R639 VSS.n0 VSS.t5 3.85835
R640 VSS.t29 VSS.n270 14.1229
R641 VSS.n379 VSS.t36 14.1229
R642 VSS.n313 VSS.n312 14.0894
R643 VSS.t0 VSS.n0 4.16307
R644 VSS.n0 VSS.t9 4.16041
R645 VSS.t104 VSS.n339 13.9432
R646 VSS.n575 VSS.n0 4.14599
R647 VSS.t133 VSS.n138 13.8474
R648 VSS.n172 VSS.t21 13.8254
R649 VSS.t98 VSS.n153 13.7866
R650 VSS.t100 VSS.n180 13.7866
R651 VSS.t102 VSS.n150 13.7866
R652 VSS.t124 VSS.n191 13.7866
R653 VSS.t126 VSS.n144 13.7866
R654 VSS.n195 VSS.t128 13.7866
R655 VSS.n269 VSS.n185 13.6726
R656 VSS.n378 VSS.n149 13.6726
R657 VSS.n311 VSS.n293 13.5948
R658 VSS.n303 VSS.n80 13.5948
R659 VSS.n292 VSS.n291 13.5948
R660 VSS.t49 VSS.n134 13.0858
R661 VSS.t19 VSS.n159 12.9689
R662 VSS.n382 VSS.n372 12.7436
R663 VSS.n4 VSS.n0 2.22323
R664 VSS.n260 VSS.t131 12.2584
R665 VSS.t51 VSS.n134 12.1771
R666 VSS.n166 VSS.t15 11.3424
R667 VSS.n342 VSS.t119 11.0303
R668 VSS.t96 VSS.n155 10.9791
R669 VSS.t93 VSS.n158 10.4718
R670 VSS.t45 VSS.n140 10.4424
R671 VSS.t101 VSS.t32 10.4242
R672 VSS.t125 VSS.t41 10.4242
R673 VSS.n562 VSS.t54 10.3618
R674 VSS.t3 VSS.n0 4.98418
R675 VSS.t32 VSS.n180 10.0879
R676 VSS.t41 VSS.n144 10.0879
R677 VSS.n158 VSS.t22 10.0651
R678 VSS.n579 VSS.n578 9.76416
R679 VSS.n560 VSS.t48 9.4531
R680 VSS.n263 VSS.t130 9.3074
R681 VSS.n198 VSS.t132 9.3074
R682 VSS.t68 VSS.n343 9.12915
R683 VSS.t59 VSS.n7 7.43062
R684 VSS.n179 VSS.t98 9.07918
R685 VSS.n272 VSS.t100 9.07918
R686 VSS.n374 VSS.t102 9.07918
R687 VSS.n265 VSS.t124 9.07918
R688 VSS.n381 VSS.t126 9.07918
R689 VSS.t128 VSS.n142 9.07918
R690 VSS.t24 VSS.n155 8.94601
R691 VSS.n376 VSS.t29 8.74293
R692 VSS.t36 VSS.n148 8.74293
R693 VSS.n132 VSS.t55 8.54511
R694 VSS.t22 VSS.t94 8.5394
R695 VSS.n371 VSS.n28 2.83417
R696 VSS.n28 VSS.n27 0.00166658
R697 VSS.n371 VSS.n30 2.83417
R698 VSS.n30 VSS.n29 0.00166658
R699 VSS.n371 VSS.n24 1.88961
R700 VSS.n32 VSS.n31 0.00216799
R701 VSS.n31 VSS.n33 0.00172462
R702 VSS.n33 VSS.n34 0.00170812
R703 VSS.n34 VSS.n35 0.00166658
R704 VSS.n371 VSS.n37 2.83417
R705 VSS.n37 VSS.n36 0.00166658
R706 VSS.n39 VSS.n38 0.00216799
R707 VSS.n38 VSS.n40 0.00172462
R708 VSS.n40 VSS.n41 0.00170812
R709 VSS.n41 VSS.n42 0.00166658
R710 VSS.n42 VSS.n21 0.00149997
R711 VSS.n371 VSS.n22 4.25113
R712 VSS.n63 VSS.n260 2.12569
R713 VSS.n63 VSS.n62 0.00170812
R714 VSS.n62 VSS.n64 0.00166658
R715 VSS.n260 VSS.n65 2.42956
R716 VSS.n260 VSS.n67 2.12578
R717 VSS.n67 VSS.n68 0.00274975
R718 VSS.n68 VSS.n49 0.00149997
R719 VSS.n260 VSS.n69 3.40102
R720 VSS.n260 VSS.n71 2.42956
R721 VSS.n260 VSS.n73 2.42956
R722 VSS.n260 VSS.n76 2.83417
R723 VSS.n76 VSS.n75 0.00166658
R724 VSS.n75 VSS.n56 0.00149997
R725 VSS.n260 VSS.n77 4.251
R726 VSS.n260 VSS.n58 2.83417
R727 VSS.n58 VSS.n78 0.00343129
R728 VSS.n352 VSS.n351 8.5005
R729 VSS.n78 VSS.n243 8.50224
R730 VSS.n332 VSS.n274 8.49288
R731 VSS.n356 VSS.n350 8.48628
R732 VSS.n357 VSS.n355 8.48544
R733 VSS.n358 VSS.n27 8.48544
R734 VSS.n358 VSS.n11 0.188868
R735 VSS.n11 VSS.n10 4.21231
R736 VSS.n359 VSS.n29 8.48544
R737 VSS.n359 VSS.n13 0.219757
R738 VSS.n13 VSS.n26 0.282981
R739 VSS.n26 VSS.n25 4.21231
R740 VSS.n26 VSS.n15 0.282573
R741 VSS.n360 VSS.n31 8.48544
R742 VSS.n361 VSS.n33 8.48544
R743 VSS.n362 VSS.n34 8.48544
R744 VSS.n363 VSS.n35 8.48544
R745 VSS.n363 VSS.n17 0.188868
R746 VSS.n17 VSS.n16 4.21231
R747 VSS.n364 VSS.n36 8.48544
R748 VSS.n364 VSS.n19 0.219757
R749 VSS.n365 VSS.n38 8.48544
R750 VSS.n366 VSS.n40 8.48544
R751 VSS.n367 VSS.n41 8.48544
R752 VSS.n368 VSS.n42 8.48544
R753 VSS.n369 VSS.n21 8.48544
R754 VSS.n369 VSS.n23 0.188868
R755 VSS.n23 VSS.n22 4.21231
R756 VSS.n354 VSS.n353 8.48544
R757 VSS.n62 VSS.n61 8.48544
R758 VSS.n248 VSS.n64 8.48544
R759 VSS.n248 VSS.n44 0.219757
R760 VSS.n249 VSS.n66 8.48544
R761 VSS.n47 VSS.n46 4.21231
R762 VSS.n250 VSS.n45 8.48544
R763 VSS.n251 VSS.n68 8.48544
R764 VSS.n50 VSS.n49 3.35165
R765 VSS.n254 VSS.n70 8.48544
R766 VSS.n256 VSS.n72 8.48544
R767 VSS.n52 VSS.n51 3.35165
R768 VSS.n257 VSS.n74 8.48544
R769 VSS.n54 VSS.n53 4.21231
R770 VSS.n258 VSS.n75 8.48544
R771 VSS.n57 VSS.n56 3.35165
R772 VSS.n259 VSS.n244 8.48544
R773 VSS.n259 VSS.n60 0.188868
R774 VSS.n59 VSS.n60 4.21231
R775 VSS.n60 VSS.n78 2.70154
R776 VSS.n580 VSS.n579 8.02386
R777 VSS.n578 VSS.n81 7.76695
R778 VSS.t39 VSS.n138 7.71842
R779 VSS.n176 VSS.n79 7.56743
R780 VSS.n556 VSS.n555 7.56743
R781 VSS.n5 VSS.n8 0.00674571
R782 VSS.n382 VSS.t25 6.91294
R783 VSS.n2 VSS.t137 6.90359
R784 VSS.n107 VSS.t139 6.90359
R785 VSS.n107 VSS.t141 6.90359
R786 VSS.t142 VSS.n101 6.90359
R787 VSS.t144 VSS.n101 6.90359
R788 VSS.n112 VSS.t145 6.90359
R789 VSS.n112 VSS.t147 6.90359
R790 VSS.t150 VSS.n98 6.90359
R791 VSS.n570 VSS.t151 6.90359
R792 VSS.n569 VSS.t153 6.90359
R793 VSS.n123 VSS.t155 6.90359
R794 VSS.t158 VSS.n118 6.90359
R795 VSS.t160 VSS.n118 6.90359
R796 VSS.n128 VSS.t161 6.90359
R797 VSS.n128 VSS.t163 6.90359
R798 VSS.t164 VSS.n115 6.90359
R799 VSS.t166 VSS.n115 6.90359
R800 VSS.n567 VSS.t167 6.90359
R801 VSS.n139 VSS.t133 6.89806
R802 VSS.n378 VSS.n148 6.83654
R803 VSS.n269 VSS.n186 6.83654
R804 VSS.n381 VSS.n143 6.83654
R805 VSS.n380 VSS.n145 6.83654
R806 VSS.n379 VSS.n147 6.83654
R807 VSS.n268 VSS.n187 6.83654
R808 VSS.n270 VSS.n182 6.83654
R809 VSS.n271 VSS.n181 6.83654
R810 VSS.n373 VSS.n152 6.83654
R811 VSS.n272 VSS.n152 6.83654
R812 VSS.n374 VSS.n181 6.83654
R813 VSS.n375 VSS.n182 6.83654
R814 VSS.n376 VSS.n185 6.83654
R815 VSS.n377 VSS.n187 6.83654
R816 VSS.n267 VSS.n149 6.83654
R817 VSS.n266 VSS.n147 6.83654
R818 VSS.n265 VSS.n145 6.83654
R819 VSS.n264 VSS.n143 6.83654
R820 VSS.n571 VSS.n113 6.69018
R821 VSS.n571 VSS.n100 6.69018
R822 VSS.n571 VSS.n108 6.69018
R823 VSS.n571 VSS.n103 6.69018
R824 VSS.n571 VSS.n104 6.69018
R825 VSS.n568 VSS.n129 6.69018
R826 VSS.n568 VSS.n117 6.69018
R827 VSS.n568 VSS.n124 6.69018
R828 VSS.n568 VSS.n120 6.69018
R829 VSS.n568 VSS.n122 6.69018
R830 VSS.t47 VSS.n139 6.67106
R831 VSS.n302 VSS.n294 6.67035
R832 VSS.n486 VSS.n485 6.61367
R833 VSS.n411 VSS.n234 6.51503
R834 VSS.n233 VSS.n224 6.5067
R835 VSS.n223 VSS.n214 6.5067
R836 VSS.n520 VSS.n519 6.34066
R837 VSS.t130 VSS.n197 6.12943
R838 VSS.n465 VSS.n464 6.09818
R839 VSS.n318 VSS.t71 6.07511
R840 VSS.n278 VSS.t172 6.07511
R841 VSS.n213 VSS.n201 6.04071
R842 VSS.n104 VSS.t137 5.92367
R843 VSS.t139 VSS.n104 5.92367
R844 VSS.t141 VSS.n103 5.92367
R845 VSS.n103 VSS.t142 5.92367
R846 VSS.n108 VSS.t144 5.92367
R847 VSS.t145 VSS.n108 5.92367
R848 VSS.t147 VSS.n100 5.92367
R849 VSS.t148 VSS.n100 5.92367
R850 VSS.n113 VSS.t150 5.92367
R851 VSS.t151 VSS.n113 5.92367
R852 VSS.n122 VSS.t153 5.92367
R853 VSS.t155 VSS.n122 5.92367
R854 VSS.t157 VSS.n120 5.92367
R855 VSS.n120 VSS.t158 5.92367
R856 VSS.n124 VSS.t160 5.92367
R857 VSS.t161 VSS.n124 5.92367
R858 VSS.t163 VSS.n117 5.92367
R859 VSS.n117 VSS.t164 5.92367
R860 VSS.n129 VSS.t166 5.92367
R861 VSS.t167 VSS.n129 5.92367
R862 VSS.n565 VSS.n561 5.84696
R863 VSS.n565 VSS.n137 5.84696
R864 VSS.n565 VSS.n139 5.84696
R865 VSS.n565 VSS.n196 5.84696
R866 VSS.n383 VSS.t44 5.71671
R867 VSS.n371 VSS.n350 5.66778
R868 VSS.n24 VSS.n12 0.00377745
R869 VSS.n371 VSS.n32 1.30786
R870 VSS.n371 VSS.n39 1.30786
R871 VSS.n371 VSS.n349 5.66778
R872 VSS.n65 VSS.n43 0.00249991
R873 VSS.n260 VSS.n48 5.66778
R874 VSS.n260 VSS.n242 5.66778
R875 VSS.n69 VSS.n246 0.00229996
R876 VSS.n71 VSS.n245 0.00249991
R877 VSS.n260 VSS.n55 5.66778
R878 VSS.n3 VSS.n0 1.33836
R879 VSS.n240 VSS.n3 0.607939
R880 VSS.n332 VSS.n331 5.65335
R881 VSS.n332 VSS.n324 5.65335
R882 VSS.n571 VSS.n114 5.65086
R883 VSS.n571 VSS.n99 5.65086
R884 VSS.n571 VSS.n111 5.65086
R885 VSS.n571 VSS.n102 5.65086
R886 VSS.n568 VSS.n131 5.65086
R887 VSS.n568 VSS.n116 5.65086
R888 VSS.n568 VSS.n127 5.65086
R889 VSS.n568 VSS.n121 5.65086
R890 VSS.n13 VSS.n12 3.35165
R891 VSS.n15 VSS.n14 3.35165
R892 VSS.n19 VSS.n18 3.35165
R893 VSS.n20 VSS.n370 5.64018
R894 VSS.n44 VSS.n43 3.35165
R895 VSS.n252 VSS.n247 5.64018
R896 VSS.n253 VSS.n246 5.64018
R897 VSS.n255 VSS.n245 5.64018
R898 VSS.n263 VSS.n196 5.30908
R899 VSS.n384 VSS.n196 5.30908
R900 VSS.n385 VSS.n378 5.08323
R901 VSS.n385 VSS.n269 5.08323
R902 VSS.n565 VSS.n143 5.08323
R903 VSS.n565 VSS.n145 5.08323
R904 VSS.n565 VSS.n147 5.08323
R905 VSS.n565 VSS.n149 5.08323
R906 VSS.n565 VSS.n187 5.08323
R907 VSS.n565 VSS.n185 5.08323
R908 VSS.n565 VSS.n182 5.08323
R909 VSS.n565 VSS.n181 5.08323
R910 VSS.n565 VSS.n152 5.08323
R911 VSS.n197 VSS.t45 4.99445
R912 VSS.n345 VSS.t108 4.87987
R913 VSS.t132 VSS.t47 4.76745
R914 VSS.t33 VSS.n186 4.70796
R915 VSS.t34 VSS.n267 4.70796
R916 VSS.n565 VSS.n158 4.68877
R917 VSS.n565 VSS.n160 4.68877
R918 VSS.n565 VSS.n167 4.68877
R919 VSS.n578 VSS.n577 4.67815
R920 VSS.n351 VSS.t148 4.60256
R921 VSS.n243 VSS.t157 4.60256
R922 VSS.n290 VSS.n282 4.3831
R923 VSS.t7 VSS.n4 6.64567
R924 VSS.n577 VSS.n6 0.239722
R925 VSS.n81 VSS.n1 0.239728
R926 VSS.n371 VSS.n348 4.251
R927 VSS.n342 VSS.n332 4.24177
R928 VSS.n332 VSS.n329 4.23094
R929 VSS.n332 VSS.n277 4.23094
R930 VSS.n332 VSS.n319 4.23094
R931 VSS.n571 VSS.n106 4.22744
R932 VSS.n568 VSS.n119 4.22744
R933 VSS.n553 VSS.n552 3.93263
R934 VSS.n387 VSS.n240 3.89224
R935 VSS.n387 VSS.n386 3.88607
R936 VSS.n371 VSS.n347 3.59762
R937 VSS.n391 VSS.n388 3.57733
R938 VSS.n518 VSS.n517 3.57193
R939 VSS.n354 VSS.n352 3.56864
R940 VSS.n397 VSS.t156 3.45423
R941 VSS.n125 VSS.t159 3.45423
R942 VSS.n126 VSS.t162 3.45423
R943 VSS.n130 VSS.t165 3.45423
R944 VSS.n105 VSS.t140 3.45423
R945 VSS.n109 VSS.t143 3.45423
R946 VSS.n110 VSS.t146 3.45423
R947 VSS.n389 VSS.t149 3.45423
R948 VSS.n237 VSS.t154 3.45313
R949 VSS.n517 VSS.t168 3.45313
R950 VSS.n239 VSS.t138 3.45313
R951 VSS.n238 VSS.t152 3.45313
R952 VSS.n565 VSS.n564 3.38758
R953 VSS.n565 VSS.n136 3.38758
R954 VSS.n565 VSS.n559 3.38758
R955 VSS.n565 VSS.n141 3.38758
R956 VSS.n565 VSS.n194 3.38758
R957 VSS.n565 VSS.n146 3.38758
R958 VSS.n565 VSS.n184 3.38758
R959 VSS.n565 VSS.n151 3.38758
R960 VSS.n565 VSS.n178 3.38758
R961 VSS.n565 VSS.n157 3.38758
R962 VSS.n565 VSS.n171 3.38758
R963 VSS.n565 VSS.n164 3.38758
R964 VSS.n399 VSS.n398 3.3755
R965 VSS.n396 VSS.n395 3.3755
R966 VSS.n394 VSS.n236 3.3755
R967 VSS.n393 VSS.n392 3.3755
R968 VSS.n391 VSS.n390 3.3755
R969 VSS.n332 VSS.n322 3.37539
R970 VSS.n332 VSS.n279 3.37539
R971 VSS.n332 VSS.n316 3.37539
R972 VSS.n331 VSS.t121 3.18948
R973 VSS.n320 VSS.t58 3.14902
R974 VSS.n275 VSS.t116 3.14902
R975 VSS.n323 VSS.t117 3.14902
R976 VSS.n325 VSS.t105 3.14902
R977 VSS.n327 VSS.t107 3.14902
R978 VSS.n330 VSS.t120 3.14902
R979 VSS.t21 VSS.t92 2.8468
R980 VSS.n173 VSS.t95 2.8468
R981 VSS.t97 VSS.n154 2.8468
R982 VSS.n565 VSS.n133 2.81806
R983 VSS.n565 VSS.n190 2.81806
R984 VSS.n565 VSS.n161 2.81806
R985 VSS.n332 VSS.n326 2.80331
R986 VSS.n315 VSS.n314 2.71772
R987 VSS.n3 VSS.t7 5.379
R988 VSS.n383 VSS.t129 2.69048
R989 VSS.n164 VSS.t16 2.40146
R990 VSS.n564 VSS.t56 2.39941
R991 VSS.n169 VSS.t14 2.3605
R992 VSS.n563 VSS.t53 2.3605
R993 VSS.n177 VSS.t26 2.36013
R994 VSS.n192 VSS.t38 2.36006
R995 VSS.n557 VSS.t46 2.36006
R996 VSS.n188 VSS.t30 2.35993
R997 VSS.n183 VSS.t28 2.35987
R998 VSS.n189 VSS.t35 2.35974
R999 VSS.n193 VSS.t43 2.35963
R1000 VSS.n135 VSS.t50 2.35945
R1001 VSS.n558 VSS.t40 2.35938
R1002 VSS.n175 VSS.t23 2.35906
R1003 VSS.n163 VSS.t12 2.35901
R1004 VSS.n170 VSS.t20 2.35901
R1005 VSS.n373 VSS.t99 2.35423
R1006 VSS.n271 VSS.t101 2.35423
R1007 VSS.n375 VSS.t103 2.35423
R1008 VSS.n266 VSS.t123 2.35423
R1009 VSS.n380 VSS.t125 2.35423
R1010 VSS.n264 VSS.t127 2.35423
R1011 VSS.n351 VSS.n98 2.30153
R1012 VSS.n243 VSS.n123 2.30153
R1013 VSS.n565 VSS.n132 2.28106
R1014 VSS.n565 VSS.n562 2.28106
R1015 VSS.n565 VSS.n134 2.28106
R1016 VSS.n565 VSS.n560 2.28106
R1017 VSS.n88 VSS.t89 2.2115
R1018 VSS.n89 VSS.t91 2.2112
R1019 VSS.n86 VSS.t85 2.21086
R1020 VSS.n85 VSS.t83 2.21084
R1021 VSS.n572 VSS.t67 2.21082
R1022 VSS.n577 VSS.t82 2.21073
R1023 VSS.n81 VSS.t60 2.21042
R1024 VSS.n96 VSS.t63 2.21036
R1025 VSS.n95 VSS.t61 2.21005
R1026 VSS.n573 VSS.t69 2.21005
R1027 VSS.n93 VSS.t65 2.20978
R1028 VSS.n83 VSS.t87 2.20953
R1029 VSS.n83 VSS.t77 2.20242
R1030 VSS.n86 VSS.t75 2.20216
R1031 VSS.n93 VSS.t6 2.20193
R1032 VSS.n573 VSS.t10 2.20188
R1033 VSS.n85 VSS.t73 2.20185
R1034 VSS.n88 VSS.t79 2.20164
R1035 VSS.n577 VSS.t72 2.20155
R1036 VSS.n96 VSS.t4 2.20147
R1037 VSS.n89 VSS.t81 2.20128
R1038 VSS.n572 VSS.t8 2.20119
R1039 VSS.n95 VSS.t2 2.20112
R1040 VSS.n81 VSS.t1 2.20097
R1041 VSS.n240 VSS.n4 2.38888
R1042 VSS.t131 VSS.n140 1.58948
R1043 VSS.n260 VSS.n198 1.58948
R1044 VSS.t134 VSS.t39 1.58948
R1045 VSS.n565 VSS.n159 1.40016
R1046 VSS.n565 VSS.n168 1.40016
R1047 VSS.n565 VSS.n162 1.40016
R1048 VSS.n565 VSS.n166 1.40016
R1049 VSS.n540 VSS.n539 1.30527
R1050 VSS.t99 VSS.t31 1.00924
R1051 VSS.t127 VSS.t42 1.00924
R1052 VSS.n262 VSS.n261 0.920695
R1053 VSS.n262 VSS.n241 0.882565
R1054 VSS.n530 VSS.n529 0.812182
R1055 VSS.t27 VSS.n150 0.672995
R1056 VSS.t37 VSS.n191 0.672995
R1057 VSS.n293 VSS.n80 0.471929
R1058 VSS.n313 VSS.n293 0.471929
R1059 VSS.n450 VSS.n434 0.4405
R1060 VSS.n226 VSS.n225 0.4405
R1061 VSS.n216 VSS.n215 0.4405
R1062 VSS.n206 VSS.n205 0.4405
R1063 VSS.n410 VSS.n409 0.4405
R1064 VSS.n434 VSS.n433 0.4405
R1065 VSS.n225 VSS.n224 0.4405
R1066 VSS.n215 VSS.n214 0.4405
R1067 VSS.n205 VSS.n204 0.4405
R1068 VSS.n411 VSS.n410 0.4405
R1069 VSS.n475 VSS.n474 0.424088
R1070 VSS.n414 VSS.n412 0.422335
R1071 VSS.n382 VSS.n154 0.407114
R1072 VSS.n422 VSS.n421 0.367167
R1073 VSS.n437 VSS.n436 0.367167
R1074 VSS.n439 VSS.n438 0.367167
R1075 VSS.n444 VSS.n440 0.367167
R1076 VSS.n455 VSS.n454 0.367167
R1077 VSS.n457 VSS.n456 0.367167
R1078 VSS.n461 VSS.n199 0.367167
R1079 VSS.n554 VSS.n553 0.367167
R1080 VSS.n449 VSS.n448 0.3635
R1081 VSS.n448 VSS.n447 0.3635
R1082 VSS.n467 VSS.n466 0.3635
R1083 VSS.n468 VSS.n467 0.3635
R1084 VSS.n471 VSS.n470 0.3635
R1085 VSS.n472 VSS.n471 0.3635
R1086 VSS.n230 VSS.n229 0.3635
R1087 VSS.n229 VSS.n228 0.3635
R1088 VSS.n220 VSS.n219 0.3635
R1089 VSS.n219 VSS.n218 0.3635
R1090 VSS.n210 VSS.n209 0.3635
R1091 VSS.n209 VSS.n208 0.3635
R1092 VSS.n406 VSS.n405 0.3635
R1093 VSS.n407 VSS.n406 0.3635
R1094 VSS.n419 VSS.n418 0.3635
R1095 VSS.n481 VSS.n478 0.3635
R1096 VSS.n479 VSS.n478 0.3635
R1097 VSS.n418 VSS.n417 0.3635
R1098 VSS.n415 VSS.n414 0.3635
R1099 VSS.n290 VSS.n289 0.346655
R1100 VSS.n486 VSS.n480 0.338523
R1101 VSS.n394 VSS.n393 0.337235
R1102 VSS.n395 VSS.n394 0.337235
R1103 VSS.n540 VSS.n213 0.31812
R1104 VSS.n520 VSS.n233 0.31812
R1105 VSS.n530 VSS.n223 0.31812
R1106 VSS.n519 VSS.n234 0.31812
R1107 VSS.n302 VSS.n301 0.307456
R1108 VSS.n289 VSS.n288 0.303948
R1109 VSS.n288 VSS.n287 0.303948
R1110 VSS.n287 VSS.n286 0.303948
R1111 VSS.n286 VSS.n282 0.303948
R1112 VSS.n335 VSS.n332 0.302472
R1113 VSS.n579 VSS.n80 0.302214
R1114 VSS.n385 VSS.n372 0.291211
R1115 VSS.n513 VSS.n512 0.288357
R1116 VSS.n580 VSS.n79 0.27725
R1117 VSS.n464 VSS.n463 0.276447
R1118 VSS.n433 VSS.n432 0.276447
R1119 VSS.n451 VSS.n450 0.276447
R1120 VSS.n451 VSS.n449 0.276447
R1121 VSS.n447 VSS.n446 0.276447
R1122 VSS.n469 VSS.n468 0.276447
R1123 VSS.n470 VSS.n469 0.276447
R1124 VSS.n473 VSS.n472 0.276447
R1125 VSS.n211 VSS.n210 0.276447
R1126 VSS.n208 VSS.n207 0.276447
R1127 VSS.n207 VSS.n206 0.276447
R1128 VSS.n204 VSS.n203 0.276447
R1129 VSS.n202 VSS.n201 0.276447
R1130 VSS.n231 VSS.n230 0.276188
R1131 VSS.n228 VSS.n227 0.276188
R1132 VSS.n227 VSS.n226 0.276188
R1133 VSS.n221 VSS.n220 0.276188
R1134 VSS.n218 VSS.n217 0.276188
R1135 VSS.n217 VSS.n216 0.276188
R1136 VSS.n405 VSS.n400 0.276188
R1137 VSS.n408 VSS.n407 0.276188
R1138 VSS.n409 VSS.n408 0.276188
R1139 VSS.n483 VSS.n481 0.276188
R1140 VSS.n480 VSS.n479 0.276188
R1141 VSS.n417 VSS.n416 0.276188
R1142 VSS.n416 VSS.n415 0.276188
R1143 VSS.n487 VSS.n476 0.2755
R1144 VSS.n492 VSS.n491 0.2755
R1145 VSS.n494 VSS.n493 0.2755
R1146 VSS.n498 VSS.n413 0.2755
R1147 VSS.n503 VSS.n502 0.2755
R1148 VSS.n505 VSS.n504 0.2755
R1149 VSS.n507 VSS.n402 0.2755
R1150 VSS.n512 VSS.n511 0.2755
R1151 VSS.n474 VSS.n473 0.271823
R1152 VSS.n301 VSS.n300 0.267167
R1153 VSS.n300 VSS.n299 0.267167
R1154 VSS.n299 VSS.n298 0.267167
R1155 VSS.n298 VSS.n297 0.267167
R1156 VSS.n297 VSS.n296 0.267167
R1157 VSS.n296 VSS.n295 0.267167
R1158 VSS.n295 VSS.n294 0.267167
R1159 VSS.n466 VSS.n465 0.2645
R1160 VSS.n485 VSS.n419 0.2645
R1161 VSS.n6 VSS.n85 0.225224
R1162 VSS.n95 VSS.n1 0.225221
R1163 VSS.n87 VSS.n85 0.243424
R1164 VSS.n97 VSS.n95 0.243424
R1165 VSS.n83 VSS.n82 0.24245
R1166 VSS.n93 VSS.n92 0.24245
R1167 VSS.n393 VSS.n238 0.241827
R1168 VSS.n395 VSS.n237 0.241827
R1169 VSS.n86 VSS.n84 0.240796
R1170 VSS.n96 VSS.n94 0.240796
R1171 VSS.n90 VSS.n88 0.239822
R1172 VSS.n574 VSS.n572 0.239822
R1173 VSS.n5 VSS.n6 0.207274
R1174 VSS.n88 VSS.n82 0.227974
R1175 VSS.n572 VSS.n92 0.227974
R1176 VSS.n384 VSS.n383 0.227498
R1177 VSS.n87 VSS.n86 0.227001
R1178 VSS.n97 VSS.n96 0.227001
R1179 VSS.n385 VSS.n262 0.22697
R1180 VSS.n314 VSS.n292 0.226786
R1181 VSS.n90 VSS.n89 0.225646
R1182 VSS.n574 VSS.n573 0.225646
R1183 VSS.n84 VSS.n83 0.224672
R1184 VSS.n94 VSS.n93 0.224672
R1185 VSS.n0 VSS.n92 0.218846
R1186 VSS.n0 VSS.n97 0.218846
R1187 VSS.n5 VSS.n82 0.218846
R1188 VSS.n5 VSS.n87 0.218846
R1189 VSS.n314 VSS.n313 0.214214
R1190 VSS.n0 VSS.n574 0.208386
R1191 VSS.n0 VSS.n94 0.208386
R1192 VSS.n5 VSS.n90 0.208386
R1193 VSS.n5 VSS.n84 0.208386
R1194 VSS.n463 VSS.n432 0.199447
R1195 VSS.n446 VSS.n431 0.199447
R1196 VSS.n212 VSS.n211 0.199447
R1197 VSS.n203 VSS.n202 0.199447
R1198 VSS.n232 VSS.n231 0.199188
R1199 VSS.n222 VSS.n221 0.199188
R1200 VSS.n400 VSS.n235 0.199188
R1201 VSS.n484 VSS.n483 0.199188
R1202 VSS.n252 VSS.n50 0.251491
R1203 VSS.n253 VSS.n252 0.189041
R1204 VSS.n476 VSS.n475 0.165999
R1205 VSS.n515 VSS.n399 0.161968
R1206 VSS.n360 VSS.n15 0.220165
R1207 VSS.n365 VSS.n19 0.220165
R1208 VSS.n370 VSS.n354 0.157715
R1209 VSS.n249 VSS.n44 0.220165
R1210 VSS.n254 VSS.n253 0.157715
R1211 VSS.n256 VSS.n255 0.157715
R1212 VSS.n257 VSS.n52 0.220165
R1213 VSS.n259 VSS.n57 0.220165
R1214 VSS.n370 VSS.n23 0.220194
R1215 VSS.n50 VSS.n251 0.219757
R1216 VSS.n255 VSS.n254 0.157378
R1217 VSS.n52 VSS.n256 0.219757
R1218 VSS.n57 VSS.n258 0.219757
R1219 VSS.n356 VSS.n241 0.154026
R1220 VSS.n357 VSS.n356 0.126053
R1221 VSS.n358 VSS.n357 0.126053
R1222 VSS.n359 VSS.n11 0.188868
R1223 VSS.n361 VSS.n360 0.126053
R1224 VSS.n362 VSS.n361 0.126053
R1225 VSS.n363 VSS.n362 0.126053
R1226 VSS.n364 VSS.n17 0.188868
R1227 VSS.n366 VSS.n365 0.126053
R1228 VSS.n367 VSS.n366 0.126053
R1229 VSS.n368 VSS.n367 0.126053
R1230 VSS.n369 VSS.n368 0.126053
R1231 VSS.n248 VSS.n61 0.126053
R1232 VSS.n47 VSS.n249 0.188868
R1233 VSS.n250 VSS.n47 0.188868
R1234 VSS.n251 VSS.n250 0.126053
R1235 VSS.n54 VSS.n257 0.188868
R1236 VSS.n258 VSS.n54 0.188868
R1237 VSS.n555 VSS.n554 0.12605
R1238 VSS.n392 VSS.n391 0.121601
R1239 VSS.n392 VSS.n236 0.121601
R1240 VSS.n396 VSS.n236 0.121601
R1241 VSS.n399 VSS.n396 0.121601
R1242 VSS.n285 VSS.n280 0.103584
R1243 VSS.n521 VSS.n520 0.102006
R1244 VSS.n531 VSS.n530 0.102006
R1245 VSS.n541 VSS.n540 0.102006
R1246 VSS.n463 VSS.n462 0.101071
R1247 VSS.n460 VSS.n432 0.101071
R1248 VSS.n452 VSS.n451 0.101071
R1249 VSS.n448 VSS.n441 0.101071
R1250 VSS.n446 VSS.n445 0.101071
R1251 VSS.n443 VSS.n431 0.101071
R1252 VSS.n467 VSS.n429 0.101071
R1253 VSS.n469 VSS.n427 0.101071
R1254 VSS.n471 VSS.n425 0.101071
R1255 VSS.n473 VSS.n423 0.101071
R1256 VSS.n521 VSS.n232 0.101071
R1257 VSS.n522 VSS.n231 0.101071
R1258 VSS.n524 VSS.n229 0.101071
R1259 VSS.n526 VSS.n227 0.101071
R1260 VSS.n531 VSS.n222 0.101071
R1261 VSS.n532 VSS.n221 0.101071
R1262 VSS.n534 VSS.n219 0.101071
R1263 VSS.n536 VSS.n217 0.101071
R1264 VSS.n541 VSS.n212 0.101071
R1265 VSS.n542 VSS.n211 0.101071
R1266 VSS.n544 VSS.n209 0.101071
R1267 VSS.n546 VSS.n207 0.101071
R1268 VSS.n550 VSS.n203 0.101071
R1269 VSS.n551 VSS.n202 0.101071
R1270 VSS.n516 VSS.n235 0.101071
R1271 VSS.n514 VSS.n400 0.101071
R1272 VSS.n406 VSS.n404 0.101071
R1273 VSS.n510 VSS.n408 0.101071
R1274 VSS.n484 VSS.n420 0.101071
R1275 VSS.n483 VSS.n482 0.101071
R1276 VSS.n490 VSS.n478 0.101071
R1277 VSS.n488 VSS.n480 0.101071
R1278 VSS.n496 VSS.n418 0.101071
R1279 VSS.n499 VSS.n416 0.101071
R1280 VSS.n501 VSS.n414 0.101071
R1281 VSS.n261 VSS.n61 0.094443
R1282 VSS.n326 VSS.n325 0.0927224
R1283 VSS.n327 VSS.n326 0.0891245
R1284 VSS.n552 VSS.n551 0.0885
R1285 VSS.n551 VSS.n550 0.0885
R1286 VSS.n550 VSS.n549 0.0885
R1287 VSS.n549 VSS.n548 0.0885
R1288 VSS.n548 VSS.n547 0.0885
R1289 VSS.n547 VSS.n546 0.0885
R1290 VSS.n546 VSS.n545 0.0885
R1291 VSS.n545 VSS.n544 0.0885
R1292 VSS.n544 VSS.n543 0.0885
R1293 VSS.n543 VSS.n542 0.0885
R1294 VSS.n542 VSS.n541 0.0885
R1295 VSS.n539 VSS.n538 0.0885
R1296 VSS.n538 VSS.n537 0.0885
R1297 VSS.n537 VSS.n536 0.0885
R1298 VSS.n536 VSS.n535 0.0885
R1299 VSS.n535 VSS.n534 0.0885
R1300 VSS.n534 VSS.n533 0.0885
R1301 VSS.n533 VSS.n532 0.0885
R1302 VSS.n532 VSS.n531 0.0885
R1303 VSS.n529 VSS.n528 0.0885
R1304 VSS.n528 VSS.n527 0.0885
R1305 VSS.n527 VSS.n526 0.0885
R1306 VSS.n526 VSS.n525 0.0885
R1307 VSS.n525 VSS.n524 0.0885
R1308 VSS.n524 VSS.n523 0.0885
R1309 VSS.n523 VSS.n522 0.0885
R1310 VSS.n522 VSS.n521 0.0885
R1311 VSS.n305 VSS.n304 0.0885
R1312 VSS.n306 VSS.n305 0.0885
R1313 VSS.n307 VSS.n306 0.0885
R1314 VSS.n308 VSS.n307 0.0885
R1315 VSS.n309 VSS.n308 0.0885
R1316 VSS.n310 VSS.n309 0.0885
R1317 VSS.n283 VSS.n281 0.0885
R1318 VSS.n284 VSS.n283 0.0885
R1319 VSS.n285 VSS.n284 0.0885
R1320 VSS.n291 VSS.n290 0.0853311
R1321 VSS.n388 VSS.n239 0.0846837
R1322 VSS.n311 VSS.n310 0.0841
R1323 VSS.n341 VSS.n332 0.0817061
R1324 VSS.n340 VSS.n332 0.0817061
R1325 VSS.n338 VSS.n332 0.0817061
R1326 VSS.n337 VSS.n332 0.0817061
R1327 VSS.n336 VSS.n332 0.0817061
R1328 VSS.n334 VSS.n332 0.0817061
R1329 VSS.n279 VSS.n278 0.0814472
R1330 VSS.n319 VSS.n318 0.0794206
R1331 VSS.n320 VSS.n277 0.0784641
R1332 VSS.n105 VSS.n102 0.0779076
R1333 VSS.n111 VSS.n109 0.0779076
R1334 VSS.n110 VSS.n99 0.0779076
R1335 VSS.n127 VSS.n125 0.0779076
R1336 VSS.n126 VSS.n116 0.0779076
R1337 VSS.n131 VSS.n130 0.0779076
R1338 VSS.n317 VSS.n316 0.0776211
R1339 VSS.n329 VSS.n327 0.0773061
R1340 VSS.n464 VSS.n200 0.0759286
R1341 VSS.n472 VSS.n424 0.0759286
R1342 VSS.n470 VSS.n426 0.0759286
R1343 VSS.n468 VSS.n428 0.0759286
R1344 VSS.n466 VSS.n430 0.0759286
R1345 VSS.n447 VSS.n442 0.0759286
R1346 VSS.n453 VSS.n449 0.0759286
R1347 VSS.n450 VSS.n435 0.0759286
R1348 VSS.n458 VSS.n434 0.0759286
R1349 VSS.n459 VSS.n433 0.0759286
R1350 VSS.n529 VSS.n224 0.0759286
R1351 VSS.n528 VSS.n225 0.0759286
R1352 VSS.n527 VSS.n226 0.0759286
R1353 VSS.n525 VSS.n228 0.0759286
R1354 VSS.n523 VSS.n230 0.0759286
R1355 VSS.n539 VSS.n214 0.0759286
R1356 VSS.n538 VSS.n215 0.0759286
R1357 VSS.n537 VSS.n216 0.0759286
R1358 VSS.n535 VSS.n218 0.0759286
R1359 VSS.n533 VSS.n220 0.0759286
R1360 VSS.n552 VSS.n201 0.0759286
R1361 VSS.n549 VSS.n204 0.0759286
R1362 VSS.n548 VSS.n205 0.0759286
R1363 VSS.n547 VSS.n206 0.0759286
R1364 VSS.n545 VSS.n208 0.0759286
R1365 VSS.n543 VSS.n210 0.0759286
R1366 VSS.n509 VSS.n409 0.0759286
R1367 VSS.n508 VSS.n410 0.0759286
R1368 VSS.n506 VSS.n411 0.0759286
R1369 VSS.n407 VSS.n403 0.0759286
R1370 VSS.n405 VSS.n401 0.0759286
R1371 VSS.n489 VSS.n479 0.0759286
R1372 VSS.n481 VSS.n477 0.0759286
R1373 VSS.n500 VSS.n415 0.0759286
R1374 VSS.n497 VSS.n417 0.0759286
R1375 VSS.n495 VSS.n419 0.0759286
R1376 VSS.n310 VSS.n295 0.0759286
R1377 VSS.n309 VSS.n296 0.0759286
R1378 VSS.n308 VSS.n297 0.0759286
R1379 VSS.n307 VSS.n298 0.0759286
R1380 VSS.n306 VSS.n299 0.0759286
R1381 VSS.n305 VSS.n300 0.0759286
R1382 VSS.n304 VSS.n301 0.0759286
R1383 VSS.n286 VSS.n285 0.0759286
R1384 VSS.n287 VSS.n284 0.0759286
R1385 VSS.n288 VSS.n283 0.0759286
R1386 VSS.n289 VSS.n281 0.0759286
R1387 VSS.n316 VSS.n315 0.0750054
R1388 VSS.n319 VSS.n317 0.0725235
R1389 VSS.n322 VSS.n320 0.0721359
R1390 VSS.n318 VSS.n279 0.0711793
R1391 VSS.n278 VSS.n277 0.0686974
R1392 VSS.n322 VSS.n321 0.0675776
R1393 VSS.n303 VSS.n302 0.064985
R1394 VSS.n329 VSS.n328 0.061725
R1395 VSS.n239 VSS.n106 0.0594056
R1396 VSS.n397 VSS.n119 0.0594056
R1397 VSS.n390 VSS.n114 0.058826
R1398 VSS.n106 VSS.n105 0.0586497
R1399 VSS.n125 VSS.n119 0.0586497
R1400 VSS.n398 VSS.n121 0.0584906
R1401 VSS.n325 VSS.n324 0.0581825
R1402 VSS.n388 VSS.n387 0.0566224
R1403 VSS.n555 VSS.n79 0.0545
R1404 VSS.n171 VSS.n169 0.0539757
R1405 VSS.n189 VSS.n146 0.0529665
R1406 VSS.n506 VSS.n505 0.0528809
R1407 VSS.n136 VSS.n135 0.0527701
R1408 VSS.n564 VSS.n563 0.0519573
R1409 VSS.n553 VSS.n200 0.0518333
R1410 VSS.n188 VSS.n184 0.0517609
R1411 VSS.n282 VSS.n280 0.0511625
R1412 VSS.n170 VSS.n157 0.0509482
R1413 VSS.n164 VSS.n163 0.0507518
R1414 VSS.n194 VSS.n192 0.049939
R1415 VSS.n559 VSS.n558 0.0497426
R1416 VSS.n163 VSS.n161 0.0490925
R1417 VSS.n312 VSS.n294 0.0490265
R1418 VSS.n304 VSS.n303 0.0489
R1419 VSS.n183 VSS.n151 0.0487334
R1420 VSS.n190 VSS.n188 0.0480833
R1421 VSS.n563 VSS.n133 0.0474161
R1422 VSS.n505 VSS.n412 0.0473412
R1423 VSS.n135 VSS.n133 0.0470742
R1424 VSS.n193 VSS.n141 0.0469115
R1425 VSS.n323 VSS.n274 0.0464192
R1426 VSS.n190 VSS.n189 0.0464069
R1427 VSS.n519 VSS.n518 0.046273
R1428 VSS.n331 VSS.n330 0.0460827
R1429 VSS.n178 VSS.n177 0.0457059
R1430 VSS.n169 VSS.n161 0.0453978
R1431 VSS.n177 VSS.n151 0.0448931
R1432 VSS.n559 VSS.n557 0.0438839
R1433 VSS.n194 VSS.n193 0.0436875
R1434 VSS.n175 VSS.n157 0.0426784
R1435 VSS.n184 VSS.n183 0.0418656
R1436 VSS.n558 VSS.n136 0.0408564
R1437 VSS.n192 VSS.n146 0.04066
R1438 VSS.n575 VSS.n8 9.63628
R1439 VSS.n178 VSS.n176 0.0398472
R1440 VSS.n237 VSS.n121 0.0397443
R1441 VSS.n275 VSS.n274 0.0397236
R1442 VSS.n171 VSS.n170 0.0396508
R1443 VSS.n109 VSS.n102 0.039409
R1444 VSS.n111 VSS.n110 0.039409
R1445 VSS.n389 VSS.n99 0.039409
R1446 VSS.n238 VSS.n114 0.039409
R1447 VSS.n127 VSS.n126 0.039409
R1448 VSS.n130 VSS.n116 0.039409
R1449 VSS.n517 VSS.n131 0.039409
R1450 VSS.n556 VSS.n141 0.0386417
R1451 VSS.n324 VSS.n323 0.037474
R1452 VSS.n321 VSS.n276 0.0320652
R1453 VSS.n474 VSS.n422 0.0302645
R1454 VSS.n462 VSS.n200 0.0298333
R1455 VSS.n460 VSS.n459 0.0298333
R1456 VSS.n459 VSS.n458 0.0298333
R1457 VSS.n452 VSS.n435 0.0298333
R1458 VSS.n453 VSS.n452 0.0298333
R1459 VSS.n442 VSS.n441 0.0298333
R1460 VSS.n445 VSS.n442 0.0298333
R1461 VSS.n443 VSS.n430 0.0298333
R1462 VSS.n430 VSS.n429 0.0298333
R1463 VSS.n428 VSS.n427 0.0298333
R1464 VSS.n427 VSS.n426 0.0298333
R1465 VSS.n425 VSS.n424 0.0298333
R1466 VSS.n424 VSS.n423 0.0298333
R1467 VSS.n291 VSS.n281 0.0269
R1468 VSS.n339 VSS.n332 0.022573
R1469 VSS.n461 VSS.n460 0.0225
R1470 VSS.n457 VSS.n435 0.0225
R1471 VSS.n454 VSS.n441 0.0225
R1472 VSS.n444 VSS.n443 0.0225
R1473 VSS.n438 VSS.n428 0.0225
R1474 VSS.n436 VSS.n425 0.0225
R1475 VSS.n328 VSS.n273 0.0215435
R1476 VSS.n489 VSS.n488 0.0214524
R1477 VSS.n490 VSS.n489 0.0214524
R1478 VSS.n482 VSS.n477 0.0214524
R1479 VSS.n482 VSS.n420 0.0214524
R1480 VSS.n496 VSS.n495 0.0214524
R1481 VSS.n497 VSS.n496 0.0214524
R1482 VSS.n500 VSS.n499 0.0214524
R1483 VSS.n501 VSS.n500 0.0214524
R1484 VSS.n509 VSS.n508 0.0214524
R1485 VSS.n510 VSS.n509 0.0214524
R1486 VSS.n404 VSS.n403 0.0214524
R1487 VSS.n404 VSS.n401 0.0214524
R1488 VSS.n312 VSS.n311 0.0213089
R1489 VSS.n330 VSS.n273 0.0210652
R1490 VSS.n390 VSS.n389 0.0195816
R1491 VSS.n398 VSS.n397 0.0195816
R1492 VSS VSS.n580 0.0185
R1493 VSS.n554 VSS.n199 0.0185
R1494 VSS.n456 VSS.n199 0.0185
R1495 VSS.n456 VSS.n455 0.0185
R1496 VSS.n455 VSS.n440 0.0185
R1497 VSS.n440 VSS.n439 0.0185
R1498 VSS.n439 VSS.n437 0.0185
R1499 VSS.n437 VSS.n421 0.0185
R1500 VSS.n475 VSS.n421 0.0185
R1501 VSS.n502 VSS.n412 0.0159153
R1502 VSS.n487 VSS.n486 0.0156425
R1503 VSS.n515 VSS.n514 0.0143286
R1504 VSS.n492 VSS.n476 0.0133571
R1505 VSS.n493 VSS.n492 0.0133571
R1506 VSS.n493 VSS.n413 0.0133571
R1507 VSS.n503 VSS.n413 0.0133571
R1508 VSS.n504 VSS.n503 0.0133571
R1509 VSS.n504 VSS.n402 0.0133571
R1510 VSS.n512 VSS.n402 0.0133571
R1511 VSS.n465 VSS.n431 0.0124467
R1512 VSS.n213 VSS.n212 0.0124467
R1513 VSS.n233 VSS.n232 0.0121878
R1514 VSS.n223 VSS.n222 0.0121878
R1515 VSS.n235 VSS.n234 0.0121878
R1516 VSS.n485 VSS.n484 0.0121878
R1517 VSS.n488 VSS.n487 0.0109762
R1518 VSS.n491 VSS.n490 0.0109762
R1519 VSS.n491 VSS.n477 0.0109762
R1520 VSS.n494 VSS.n420 0.0109762
R1521 VSS.n495 VSS.n494 0.0109762
R1522 VSS.n498 VSS.n497 0.0109762
R1523 VSS.n499 VSS.n498 0.0109762
R1524 VSS.n502 VSS.n501 0.0109762
R1525 VSS.n507 VSS.n506 0.0109762
R1526 VSS.n508 VSS.n507 0.0109762
R1527 VSS.n511 VSS.n510 0.0109762
R1528 VSS.n511 VSS.n403 0.0109762
R1529 VSS.n513 VSS.n401 0.0109762
R1530 VSS.n514 VSS.n513 0.0109762
R1531 VSS.n276 VSS.n275 0.0105435
R1532 VSS.n176 VSS.n175 0.0085734
R1533 VSS.n557 VSS.n556 0.0085734
R1534 VSS.n462 VSS.n461 0.00783333
R1535 VSS.n458 VSS.n457 0.00783333
R1536 VSS.n454 VSS.n453 0.00783333
R1537 VSS.n445 VSS.n444 0.00783333
R1538 VSS.n438 VSS.n429 0.00783333
R1539 VSS.n436 VSS.n426 0.00783333
R1540 VSS.n423 VSS.n422 0.00783333
R1541 VSS.n516 VSS.n515 0.00762381
R1542 VSS.n386 VSS.n241 0.00691667
R1543 VSS.n518 VSS.n516 0.00594762
R1544 VSS.n261 VSS.n63 17.0036
R1545 VSS.n39 VSS.n18 0.00572691
R1546 VSS.n32 VSS.n14 0.00572691
R1547 VSS.n25 VSS.n14 0.00349994
R1548 VSS.n76 VSS.n53 0.00333308
R1549 VSS.n74 VSS.n53 0.00299994
R1550 VSS.n72 VSS.n51 0.00299994
R1551 VSS.n66 VSS.n46 0.00299994
R1552 VSS.n73 VSS.n51 0.00299991
R1553 VSS.n59 VSS.n58 0.00283308
R1554 VSS.n67 VSS.n45 0.00274942
R1555 VSS.n37 VSS.n16 0.00283308
R1556 VSS.n30 VSS.n10 0.00283308
R1557 VSS.n28 VSS.n355 0.00283308
R1558 VSS.n25 VSS.n24 0.00222181
R1559 VSS.n22 VSS.n20 0.00224999
R1560 VSS.n22 VSS.n21 0.00224999
R1561 VSS.n46 VSS.n45 0.002
R1562 VSS.n353 VSS.n348 0.00175
R1563 VSS.n355 VSS.n350 0.00166667
R1564 VSS.n353 VSS.n349 0.00166667
R1565 VSS.n66 VSS.n65 0.00149995
R1566 VSS.n247 VSS.n48 0.00166667
R1567 VSS.n246 VSS.n242 0.00166667
R1568 VSS.n70 VSS.n69 0.00169993
R1569 VSS.n72 VSS.n71 0.00149995
R1570 VSS.n74 VSS.n73 0.00149995
R1571 VSS.n244 VSS.n55 0.00166667
R1572 VSS.n77 VSS.n244 0.00199997
R1573 VSS.n77 VSS.n59 0.00199997
R1574 VSS.n64 VSS.n43 0.00199997
R1575 VSS.n36 VSS.n18 0.00199997
R1576 VSS.n35 VSS.n16 0.00199997
R1577 VSS.n29 VSS.n12 0.00199997
R1578 VSS.n27 VSS.n10 0.00199997
R1579 VSS.n56 VSS.n55 0.00183332
R1580 VSS.n49 VSS.n48 0.00183332
R1581 VSS.n343 VSS.n5 0.00150042
R1582 VSS.n91 VSS.n5 0.00150001
R1583 VSS.n245 VSS.n70 0.0015
R1584 VSS.n20 VSS.n349 0.00133332
R1585 VSS.n247 VSS.n242 0.00133332
R1586 VSS.n352 VSS.n348 0.00124998
R1587 VSS.n346 VSS.n5 0.00120424
R1588 VSS.n344 VSS.n5 0.0010341
R1589 VSS.n0 VSS.n2 100.391
R1590 VSS.n576 VSS.n7 33.7948
R1591 VSS.n0 VSS.n1 0.280399
R1592 a_11798_1860.n0 a_11798_1860.n4 9.42143
R1593 a_11798_1860.n1 a_11798_1860.n12 9.42143
R1594 a_11798_1860.n1 a_11798_1860.n5 9.42143
R1595 a_11798_1860.n1 a_11798_1860.n6 9.42143
R1596 a_11798_1860.n2 a_11798_1860.n9 9.42143
R1597 a_11798_1860.n2 a_11798_1860.n7 9.42143
R1598 a_11798_1860.n4 a_11798_1860.t15 3.60374
R1599 a_11798_1860.n5 a_11798_1860.t21 3.60255
R1600 a_11798_1860.n6 a_11798_1860.t22 3.60255
R1601 a_11798_1860.n7 a_11798_1860.t28 3.60255
R1602 a_11798_1860.n4 a_11798_1860.t16 3.45423
R1603 a_11798_1860.n13 a_11798_1860.t17 3.45423
R1604 a_11798_1860.n11 a_11798_1860.t19 3.45423
R1605 a_11798_1860.n5 a_11798_1860.t20 3.45423
R1606 a_11798_1860.n12 a_11798_1860.t18 3.45423
R1607 a_11798_1860.n6 a_11798_1860.t23 3.45423
R1608 a_11798_1860.n10 a_11798_1860.t24 3.45423
R1609 a_11798_1860.n8 a_11798_1860.t26 3.45423
R1610 a_11798_1860.n7 a_11798_1860.t27 3.45423
R1611 a_11798_1860.n9 a_11798_1860.t25 3.45423
R1612 a_11798_1860.t14 a_11798_1860.n3 2.61386
R1613 a_11798_1860.n0 a_11798_1860.t0 2.61049
R1614 a_11798_1860.n2 a_11798_1860.t10 2.56233
R1615 a_11798_1860.n0 a_11798_1860.t1 2.56233
R1616 a_11798_1860.n1 a_11798_1860.t4 2.5622
R1617 a_11798_1860.n1 a_11798_1860.t8 2.56174
R1618 a_11798_1860.n2 a_11798_1860.t11 2.56173
R1619 a_11798_1860.n1 a_11798_1860.t9 2.56173
R1620 a_11798_1860.n1 a_11798_1860.t5 2.56173
R1621 a_11798_1860.n0 a_11798_1860.t3 2.56173
R1622 a_11798_1860.n1 a_11798_1860.t6 2.56161
R1623 a_11798_1860.n0 a_11798_1860.t2 2.56161
R1624 a_11798_1860.n1 a_11798_1860.t7 2.5616
R1625 a_11798_1860.n3 a_11798_1860.t13 2.56146
R1626 a_11798_1860.n3 a_11798_1860.t12 2.56146
R1627 a_11798_1860.n2 a_11798_1860.n1 0.245563
R1628 a_11798_1860.n8 a_11798_1860.n7 0.225083
R1629 a_11798_1860.n6 a_11798_1860.n10 0.225083
R1630 a_11798_1860.n11 a_11798_1860.n5 0.225083
R1631 a_11798_1860.n4 a_11798_1860.n13 0.225083
R1632 a_11798_1860.n1 a_11798_1860.n0 0.196551
R1633 a_11798_1860.n13 a_11798_1860.n12 0.1875
R1634 a_11798_1860.n12 a_11798_1860.n11 0.1875
R1635 a_11798_1860.n10 a_11798_1860.n9 0.1875
R1636 a_11798_1860.n9 a_11798_1860.n8 0.1875
R1637 a_11798_1860.n3 a_11798_1860.n2 0.147538
R1638 a_5560_4622.n0 a_5560_4622.t2 27.72
R1639 a_5560_4622.n0 a_5560_4622.t0 24.1197
R1640 a_5560_4622.t1 a_5560_4622.n0 9.38813
R1641 a_5560_6408.n0 a_5560_6408.t2 55.3005
R1642 a_5560_6408.n0 a_5560_6408.t1 27.8842
R1643 a_5560_6408.t0 a_5560_6408.n0 7.50485
R1644 a_6568_6836.n2 a_6568_6836.t1 19.9393
R1645 a_6568_6836.n0 a_6568_6836.t4 19.6783
R1646 a_6568_6836.n1 a_6568_6836.t3 17.974
R1647 a_6568_6836.n2 a_6568_6836.n1 5.04317
R1648 a_6568_6836.n0 a_6568_6836.t0 4.81727
R1649 a_6568_6836.n1 a_6568_6836.n0 4.76157
R1650 a_6568_6836.t2 a_6568_6836.n2 3.15445
R1651 a_5948_5116.n0 a_5948_5116.t2 30.2902
R1652 a_5948_5116.n0 a_5948_5116.t1 27.2706
R1653 a_5948_5116.t0 a_5948_5116.n0 11.5346
R1654 a_5905_5252.n0 a_5905_5252.t1 27.1774
R1655 a_5905_5252.n2 a_5905_5252.t2 25.4059
R1656 a_5905_5252.n1 a_5905_5252.t5 20.7725
R1657 a_5905_5252.n1 a_5905_5252.t4 20.4909
R1658 a_5905_5252.n0 a_5905_5252.t3 20.4287
R1659 a_5905_5252.t0 a_5905_5252.n0 12.1418
R1660 a_5905_5252.n2 a_5905_5252.n1 5.30277
R1661 a_5905_5252.n0 a_5905_5252.n2 4.5269
R1662 vco_bias_0.vbn_buf.n3 vco_bias_0.vbn_buf.t1 45.1624
R1663 vco_bias_0.vbn_buf.n2 vco_bias_0.vbn_buf.t4 34.2391
R1664 vco_bias_0.vbn_buf.n2 vco_bias_0.vbn_buf.t3 28.5544
R1665 vco_bias_0.vbn_buf.n1 vco_bias_0.vbn_buf.n0 22.8295
R1666 vco_bias_0.vbn_buf.n0 vco_bias_0.vbn_buf.t2 21.7736
R1667 vco_bias_0.vbn_buf.n4 vco_bias_0.vbn_buf.t0 17.3253
R1668 vco_bias_0.vbn_buf.n4 vco_bias_0.vbn_buf.n3 13.5293
R1669 vco_bias_0.vbn_buf.n3 vco_bias_0.vbn_buf.n2 6.81757
R1670 vco_bias_0.vbn_buf vco_bias_0.vbn_buf.n4 2.55837
R1671 vco_bias_0.vbn_buf vco_bias_0.vbn_buf.n1 0.2645
R1672 vco_bias_0.vbn_buf.n1 vco_bias_0.vbn_buf 0.1985
R1673 vco_bias_0.vbn_buf.n0 vco_bias_0.vbn_buf 0.1105
C0 vtune VDD 0.34199f
C1 a_9400_4966# VDD 0.01049f
C2 a_10100_4160# a_9400_4880# 0.15006f
C3 a_10100_4160# vco_bias_0.vbn_buf 0.01643f
C4 vco_bias_0.vbg_buf di_en 3.60972f
C5 a_14668_3324# rf_out_p 1.12362f
C6 a_1160_2070# a_1560_1770# 0.60592f
C7 ibias_100u a_1560_1770# 0.01906f
C8 rf_out_p vco_bias_0.vbn_buf 0.18271f
C9 a_14668_3324# vco_bias_0.vbg_buf 0.04293f
C10 vdd_core a_14668_3324# 0.15264p
C11 a_10100_4160# rf_out_n 0.47919f
C12 a_9400_4880# vco_bias_0.vbg_buf 0.08032f
C13 vdd_core a_9400_4880# 0.15264p
C14 VDD a_1560_1770# 0.02705f
C15 vco_bias_0.vbg_buf vco_bias_0.vbn_buf 10.6196f
C16 vdd_core vco_bias_0.vbn_buf 0.45012f
C17 vco_bias_0.vbg_buf a_5560_4708# 0.12015f
C18 rf_out_p rf_out_n 0.0144f
C19 a_10100_4160# VDD 0.35416f
C20 a_1160_2070# vco_bias_0.vbg_buf 0.04989f
C21 vco_bias_0.vbg_buf ibias_100u 2.69378f
C22 vdd_core ibias_100u 0.02664f
C23 di_en vco_bias_0.vbn_buf 0.13248f
C24 rf_out_p VDD 0.4468f
C25 a_9400_4880# a_14668_3324# 0.12351f
C26 a_16500_4160# rf_out_p 0.47919f
C27 a_14668_3324# vco_bias_0.vbn_buf 0.05196f
C28 vco_bias_0.vbg_buf VDD 4.2051f
C29 vdd_core VDD 1.78729f
C30 a_9400_4880# vco_bias_0.vbn_buf 0.06509f
C31 di_en ibias_100u 3.71937f
C32 a_9400_4880# rf_out_n 1.12362f
C33 VDD di_en 0.60496f
C34 a_1160_2070# vco_bias_0.vbn_buf 0.02902f
C35 rf_out_n vco_bias_0.vbn_buf 0.21445f
C36 ibias_100u vco_bias_0.vbn_buf 0.20655f
C37 a_14668_3324# VDD 1.31003f
C38 rf_out_p vtune 0.03176f
C39 a_9400_4880# VDD 1.4015f
C40 a_16500_4160# a_14668_3324# 0.15006f
C41 a_1160_2070# ibias_100u 0.02966f
C42 VDD vco_bias_0.vbn_buf 1.52469f
C43 VDD a_5560_4708# 0.04174f
C44 vco_bias_0.vbg_buf vtune 0.07434f
C45 vdd_core vtune 13.5168f
C46 a_9400_4966# vco_bias_0.vbg_buf 0.03293f
C47 vdd_core a_9400_4966# 0.0801f
C48 VDD rf_out_n 0.46067f
C49 VDD ibias_100u 0.48281f
C50 a_19100_4966# vco_bias_0.vbg_buf 0.03283f
C51 vdd_core a_19100_4966# 0.08348f
C52 a_14668_3324# vtune 0.23027f
C53 a_16500_4160# VDD 0.32132f
C54 vco_bias_0.vbg_buf a_1560_1770# 0.03498f
C55 a_9400_4880# vtune 0.2399f
C56 a_9400_4966# a_9400_4880# 0.04847f
C57 vtune vco_bias_0.vbn_buf 0.09134f
C58 a_9400_4966# vco_bias_0.vbn_buf 0.01696f
C59 a_19100_4966# a_14668_3324# 0.04847f
C60 vtune rf_out_n 0.03176f
C61 vdd_core vco_bias_0.vbg_buf 3.59935f
C62 rf_out_p VSS 4.42943f
C63 rf_out_n VSS 4.40673f
C64 ibias_100u VSS 6.02453f
C65 di_en VSS 4.84792f
C66 vdd_core VSS 3.78256p
C67 VDD VSS 45.76983f
C68 vtune VSS 4.02849f
C69 vco_bias_0.vbn_buf VSS 0.12517p
C70 vco_bias_0.vbn_buf.n0 VSS 0.17499f
C71 vco_bias_0.vbn_buf.n1 VSS 0.09979f
C72 vco_bias_0.vbn_buf.n2 VSS 0.18669f
C73 vco_bias_0.vbn_buf.t1 VSS 2.24706f
C74 vco_bias_0.vbn_buf.n3 VSS 0.26853f
C75 vco_bias_0.vbn_buf.t0 VSS 0.14485f
C76 vco_bias_0.vbn_buf.n4 VSS 0.18228f
C77 a_5905_5252.n0 VSS 1.32132f
C78 a_5905_5252.n1 VSS 1.05369f
C79 a_5905_5252.n2 VSS 0.8442f
C80 a_5905_5252.t1 VSS 0.24331f
C81 a_5905_5252.t0 VSS 0.32721f
C82 a_5948_5116.t1 VSS 0.17174f
C83 a_5948_5116.n0 VSS 2.17987f
C84 a_5948_5116.t0 VSS 0.31368f
C85 a_6568_6836.t3 VSS 0.59498f
C86 a_6568_6836.t0 VSS 0.62444f
C87 a_6568_6836.n0 VSS 0.69426f
C88 a_6568_6836.n1 VSS 1.04094f
C89 a_6568_6836.n2 VSS 0.69477f
C90 a_6568_6836.t2 VSS 1.11197f
C91 a_5560_6408.t2 VSS 2.58874f
C92 a_5560_6408.t1 VSS 0.79162f
C93 a_5560_6408.n0 VSS 3.29525f
C94 a_5560_6408.t0 VSS 1.25741f
C95 a_5560_4622.t2 VSS 0.77468f
C96 a_5560_4622.n0 VSS 1.03976f
C97 a_5560_4622.t1 VSS 0.53225f
C98 a_11798_1860.n0 VSS 2.00542f
C99 a_11798_1860.n1 VSS 3.45402f
C100 a_11798_1860.n2 VSS 1.40912f
C101 a_11798_1860.n3 VSS 1.32792f
C102 a_11798_1860.n4 VSS 0.13917f
C103 a_11798_1860.n5 VSS 0.13917f
C104 a_11798_1860.n6 VSS 0.13917f
C105 a_11798_1860.n7 VSS 0.13917f
C106 a_11798_1860.t28 VSS 0.06536f
C107 a_11798_1860.t25 VSS 0.06995f
C108 a_11798_1860.t26 VSS 0.06995f
C109 a_11798_1860.t27 VSS 0.06995f
C110 a_11798_1860.n8 VSS 0.07813f
C111 a_11798_1860.n9 VSS 0.08176f
C112 a_11798_1860.t23 VSS 4.6161f
C113 a_11798_1860.t24 VSS 0.06995f
C114 a_11798_1860.n10 VSS 0.07813f
C115 a_11798_1860.t22 VSS 0.06536f
C116 a_11798_1860.t21 VSS 0.06536f
C117 a_11798_1860.t18 VSS 0.06995f
C118 a_11798_1860.t19 VSS 0.06995f
C119 a_11798_1860.t20 VSS 4.48061f
C120 a_11798_1860.n11 VSS 0.07813f
C121 a_11798_1860.n12 VSS 0.08176f
C122 a_11798_1860.t16 VSS 0.06995f
C123 a_11798_1860.t17 VSS 0.06995f
C124 a_11798_1860.n13 VSS 0.07813f
C125 a_11798_1860.t15 VSS 0.06536f
C126 a_11798_1860.t0 VSS 0.21078f
C127 a_11798_1860.t1 VSS 0.20507f
C128 a_11798_1860.t2 VSS 0.20507f
C129 a_11798_1860.t3 VSS 0.20507f
C130 a_11798_1860.t4 VSS 0.20506f
C131 a_11798_1860.t5 VSS 0.20507f
C132 a_11798_1860.t6 VSS 0.20507f
C133 a_11798_1860.t7 VSS 0.20507f
C134 a_11798_1860.t8 VSS 0.20507f
C135 a_11798_1860.t9 VSS 0.20507f
C136 a_11798_1860.t10 VSS 0.20507f
C137 a_11798_1860.t11 VSS 1.2115f
C138 a_11798_1860.t12 VSS 0.20507f
C139 a_11798_1860.t13 VSS 0.20507f
C140 a_11798_1860.t14 VSS 0.21074f
C141 VSS.t72 VSS 1.0016f
C142 VSS.t82 VSS 0.39453p
C143 VSS.t77 VSS 0.28406f
C144 VSS.t87 VSS 0.25969f
C145 VSS.t73 VSS 1.0016f
C146 VSS.t83 VSS 0.39453p
C147 VSS.t85 VSS 0.25969f
C148 VSS.t79 VSS 0.28406f
C149 VSS.t2 VSS 4.4889f
C150 VSS.t4 VSS 4.4889f
C151 VSS.t165 VSS 0.37432f
C152 VSS.t46 VSS 1.00644f
C153 VSS.t172 VSS 0.11733f
C154 VSS.t170 VSS 0.06243f
C155 VSS.t136 VSS 0.16904f
C156 VSS.t71 VSS 0.07192f
C157 VSS.t58 VSS 0.18791f
C158 VSS.t105 VSS 0.28072f
C159 VSS.t107 VSS 0.28072f
C160 VSS.t149 VSS 0.53979f
C161 VSS.t67 VSS 4.48256f
C162 VSS.t69 VSS 4.48256f
C163 vtune.t0 VSS 7.22474f
C164 vtune.t3 VSS 7.21059f
C165 vtune.n0 VSS 0.41124f
C166 vtune.t6 VSS 8.76946f
C167 vtune.n1 VSS 1.1151f
C168 VDD.n0 VSS 0.20245f
C169 VDD.n1 VSS 0.09757f
C170 VDD.n2 VSS 0.18214f
C171 VDD.n3 VSS 0.03578f
C172 VDD.n4 VSS 0.05857f
C173 VDD.n5 VSS 0.04753f
C174 VDD.n6 VSS 0.50027f
C175 VDD.n8 VSS 0.12746f
C176 VDD.t3 VSS 0.08663f
C177 VDD.t18 VSS 0.14902f
C178 VDD.t19 VSS 0.27402f
C179 VDD.t2 VSS 0.4927f
C180 VDD.t14 VSS 0.11164f
C181 VDD.t15 VSS 0.10905f
C182 VDD.t1 VSS 0.49081f
C183 VDD.t11 VSS 0.10905f
C184 VDD.t12 VSS 0.10905f
C185 VDD.t8 VSS 0.10905f
C186 VDD.t9 VSS 0.10905f
C187 VDD.t5 VSS 0.01523f
C188 VDD.t6 VSS 0.01523f
C189 VDD.n10 VSS 0.0512f
C190 VDD.t0 VSS 3.25916f
C191 VDD.n11 VSS 0.26731f
C192 VDD.t17 VSS 1.62107f
C193 VDD.t16 VSS 0.92487f
C194 VDD.n12 VSS 1.84438f
C195 vdd_core.n0 VSS 0.08493f
C196 vdd_core.n1 VSS 0.11402f
C197 vdd_core.n2 VSS 0.93002f
C198 vdd_core.n3 VSS 0.08493f
C199 vdd_core.n4 VSS 0.11402f
C200 vdd_core.n5 VSS 1.95854f
C201 vdd_core.n6 VSS 0.40004f
C202 vdd_core.n7 VSS 0.48681f
C203 vdd_core.n8 VSS 0.53856f
C204 vdd_core.n9 VSS 0.33057f
C205 vdd_core.n10 VSS 0.10124f
C206 vdd_core.n11 VSS 0.22711f
C207 vdd_core.n12 VSS 0.11662f
C208 vdd_core.n13 VSS 0.0753f
C209 vdd_core.n14 VSS 0.05509f
C210 vdd_core.n15 VSS 0.10124f
C211 vdd_core.n16 VSS 0.11662f
C212 vdd_core.n17 VSS 0.07369f
C213 vdd_core.n18 VSS 0.10284f
C214 vdd_core.n19 VSS 0.11501f
C215 vdd_core.n20 VSS 0.0753f
C216 vdd_core.n21 VSS 0.10124f
C217 vdd_core.n22 VSS 0.12112f
C218 vdd_core.n23 VSS 0.258f
C219 vdd_core.n24 VSS 5.62472f
C220 vdd_core.n25 VSS 0.0753f
C221 vdd_core.n26 VSS 0.33057f
C222 vdd_core.n27 VSS 0.3926f
C223 vdd_core.n28 VSS 0.29498f
C224 vdd_core.n29 VSS 0.22675f
C225 vdd_core.n30 VSS 0.37867f
C226 vdd_core.n31 VSS 0.37867f
C227 vdd_core.n32 VSS 0.22952f
C228 vdd_core.n33 VSS 0.22952f
C229 vdd_core.n34 VSS 0.34727f
C230 vdd_core.n35 VSS 0.34727f
C231 vdd_core.n36 VSS 0.11501f
C232 vdd_core.n37 VSS 0.33057f
C233 vdd_core.n38 VSS 0.34868f
C234 vdd_core.n39 VSS 0.34868f
C235 vdd_core.n40 VSS 0.11501f
C236 vdd_core.n41 VSS 0.16263f
C237 vdd_core.n42 VSS 0.2096f
C238 vdd_core.n43 VSS 0.30885f
C239 vdd_core.n44 VSS 0.2096f
C240 vdd_core.n45 VSS 12.3873f
C241 vdd_core.n46 VSS 5.36702f
C242 vdd_core.n47 VSS 0.16528f
C243 vdd_core.n48 VSS 0.30885f
C244 vdd_core.n49 VSS 0.24528f
C245 vdd_core.n50 VSS 0.24528f
C246 vdd_core.n51 VSS 0.37867f
C247 vdd_core.n52 VSS 0.37867f
C248 vdd_core.n53 VSS 0.2249f
C249 vdd_core.n54 VSS 0.2249f
C250 vdd_core.n55 VSS 0.22213f
C251 vdd_core.n56 VSS 0.34727f
C252 vdd_core.n57 VSS 0.22213f
C253 vdd_core.n58 VSS 0.34727f
C254 vdd_core.n59 VSS 0.11662f
C255 vdd_core.n60 VSS 0.11501f
C256 vdd_core.n61 VSS 0.11662f
C257 vdd_core.n62 VSS 0.11501f
C258 vdd_core.n63 VSS 0.33057f
C259 vdd_core.n64 VSS 0.31401f
C260 vdd_core.n65 VSS 0.22028f
C261 vdd_core.n66 VSS 0.34727f
C262 vdd_core.n67 VSS 0.34727f
C263 vdd_core.n68 VSS 0.22675f
C264 vdd_core.n69 VSS 0.22675f
C265 vdd_core.n70 VSS 0.37867f
C266 vdd_core.n71 VSS 0.37867f
C267 vdd_core.n72 VSS 0.22952f
C268 vdd_core.n73 VSS 0.22952f
C269 vdd_core.n74 VSS 0.34727f
C270 vdd_core.n75 VSS 0.34727f
C271 vdd_core.n76 VSS 0.2096f
C272 vdd_core.n77 VSS 0.2096f
C273 vdd_core.n78 VSS 0.11662f
C274 vdd_core.n79 VSS 0.126f
C275 vdd_core.n80 VSS 0.22213f
C276 vdd_core.n81 VSS 0.22213f
C277 vdd_core.n82 VSS 0.11662f
C278 vdd_core.n83 VSS 0.34868f
C279 vdd_core.n84 VSS 0.30885f
C280 vdd_core.n85 VSS 0.16263f
C281 vdd_core.n86 VSS 12.3873f
C282 vdd_core.n87 VSS 5.36702f
C283 vdd_core.n88 VSS 0.30885f
C284 vdd_core.n89 VSS 0.24528f
C285 vdd_core.n90 VSS 0.37867f
C286 vdd_core.n91 VSS 0.34727f
C287 vdd_core.n92 VSS 0.2249f
C288 vdd_core.n93 VSS 0.11501f
C289 vdd_core.n94 VSS 0.34727f
C290 vdd_core.n95 VSS 0.2249f
C291 vdd_core.n96 VSS 0.37867f
C292 vdd_core.n97 VSS 0.24528f
C293 vdd_core.n98 VSS 0.11501f
C294 vdd_core.n99 VSS 0.11501f
C295 vdd_core.n100 VSS 0.11501f
C296 vdd_core.n101 VSS 5.41157f
C297 vdd_core.n102 VSS 12.3427f
C298 vdd_core.n103 VSS 0.16263f
C299 vdd_core.n104 VSS 0.34868f
C300 vdd_core.n105 VSS 0.11662f
C301 vdd_core.n106 VSS 0.11501f
C302 vdd_core.t9 VSS 0.04269f
C303 vdd_core.n107 VSS 0.07709f
C304 vdd_core.n108 VSS 12.3787f
C305 vdd_core.n109 VSS 1.14381f
C306 vdd_core.t5 VSS 0.58233f
C307 vdd_core.t6 VSS 0.04307f
C308 vdd_core.t8 VSS 0.04253f
C309 vdd_core.n110 VSS 0.06804f
C310 vdd_core.t7 VSS 0.04253f
C311 vdd_core.n111 VSS 0.08193f
C312 vdd_core.n112 VSS 0.01812f
C313 vdd_core.n113 VSS 23.9245f
C314 vdd_core.n114 VSS 0.14408f
C315 vdd_core.n115 VSS 0.19357f
C316 vdd_core.n116 VSS 0.09634f
C317 vdd_core.n117 VSS 0.08408f
C318 vdd_core.n118 VSS 1.39318f
C319 vdd_core.n119 VSS 0.55395f
C320 vdd_core.n120 VSS 0.10053f
C321 vdd_core.t12 VSS 0.04253f
C322 vdd_core.t3 VSS 0.04253f
C323 vdd_core.t2 VSS 0.04307f
C324 vdd_core.n121 VSS 0.06857f
C325 vdd_core.n122 VSS 0.01801f
C326 vdd_core.n123 VSS 12.3341f
C327 vdd_core.n124 VSS 0.88328f
C328 vdd_core.t1 VSS 0.04269f
C329 vdd_core.t14 VSS 0.41685f
C330 vdd_core.n125 VSS 0.08151f
C331 vdd_core.n126 VSS 0.07709f
C332 vdd_core.n127 VSS 0.63666f
C333 vdd_core.n128 VSS 13.2047f
C334 vdd_core.n129 VSS 22.4631f
C335 vdd_core.n130 VSS 1.93512f
C336 vdd_core.n131 VSS 0.35297f
C337 vdd_core.n132 VSS 0.07102f
C338 vdd_core.n133 VSS 0.06785f
C339 vdd_core.n134 VSS 0.03009f
C340 vdd_core.n135 VSS 0.03882f
C341 vdd_core.n136 VSS 0.1542f
C342 vdd_core.n137 VSS 0.09215f
C343 vdd_core.n138 VSS 0.13617f
C344 vdd_core.n139 VSS 0.03728f
C345 vdd_core.n140 VSS 0.02898f
C346 vdd_core.n141 VSS 0.09634f
C347 vdd_core.n142 VSS 0.08783f
C348 vdd_core.n143 VSS 0.08783f
C349 vdd_core.n144 VSS 0.08709f
C350 vdd_core.n145 VSS 0.02898f
C351 vdd_core.n146 VSS 0.03728f
C352 vdd_core.n147 VSS 0.08408f
C353 vdd_core.n148 VSS 4.24482f
C354 vdd_core.n149 VSS 48.8486f
C355 vdd_core.n150 VSS 9.33952f
C356 vdd_core.n151 VSS 0.24793f
C357 vdd_core.n152 VSS 0.11501f
C358 vdd_core.n153 VSS 0.11662f
C359 vdd_core.n154 VSS 0.11501f
C360 vdd_core.n155 VSS 0.11662f
C361 vdd_core.n156 VSS 0.11501f
C362 vdd_core.n157 VSS 0.11662f
C363 vdd_core.n158 VSS 0.37206f
C364 vdd_core.n159 VSS 0.59082f
C365 vdd_core.n160 VSS 0.46579f
C366 vdd_core.n161 VSS 0.11662f
C367 vdd_core.n162 VSS 0.11501f
C368 vdd_core.n163 VSS 0.33057f
C369 vdd_core.n164 VSS 0.33057f
C370 vdd_core.n165 VSS 0.33057f
C371 vdd_core.n166 VSS 0.11501f
C372 vdd_core.n167 VSS 0.1701f
C373 vdd_core.n168 VSS 5.41157f
C374 vdd_core.n169 VSS 12.3427f
C375 vdd_core.n170 VSS 0.16263f
C376 vdd_core.n171 VSS 0.11662f
C377 vdd_core.n172 VSS 0.11662f
C378 vdd_core.n173 VSS 0.33057f
C379 vdd_core.n174 VSS 0.33057f
C380 vdd_core.n175 VSS 0.11662f
C381 vdd_core.n176 VSS 0.11501f
C382 vdd_core.n177 VSS 0.11662f
C383 vdd_core.n178 VSS 0.11501f
C384 vdd_core.n179 VSS 0.11662f
C385 vdd_core.n180 VSS 1.03597f
C386 vdd_core.n181 VSS 0.33057f
C387 vdd_core.n182 VSS 0.10124f
C388 vdd_core.n183 VSS 0.2269f
C389 vdd_core.n184 VSS 0.19843f
C390 vdd_core.n185 VSS 0.22743f
C391 vdd_core.n186 VSS 0.11662f
C392 vdd_core.n187 VSS 0.258f
C393 vdd_core.n188 VSS 0.24852f
C394 vdd_core.n189 VSS 0.17735f
C395 vdd_core.n190 VSS 0.2269f
C396 vdd_core.n191 VSS 0.18056f
C397 vdd_core.n192 VSS 0.18056f
C398 vdd_core.n193 VSS 0.27788f
C399 vdd_core.n194 VSS 0.27788f
C400 vdd_core.n195 VSS 0.16554f
C401 vdd_core.n196 VSS 0.16554f
C402 vdd_core.n197 VSS 0.25495f
C403 vdd_core.n198 VSS 0.25495f
C404 vdd_core.n199 VSS 0.16351f
C405 vdd_core.n200 VSS 0.16351f
C406 vdd_core.n201 VSS 0.25589f
C407 vdd_core.n202 VSS 0.25589f
C408 vdd_core.n203 VSS 0.25273f
C409 vdd_core.n204 VSS 0.25379f
C410 vdd_core.n205 VSS 0.16216f
C411 vdd_core.n206 VSS 0.25495f
C412 vdd_core.n207 VSS 0.16689f
C413 vdd_core.n208 VSS 0.27788f
C414 vdd_core.n209 VSS 0.16891f
C415 vdd_core.n210 VSS 0.25495f
C416 vdd_core.n211 VSS 0.15428f
C417 vdd_core.n212 VSS 11.6309f
C418 vdd_core.n213 VSS 0.12112f
C419 vdd_core.n214 VSS 0.11662f
C420 vdd_core.n215 VSS 0.0753f
C421 vdd_core.n216 VSS 0.05509f
C422 vdd_core.n217 VSS 0.33057f
C423 vdd_core.n218 VSS 0.05509f
C424 vdd_core.n219 VSS 0.33057f
C425 vdd_core.n220 VSS 0.33057f
C426 vdd_core.n221 VSS 0.05509f
C427 vdd_core.n222 VSS 0.10124f
C428 vdd_core.n223 VSS 0.11662f
C429 vdd_core.n224 VSS 0.07369f
C430 vdd_core.n225 VSS 0.05509f
C431 vdd_core.n226 VSS 0.10284f
C432 vdd_core.n227 VSS 0.11501f
C433 vdd_core.n228 VSS 0.07369f
C434 vdd_core.n229 VSS 0.05509f
C435 vdd_core.n230 VSS 0.33057f
C436 vdd_core.n231 VSS 0.94373f
C437 vdd_core.n232 VSS 0.05509f
C438 vdd_core.n233 VSS 0.12878f
C439 vdd_core.n234 VSS 5.5819f
C440 vdd_core.n235 VSS 11.6738f
C441 vdd_core.n236 VSS 0.15428f
C442 vdd_core.n237 VSS 0.25495f
C443 vdd_core.n238 VSS 0.16891f
C444 vdd_core.n239 VSS 0.27788f
C445 vdd_core.n240 VSS 0.16689f
C446 vdd_core.n241 VSS 0.25495f
C447 vdd_core.n242 VSS 0.16216f
C448 vdd_core.n243 VSS 0.25379f
C449 vdd_core.n244 VSS 0.25273f
C450 vdd_core.n245 VSS 0.22552f
C451 vdd_core.n246 VSS 1.19477f
C452 vdd_core.n247 VSS 0.06693f
C453 vdd_core.n248 VSS 1.58525f
C454 di_en.n0 VSS 4.60276f
C455 ibias_100u.t3 VSS 2.63913f
C456 ibias_100u.t0 VSS 0.36305f
C457 ibias_100u.n0 VSS 1.04888f
C458 ibias_100u.n1 VSS 0.35091f
C459 ibias_100u.t2 VSS 0.79875f
C460 ibias_100u.n2 VSS 0.34302f
C461 ibias_100u.n3 VSS 3.72822f
C462 rf_out_n.n0 VSS 0.72156f
C463 rf_out_n.n1 VSS 0.89372f
C464 rf_out_n.t6 VSS 1.78871f
C465 rf_out_n.t3 VSS 4.26694f
C466 rf_out_n.t4 VSS 0.37393f
C467 rf_out_n.t5 VSS 0.11424f
C468 rf_out_n.t1 VSS 0.11424f
C469 rf_out_n.t0 VSS 0.11424f
C470 rf_out_n.t2 VSS 0.11424f
C471 rf_out_n.n2 VSS 0.87325f
C472 rf_out_p.n0 VSS 0.9865f
C473 rf_out_p.n1 VSS 0.61469f
C474 rf_out_p.t0 VSS 1.79234f
C475 rf_out_p.t3 VSS 4.37703f
C476 rf_out_p.t6 VSS 0.39731f
C477 rf_out_p.t1 VSS 0.11325f
C478 rf_out_p.t2 VSS 0.11325f
C479 rf_out_p.t4 VSS 0.11325f
C480 rf_out_p.t5 VSS 0.11325f
C481 rf_out_p.n2 VSS 0.86563f
.ends
