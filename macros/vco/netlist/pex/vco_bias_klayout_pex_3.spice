* NGSPICE file created from vco_bias_pex.ext - technology: ihp-sg13cmos5l

.subckt vco_bias_pex ibias_100u di_en VDD VSS vbg_buf vbn_buf
X0 a_4268_n12616# a_4268_n12616# VSS.t6 VSS.t0 sg13_lv_nmos ad=0.85p pd=5.68u as=0.85p ps=5.68u w=2.5u l=0.5u
X1 VSS.t12 vbn_buf VSS.t12 VSS.t13 sg13_lv_nmos ad=1.52p pd=8.38u as=0 ps=0 w=8u l=10u
X2 VSS.t12 vbn_buf VSS.t12 VSS.t15 sg13_lv_nmos ad=1.52p pd=8.38u as=0 ps=0 w=8u l=10u
X3 VSS.t12 vbg_buf VSS.t12 VSS.t14 sg13_lv_nmos ad=1.52p pd=8.38u as=0 ps=0 w=8u l=10u
X4 VSS.t12 vbg_buf VSS.t12 VSS.t16 sg13_lv_nmos ad=1.52p pd=8.38u as=0 ps=0 w=8u l=10u
X5 ibias_100u vbn_buf VSS.t5 rhigh l=32u w=0.5u
X6 a_794_n12180# a_94_n12180# VDD VDD sg13_lv_pmos ad=0.34p pd=2.68u as=0.34p ps=2.68u w=1u l=0.13u
X7 ibias_100u a_94_n12180# VSS VSS.t9 sg13_lv_nmos ad=0.34p pd=2.68u as=0.34p ps=2.68u w=1u l=0.13u
X8 a_1494_n10160# a_794_n12180# VDD VDD sg13_lv_pmos ad=0.34p pd=2.68u as=0.34p ps=2.68u w=1u l=0.13u
X9 VSS.t12 vbn_buf VSS.t12 VSS.t14 sg13_lv_nmos ad=1.52p pd=8.38u as=0 ps=0 w=8u l=10u
X10 VSS.t12 vbn_buf VSS.t12 VSS.t16 sg13_lv_nmos ad=1.52p pd=8.38u as=0 ps=0 w=8u l=10u
X11 VSS.t12 vbg_buf VSS.t12 VSS.t11 sg13_lv_nmos ad=2.72p pd=16.68u as=0 ps=0 w=8u l=10u
X12 a_1494_n10160# a_1494_n10160# VDD VDD sg13_lv_pmos ad=1.7p pd=10.68u as=1.7p ps=10.68u w=5u l=0.5u
X13 VSS.t12 vbg_buf VSS.t12 VSS.t14 sg13_lv_nmos ad=1.52p pd=8.38u as=0 ps=0 w=8u l=10u
X14 VSS.t12 vbg_buf VSS.t12 VSS.t16 sg13_lv_nmos ad=1.52p pd=8.38u as=0 ps=0 w=8u l=10u
X15 a_1494_n10160# ibias_100u VSS.t1 VSS.t0 sg13_lv_nmos ad=0.85p pd=5.68u as=0.85p ps=5.68u w=2.5u l=0.5u
X16 VSS.t12 vbg_buf VSS.t12 VSS.t13 sg13_lv_nmos ad=1.52p pd=8.38u as=0 ps=0 w=8u l=10u
X17 VSS.t12 vbg_buf VSS.t12 VSS.t15 sg13_lv_nmos ad=1.52p pd=8.38u as=0 ps=0 w=8u l=10u
X18 a_94_n12180# di_en VDD VDD sg13_lv_pmos ad=0.34p pd=2.68u as=0.34p ps=2.68u w=1u l=0.13u
X19 a_794_n12180# a_94_n12180# VSS VSS.t3 sg13_lv_nmos ad=0.17p pd=1.68u as=0.17p ps=1.68u w=0.5u l=0.13u
X20 VSS.t12 vbn_buf VSS.t12 VSS.t14 sg13_lv_nmos ad=1.52p pd=8.38u as=0 ps=0 w=8u l=10u
X21 VSS.t12 vbn_buf VSS.t12 VSS.t16 sg13_lv_nmos ad=1.52p pd=8.38u as=0 ps=0 w=8u l=10u
X22 ibias_100u ibias_100u VSS.t1 VSS.t0 sg13_lv_nmos ad=0.85p pd=5.68u as=0.85p ps=5.68u w=2.5u l=0.5u
X23 vbn_buf a_94_n12180# VSS.t1 VSS.t9 sg13_lv_nmos ad=0.34p pd=2.68u as=0.34p ps=2.68u w=1u l=0.13u
X24 a_314_n13910# vbg_buf VSS.t5 rhigh l=32u w=0.5u
X25 VSS.t12 vbn_buf VSS.t12 VSS.t11 sg13_lv_nmos ad=2.72p pd=16.68u as=0 ps=0 w=8u l=10u
X26 a_314_n13910# a_1494_n10160# VDD VDD sg13_lv_pmos ad=1.7p pd=10.68u as=1.7p ps=10.68u w=5u l=0.5u
X27 a_94_n12180# di_en VSS.t4 VSS.t3 sg13_lv_nmos ad=0.17p pd=1.68u as=0.17p ps=1.68u w=0.5u l=0.13u
X28 VSS.t12 vbg_buf VSS.t12 VSS.t11 sg13_lv_nmos ad=2.72p pd=16.68u as=0 ps=0 w=8u l=10u
X29 VSS.t12 vbn_buf VSS.t12 VSS.t13 sg13_lv_nmos ad=1.52p pd=8.38u as=0 ps=0 w=8u l=10u
X30 VSS.t12 vbn_buf VSS.t12 VSS.t15 sg13_lv_nmos ad=1.52p pd=8.38u as=0 ps=0 w=8u l=10u
X31 VSS.t12 vbn_buf VSS.t12 VSS.t11 sg13_lv_nmos ad=2.72p pd=16.68u as=0 ps=0 w=8u l=10u
X32 a_314_n13910# a_4268_n12616# VSS.t7 rppd l=8.5u w=0.5u
X33 VSS.t12 vbg_buf VSS.t12 VSS.t13 sg13_lv_nmos ad=1.52p pd=8.38u as=0 ps=0 w=8u l=10u
X34 VSS.t12 vbg_buf VSS.t12 VSS.t15 sg13_lv_nmos ad=1.52p pd=8.38u as=0 ps=0 w=8u l=10u
C0 vbg_buf a_4268_n12616# 0.05862f
C1 vbn_buf a_314_n13910# 0.56919f
C2 a_5600_n10750# a_4268_n12616# 0.06026f
C3 a_94_n12180# a_1494_n10160# 0.1486f
C4 a_1494_n10160# vbg_buf 0.2279f
C5 a_1494_n10160# VDD 1.33799f
C6 a_1494_n10160# a_4268_n12616# 0.17543f
C7 a_94_n12180# vbn_buf 0.20161f
C8 ibias_100u a_314_n13910# 0.4187f
C9 a_400_n13910# a_0_n13610# 0.60592f
C10 vbn_buf vbg_buf 6.85977f
C11 vbn_buf a_5600_n10750# 0.04105f
C12 a_94_n12180# di_en 0.38176f
C13 a_794_n12180# a_314_n13910# 0.10623f
C14 vbn_buf a_4268_n12616# 1.32792f
C15 vbg_buf di_en 0.06389f
C16 a_314_n13910# a_0_n13610# 0.02728f
C17 VDD di_en 0.11049f
C18 a_94_n12180# ibias_100u 0.74091f
C19 vbn_buf a_1494_n10160# 0.29456f
C20 a_400_n13910# a_314_n13910# 0.03564f
C21 a_94_n12180# a_794_n12180# 0.68546f
C22 a_794_n12180# vbg_buf 0.09645f
C23 a_794_n12180# VDD 0.2499f
C24 ibias_100u a_1494_n10160# 0.70174f
C25 a_400_n13910# vbg_buf 0.03564f
C26 vbn_buf di_en 0.04954f
C27 a_794_n12180# a_1494_n10160# 0.19776f
C28 a_94_n12180# a_314_n13910# 0.16094f
C29 ibias_100u vbn_buf 0.0424f
C30 vbg_buf a_314_n13910# 0.05405f
C31 a_5600_n10750# a_314_n13910# 0.03094f
C32 VDD a_314_n13910# 0.29752f
C33 vbn_buf a_794_n12180# 0.08537f
C34 ibias_100u di_en 0.20081f
C35 a_4268_n12616# a_314_n13910# 0.69174f
C36 vbn_buf a_0_n13610# 0.03589f
C37 a_1494_n10160# a_314_n13910# 1.58315f
C38 a_94_n12180# vbg_buf 0.10514f
C39 a_400_n13910# vbn_buf 0.01263f
C40 a_94_n12180# VDD 0.24905f
C41 a_5600_n10750# vbg_buf 0.01207f
C42 ibias_100u a_794_n12180# 0.33716f
C43 VDD vbg_buf 0.70729f
C44 a_94_n12180# a_4268_n12616# 0.01008f
C45 ibias_100u a_0_n13610# 0.03793f
R0 VSS.n9 VSS.n8 2420.69
R1 VSS.n9 VSS.n6 1881.03
R2 VSS.n13 VSS.t7 1071.75
R3 VSS.n12 VSS.n9 883.99
R4 VSS.t7 VSS.n12 777.904
R5 VSS.n7 VSS.t5 4.80212
R6 VSS.t9 VSS.t0 71.9085
R7 VSS.n11 VSS.n10 47.9391
R8 VSS.t0 VSS.n11 33.5575
R9 VSS.n12 VSS.t3 30.6812
R10 VSS.n3 VSS.t12 0.00100013
R11 VSS.t3 VSS.t9 23.9698
R12 VSS.t16 VSS.n3 4.29923
R13 VSS.t11 VSS.n6 25.4011
R14 VSS.n11 VSS.t4 8.26788
R15 VSS.n10 VSS 17.0005
R16 VSS.n10 VSS.n7 14.6964
R17 VSS.n13 VSS.n3 17.2831
R18 VSS.t1 VSS.n7 0.568525
R19 VSS.t6 VSS.t5 11.3338
R20 VSS.n4 VSS.t13 14.5604
R21 VSS.t14 VSS.n2 6.45629
R22 VSS.n0 VSS.n13 13.1985
R23 VSS.n4 VSS.t11 5.03342
R24 VSS.n1 VSS.t13 15.9176
R25 VSS VSS.t12 12.4069
R26 VSS.t15 VSS.n0 14.5573
R27 VSS.n5 VSS.t14 6.4583
R28 VSS.t12 VSS.n4 0.00100002
R29 VSS.n1 VSS.n8 17.2812
R30 VSS.t12 VSS.n6 0.0440795
R31 VSS.t12 VSS.n0 0.00104347
R32 VSS.n2 VSS.t15 15.9226
R33 VSS.t12 VSS.n2 0.00100956
R34 VSS.t12 VSS.n5 0.00100002
R35 VSS.n5 VSS.n8 13.1985
R36 VSS.t12 VSS.n1 0.00128955
R37 VSS.t4 VSS 1.68824
R38 VSS.t1 VSS.t6 1.61282
R39 VSS.t1 VSS 1.00856
C46 ibias_100u VSS 5.00754f
C47 di_en VSS 1.12969f
C48 vbg_buf VSS 0.10788p
C49 vbn_buf VSS 0.10994p
C50 VDD VSS 4.14085f
C51 a_4268_n12616# VSS 2.48777f ; **FLOATING
C52 a_314_n13910# VSS 4.42842f ; **FLOATING
C53 a_794_n12180# VSS 0.81496f ; **FLOATING
C54 a_94_n12180# VSS 2.42534f ; **FLOATING
C55 a_1494_n10160# VSS 2.44756f ; **FLOATING
.ends
