* PEX produced on Fri Nov  6 11:37:32 PM CET 2026 using /foss/tools/sak/sak-pex.sh with m=3 and s=1 (extresist threshold=1000 mOhm, minres=100 mOhm, mindelay=0 ps)
* NGSPICE file created from vco_bias_pex.ext - technology: ihp-sg13cmos5l

.subckt vco_bias_pex ibias_100u di_en VDD VSS vbg_buf vbn_buf
X0 a_4745_n10428.t1 di_en.t1 VDD.t4 VDD.t0 sg13_lv_pmos ad=0.34p pd=2.68u as=0.34p ps=2.68u w=1u l=0.13u
X1 a_4745_n10428.t0 di_en.t0 VSS.t13 VSS.t12 sg13_lv_nmos ad=0.17p pd=1.68u as=0.17p ps=1.68u w=0.5u l=0.13u
X2 ibias_100u.t2 ibias_100u.t1 VSS.t9 VSS.t8 sg13_lv_nmos ad=0.85p pd=5.68u as=0.85p ps=5.68u w=2.5u l=0.5u
X3 VSS.t49 vbn_buf.t3 VSS.t47 VSS.t17 sg13_lv_nmos ad=1.52p pd=8.38u as=0 ps=0 w=8u l=10u
X4 VSS.t53 vbn_buf.t3 VSS.t51 VSS.t21 sg13_lv_nmos ad=1.52p pd=8.38u as=0 ps=0 w=8u l=10u
X5 VSS.t30 vbg_buf.t1 VSS.t28 VSS.t19 sg13_lv_nmos ad=1.52p pd=8.38u as=0 ps=0 w=8u l=10u
X6 VSS.t34 vbg_buf.t1 VSS.t32 VSS.t23 sg13_lv_nmos ad=1.52p pd=8.38u as=0 ps=0 w=8u l=10u
X7 a_5408_n8844.t3 a_5408_n8844.t2 VDD.t2 VDD.t0 sg13_lv_pmos ad=1.7p pd=10.68u as=1.7p ps=10.68u w=5u l=0.5u
X8 VDD.t16 VDD.t14 VDD.t15 VDD.t0 sg13_lv_pmos ad=1.7p pd=10.68u as=0 ps=0 w=5u l=0.5u
X9 vbn_buf.t1 ibias_100u.t3 VSS.t44 rhigh l=32u w=0.5u
X10 VSS.t38 VSS.t35 VSS.t37 VSS.t36 sg13_lv_nmos ad=0.85p pd=5.68u as=0 ps=0 w=2.5u l=0.5u
X11 VDD.t10 VDD.t8 VDD.t9 VDD.t0 sg13_lv_pmos ad=1.7p pd=10.68u as=0 ps=0 w=5u l=0.5u
X12 VSS.t42 VSS.t39 VSS.t41 VSS.t40 sg13_lv_nmos ad=0.85p pd=5.68u as=0 ps=0 w=2.5u l=0.5u
X13 VSS.t61 vbn_buf.t2 VSS.t59 VSS.t19 sg13_lv_nmos ad=1.52p pd=8.38u as=0 ps=0 w=8u l=10u
X14 a_5408_n8844.t1 ibias_100u.t4 VSS.t7 VSS.t6 sg13_lv_nmos ad=0.85p pd=5.68u as=0.85p ps=5.68u w=2.5u l=0.5u
X15 VSS.t65 vbn_buf.t2 VSS.t63 VSS.t23 sg13_lv_nmos ad=1.52p pd=8.38u as=0 ps=0 w=8u l=10u
X16 VSS.t26 vbg_buf.t1 VSS.t25 VSS.t14 sg13_lv_nmos ad=2.72p pd=16.68u as=0 ps=0 w=8u l=10u
X17 a_5408_n8844.t0 a_4788_n10564.t2 VDD.t1 VDD.t0 sg13_lv_pmos ad=0.34p pd=2.68u as=0.34p ps=2.68u w=1u l=0.13u
X18 VSS.t20 vbg_buf.t2 VSS.t18 VSS.t19 sg13_lv_nmos ad=1.52p pd=8.38u as=0 ps=0 w=8u l=10u
X19 VSS.t24 vbg_buf.t2 VSS.t22 VSS.t23 sg13_lv_nmos ad=1.52p pd=8.38u as=0 ps=0 w=8u l=10u
X20 VSS.t28 vbg_buf.t1 VSS.t26 VSS.t17 sg13_lv_nmos ad=1.52p pd=8.38u as=0 ps=0 w=8u l=10u
X21 VSS.t32 vbg_buf.t1 VSS.t30 VSS.t21 sg13_lv_nmos ad=1.52p pd=8.38u as=0 ps=0 w=8u l=10u
X22 a_4400_n9272.t1 a_4400_n11058.t2 VSS.t43 rppd l=8.5u w=0.5u
X23 VDD.t13 VDD.t11 VDD.t12 VDD.t0 sg13_lv_pmos ad=1.7p pd=10.68u as=0 ps=0 w=5u l=0.5u
X24 VSS.t51 vbn_buf.t3 VSS.t49 VSS.t19 sg13_lv_nmos ad=1.52p pd=8.38u as=0 ps=0 w=8u l=10u
X25 VSS.t55 vbn_buf.t3 VSS.t53 VSS.t23 sg13_lv_nmos ad=1.52p pd=8.38u as=0 ps=0 w=8u l=10u
X26 a_4400_n11058.t1 a_4400_n11058.t0 VSS.t11 VSS.t10 sg13_lv_nmos ad=0.85p pd=5.68u as=0.85p ps=5.68u w=2.5u l=0.5u
X27 a_4788_n10564.t1 a_4745_n10428.t5 VDD.t17 VDD.t0 sg13_lv_pmos ad=0.34p pd=2.68u as=0.34p ps=2.68u w=1u l=0.13u
X28 vbn_buf.t0 a_4745_n10428.t2 VSS.t1 VSS.t0 sg13_lv_nmos ad=0.34p pd=2.68u as=0.34p ps=2.68u w=1u l=0.13u
X29 a_4788_n10564.t0 a_4745_n10428.t4 VSS.t5 VSS.t4 sg13_lv_nmos ad=0.17p pd=1.68u as=0.17p ps=1.68u w=0.5u l=0.13u
X30 vbg_buf.t0 a_4400_n9272.t2 VSS.t45 rhigh l=32u w=0.5u
X31 VSS.t57 vbn_buf.t2 VSS.t56 VSS.t14 sg13_lv_nmos ad=2.72p pd=16.68u as=0 ps=0 w=8u l=10u
X32 VSS.t16 vbg_buf.t2 VSS.t15 VSS.t14 sg13_lv_nmos ad=2.72p pd=16.68u as=0 ps=0 w=8u l=10u
X33 ibias_100u.t0 a_4745_n10428.t3 VSS.t3 VSS.t2 sg13_lv_nmos ad=0.34p pd=2.68u as=0.34p ps=2.68u w=1u l=0.13u
X34 VSS.t59 vbn_buf.t2 VSS.t57 VSS.t17 sg13_lv_nmos ad=1.52p pd=8.38u as=0 ps=0 w=8u l=10u
X35 VSS.t63 vbn_buf.t2 VSS.t61 VSS.t21 sg13_lv_nmos ad=1.52p pd=8.38u as=0 ps=0 w=8u l=10u
X36 a_4400_n9272.t0 a_5408_n8844.t4 VDD.t3 VDD.t0 sg13_lv_pmos ad=1.7p pd=10.68u as=1.7p ps=10.68u w=5u l=0.5u
X37 VSS.t47 vbn_buf.t3 VSS.t46 VSS.t14 sg13_lv_nmos ad=2.72p pd=16.68u as=0 ps=0 w=8u l=10u
X38 VSS.t18 vbg_buf.t2 VSS.t16 VSS.t17 sg13_lv_nmos ad=1.52p pd=8.38u as=0 ps=0 w=8u l=10u
X39 VSS.t22 vbg_buf.t2 VSS.t20 VSS.t21 sg13_lv_nmos ad=1.52p pd=8.38u as=0 ps=0 w=8u l=10u
X40 VDD.t7 VDD.t5 VDD.t6 VDD.t0 sg13_lv_pmos ad=0.34p pd=2.68u as=0 ps=0 w=1u l=0.13u
R0 ibias_100u.n3 ibias_100u.t3 48.9114
R1 ibias_100u.n0 ibias_100u.t4 24.2693
R2 ibias_100u.n1 ibias_100u.t1 24.2693
R3 ibias_100u ibias_100u.n3 19.0674
R4 ibias_100u.n0 ibias_100u.t0 17.3756
R5 ibias_100u.n2 ibias_100u.t2 9.21754
R6 ibias_100u.n3 ibias_100u.n2 4.77917
R7 ibias_100u.n1 ibias_100u.n0 0.543167
R8 ibias_100u.n2 ibias_100u.n1 0.320233
R9 di_en.n0 di_en.t0 21.6583
R10 di_en.n0 di_en.t1 19.605
R11 di_en di_en.n0 13.9942
R12 vbg_buf.n1 vbg_buf.t0 50.4632
R13 vbg_buf.n0 vbg_buf.t2 33.9824
R14 vbg_buf.n0 vbg_buf.t1 28.2977
R15 vbg_buf vbg_buf.n1 14.32
R16 vbg_buf.n1 vbg_buf.n0 0.455167
R17 vbn_buf.n1 vbn_buf.t1 45.1624
R18 vbn_buf.n0 vbn_buf.t3 34.2391
R19 vbn_buf.n0 vbn_buf.t2 28.5544
R20 vbn_buf.n2 vbn_buf.t0 17.3257
R21 vbn_buf.n2 vbn_buf.n1 13.5293
R22 vbn_buf.n1 vbn_buf.n0 6.81757
R23 vbn_buf vbn_buf.n2 2.55837
R24 VDD.n0 VDD.t14 17.5809
R25 VDD.n2 VDD.t11 17.5809
R26 VDD.n8 VDD.t8 17.5809
R27 VDD.n7 VDD.n8 0.0636783
R28 VDD.n11 VDD.n7 1.85672
R29 VDD.n3 VDD.t15 2.54555
R30 VDD.n10 VDD.t5 15.8062
R31 VDD.n11 VDD.n9 2.10335
R32 VDD.n8 VDD.t6 6.07554
R33 VDD.n8 VDD.t7 6.07554
R34 VDD.n4 VDD.t1 6.07554
R35 VDD.n5 VDD.t4 6.07554
R36 VDD.n6 VDD.t17 6.07554
R37 VDD VDD.n6 5.67699
R38 VDD.n11 VDD.n4 2.40129
R39 VDD.n4 VDD.n5 0.1061
R40 VDD.n6 VDD.n11 3.37539
R41 VDD.n11 VDD.n3 1.16155
R42 VDD.n1 VDD.t3 2.36466
R43 VDD.n0 VDD.t2 2.36447
R44 VDD.n1 VDD.t12 2.36447
R45 VDD.n0 VDD.t16 2.36417
R46 VDD.n2 VDD.t13 2.36357
R47 VDD.n2 VDD.t9 2.36308
R48 VDD.n2 VDD.t10 2.36308
R49 VDD.n11 VDD.t0 0.395849
R50 VDD.n1 VDD.n0 0.181347
R51 VDD.n6 VDD.n5 0.152127
R52 VDD.n3 VDD.n0 0.0814646
R53 VDD.n10 VDD.n4 0.144689
R54 VDD.n9 VDD.n1 0.139765
R55 VDD.n9 VDD.n2 0.137132
R56 VDD.n2 VDD.n7 0.120382
R57 VDD.n8 VDD.n10 0.102865
R58 VSS.n138 VSS.n137 2596.43
R59 VSS.n181 VSS.t44 740.371
R60 VSS.t45 VSS.t43 454.709
R61 VSS.t44 VSS.t45 213.981
R62 VSS.t6 VSS.n17 12.2796
R63 VSS.n1 VSS.t40 58.2585
R64 VSS.n4 VSS.t12 13.4559
R65 VSS.n0 VSS.t10 53.9994
R66 VSS.t0 VSS.n3 16.0639
R67 VSS.n1 VSS.t8 38.2794
R68 VSS.n5 VSS.t4 11.7783
R69 VSS.t36 VSS.n0 18.4512
R70 VSS.n2 VSS.n4 0.0166315
R71 VSS.n222 VSS.t23 26.5384
R72 VSS.n57 VSS.t14 26.5384
R73 VSS.t43 VSS.n5 179.258
R74 VSS.n130 VSS.n63 24.5729
R75 VSS.n184 VSS.n50 24.5729
R76 VSS.n121 VSS.n69 24.5729
R77 VSS.n190 VSS.n44 24.5729
R78 VSS.n118 VSS.n71 24.5729
R79 VSS.n195 VSS.n42 24.5729
R80 VSS.n116 VSS.n73 24.5729
R81 VSS.n198 VSS.n40 24.5729
R82 VSS.n111 VSS.n78 24.5729
R83 VSS.n201 VSS.n36 24.5729
R84 VSS.n106 VSS.n83 24.5729
R85 VSS.n206 VSS.n33 24.5729
R86 VSS.n211 VSS.n28 24.5729
R87 VSS.n99 VSS.n89 24.5729
R88 VSS.n212 VSS.n26 24.5729
R89 VSS.n2 VSS.n3 0.0120382
R90 VSS.n181 VSS.n131 23.1275
R91 VSS.n137 VSS.n93 20.2366
R92 VSS.n166 VSS.t5 17.3443
R93 VSS.n168 VSS.t13 17.3443
R94 VSS.n2 VSS.n9 4.23471
R95 VSS.n2 VSS.n15 5.65558
R96 VSS.n5 VSS.n2 7.79452
R97 VSS.n172 VSS.t35 16.4809
R98 VSS.n179 VSS.t39 16.4809
R99 VSS.n19 VSS.n18 13.5948
R100 VSS.n149 VSS.n20 13.5948
R101 VSS.n12 VSS.n6 13.5948
R102 VSS.t40 VSS.n138 13.5651
R103 VSS.n186 VSS.t17 13.0094
R104 VSS.t21 VSS.n86 13.0094
R105 VSS.t17 VSS.n122 11.564
R106 VSS.n103 VSS.t21 11.564
R107 VSS.n96 VSS.n25 10.0498
R108 VSS.n100 VSS.n30 10.0498
R109 VSS.n101 VSS.n31 10.0498
R110 VSS.n109 VSS.n38 10.0498
R111 VSS.n113 VSS.n39 10.0498
R112 VSS.n119 VSS.n46 10.0498
R113 VSS.n187 VSS.n48 10.0498
R114 VSS.n123 VSS.n49 10.0498
R115 VSS.n124 VSS.n52 10.0498
R116 VSS.n125 VSS.n53 10.0498
R117 VSS.n127 VSS.n54 10.0498
R118 VSS.n132 VSS.n55 10.0498
R119 VSS.n215 VSS.n92 10.0498
R120 VSS.n208 VSS.n84 10.0498
R121 VSS.n204 VSS.n81 10.0498
R122 VSS.n203 VSS.n80 10.0498
R123 VSS.n197 VSS.n74 10.0498
R124 VSS.n187 VSS.n67 10.0498
R125 VSS.n136 VSS.n60 10.0498
R126 VSS.n135 VSS.n59 10.0498
R127 VSS.n133 VSS.n58 10.0498
R128 VSS.n132 VSS.n58 10.0498
R129 VSS.n134 VSS.n55 10.0498
R130 VSS.n134 VSS.n59 10.0498
R131 VSS.n135 VSS.n60 10.0498
R132 VSS.n136 VSS.n61 10.0498
R133 VSS.n129 VSS.n64 10.0498
R134 VSS.n128 VSS.n64 10.0498
R135 VSS.n128 VSS.n54 10.0498
R136 VSS.n127 VSS.n65 10.0498
R137 VSS.n126 VSS.n65 10.0498
R138 VSS.n126 VSS.n53 10.0498
R139 VSS.n125 VSS.n52 10.0498
R140 VSS.n124 VSS.n51 10.0498
R141 VSS.n185 VSS.n66 10.0498
R142 VSS.n123 VSS.n66 10.0498
R143 VSS.n188 VSS.n48 10.0498
R144 VSS.n188 VSS.n68 10.0498
R145 VSS.n120 VSS.n47 10.0498
R146 VSS.n189 VSS.n47 10.0498
R147 VSS.n189 VSS.n46 10.0498
R148 VSS.n119 VSS.n45 10.0498
R149 VSS.n191 VSS.n70 10.0498
R150 VSS.n117 VSS.n43 10.0498
R151 VSS.n196 VSS.n72 10.0498
R152 VSS.n115 VSS.n74 10.0498
R153 VSS.n115 VSS.n75 10.0498
R154 VSS.n114 VSS.n75 10.0498
R155 VSS.n114 VSS.n41 10.0498
R156 VSS.n113 VSS.n76 10.0498
R157 VSS.n200 VSS.n39 10.0498
R158 VSS.n200 VSS.n77 10.0498
R159 VSS.n112 VSS.n77 10.0498
R160 VSS.n110 VSS.n79 10.0498
R161 VSS.n110 VSS.n38 10.0498
R162 VSS.n109 VSS.n37 10.0498
R163 VSS.n202 VSS.n80 10.0498
R164 VSS.n203 VSS.n81 10.0498
R165 VSS.n204 VSS.n82 10.0498
R166 VSS.n105 VSS.n35 10.0498
R167 VSS.n205 VSS.n35 10.0498
R168 VSS.n205 VSS.n34 10.0498
R169 VSS.n207 VSS.n84 10.0498
R170 VSS.n208 VSS.n85 10.0498
R171 VSS.n104 VSS.n85 10.0498
R172 VSS.n102 VSS.n87 10.0498
R173 VSS.n102 VSS.n32 10.0498
R174 VSS.n209 VSS.n32 10.0498
R175 VSS.n209 VSS.n31 10.0498
R176 VSS.n101 VSS.n30 10.0498
R177 VSS.n100 VSS.n29 10.0498
R178 VSS.n210 VSS.n29 10.0498
R179 VSS.n98 VSS.n27 10.0498
R180 VSS.n213 VSS.n90 10.0498
R181 VSS.n96 VSS.n90 10.0498
R182 VSS.n214 VSS.n25 10.0498
R183 VSS.n214 VSS.n91 10.0498
R184 VSS.n95 VSS.n91 10.0498
R185 VSS.n95 VSS.n92 10.0498
R186 VSS.n216 VSS.n24 10.0498
R187 VSS.n216 VSS.n23 10.0498
R188 VSS.n217 VSS.n23 10.0498
R189 VSS VSS.n235 9.6573
R190 VSS.n221 VSS.n94 8.5005
R191 VSS.n221 VSS.n212 8.5005
R192 VSS.n221 VSS.n99 8.5005
R193 VSS.n221 VSS.n211 8.5005
R194 VSS.n221 VSS.n103 8.5005
R195 VSS.n221 VSS.n206 8.5005
R196 VSS.n221 VSS.n106 8.5005
R197 VSS.n221 VSS.n201 8.5005
R198 VSS.n221 VSS.n111 8.5005
R199 VSS.n221 VSS.n198 8.5005
R200 VSS.n221 VSS.n116 8.5005
R201 VSS.n221 VSS.n195 8.5005
R202 VSS.n221 VSS.n118 8.5005
R203 VSS.n221 VSS.n190 8.5005
R204 VSS.n221 VSS.n121 8.5005
R205 VSS.n221 VSS.n186 8.5005
R206 VSS.n221 VSS.n122 8.5005
R207 VSS.n221 VSS.n184 8.5005
R208 VSS.n221 VSS.n130 8.5005
R209 VSS.n221 VSS.n182 8.5005
R210 VSS.n221 VSS.n131 8.5005
R211 VSS.n223 VSS.n93 8.5005
R212 VSS.n223 VSS.n89 8.5005
R213 VSS.n223 VSS.n86 8.5005
R214 VSS.n223 VSS.n83 8.5005
R215 VSS.n223 VSS.n78 8.5005
R216 VSS.n223 VSS.n73 8.5005
R217 VSS.n223 VSS.n71 8.5005
R218 VSS.n223 VSS.n69 8.5005
R219 VSS.n223 VSS.n63 8.5005
R220 VSS.n223 VSS.n22 8.5005
R221 VSS.n223 VSS.n26 8.5005
R222 VSS.n223 VSS.n28 8.5005
R223 VSS.n223 VSS.n33 8.5005
R224 VSS.n223 VSS.n36 8.5005
R225 VSS.n223 VSS.n40 8.5005
R226 VSS.n223 VSS.n42 8.5005
R227 VSS.n223 VSS.n44 8.5005
R228 VSS.n223 VSS.n50 8.5005
R229 VSS.n223 VSS.n56 8.5005
R230 VSS.n15 VSS.n174 0.0599659
R231 VSS.n235 VSS.n21 7.76695
R232 VSS.n10 VSS.n163 6.75907
R233 VSS.n169 VSS.t3 6.07511
R234 VSS.n140 VSS.t1 6.07511
R235 VSS.n9 VSS.t42 3.20134
R236 VSS.n2 VSS.n175 5.65335
R237 VSS.n217 VSS.n22 5.02514
R238 VSS.n213 VSS.n26 5.02514
R239 VSS.n98 VSS.n89 5.02514
R240 VSS.n210 VSS.n28 5.02514
R241 VSS.n104 VSS.n86 5.02514
R242 VSS.n207 VSS.n33 5.02514
R243 VSS.n105 VSS.n83 5.02514
R244 VSS.n202 VSS.n36 5.02514
R245 VSS.n112 VSS.n78 5.02514
R246 VSS.n199 VSS.n40 5.02514
R247 VSS.n196 VSS.n42 5.02514
R248 VSS.n117 VSS.n71 5.02514
R249 VSS.n191 VSS.n44 5.02514
R250 VSS.n120 VSS.n69 5.02514
R251 VSS.n185 VSS.n50 5.02514
R252 VSS.n129 VSS.n63 5.02514
R253 VSS.n133 VSS.n56 5.02514
R254 VSS.n212 VSS.n27 5.02514
R255 VSS.n206 VSS.n34 5.02514
R256 VSS.n201 VSS.n37 5.02514
R257 VSS.n198 VSS.n41 5.02514
R258 VSS.n195 VSS.n43 5.02514
R259 VSS.n190 VSS.n45 5.02514
R260 VSS.n184 VSS.n51 5.02514
R261 VSS.n99 VSS.n88 5.02514
R262 VSS.n103 VSS.n87 5.02514
R263 VSS.n106 VSS.n82 5.02514
R264 VSS.n111 VSS.n79 5.02514
R265 VSS.n116 VSS.n72 5.02514
R266 VSS.n118 VSS.n70 5.02514
R267 VSS.n121 VSS.n68 5.02514
R268 VSS.n130 VSS.n62 5.02514
R269 VSS.n131 VSS.n61 5.02514
R270 VSS.n182 VSS.n62 5.02514
R271 VSS.n122 VSS.n49 5.02514
R272 VSS.n186 VSS.n67 5.02514
R273 VSS.n197 VSS.n73 5.02514
R274 VSS.n199 VSS.t19 5.02514
R275 VSS.t19 VSS.n76 5.02514
R276 VSS.n211 VSS.n88 5.02514
R277 VSS.n215 VSS.n93 5.02514
R278 VSS.n94 VSS.n24 5.02514
R279 VSS.n235 VSS.n234 4.67815
R280 VSS.n7 VSS.n14 4.41876
R281 VSS.n137 VSS.n94 4.3368
R282 VSS.n2 VSS.n180 4.23094
R283 VSS.n2 VSS.n139 4.23094
R284 VSS.n2 VSS.n170 4.23094
R285 VSS.n2 VSS.n138 3.50296
R286 VSS.n2 VSS.n173 3.37539
R287 VSS.n2 VSS.n141 3.37539
R288 VSS.n2 VSS.n167 3.37539
R289 VSS.n171 VSS.t11 3.14902
R290 VSS.n16 VSS.t37 3.14902
R291 VSS.n174 VSS.t38 3.14902
R292 VSS.n176 VSS.t7 3.14902
R293 VSS.n178 VSS.t9 3.14902
R294 VSS.n8 VSS.t41 3.14902
R295 VSS.n2 VSS.n177 2.80331
R296 VSS.n166 VSS.n165 2.71772
R297 VSS.n226 VSS.t32 2.21156
R298 VSS.n224 VSS.t34 2.21093
R299 VSS.n219 VSS.t65 2.21075
R300 VSS.n193 VSS.t59 2.21062
R301 VSS.n230 VSS.t28 2.21055
R302 VSS.n192 VSS.t57 2.21042
R303 VSS.n234 VSS.t25 2.2104
R304 VSS.n21 VSS.t56 2.21032
R305 VSS.n228 VSS.t30 2.20994
R306 VSS.n107 VSS.t61 2.20994
R307 VSS.n218 VSS.t63 2.2099
R308 VSS.n232 VSS.t26 2.20978
R309 VSS.n21 VSS.t46 2.20312
R310 VSS.n234 VSS.t15 2.20298
R311 VSS.n226 VSS.t22 2.20225
R312 VSS.n218 VSS.t53 2.20219
R313 VSS.n192 VSS.t47 2.20209
R314 VSS.n193 VSS.t49 2.20208
R315 VSS.n232 VSS.t16 2.20205
R316 VSS.n228 VSS.t20 2.20198
R317 VSS.n230 VSS.t18 2.20183
R318 VSS.n107 VSS.t51 2.20167
R319 VSS.n224 VSS.t24 2.20146
R320 VSS.n219 VSS.t55 2.20096
R321 VSS.n221 VSS.n199 1.73893
R322 VSS.n221 VSS.n217 1.73893
R323 VSS.n221 VSS.n216 1.73893
R324 VSS.n221 VSS.n215 1.73893
R325 VSS.n221 VSS.n95 1.73893
R326 VSS.n221 VSS.n214 1.73893
R327 VSS.n221 VSS.n96 1.73893
R328 VSS.n221 VSS.n213 1.73893
R329 VSS.n221 VSS.n98 1.73893
R330 VSS.n221 VSS.n210 1.73893
R331 VSS.n221 VSS.n100 1.73893
R332 VSS.n221 VSS.n101 1.73893
R333 VSS.n221 VSS.n209 1.73893
R334 VSS.n221 VSS.n102 1.73893
R335 VSS.n221 VSS.n104 1.73893
R336 VSS.n221 VSS.n208 1.73893
R337 VSS.n221 VSS.n207 1.73893
R338 VSS.n221 VSS.n205 1.73893
R339 VSS.n221 VSS.n105 1.73893
R340 VSS.n221 VSS.n204 1.73893
R341 VSS.n221 VSS.n203 1.73893
R342 VSS.n221 VSS.n202 1.73893
R343 VSS.n221 VSS.n109 1.73893
R344 VSS.n221 VSS.n110 1.73893
R345 VSS.n221 VSS.n112 1.73893
R346 VSS.n221 VSS.n200 1.73893
R347 VSS.n221 VSS.n113 1.73893
R348 VSS.n221 VSS.n114 1.73893
R349 VSS.n221 VSS.n115 1.73893
R350 VSS.n221 VSS.n197 1.73893
R351 VSS.n221 VSS.n196 1.73893
R352 VSS.n221 VSS.n117 1.73893
R353 VSS.n221 VSS.n191 1.73893
R354 VSS.n221 VSS.n119 1.73893
R355 VSS.n221 VSS.n189 1.73893
R356 VSS.n221 VSS.n120 1.73893
R357 VSS.n221 VSS.n188 1.73893
R358 VSS.n221 VSS.n187 1.73893
R359 VSS.n221 VSS.n123 1.73893
R360 VSS.n221 VSS.n185 1.73893
R361 VSS.n221 VSS.n124 1.73893
R362 VSS.n221 VSS.n125 1.73893
R363 VSS.n221 VSS.n126 1.73893
R364 VSS.n221 VSS.n127 1.73893
R365 VSS.n221 VSS.n128 1.73893
R366 VSS.n221 VSS.n129 1.73893
R367 VSS.n221 VSS.n136 1.73893
R368 VSS.n221 VSS.n135 1.73893
R369 VSS.n221 VSS.n134 1.73893
R370 VSS.n221 VSS.n132 1.73893
R371 VSS.n221 VSS.n133 1.73893
R372 VSS.n223 VSS.n92 1.73893
R373 VSS.n223 VSS.n91 1.73893
R374 VSS.n223 VSS.n90 1.73893
R375 VSS.n223 VSS.n88 1.73893
R376 VSS.n223 VSS.n87 1.73893
R377 VSS.n223 VSS.n85 1.73893
R378 VSS.n223 VSS.n84 1.73893
R379 VSS.n223 VSS.n82 1.73893
R380 VSS.n223 VSS.n81 1.73893
R381 VSS.n223 VSS.n80 1.73893
R382 VSS.n223 VSS.n79 1.73893
R383 VSS.n223 VSS.n77 1.73893
R384 VSS.n223 VSS.n76 1.73893
R385 VSS.n223 VSS.n75 1.73893
R386 VSS.n223 VSS.n74 1.73893
R387 VSS.n223 VSS.n72 1.73893
R388 VSS.n223 VSS.n70 1.73893
R389 VSS.n223 VSS.n68 1.73893
R390 VSS.n223 VSS.n67 1.73893
R391 VSS.n223 VSS.n66 1.73893
R392 VSS.n223 VSS.n65 1.73893
R393 VSS.n223 VSS.n64 1.73893
R394 VSS.n223 VSS.n62 1.73893
R395 VSS.n223 VSS.n61 1.73893
R396 VSS.n223 VSS.n60 1.73893
R397 VSS.n223 VSS.n59 1.73893
R398 VSS.n223 VSS.n58 1.73893
R399 VSS.n223 VSS.n23 1.73893
R400 VSS.n223 VSS.n24 1.73893
R401 VSS.n223 VSS.n25 1.73893
R402 VSS.n223 VSS.n27 1.73893
R403 VSS.n223 VSS.n29 1.73893
R404 VSS.n223 VSS.n30 1.73893
R405 VSS.n223 VSS.n31 1.73893
R406 VSS.n223 VSS.n32 1.73893
R407 VSS.n223 VSS.n34 1.73893
R408 VSS.n223 VSS.n35 1.73893
R409 VSS.n223 VSS.n37 1.73893
R410 VSS.n223 VSS.n38 1.73893
R411 VSS.n223 VSS.n39 1.73893
R412 VSS.n223 VSS.n41 1.73893
R413 VSS.n223 VSS.n43 1.73893
R414 VSS.n223 VSS.n45 1.73893
R415 VSS.n223 VSS.n46 1.73893
R416 VSS.n223 VSS.n47 1.73893
R417 VSS.n223 VSS.n48 1.73893
R418 VSS.n223 VSS.n49 1.73893
R419 VSS.n223 VSS.n51 1.73893
R420 VSS.n223 VSS.n52 1.73893
R421 VSS.n223 VSS.n53 1.73893
R422 VSS.n223 VSS.n54 1.73893
R423 VSS.n223 VSS.n55 1.73893
R424 VSS.t14 VSS.n56 1.44593
R425 VSS.n182 VSS.n181 1.44593
R426 VSS.t23 VSS.n22 1.44593
R427 VSS.n221 VSS.n57 0.570667
R428 VSS.n223 VSS.n222 0.570527
R429 VSS.n223 VSS.n57 0.570155
R430 VSS.n222 VSS.n221 0.570015
R431 VSS.n18 VSS.n20 0.471929
R432 VSS.n164 VSS.n18 0.471929
R433 VSS.n14 VSS.n13 0.0605836
R434 VSS.n232 VSS.n231 0.243424
R435 VSS.n194 VSS.n192 0.243424
R436 VSS.n183 VSS.n21 0.242716
R437 VSS.n234 VSS.n233 0.242681
R438 VSS.n228 VSS.n227 0.24245
R439 VSS.n107 VSS.n97 0.24245
R440 VSS.n230 VSS.n229 0.240796
R441 VSS.n193 VSS.n108 0.240796
R442 VSS.n226 VSS.n225 0.239822
R443 VSS.n220 VSS.n218 0.239822
R444 VSS.n11 VSS.n10 0.0590735
R445 VSS.n227 VSS.n226 0.227974
R446 VSS.n218 VSS.n97 0.227974
R447 VSS.n231 VSS.n230 0.227001
R448 VSS.n194 VSS.n193 0.227001
R449 VSS.n165 VSS.n12 0.226786
R450 VSS.n225 VSS.n224 0.225646
R451 VSS.n220 VSS.n219 0.225646
R452 VSS.n229 VSS.n228 0.224672
R453 VSS.n108 VSS.n107 0.224672
R454 VSS.n233 VSS.n232 0.223727
R455 VSS.n192 VSS.n183 0.223715
R456 VSS.n221 VSS.n97 0.218846
R457 VSS.n221 VSS.n194 0.218846
R458 VSS.n227 VSS.n223 0.218846
R459 VSS.n231 VSS.n223 0.218846
R460 VSS.n163 VSS.n162 0.21526
R461 VSS.n165 VSS.n164 0.214214
R462 VSS.n221 VSS.n220 0.208386
R463 VSS.n221 VSS.n108 0.208386
R464 VSS.n225 VSS.n223 0.208386
R465 VSS.n229 VSS.n223 0.208386
R466 VSS.n221 VSS.n183 0.208371
R467 VSS.n233 VSS.n223 0.20836
R468 VSS.n145 VSS.n14 0.197741
R469 VSS.n146 VSS.n145 0.197741
R470 VSS.n147 VSS.n146 0.197741
R471 VSS.n10 VSS.n148 0.173833
R472 VSS.n157 VSS.n148 0.173833
R473 VSS.n158 VSS.n157 0.173833
R474 VSS.n159 VSS.n158 0.173833
R475 VSS.n160 VSS.n159 0.173833
R476 VSS.n161 VSS.n160 0.173833
R477 VSS.n162 VSS.n161 0.173833
R478 VSS.n4 VSS.t2 18.096
R479 VSS.n164 VSS.n11 14.0284
R480 VSS.n155 VSS.n148 0.117414
R481 VSS.n157 VSS.n156 0.117414
R482 VSS.n158 VSS.n154 0.117414
R483 VSS.n159 VSS.n153 0.117414
R484 VSS.n160 VSS.n152 0.117414
R485 VSS.n161 VSS.n151 0.117414
R486 VSS.n162 VSS.n150 0.117414
R487 VSS.n13 VSS.n12 14.3176
R488 VSS.n145 VSS.n144 0.112386
R489 VSS.n146 VSS.n143 0.112386
R490 VSS.n147 VSS.n142 0.112386
R491 VSS.n147 VSS.n7 0.257009
R492 VSS.n6 VSS.n7 0.0268464
R493 VSS.n177 VSS.n176 0.0927224
R494 VSS.n178 VSS.n177 0.0891245
R495 VSS.n163 VSS.n149 0.088983
R496 VSS.n151 VSS.n150 0.0885
R497 VSS.n152 VSS.n151 0.0885
R498 VSS.n153 VSS.n152 0.0885
R499 VSS.n154 VSS.n153 0.0885
R500 VSS.n156 VSS.n154 0.0885
R501 VSS.n156 VSS.n155 0.0885
R502 VSS.n143 VSS.n142 0.0885
R503 VSS.n144 VSS.n143 0.0885
R504 VSS.n155 VSS.n19 0.0885
R505 VSS.n141 VSS.n140 0.0814472
R506 VSS.n170 VSS.n169 0.0794206
R507 VSS.n171 VSS.n139 0.0784641
R508 VSS.n168 VSS.n167 0.0776211
R509 VSS.n180 VSS.n178 0.0773061
R510 VSS.n167 VSS.n166 0.0750054
R511 VSS.n170 VSS.n168 0.0725235
R512 VSS.n173 VSS.n171 0.0721359
R513 VSS.n169 VSS.n141 0.0711793
R514 VSS.n140 VSS.n139 0.0686974
R515 VSS.n173 VSS.n172 0.0675776
R516 VSS.n180 VSS.n179 0.061725
R517 VSS.n176 VSS.n175 0.0581825
R518 VSS.n150 VSS.n149 0.0489
R519 VSS.n9 VSS.n8 0.0351392
R520 VSS.n17 VSS.t8 36.8855
R521 VSS VSS.n20 0.409071
R522 VSS.n11 VSS.n19 0.0305639
R523 VSS.n144 VSS.n13 0.115446
R524 VSS.n142 VSS.n6 0.1149
R525 VSS.n2 VSS.n0 0.0520648
R526 VSS.n2 VSS.n17 0.0456104
R527 VSS.n172 VSS.n16 0.0421087
R528 VSS.n179 VSS.n8 0.0421087
R529 VSS.n16 VSS.n15 0.0271167
R530 VSS.n175 VSS.n174 0.037474
R531 VSS.n2 VSS.n1 0.0361218
R532 VSS.n3 VSS.t10 21.176
R533 a_4400_n11058.n0 a_4400_n11058.t2 27.72
R534 a_4400_n11058.n0 a_4400_n11058.t0 24.1197
R535 a_4400_n11058.t1 a_4400_n11058.n0 9.38813
R536 a_4400_n9272.n0 a_4400_n9272.t2 55.3005
R537 a_4400_n9272.n0 a_4400_n9272.t1 27.8842
R538 a_4400_n9272.t0 a_4400_n9272.n0 7.50485
R539 a_5408_n8844.n2 a_5408_n8844.t2 19.9393
R540 a_5408_n8844.n0 a_5408_n8844.t4 19.6783
R541 a_5408_n8844.n1 a_5408_n8844.t0 17.974
R542 a_5408_n8844.n2 a_5408_n8844.n1 5.04317
R543 a_5408_n8844.n0 a_5408_n8844.t1 4.81727
R544 a_5408_n8844.n1 a_5408_n8844.n0 4.76157
R545 a_5408_n8844.t3 a_5408_n8844.n2 3.15445
R546 a_4788_n10564.n0 a_4788_n10564.t2 30.2902
R547 a_4788_n10564.n0 a_4788_n10564.t0 27.2706
R548 a_4788_n10564.t1 a_4788_n10564.n0 11.5346
R549 a_4745_n10428.n0 a_4745_n10428.t0 27.1774
R550 a_4745_n10428.n2 a_4745_n10428.t2 25.4059
R551 a_4745_n10428.n1 a_4745_n10428.t5 20.7725
R552 a_4745_n10428.n1 a_4745_n10428.t4 20.4909
R553 a_4745_n10428.n0 a_4745_n10428.t3 20.4287
R554 a_4745_n10428.t1 a_4745_n10428.n0 12.1418
R555 a_4745_n10428.n2 a_4745_n10428.n1 5.30277
R556 a_4745_n10428.n0 a_4745_n10428.n2 4.5269
C0 di_en VDD 0.53932f
C1 ibias_100u vbn_buf 0.15213f
C2 vbg_buf vbn_buf 10.2957f
C3 a_4400_n10972# vbg_buf 0.12015f
C4 a_400_n13910# ibias_100u 0.01906f
C5 a_400_n13910# vbg_buf 0.03498f
C6 di_en ibias_100u 3.62371f
C7 di_en vbg_buf 3.60972f
C8 a_0_n13610# vbn_buf 0.02902f
C9 ibias_100u VDD 0.47354f
C10 vbg_buf VDD 4.13316f
C11 a_400_n13910# a_0_n13610# 0.60592f
C12 ibias_100u vbg_buf 2.66487f
C13 di_en vbn_buf 0.13197f
C14 a_0_n13610# ibias_100u 0.02966f
C15 a_0_n13610# vbg_buf 0.04989f
C16 VDD vbn_buf 0.8997f
C17 a_4400_n10972# VDD 0.04174f
C18 ibias_100u VSS 6.07536f
C19 di_en VSS 4.75337f
C20 vbg_buf VSS 0.79087p
C21 vbn_buf VSS 0.10817p
C22 VDD VSS 1.56387f
C23 a_4745_n10428.n0 VSS 1.32132f
C24 a_4745_n10428.n1 VSS 1.05369f
C25 a_4745_n10428.n2 VSS 0.8442f
C26 a_4745_n10428.t0 VSS 0.24325f
C27 a_4745_n10428.t1 VSS 0.32717f
C28 a_4788_n10564.t0 VSS 0.17174f
C29 a_4788_n10564.n0 VSS 2.17987f
C30 a_4788_n10564.t1 VSS 0.31368f
C31 a_5408_n8844.t0 VSS 0.59248f
C32 a_5408_n8844.t1 VSS 0.61776f
C33 a_5408_n8844.n0 VSS 0.68902f
C34 a_5408_n8844.n1 VSS 1.03309f
C35 a_5408_n8844.n2 VSS 0.68953f
C36 a_5408_n8844.t3 VSS 1.10359f
C37 a_4400_n9272.t2 VSS 2.51816f
C38 a_4400_n9272.t1 VSS 0.77746f
C39 a_4400_n9272.n0 VSS 3.05383f
C40 a_4400_n9272.t0 VSS 1.19339f
C41 a_4400_n11058.t2 VSS 0.77468f
C42 a_4400_n11058.n0 VSS 1.03976f
C43 a_4400_n11058.t1 VSS 0.53225f
C44 VSS.t61 VSS 2.9662f
C45 VSS.t1 VSS 0.11733f
C46 VSS.t5 VSS 0.06243f
C47 VSS.t13 VSS 0.16898f
C48 VSS.t3 VSS 0.07192f
C49 VSS.t11 VSS 0.18791f
C50 VSS.t7 VSS 0.27664f
C51 VSS.t9 VSS 0.27664f
C52 VSS.t47 VSS 2.9704f
C53 VSS.t49 VSS 2.9704f
C54 VSS.t59 VSS 2.9662f
C55 VSS.t18 VSS 3.29335f
C56 VSS.t28 VSS 3.28875f
C57 VSS.t20 VSS 3.29335f
C58 VSS.t30 VSS 3.28875f
C59 VDD.n0 VSS 0.38047f
C60 VDD.n1 VSS 0.18336f
C61 VDD.n2 VSS 0.34228f
C62 VDD.n3 VSS 0.06724f
C63 VDD.n4 VSS 0.11006f
C64 VDD.n5 VSS 0.08933f
C65 VDD.n6 VSS 0.45678f
C66 VDD.n8 VSS 0.23953f
C67 VDD.t17 VSS 0.09597f
C68 VDD.t4 VSS 0.15831f
C69 VDD.t1 VSS 0.28336f
C70 VDD.t2 VSS 0.54503f
C71 VDD.t15 VSS 0.20979f
C72 VDD.t16 VSS 0.20493f
C73 VDD.t3 VSS 0.54315f
C74 VDD.t12 VSS 0.20493f
C75 VDD.t13 VSS 0.20493f
C76 VDD.t9 VSS 0.20494f
C77 VDD.t10 VSS 0.20494f
C78 VDD.t6 VSS 0.02863f
C79 VDD.t7 VSS 0.02863f
C80 VDD.n10 VSS 0.09621f
C81 VDD.t0 VSS 6.12485f
C82 VDD.n11 VSS 0.50235f
C83 vbn_buf.n0 VSS 0.12354f
C84 vbn_buf.t1 VSS 2.22323f
C85 vbn_buf.n1 VSS 0.17769f
C86 vbn_buf.t0 VSS 0.13554f
C87 vbn_buf.n2 VSS 0.12062f
C88 vbg_buf.n0 VSS 0.0899f
C89 vbg_buf.t0 VSS 1.99504f
C90 vbg_buf.n1 VSS 3.6703f
C91 di_en.n0 VSS 4.53205f
C92 ibias_100u.t3 VSS 2.61798f
C93 ibias_100u.t0 VSS 0.35882f
C94 ibias_100u.n0 VSS 1.03363f
C95 ibias_100u.n1 VSS 0.3458f
C96 ibias_100u.t2 VSS 0.78714f
C97 ibias_100u.n2 VSS 0.33803f
C98 ibias_100u.n3 VSS 3.64325f
.ends
