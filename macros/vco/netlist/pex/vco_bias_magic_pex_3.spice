* PEX produced on Wed Nov  4 01:43:20 PM CET 2026 using /foss/tools/sak/sak-pex.sh with m=3 and s=1 (extresist threshold=1000 mOhm, minres=100 mOhm, mindelay=0 ps)
* NGSPICE file created from vco_bias_pex.ext - technology: ihp-sg13cmos5l

.subckt vco_bias_pex ibias_100u di_en VDD VSS vbg_buf vbn_buf
X0 a_4268_n12616.t1 a_4268_n12616.t0 VSS.t3 VSS.t2 sg13_lv_nmos ad=0.85p pd=5.68u as=0.85p ps=5.68u w=2.5u l=0.5u
X1 VSS.t37 vbn_buf.t3 VSS.t35 VSS.t13 sg13_lv_nmos ad=1.52p pd=8.38u as=0 ps=0 w=8u l=10u
X2 VSS.t41 vbn_buf.t3 VSS.t39 VSS.t17 sg13_lv_nmos ad=1.52p pd=8.38u as=0 ps=0 w=8u l=10u
X3 VSS.t26 vbg_buf.t1 VSS.t24 VSS.t15 sg13_lv_nmos ad=1.52p pd=8.38u as=0 ps=0 w=8u l=10u
X4 VSS.t30 vbg_buf.t1 VSS.t28 VSS.t19 sg13_lv_nmos ad=1.52p pd=8.38u as=0 ps=0 w=8u l=10u
X5 ibias_100u.t3 vbn_buf.t1 VSS.t32 rhigh l=32u w=0.5u
X6 a_794_n12180.t1 a_94_n12180.t5 VDD.t7 VDD.t6 sg13_lv_pmos ad=0.34p pd=2.68u as=0.34p ps=2.68u w=1u l=0.13u
X7 ibias_100u.t2 a_94_n12180.t3 VSS.t8 VSS.t0 sg13_lv_nmos ad=0.34p pd=2.68u as=0.34p ps=2.68u w=1u l=0.13u
X8 a_1494_n10160.t1 a_794_n12180.t2 VDD.t5 VDD.t4 sg13_lv_pmos ad=0.34p pd=2.68u as=0.34p ps=2.68u w=1u l=0.13u
X9 VSS.t49 vbn_buf.t2 VSS.t47 VSS.t15 sg13_lv_nmos ad=1.52p pd=8.38u as=0 ps=0 w=8u l=10u
X10 VSS.t53 vbn_buf.t2 VSS.t51 VSS.t19 sg13_lv_nmos ad=1.52p pd=8.38u as=0 ps=0 w=8u l=10u
X11 VSS.t22 vbg_buf.t1 VSS.t21 VSS.t10 sg13_lv_nmos ad=2.72p pd=16.68u as=0 ps=0 w=8u l=10u
X12 a_1494_n10160.t3 a_1494_n10160.t2 VDD.t1 VDD.t0 sg13_lv_pmos ad=1.7p pd=10.68u as=1.7p ps=10.68u w=5u l=0.5u
X13 VSS.t16 vbg_buf.t2 VSS.t14 VSS.t15 sg13_lv_nmos ad=1.52p pd=8.38u as=0 ps=0 w=8u l=10u
X14 VSS.t20 vbg_buf.t2 VSS.t18 VSS.t19 sg13_lv_nmos ad=1.52p pd=8.38u as=0 ps=0 w=8u l=10u
X15 a_1494_n10160.t0 ibias_100u.t4 VSS.t4 VSS.t2 sg13_lv_nmos ad=0.85p pd=5.68u as=0.85p ps=5.68u w=2.5u l=0.5u
X16 VSS.t24 vbg_buf.t1 VSS.t22 VSS.t13 sg13_lv_nmos ad=1.52p pd=8.38u as=0 ps=0 w=8u l=10u
X17 VSS.t28 vbg_buf.t1 VSS.t26 VSS.t17 sg13_lv_nmos ad=1.52p pd=8.38u as=0 ps=0 w=8u l=10u
X18 a_94_n12180.t1 di_en.t1 VDD.t9 VDD.t8 sg13_lv_pmos ad=0.34p pd=2.68u as=0.34p ps=2.68u w=1u l=0.13u
X19 a_794_n12180.t0 a_94_n12180.t4 VSS.t7 VSS.t6 sg13_lv_nmos ad=0.17p pd=1.68u as=0.17p ps=1.68u w=0.5u l=0.13u
X20 VSS.t39 vbn_buf.t3 VSS.t37 VSS.t15 sg13_lv_nmos ad=1.52p pd=8.38u as=0 ps=0 w=8u l=10u
X21 VSS.t43 vbn_buf.t3 VSS.t41 VSS.t19 sg13_lv_nmos ad=1.52p pd=8.38u as=0 ps=0 w=8u l=10u
X22 ibias_100u.t1 ibias_100u.t0 VSS.t5 VSS.t2 sg13_lv_nmos ad=0.85p pd=5.68u as=0.85p ps=5.68u w=2.5u l=0.5u
X23 vbn_buf.t0 a_94_n12180.t2 VSS.t1 VSS.t0 sg13_lv_nmos ad=0.34p pd=2.68u as=0.34p ps=2.68u w=1u l=0.13u
X24 a_314_n13910.t2 vbg_buf.t0 VSS.t33 rhigh l=32u w=0.5u
X25 VSS.t45 vbn_buf.t2 VSS.t44 VSS.t10 sg13_lv_nmos ad=2.72p pd=16.68u as=0 ps=0 w=8u l=10u
X26 a_314_n13910.t0 a_1494_n10160.t4 VDD.t3 VDD.t2 sg13_lv_pmos ad=1.7p pd=10.68u as=1.7p ps=10.68u w=5u l=0.5u
X27 a_94_n12180.t0 di_en.t0 VSS.t9 VSS.t6 sg13_lv_nmos ad=0.17p pd=1.68u as=0.17p ps=1.68u w=0.5u l=0.13u
X28 VSS.t12 vbg_buf.t2 VSS.t11 VSS.t10 sg13_lv_nmos ad=2.72p pd=16.68u as=0 ps=0 w=8u l=10u
X29 VSS.t47 vbn_buf.t2 VSS.t45 VSS.t13 sg13_lv_nmos ad=1.52p pd=8.38u as=0 ps=0 w=8u l=10u
X30 VSS.t51 vbn_buf.t2 VSS.t49 VSS.t17 sg13_lv_nmos ad=1.52p pd=8.38u as=0 ps=0 w=8u l=10u
X31 VSS.t35 vbn_buf.t3 VSS.t34 VSS.t10 sg13_lv_nmos ad=2.72p pd=16.68u as=0 ps=0 w=8u l=10u
X32 a_314_n13910.t1 a_4268_n12616.t2 VSS.t31 rppd l=8.5u w=0.5u
X33 VSS.t14 vbg_buf.t2 VSS.t12 VSS.t13 sg13_lv_nmos ad=1.52p pd=8.38u as=0 ps=0 w=8u l=10u
X34 VSS.t18 vbg_buf.t2 VSS.t16 VSS.t17 sg13_lv_nmos ad=1.52p pd=8.38u as=0 ps=0 w=8u l=10u
R0 ibias_100u.n3 ibias_100u.t3 54.3738
R1 ibias_100u.n0 ibias_100u.t4 34.6784
R2 ibias_100u.n1 ibias_100u.t0 34.2252
R3 ibias_100u.n2 ibias_100u.t2 20.5585
R4 ibias_100u.n0 ibias_100u.t1 14.6093
R5 ibias_100u.n3 ibias_100u.n2 1.7473
R6 ibias_100u ibias_100u.n3 1.1049
R7 ibias_100u.n2 ibias_100u.n1 0.5351
R8 ibias_100u.n1 ibias_100u.n0 0.3173
R9 di_en.n0 di_en.t1 26.3252
R10 di_en.n0 di_en.t0 24.5065
R11 di_en di_en.n0 10.0532
R12 vbg_buf.n1 vbg_buf.t0 55.9872
R13 vbg_buf.n0 vbg_buf.t2 33.9824
R14 vbg_buf.n0 vbg_buf.t1 28.2977
R15 vbg_buf.n1 vbg_buf.n0 19.9242
R16 vbg_buf vbg_buf.n1 0.7749
R17 vbn_buf.n2 vbn_buf.t1 55.3125
R18 vbn_buf.n0 vbn_buf.t3 34.2391
R19 vbn_buf.n0 vbn_buf.t2 28.5544
R20 vbn_buf.n1 vbn_buf.n0 23.0981
R21 vbn_buf.n1 vbn_buf.t0 21.4972
R22 vbn_buf.n2 vbn_buf.n1 3.1069
R23 vbn_buf vbn_buf.n2 1.2149
R24 VDD.n7 VDD.t8 17.0005
R25 VDD.n5 VDD.t6 17.0005
R26 VDD.n3 VDD.t4 17.0005
R27 VDD.n1 VDD.t0 11.3356
R28 VDD.n0 VDD.t2 11.3356
R29 VDD.n7 VDD.t9 6.19097
R30 VDD.n5 VDD.t7 6.19097
R31 VDD.n3 VDD.t5 6.19097
R32 VDD.n0 VDD.t3 2.44339
R33 VDD.n1 VDD.t1 2.44287
R34 VDD.n2 VDD.n0 1.42463
R35 VDD.n4 VDD.n2 0.851625
R36 VDD.n6 VDD.n5 0.751488
R37 VDD.n4 VDD.n3 0.751488
R38 VDD VDD.n7 0.697167
R39 VDD VDD.n6 0.370375
R40 VDD.n6 VDD.n4 0.370375
R41 VDD.n2 VDD.n1 0.143127
R42 VSS.n150 VSS.n148 2420.69
R43 VSS.n150 VSS.n149 1873.62
R44 VSS.n167 VSS.t31 1071.75
R45 VSS.n166 VSS.n150 883.99
R46 VSS.t31 VSS.n166 777.904
R47 VSS.n152 VSS.t32 364.334
R48 VSS.t32 VSS.t33 143.816
R49 VSS.n163 VSS.n152 143.816
R50 VSS.t0 VSS.t2 71.9085
R51 VSS.n165 VSS.n163 47.9391
R52 VSS.t2 VSS.n165 33.5575
R53 VSS.n166 VSS.t6 30.6812
R54 VSS.t19 VSS.n2 25.1588
R55 VSS.t6 VSS.t0 23.9698
R56 VSS.n118 VSS.n37 23.135
R57 VSS.n110 VSS.n52 23.135
R58 VSS.n127 VSS.n34 23.135
R59 VSS.n106 VSS.n54 23.135
R60 VSS.n129 VSS.n30 23.135
R61 VSS.n101 VSS.n57 23.135
R62 VSS.n136 VSS.n27 23.135
R63 VSS.n98 VSS.n59 23.135
R64 VSS.t15 VSS.n21 23.135
R65 VSS.n94 VSS.n61 23.135
R66 VSS.n141 VSS.n15 23.135
R67 VSS.n85 VSS.n67 23.135
R68 VSS.n169 VSS.n9 23.135
R69 VSS.n80 VSS.n71 23.135
R70 VSS.n171 VSS.n7 23.135
R71 VSS.n77 VSS.n74 23.135
R72 VSS.n175 VSS.n4 23.135
R73 VSS.t10 VSS.n44 21.7741
R74 VSS.n164 VSS.t9 17.4597
R75 VSS.n151 VSS.t7 17.4597
R76 VSS.n165 VSS.n164 17.0005
R77 VSS.n165 VSS.n151 17.0005
R78 VSS.n163 VSS.n153 17.0005
R79 VSS.n163 VSS.n162 17.0005
R80 VSS.n149 VSS.n42 16.583
R81 VSS.n148 VSS.n102 13.609
R82 VSS.n167 VSS.n81 13.609
R83 VSS.n128 VSS.t13 12.2482
R84 VSS.n146 VSS.t17 12.2482
R85 VSS.n156 VSS.n152 11.3338
R86 VSS.n158 VSS.n152 11.3338
R87 VSS.n160 VSS.n152 11.3338
R88 VSS.t13 VSS.n107 10.8873
R89 VSS.t17 VSS.n84 10.8873
R90 VSS.n149 VSS.n114 9.86668
R91 VSS.n176 VSS.n3 9.80071
R92 VSS.n173 VSS.n6 9.80071
R93 VSS.n83 VSS.n13 9.80071
R94 VSS.n143 VSS.n14 9.80071
R95 VSS.n90 VSS.n17 9.80071
R96 VSS.n91 VSS.n19 9.80071
R97 VSS.n95 VSS.n23 9.80071
R98 VSS.n96 VSS.n24 9.80071
R99 VSS.n97 VSS.n25 9.80071
R100 VSS.n103 VSS.n29 9.80071
R101 VSS.n104 VSS.n32 9.80071
R102 VSS.n108 VSS.n33 9.80071
R103 VSS.n123 VSS.n36 9.80071
R104 VSS.n111 VSS.n39 9.80071
R105 VSS.n112 VSS.n40 9.80071
R106 VSS.n173 VSS.n72 9.80071
R107 VSS.n147 VSS.n69 9.80071
R108 VSS.n145 VSS.n65 9.80071
R109 VSS.n143 VSS.n63 9.80071
R110 VSS.n139 VSS.n62 9.80071
R111 VSS.n126 VSS.n50 9.80071
R112 VSS.n125 VSS.n49 9.80071
R113 VSS.n123 VSS.n48 9.80071
R114 VSS.n121 VSS.n47 9.80071
R115 VSS.n120 VSS.n46 9.80071
R116 VSS.n119 VSS.n45 9.80071
R117 VSS.n115 VSS.n43 9.80071
R118 VSS.n116 VSS.n41 9.80071
R119 VSS.n116 VSS.n40 9.80071
R120 VSS.n112 VSS.n39 9.80071
R121 VSS.n111 VSS.n38 9.80071
R122 VSS.n117 VSS.n38 9.80071
R123 VSS.n119 VSS.n46 9.80071
R124 VSS.n120 VSS.n47 9.80071
R125 VSS.n121 VSS.n48 9.80071
R126 VSS.n124 VSS.n36 9.80071
R127 VSS.n124 VSS.n49 9.80071
R128 VSS.n125 VSS.n50 9.80071
R129 VSS.n126 VSS.n51 9.80071
R130 VSS.n109 VSS.n35 9.80071
R131 VSS.n105 VSS.n32 9.80071
R132 VSS.n104 VSS.n31 9.80071
R133 VSS.n130 VSS.n55 9.80071
R134 VSS.n103 VSS.n55 9.80071
R135 VSS.n100 VSS.n28 9.80071
R136 VSS.n135 VSS.n28 9.80071
R137 VSS.n137 VSS.n26 9.80071
R138 VSS.n137 VSS.n58 9.80071
R139 VSS.n99 VSS.n58 9.80071
R140 VSS.n97 VSS.n24 9.80071
R141 VSS.n96 VSS.n23 9.80071
R142 VSS.n95 VSS.n22 9.80071
R143 VSS.n138 VSS.n60 9.80071
R144 VSS.n93 VSS.n20 9.80071
R145 VSS.n139 VSS.n20 9.80071
R146 VSS.n92 VSS.n62 9.80071
R147 VSS.n92 VSS.n19 9.80071
R148 VSS.n91 VSS.n18 9.80071
R149 VSS.n140 VSS.n18 9.80071
R150 VSS.n140 VSS.n17 9.80071
R151 VSS.n90 VSS.n16 9.80071
R152 VSS.n142 VSS.n63 9.80071
R153 VSS.n144 VSS.n14 9.80071
R154 VSS.n144 VSS.n64 9.80071
R155 VSS.n87 VSS.n64 9.80071
R156 VSS.n87 VSS.n65 9.80071
R157 VSS.n145 VSS.n66 9.80071
R158 VSS.n86 VSS.n66 9.80071
R159 VSS.n83 VSS.n12 9.80071
R160 VSS.n147 VSS.n12 9.80071
R161 VSS.n82 VSS.n69 9.80071
R162 VSS.n82 VSS.n11 9.80071
R163 VSS.n170 VSS.n70 9.80071
R164 VSS.n79 VSS.n8 9.80071
R165 VSS.n172 VSS.n72 9.80071
R166 VSS.n174 VSS.n6 9.80071
R167 VSS.n174 VSS.n73 9.80071
R168 VSS.n182 VSS.n181 9.80071
R169 VSS.n182 VSS.n75 9.80071
R170 VSS.n75 VSS.n5 9.80071
R171 VSS.n148 VSS.n131 9.52647
R172 VSS.n168 VSS.n167 9.52647
R173 VSS VSS.n195 9.52237
R174 VSS.n180 VSS.t15 8.5005
R175 VSS.n180 VSS.n76 8.5005
R176 VSS.n180 VSS.n175 8.5005
R177 VSS.n180 VSS.n77 8.5005
R178 VSS.n180 VSS.n171 8.5005
R179 VSS.n180 VSS.n80 8.5005
R180 VSS.n180 VSS.n169 8.5005
R181 VSS.n180 VSS.n81 8.5005
R182 VSS.n180 VSS.n168 8.5005
R183 VSS.n180 VSS.n84 8.5005
R184 VSS.n180 VSS.n146 8.5005
R185 VSS.n180 VSS.n85 8.5005
R186 VSS.n180 VSS.n141 8.5005
R187 VSS.n180 VSS.n94 8.5005
R188 VSS.n180 VSS.n98 8.5005
R189 VSS.n180 VSS.n136 8.5005
R190 VSS.n180 VSS.n101 8.5005
R191 VSS.n180 VSS.n131 8.5005
R192 VSS.n180 VSS.n102 8.5005
R193 VSS.n180 VSS.n129 8.5005
R194 VSS.n180 VSS.n106 8.5005
R195 VSS.n180 VSS.n128 8.5005
R196 VSS.n180 VSS.n107 8.5005
R197 VSS.n180 VSS.n127 8.5005
R198 VSS.n180 VSS.n110 8.5005
R199 VSS.n180 VSS.n118 8.5005
R200 VSS.n180 VSS.n113 8.5005
R201 VSS.n180 VSS.n114 8.5005
R202 VSS.n183 VSS.n74 8.5005
R203 VSS.n183 VSS.n71 8.5005
R204 VSS.n183 VSS.n67 8.5005
R205 VSS.n183 VSS.n61 8.5005
R206 VSS.n183 VSS.n59 8.5005
R207 VSS.n183 VSS.n57 8.5005
R208 VSS.n183 VSS.n54 8.5005
R209 VSS.n183 VSS.n52 8.5005
R210 VSS.n183 VSS.n44 8.5005
R211 VSS.n183 VSS.n4 8.5005
R212 VSS.n183 VSS.n7 8.5005
R213 VSS.n183 VSS.n9 8.5005
R214 VSS.n183 VSS.n15 8.5005
R215 VSS.n183 VSS.n21 8.5005
R216 VSS.n183 VSS.n27 8.5005
R217 VSS.n183 VSS.n30 8.5005
R218 VSS.n183 VSS.n34 8.5005
R219 VSS.n183 VSS.n37 8.5005
R220 VSS.n195 VSS.n1 7.76695
R221 VSS.n162 VSS.t1 6.19054
R222 VSS.n153 VSS.t8 6.19054
R223 VSS.n176 VSS.n4 4.90061
R224 VSS.n181 VSS.n74 4.90061
R225 VSS.n172 VSS.n7 4.90061
R226 VSS.n79 VSS.n71 4.90061
R227 VSS.n170 VSS.n9 4.90061
R228 VSS.n86 VSS.n67 4.90061
R229 VSS.n142 VSS.n15 4.90061
R230 VSS.n93 VSS.n61 4.90061
R231 VSS.n138 VSS.n21 4.90061
R232 VSS.n99 VSS.n59 4.90061
R233 VSS.n135 VSS.n27 4.90061
R234 VSS.n100 VSS.n57 4.90061
R235 VSS.n130 VSS.n30 4.90061
R236 VSS.n105 VSS.n54 4.90061
R237 VSS.n109 VSS.n52 4.90061
R238 VSS.n117 VSS.n37 4.90061
R239 VSS.n175 VSS.n5 4.90061
R240 VSS.n171 VSS.n8 4.90061
R241 VSS.n169 VSS.n10 4.90061
R242 VSS.n168 VSS.n11 4.90061
R243 VSS.n141 VSS.n16 4.90061
R244 VSS.t15 VSS.n22 4.90061
R245 VSS.n136 VSS.n26 4.90061
R246 VSS.n129 VSS.n31 4.90061
R247 VSS.n127 VSS.n35 4.90061
R248 VSS.n77 VSS.n73 4.90061
R249 VSS.n80 VSS.n70 4.90061
R250 VSS.n85 VSS.n68 4.90061
R251 VSS.n94 VSS.n60 4.90061
R252 VSS.n101 VSS.n56 4.90061
R253 VSS.n106 VSS.n53 4.90061
R254 VSS.n110 VSS.n51 4.90061
R255 VSS.n114 VSS.n43 4.90061
R256 VSS.n115 VSS.n44 4.90061
R257 VSS.n113 VSS.n41 4.90061
R258 VSS.n118 VSS.n45 4.90061
R259 VSS.n108 VSS.n34 4.90061
R260 VSS.n107 VSS.n33 4.90061
R261 VSS.n128 VSS.n53 4.90061
R262 VSS.n102 VSS.n29 4.90061
R263 VSS.n131 VSS.n56 4.90061
R264 VSS.n98 VSS.n25 4.90061
R265 VSS.n146 VSS.n68 4.90061
R266 VSS.n84 VSS.n13 4.90061
R267 VSS.n81 VSS.n10 4.90061
R268 VSS.n76 VSS.n3 4.90061
R269 VSS.n195 VSS.n194 4.67815
R270 VSS.n160 VSS.t3 3.22826
R271 VSS.n158 VSS.t4 3.22826
R272 VSS.n156 VSS.t5 3.22826
R273 VSS.n190 VSS.t24 2.21141
R274 VSS.n177 VSS.t51 2.21129
R275 VSS.n88 VSS.t49 2.21089
R276 VSS.n186 VSS.t28 2.21084
R277 VSS.n132 VSS.t45 2.21082
R278 VSS.n133 VSS.t47 2.21075
R279 VSS.n1 VSS.t44 2.21075
R280 VSS.n184 VSS.t30 2.21075
R281 VSS.n194 VSS.t21 2.21072
R282 VSS.n188 VSS.t26 2.21046
R283 VSS.n192 VSS.t22 2.20995
R284 VSS.n178 VSS.t53 2.20985
R285 VSS.n1 VSS.t34 2.20312
R286 VSS.n88 VSS.t39 2.20303
R287 VSS.n178 VSS.t43 2.20261
R288 VSS.n192 VSS.t12 2.2021
R289 VSS.n186 VSS.t18 2.20189
R290 VSS.n133 VSS.t37 2.20185
R291 VSS.n132 VSS.t35 2.20169
R292 VSS.n184 VSS.t20 2.2016
R293 VSS.n190 VSS.t14 2.20151
R294 VSS.n188 VSS.t16 2.20145
R295 VSS.n194 VSS.t11 2.20142
R296 VSS.n177 VSS.t41 2.20117
R297 VSS.n180 VSS.n176 1.8012
R298 VSS.n180 VSS.n75 1.8012
R299 VSS.n181 VSS.n180 1.8012
R300 VSS.n180 VSS.n174 1.8012
R301 VSS.n180 VSS.n173 1.8012
R302 VSS.n180 VSS.n172 1.8012
R303 VSS.n180 VSS.n79 1.8012
R304 VSS.n180 VSS.n170 1.8012
R305 VSS.n180 VSS.n82 1.8012
R306 VSS.n180 VSS.n147 1.8012
R307 VSS.n180 VSS.n83 1.8012
R308 VSS.n180 VSS.n86 1.8012
R309 VSS.n180 VSS.n145 1.8012
R310 VSS.n180 VSS.n87 1.8012
R311 VSS.n180 VSS.n144 1.8012
R312 VSS.n180 VSS.n143 1.8012
R313 VSS.n180 VSS.n142 1.8012
R314 VSS.n180 VSS.n90 1.8012
R315 VSS.n180 VSS.n140 1.8012
R316 VSS.n180 VSS.n91 1.8012
R317 VSS.n180 VSS.n92 1.8012
R318 VSS.n180 VSS.n139 1.8012
R319 VSS.n180 VSS.n93 1.8012
R320 VSS.n180 VSS.n138 1.8012
R321 VSS.n180 VSS.n95 1.8012
R322 VSS.n180 VSS.n96 1.8012
R323 VSS.n180 VSS.n97 1.8012
R324 VSS.n180 VSS.n99 1.8012
R325 VSS.n180 VSS.n137 1.8012
R326 VSS.n180 VSS.n135 1.8012
R327 VSS.n180 VSS.n100 1.8012
R328 VSS.n180 VSS.n103 1.8012
R329 VSS.n180 VSS.n130 1.8012
R330 VSS.n180 VSS.n104 1.8012
R331 VSS.n180 VSS.n105 1.8012
R332 VSS.n180 VSS.n108 1.8012
R333 VSS.n180 VSS.n109 1.8012
R334 VSS.n180 VSS.n126 1.8012
R335 VSS.n180 VSS.n125 1.8012
R336 VSS.n180 VSS.n124 1.8012
R337 VSS.n180 VSS.n123 1.8012
R338 VSS.n180 VSS.n121 1.8012
R339 VSS.n180 VSS.n120 1.8012
R340 VSS.n180 VSS.n119 1.8012
R341 VSS.n180 VSS.n117 1.8012
R342 VSS.n180 VSS.n111 1.8012
R343 VSS.n180 VSS.n112 1.8012
R344 VSS.n180 VSS.n116 1.8012
R345 VSS.n180 VSS.n115 1.8012
R346 VSS.n183 VSS.n182 1.8012
R347 VSS.n183 VSS.n73 1.8012
R348 VSS.n183 VSS.n72 1.8012
R349 VSS.n183 VSS.n70 1.8012
R350 VSS.n183 VSS.n69 1.8012
R351 VSS.n183 VSS.n68 1.8012
R352 VSS.n183 VSS.n66 1.8012
R353 VSS.n183 VSS.n65 1.8012
R354 VSS.n183 VSS.n64 1.8012
R355 VSS.n183 VSS.n63 1.8012
R356 VSS.n183 VSS.n62 1.8012
R357 VSS.n183 VSS.n60 1.8012
R358 VSS.n183 VSS.n58 1.8012
R359 VSS.n183 VSS.n56 1.8012
R360 VSS.n183 VSS.n55 1.8012
R361 VSS.n183 VSS.n53 1.8012
R362 VSS.n183 VSS.n51 1.8012
R363 VSS.n183 VSS.n50 1.8012
R364 VSS.n183 VSS.n49 1.8012
R365 VSS.n183 VSS.n48 1.8012
R366 VSS.n183 VSS.n47 1.8012
R367 VSS.n183 VSS.n46 1.8012
R368 VSS.n183 VSS.n45 1.8012
R369 VSS.n183 VSS.n43 1.8012
R370 VSS.n183 VSS.n3 1.8012
R371 VSS.n183 VSS.n5 1.8012
R372 VSS.n183 VSS.n6 1.8012
R373 VSS.n183 VSS.n8 1.8012
R374 VSS.n183 VSS.n10 1.8012
R375 VSS.n183 VSS.n11 1.8012
R376 VSS.n183 VSS.n12 1.8012
R377 VSS.n183 VSS.n13 1.8012
R378 VSS.n183 VSS.n14 1.8012
R379 VSS.n183 VSS.n16 1.8012
R380 VSS.n183 VSS.n17 1.8012
R381 VSS.n183 VSS.n18 1.8012
R382 VSS.n183 VSS.n19 1.8012
R383 VSS.n183 VSS.n20 1.8012
R384 VSS.n183 VSS.n22 1.8012
R385 VSS.n183 VSS.n23 1.8012
R386 VSS.n183 VSS.n24 1.8012
R387 VSS.n183 VSS.n25 1.8012
R388 VSS.n183 VSS.n26 1.8012
R389 VSS.n183 VSS.n28 1.8012
R390 VSS.n183 VSS.n29 1.8012
R391 VSS.n183 VSS.n31 1.8012
R392 VSS.n183 VSS.n32 1.8012
R393 VSS.n183 VSS.n33 1.8012
R394 VSS.n183 VSS.n35 1.8012
R395 VSS.n183 VSS.n36 1.8012
R396 VSS.n183 VSS.n38 1.8012
R397 VSS.n183 VSS.n39 1.8012
R398 VSS.n183 VSS.n40 1.8012
R399 VSS.n183 VSS.n41 1.8012
R400 VSS.n113 VSS.t10 1.36135
R401 VSS.n76 VSS.t19 1.36135
R402 VSS.n183 VSS.n42 0.711745
R403 VSS.n180 VSS.n42 0.711206
R404 VSS.n180 VSS.n2 0.570788
R405 VSS.n183 VSS.n2 0.570282
R406 VSS.n161 VSS.n160 0.513002
R407 VSS VSS.n0 0.48175
R408 VSS.n164 VSS.n0 0.479883
R409 VSS.n154 VSS.n151 0.479883
R410 VSS.n162 VSS.n161 0.411981
R411 VSS.n155 VSS.n153 0.411981
R412 VSS.n157 VSS.n155 0.370375
R413 VSS.n155 VSS.n154 0.370375
R414 VSS.n154 VSS.n0 0.370375
R415 VSS.n161 VSS.n159 0.3195
R416 VSS.n159 VSS.n157 0.3195
R417 VSS.n192 VSS.n191 0.243424
R418 VSS.n134 VSS.n132 0.243424
R419 VSS.n122 VSS.n1 0.242716
R420 VSS.n194 VSS.n193 0.242681
R421 VSS.n188 VSS.n187 0.24245
R422 VSS.n88 VSS.n78 0.24245
R423 VSS.n190 VSS.n189 0.240796
R424 VSS.n133 VSS.n89 0.240796
R425 VSS.n186 VSS.n185 0.239822
R426 VSS.n179 VSS.n177 0.239822
R427 VSS.n187 VSS.n186 0.227974
R428 VSS.n177 VSS.n78 0.227974
R429 VSS.n191 VSS.n190 0.227001
R430 VSS.n134 VSS.n133 0.227001
R431 VSS.n185 VSS.n184 0.225646
R432 VSS.n179 VSS.n178 0.225646
R433 VSS.n189 VSS.n188 0.224672
R434 VSS.n89 VSS.n88 0.224672
R435 VSS.n193 VSS.n192 0.223727
R436 VSS.n132 VSS.n122 0.223715
R437 VSS.n180 VSS.n78 0.218846
R438 VSS.n180 VSS.n134 0.218846
R439 VSS.n187 VSS.n183 0.218846
R440 VSS.n191 VSS.n183 0.218846
R441 VSS.n180 VSS.n179 0.208386
R442 VSS.n180 VSS.n89 0.208386
R443 VSS.n185 VSS.n183 0.208386
R444 VSS.n189 VSS.n183 0.208386
R445 VSS.n180 VSS.n122 0.208371
R446 VSS.n193 VSS.n183 0.20836
R447 VSS.n159 VSS.n158 0.143127
R448 VSS.n157 VSS.n156 0.143127
R449 a_4268_n12616.n0 a_4268_n12616.t2 36.3628
R450 a_4268_n12616.n0 a_4268_n12616.t0 35.246
R451 a_4268_n12616.t1 a_4268_n12616.n0 15.3137
R452 a_314_n13910.n0 a_314_n13910.t2 60.5214
R453 a_314_n13910.n0 a_314_n13910.t1 33.8343
R454 a_314_n13910.n1 a_314_n13910.n0 12.0028
R455 a_314_n13910.t0 a_314_n13910.n1 2.87353
R456 a_314_n13910.t0 a_314_n13910.n1 2.86853
R457 a_794_n12180.n0 a_794_n12180.t2 44.3673
R458 a_794_n12180.n0 a_794_n12180.t0 27.0418
R459 a_794_n12180.t1 a_794_n12180.n0 12.2034
R460 a_94_n12180.n0 a_94_n12180.t2 36.0512
R461 a_94_n12180.n0 a_94_n12180.t3 33.7412
R462 a_94_n12180.n3 a_94_n12180.t0 26.8072
R463 a_94_n12180.n1 a_94_n12180.t5 26.0905
R464 a_94_n12180.n1 a_94_n12180.t4 24.7412
R465 a_94_n12180.t1 a_94_n12180.n3 12.4381
R466 a_94_n12180.n3 a_94_n12180.n2 9.512
R467 a_94_n12180.n2 a_94_n12180.n1 9.0005
R468 a_94_n12180.n2 a_94_n12180.n0 0.7705
R469 a_1494_n10160.n1 a_1494_n10160.t4 36.3944
R470 a_1494_n10160.n0 a_1494_n10160.t2 34.4012
R471 a_1494_n10160.n0 a_1494_n10160.t1 22.0391
R472 a_1494_n10160.n2 a_1494_n10160.n1 9.0005
R473 a_1494_n10160.n2 a_1494_n10160.t0 5.84394
R474 a_1494_n10160.t3 a_1494_n10160.n2 4.67685
R475 a_1494_n10160.n1 a_1494_n10160.n0 0.3173
C0 ibias_100u a_0_n13610# 0.03793f
C1 a_5600_n10750# vbg_buf 0.01207f
C2 vbn_buf di_en 0.04954f
C3 a_400_n13910# vbg_buf 0.03564f
C4 vbn_buf vbg_buf 6.85977f
C5 a_0_n13610# a_400_n13910# 0.60592f
C6 vbn_buf a_0_n13610# 0.03589f
C7 vbn_buf ibias_100u 0.0424f
C8 vbn_buf a_5600_n10750# 0.04105f
C9 vbn_buf a_400_n13910# 0.01263f
C10 di_en vbg_buf 0.06389f
C11 VDD di_en 0.11049f
C12 VDD vbg_buf 0.70729f
C13 ibias_100u di_en 0.20081f
C14 ibias_100u VSS 3.14375f
C15 di_en VSS 1.36254f
C16 vbg_buf VSS 0.10598p
C17 vbn_buf VSS 0.10798p
C18 VDD VSS 4.30769f
C19 a_1494_n10160.t0 VSS 0.37935f
C20 a_1494_n10160.t1 VSS 0.43521f
C21 a_1494_n10160.n0 VSS 0.8291f
C22 a_1494_n10160.n1 VSS 0.87471f
C23 a_1494_n10160.n2 VSS 0.68233f
C24 a_1494_n10160.t3 VSS 0.82453f
C25 a_94_n12180.t0 VSS 0.06275f
C26 a_94_n12180.n0 VSS 0.92061f
C27 a_94_n12180.n1 VSS 0.49497f
C28 a_94_n12180.n2 VSS 0.2442f
C29 a_94_n12180.n3 VSS 0.45064f
C30 a_94_n12180.t1 VSS 0.13705f
C31 a_794_n12180.t0 VSS 0.08771f
C32 a_794_n12180.n0 VSS 1.17442f
C33 a_794_n12180.t1 VSS 0.18467f
C34 a_314_n13910.t1 VSS 0.64302f
C35 a_314_n13910.t2 VSS 2.28626f
C36 a_314_n13910.n0 VSS 2.67348f
C37 a_314_n13910.n1 VSS 0.51122f
C38 a_314_n13910.t0 VSS 0.67155f
C39 a_4268_n12616.t2 VSS 0.6589f
C40 a_4268_n12616.n0 VSS 1.38693f
C41 a_4268_n12616.t1 VSS 0.64985f
C42 VSS.t49 VSS 2.28152f
C43 VSS.t35 VSS 2.28467f
C44 VSS.t37 VSS 2.28467f
C45 VSS.t47 VSS 2.28152f
C46 VSS.t7 VSS 0.03715f
C47 VSS.t8 VSS 0.06314f
C48 VSS.t1 VSS 0.07702f
C49 VSS.t5 VSS 0.12329f
C50 VSS.t4 VSS 0.12446f
C51 VSS.t3 VSS 0.19716f
C52 VSS.t9 VSS 0.03112f
C53 VSS.t14 VSS 1.99136f
C54 VSS.t24 VSS 1.98864f
C55 VSS.t16 VSS 1.99136f
C56 VSS.t26 VSS 1.98864f
C57 VDD.t2 VSS 0.43331f
C58 VDD.t3 VSS 0.39768f
C59 VDD.n0 VSS 0.24254f
C60 VDD.t0 VSS 0.43331f
C61 VDD.t1 VSS 0.3826f
C62 VDD.n1 VSS 0.08937f
C63 VDD.n2 VSS 0.26985f
C64 VDD.t5 VSS 0.21081f
C65 VDD.t4 VSS 0.15216f
C66 VDD.n3 VSS 0.11175f
C67 VDD.n4 VSS 0.204f
C68 VDD.t7 VSS 0.06038f
C69 VDD.t6 VSS 0.15216f
C70 VDD.n5 VSS 0.11175f
C71 VDD.n6 VSS 0.1573f
C72 VDD.t9 VSS 0.05463f
C73 VDD.t8 VSS 0.15216f
C74 VDD.n7 VSS 0.10635f
C75 vbn_buf.n0 VSS 0.14385f
C76 vbn_buf.t0 VSS 0.0931f
C77 vbn_buf.n1 VSS 0.13362f
C78 vbn_buf.t1 VSS 1.9795f
C79 vbn_buf.n2 VSS 0.07436f
C80 vbg_buf.n0 VSS 0.10077f
C81 vbg_buf.t0 VSS 1.92444f
C82 vbg_buf.n1 VSS 0.14131f
C83 di_en.n0 VSS 0.43428f
C84 ibias_100u.t1 VSS 0.38579f
C85 ibias_100u.n0 VSS 0.32037f
C86 ibias_100u.n1 VSS 0.20405f
C87 ibias_100u.t2 VSS 0.18499f
C88 ibias_100u.n2 VSS 0.29997f
C89 ibias_100u.t3 VSS 2.07529f
C90 ibias_100u.n3 VSS 0.56678f
.ends
