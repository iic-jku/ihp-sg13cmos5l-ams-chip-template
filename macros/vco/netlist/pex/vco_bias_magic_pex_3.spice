* PEX produced on Sat Nov  7 09:42:54 PM CET 2026 using /foss/tools/sak/sak-pex.sh with m=3 and s=1 (extresist threshold=1000 mOhm, minres=100 mOhm, mindelay=0 ps)
* NGSPICE file created from vco_bias_pex.ext - technology: ihp-sg13cmos5l

.subckt vco_bias_pex di_en VDD VSS vbg_buf vbn_buf en_b
X0 en_b.t0 di_en.t1 VDD.t2 VDD.t0 sg13_lv_pmos ad=0.34p pd=2.68u as=0.34p ps=2.68u w=1u l=0.13u
X1 en_b.t1 di_en.t0 VSS.t3 VSS.t2 sg13_lv_nmos ad=0.17p pd=1.68u as=0.17p ps=1.68u w=0.5u l=0.13u
X2 a_3900_n11978.t3 a_3900_n11978.t2 VSS.t1 VSS.t0 sg13_lv_nmos ad=0.85p pd=5.68u as=0.85p ps=5.68u w=2.5u l=0.5u
X3 VSS.t50 vbn_buf.t3 VSS.t48 VSS.t17 sg13_lv_nmos ad=1.52p pd=8.38u as=0 ps=0 w=8u l=10u
X4 VSS.t54 vbn_buf.t3 VSS.t52 VSS.t21 sg13_lv_nmos ad=1.52p pd=8.38u as=0 ps=0 w=8u l=10u
X5 VSS.t30 vbg_buf.t1 VSS.t28 VSS.t19 sg13_lv_nmos ad=1.52p pd=8.38u as=0 ps=0 w=8u l=10u
X6 VSS.t34 vbg_buf.t1 VSS.t32 VSS.t23 sg13_lv_nmos ad=1.52p pd=8.38u as=0 ps=0 w=8u l=10u
X7 a_3900_n9272.t0 en_b.t5 VDD.t5 VDD.t0 sg13_lv_pmos ad=0.68p pd=4.68u as=0.68p ps=4.68u w=2u l=0.13u
X8 a_5408_n8844.t3 a_5408_n8844.t2 VDD.t3 VDD.t0 sg13_lv_pmos ad=1.7p pd=10.68u as=1.7p ps=10.68u w=5u l=0.5u
X9 VDD.t15 VDD.t13 VDD.t14 VDD.t0 sg13_lv_pmos ad=1.7p pd=10.68u as=0 ps=0 w=5u l=0.5u
X10 vbn_buf.t1 a_3900_n11978.t4 VSS.t45 rhigh l=32u w=0.5u
X11 VSS.t38 VSS.t35 VSS.t37 VSS.t36 sg13_lv_nmos ad=0.85p pd=5.68u as=0 ps=0 w=2.5u l=0.5u
X12 VSS.t42 VSS.t39 VSS.t41 VSS.t40 sg13_lv_nmos ad=0.85p pd=5.68u as=0 ps=0 w=2.5u l=0.5u
X13 VSS.t62 vbn_buf.t2 VSS.t60 VSS.t19 sg13_lv_nmos ad=1.52p pd=8.38u as=0 ps=0 w=8u l=10u
X14 a_5408_n8844.t1 a_3900_n11978.t5 VSS.t5 VSS.t4 sg13_lv_nmos ad=0.85p pd=5.68u as=0.85p ps=5.68u w=2.5u l=0.5u
X15 VSS.t66 vbn_buf.t2 VSS.t64 VSS.t23 sg13_lv_nmos ad=1.52p pd=8.38u as=0 ps=0 w=8u l=10u
X16 VSS.t26 vbg_buf.t1 VSS.t25 VSS.t14 sg13_lv_nmos ad=2.72p pd=16.68u as=0 ps=0 w=8u l=10u
X17 a_5408_n8844.t0 a_4788_n10564.t2 VDD.t1 VDD.t0 sg13_lv_pmos ad=0.34p pd=2.68u as=0.34p ps=2.68u w=1u l=0.13u
X18 VSS.t20 vbg_buf.t2 VSS.t18 VSS.t19 sg13_lv_nmos ad=1.52p pd=8.38u as=0 ps=0 w=8u l=10u
X19 VSS.t24 vbg_buf.t2 VSS.t22 VSS.t23 sg13_lv_nmos ad=1.52p pd=8.38u as=0 ps=0 w=8u l=10u
X20 VSS.t28 vbg_buf.t1 VSS.t26 VSS.t17 sg13_lv_nmos ad=1.52p pd=8.38u as=0 ps=0 w=8u l=10u
X21 VSS.t32 vbg_buf.t1 VSS.t30 VSS.t21 sg13_lv_nmos ad=1.52p pd=8.38u as=0 ps=0 w=8u l=10u
X22 a_4400_n9272.t1 a_4400_n11058.t2 VSS.t44 rppd l=8.5u w=0.5u
X23 VDD.t12 VDD.t10 VDD.t11 VDD.t0 sg13_lv_pmos ad=1.7p pd=10.68u as=0 ps=0 w=5u l=0.5u
X24 VSS.t52 vbn_buf.t3 VSS.t50 VSS.t19 sg13_lv_nmos ad=1.52p pd=8.38u as=0 ps=0 w=8u l=10u
X25 VSS.t56 vbn_buf.t3 VSS.t54 VSS.t23 sg13_lv_nmos ad=1.52p pd=8.38u as=0 ps=0 w=8u l=10u
X26 a_4400_n11058.t1 a_4400_n11058.t0 VSS.t7 VSS.t6 sg13_lv_nmos ad=0.85p pd=5.68u as=0.85p ps=5.68u w=2.5u l=0.5u
X27 a_4788_n10564.t1 en_b.t6 VDD.t6 VDD.t0 sg13_lv_pmos ad=0.34p pd=2.68u as=0.34p ps=2.68u w=1u l=0.13u
X28 vbn_buf.t0 en_b.t2 VSS.t13 VSS.t12 sg13_lv_nmos ad=0.34p pd=2.68u as=0.34p ps=2.68u w=1u l=0.13u
X29 a_4788_n10564.t0 en_b.t4 VSS.t9 VSS.t8 sg13_lv_nmos ad=0.17p pd=1.68u as=0.17p ps=1.68u w=0.5u l=0.13u
X30 vbg_buf.t0 a_4400_n9272.t2 VSS.t46 rhigh l=32u w=0.5u
X31 VSS.t58 vbn_buf.t2 VSS.t57 VSS.t14 sg13_lv_nmos ad=2.72p pd=16.68u as=0 ps=0 w=8u l=10u
X32 VSS.t16 vbg_buf.t2 VSS.t15 VSS.t14 sg13_lv_nmos ad=2.72p pd=16.68u as=0 ps=0 w=8u l=10u
X33 a_3900_n11978.t0 en_b.t3 VSS.t11 VSS.t10 sg13_lv_nmos ad=0.34p pd=2.68u as=0.34p ps=2.68u w=1u l=0.13u
X34 VSS.t60 vbn_buf.t2 VSS.t58 VSS.t17 sg13_lv_nmos ad=1.52p pd=8.38u as=0 ps=0 w=8u l=10u
X35 VSS.t64 vbn_buf.t2 VSS.t62 VSS.t21 sg13_lv_nmos ad=1.52p pd=8.38u as=0 ps=0 w=8u l=10u
X36 a_3900_n9272.t1 a_3900_n11978.t1 VSS.t43 rppd l=13.1u w=0.5u
X37 a_4400_n9272.t0 a_5408_n8844.t4 VDD.t4 VDD.t0 sg13_lv_pmos ad=1.7p pd=10.68u as=1.7p ps=10.68u w=5u l=0.5u
X38 VSS.t48 vbn_buf.t3 VSS.t47 VSS.t14 sg13_lv_nmos ad=2.72p pd=16.68u as=0 ps=0 w=8u l=10u
X39 VSS.t18 vbg_buf.t2 VSS.t16 VSS.t17 sg13_lv_nmos ad=1.52p pd=8.38u as=0 ps=0 w=8u l=10u
X40 VSS.t22 vbg_buf.t2 VSS.t20 VSS.t21 sg13_lv_nmos ad=1.52p pd=8.38u as=0 ps=0 w=8u l=10u
X41 VDD.t9 VDD.t7 VDD.t8 VDD.t0 sg13_lv_pmos ad=0.34p pd=2.68u as=0 ps=0 w=1u l=0.13u
R0 di_en.n0 di_en.t0 21.6583
R1 di_en.n0 di_en.t1 19.605
R2 di_en di_en.n0 13.9942
R3 en_b.n0 en_b.t1 27.1774
R4 en_b.n4 en_b.t5 24.9608
R5 en_b.n3 en_b.t2 24.8442
R6 en_b.n1 en_b.t6 20.7725
R7 en_b.n1 en_b.t4 20.4909
R8 en_b.n0 en_b.t3 20.4287
R9 en_b.n0 en_b.t0 12.1423
R10 en_b.n2 en_b.n1 5.30277
R11 en_b.n2 en_b.n0 4.5269
R12 en_b en_b.n4 2.33103
R13 en_b.n3 en_b.n2 0.562233
R14 en_b.n4 en_b.n3 0.469833
R15 vbg_buf.n12 vbg_buf.t0 50.4632
R16 vbg_buf.n11 vbg_buf.t2 33.9824
R17 vbg_buf.n11 vbg_buf.t1 28.2977
R18 vbg_buf vbg_buf.n14 5.7205
R19 vbg_buf.n13 vbg_buf.n12 5.5565
R20 vbg_buf.n14 vbg_buf.n6 4.5929
R21 vbg_buf.n0 vbg_buf.n10 4.5005
R22 vbg_buf.n13 vbg_buf.n10 2.2005
R23 vbg_buf.n14 vbg_buf.n10 2.2005
R24 vbg_buf.n12 vbg_buf.n11 0.455167
R25 vbg_buf.n9 vbg_buf.n8 0.0590766
R26 vbg_buf.n7 vbg_buf.n8 6.82308
R27 vbg_buf.n5 vbg_buf.n7 0.274377
R28 vbg_buf.n3 vbg_buf.n5 0.274377
R29 vbg_buf.n8 vbg_buf.n1 0.21526
R30 vbg_buf.n9 vbg_buf.n13 4.88081
R31 vbg_buf.n1 vbg_buf.n3 0.296336
R32 vbg_buf.n6 vbg_buf.n4 0.1765
R33 vbg_buf.n4 vbg_buf.n2 0.1765
R34 vbg_buf.n2 vbg_buf.n0 0.1765
R35 vbg_buf.n6 vbg_buf.n7 0.0345713
R36 vbg_buf.n4 vbg_buf.n5 0.0345713
R37 vbg_buf.n2 vbg_buf.n3 0.0345713
R38 vbg_buf.n0 vbg_buf.n1 0.049383
R39 vbg_buf.n0 vbg_buf.n9 0.118561
R40 vbn_buf.n1 vbn_buf.t1 45.1624
R41 vbn_buf.n0 vbn_buf.t3 34.2391
R42 vbn_buf.n0 vbn_buf.t2 28.5544
R43 vbn_buf.n2 vbn_buf.t0 17.3257
R44 vbn_buf.n2 vbn_buf.n1 13.5293
R45 vbn_buf.n1 vbn_buf.n0 6.81757
R46 vbn_buf vbn_buf.n2 2.55837
R47 VDD.n3 VDD.t13 17.5809
R48 VDD.n0 VDD.t10 17.5809
R49 VDD.n10 VDD.n1 1.2602
R50 VDD.n4 VDD.t14 2.54555
R51 VDD.n2 VDD.t7 15.8062
R52 VDD.n8 VDD.t8 6.07554
R53 VDD.n2 VDD.t9 6.07554
R54 VDD.n5 VDD.t1 6.07554
R55 VDD.n6 VDD.t2 6.07554
R56 VDD.n7 VDD.t6 6.07554
R57 VDD VDD.n7 5.67699
R58 VDD.n1 VDD.n5 0.0656783
R59 VDD.n5 VDD.n6 0.1061
R60 VDD.n8 VDD.t5 3.45404
R61 VDD.n7 VDD.n10 3.37539
R62 VDD.n10 VDD.n0 1.51113
R63 VDD.n10 VDD.n4 1.16155
R64 VDD.n0 VDD.t11 2.36441
R65 VDD.n3 VDD.t15 2.36348
R66 VDD.n3 VDD.t3 2.36348
R67 VDD.n9 VDD.t4 2.36338
R68 VDD.n0 VDD.t12 2.36338
R69 VDD.n10 VDD.t0 0.395849
R70 VDD.n0 VDD.n9 0.222999
R71 VDD.n2 VDD.n8 0.199822
R72 VDD.n9 VDD.n3 0.181347
R73 VDD.n7 VDD.n6 0.152127
R74 VDD.n4 VDD.n3 0.0814646
R75 VDD.n2 VDD.n1 0.0766266
R76 VDD.n0 VDD.n8 0.139213
R77 VSS.n136 VSS.n135 2596.43
R78 VSS.n176 VSS.t45 740.371
R79 VSS.t43 VSS.t44 267.476
R80 VSS.t45 VSS.t46 213.981
R81 VSS.t46 VSS.t43 187.233
R82 VSS.n0 VSS.t0 36.8855
R83 VSS.n1 VSS.t40 58.2585
R84 VSS.n3 VSS.t2 13.4559
R85 VSS.n18 VSS.t6 53.9994
R86 VSS.t12 VSS.n4 16.0639
R87 VSS.n18 VSS.t36 18.4512
R88 VSS.n1 VSS.t0 38.2794
R89 VSS.n5 VSS.t8 11.7783
R90 VSS.n2 VSS.n3 0.0166315
R91 VSS.t14 VSS.n59 26.5384
R92 VSS.t23 VSS.n21 26.5384
R93 VSS.t44 VSS.n5 179.258
R94 VSS.n132 VSS.n56 24.5729
R95 VSS.n127 VSS.n63 24.5729
R96 VSS.n179 VSS.n48 24.5729
R97 VSS.n191 VSS.n41 24.5729
R98 VSS.n111 VSS.n79 24.5729
R99 VSS.n198 VSS.n36 24.5729
R100 VSS.n105 VSS.n82 24.5729
R101 VSS.n100 VSS.n84 24.5729
R102 VSS.n206 VSS.n25 24.5729
R103 VSS.n213 VSS.n89 24.5729
R104 VSS.n208 VSS.n23 24.5729
R105 VSS.n2 VSS.n4 0.0120382
R106 VSS.n176 VSS.n128 23.1275
R107 VSS.n135 VSS.n90 20.2366
R108 VSS.n161 VSS.t9 17.3443
R109 VSS.n163 VSS.t3 17.3443
R110 VSS.n2 VSS.n11 4.23471
R111 VSS.n2 VSS.n16 5.65558
R112 VSS.n5 VSS.n2 7.79452
R113 VSS.n167 VSS.t35 16.4809
R114 VSS.n174 VSS.t39 16.4809
R115 VSS.n0 VSS.t4 12.2796
R116 VSS.n7 VSS.n6 6.85058
R117 VSS.n153 VSS.n19 13.5948
R118 VSS.n13 VSS.n8 13.5948
R119 VSS.t40 VSS.n136 13.5651
R120 VSS.t17 VSS.n66 13.0094
R121 VSS.n201 VSS.t21 13.0094
R122 VSS.n120 VSS.t17 11.564
R123 VSS.t21 VSS.n31 11.564
R124 VSS.n92 VSS.n22 10.0498
R125 VSS.n96 VSS.n27 10.0498
R126 VSS.n102 VSS.n33 10.0498
R127 VSS.n103 VSS.n34 10.0498
R128 VSS.n106 VSS.n35 10.0498
R129 VSS.n109 VSS.n38 10.0498
R130 VSS.n112 VSS.n39 10.0498
R131 VSS.n114 VSS.n44 10.0498
R132 VSS.n121 VSS.n50 10.0498
R133 VSS.n122 VSS.n51 10.0498
R134 VSS.n123 VSS.n52 10.0498
R135 VSS.n124 VSS.n53 10.0498
R136 VSS.n125 VSS.n54 10.0498
R137 VSS.n129 VSS.n55 10.0498
R138 VSS.n130 VSS.n58 10.0498
R139 VSS.n204 VSS.n86 10.0498
R140 VSS.n197 VSS.n77 10.0498
R141 VSS.n195 VSS.n75 10.0498
R142 VSS.n193 VSS.n74 10.0498
R143 VSS.n190 VSS.n73 10.0498
R144 VSS.n189 VSS.n72 10.0498
R145 VSS.n185 VSS.n71 10.0498
R146 VSS.n184 VSS.n70 10.0498
R147 VSS.n183 VSS.n69 10.0498
R148 VSS.n182 VSS.n68 10.0498
R149 VSS.n181 VSS.n64 10.0498
R150 VSS.n130 VSS.n57 10.0498
R151 VSS.n133 VSS.n60 10.0498
R152 VSS.n129 VSS.n60 10.0498
R153 VSS.n134 VSS.n55 10.0498
R154 VSS.n134 VSS.n61 10.0498
R155 VSS.n126 VSS.n54 10.0498
R156 VSS.n125 VSS.n53 10.0498
R157 VSS.n124 VSS.n52 10.0498
R158 VSS.n123 VSS.n51 10.0498
R159 VSS.n122 VSS.n50 10.0498
R160 VSS.n121 VSS.n49 10.0498
R161 VSS.n180 VSS.n64 10.0498
R162 VSS.n181 VSS.n65 10.0498
R163 VSS.n119 VSS.n67 10.0498
R164 VSS.n118 VSS.n67 10.0498
R165 VSS.n118 VSS.n47 10.0498
R166 VSS.n182 VSS.n47 10.0498
R167 VSS.n117 VSS.n68 10.0498
R168 VSS.n117 VSS.n46 10.0498
R169 VSS.n183 VSS.n46 10.0498
R170 VSS.n116 VSS.n69 10.0498
R171 VSS.n116 VSS.n45 10.0498
R172 VSS.n184 VSS.n45 10.0498
R173 VSS.n185 VSS.n70 10.0498
R174 VSS.n115 VSS.n71 10.0498
R175 VSS.n115 VSS.n44 10.0498
R176 VSS.n114 VSS.n43 10.0498
R177 VSS.n189 VSS.n43 10.0498
R178 VSS.n190 VSS.n72 10.0498
R179 VSS.n113 VSS.n73 10.0498
R180 VSS.n113 VSS.n42 10.0498
R181 VSS.n192 VSS.n74 10.0498
R182 VSS.n194 VSS.n40 10.0498
R183 VSS.n194 VSS.n75 10.0498
R184 VSS.n195 VSS.n76 10.0498
R185 VSS.n112 VSS.n76 10.0498
R186 VSS.n196 VSS.n39 10.0498
R187 VSS.n196 VSS.n77 10.0498
R188 VSS.n197 VSS.n78 10.0498
R189 VSS.n110 VSS.n38 10.0498
R190 VSS.n109 VSS.n37 10.0498
R191 VSS.n199 VSS.n80 10.0498
R192 VSS.n106 VSS.n80 10.0498
R193 VSS.n200 VSS.n35 10.0498
R194 VSS.n200 VSS.n81 10.0498
R195 VSS.n104 VSS.n34 10.0498
R196 VSS.n103 VSS.n33 10.0498
R197 VSS.n102 VSS.n32 10.0498
R198 VSS.n202 VSS.n83 10.0498
R199 VSS.n101 VSS.n83 10.0498
R200 VSS.n99 VSS.n85 10.0498
R201 VSS.n99 VSS.n30 10.0498
R202 VSS.n203 VSS.n30 10.0498
R203 VSS.n203 VSS.n29 10.0498
R204 VSS.n204 VSS.n29 10.0498
R205 VSS.n98 VSS.n86 10.0498
R206 VSS.n98 VSS.n28 10.0498
R207 VSS.n205 VSS.n28 10.0498
R208 VSS.n205 VSS.n27 10.0498
R209 VSS.n96 VSS.n87 10.0498
R210 VSS.n95 VSS.n87 10.0498
R211 VSS.n95 VSS.n26 10.0498
R212 VSS.n207 VSS.n88 10.0498
R213 VSS.n94 VSS.n88 10.0498
R214 VSS VSS.n227 9.6573
R215 VSS.n212 VSS.n91 8.5005
R216 VSS.n212 VSS.n208 8.5005
R217 VSS.n212 VSS.n93 8.5005
R218 VSS.n212 VSS.n90 8.5005
R219 VSS.n213 VSS.n212 8.5005
R220 VSS.n212 VSS.n206 8.5005
R221 VSS.n212 VSS.n100 8.5005
R222 VSS.n212 VSS.n201 8.5005
R223 VSS.n212 VSS.n105 8.5005
R224 VSS.n212 VSS.n198 8.5005
R225 VSS.n212 VSS.n111 8.5005
R226 VSS.n212 VSS.n191 8.5005
R227 VSS.n212 VSS.n120 8.5005
R228 VSS.n212 VSS.n179 8.5005
R229 VSS.n212 VSS.n127 8.5005
R230 VSS.n212 VSS.n177 8.5005
R231 VSS.n212 VSS.n128 8.5005
R232 VSS.n212 VSS.n132 8.5005
R233 VSS.n212 VSS.n131 8.5005
R234 VSS.n215 VSS.n89 8.5005
R235 VSS.n215 VSS.n84 8.5005
R236 VSS.n215 VSS.n82 8.5005
R237 VSS.n215 VSS.n79 8.5005
R238 VSS.n215 VSS.n66 8.5005
R239 VSS.n215 VSS.n63 8.5005
R240 VSS.n215 VSS.n23 8.5005
R241 VSS.n215 VSS.n25 8.5005
R242 VSS.n215 VSS.n31 8.5005
R243 VSS.n215 VSS.n36 8.5005
R244 VSS.n215 VSS.n41 8.5005
R245 VSS.n215 VSS.n48 8.5005
R246 VSS.n215 VSS.n56 8.5005
R247 VSS.n16 VSS.n169 0.0599659
R248 VSS.n227 VSS.n20 7.76695
R249 VSS.n152 VSS.n12 6.86385
R250 VSS.n164 VSS.t11 6.07511
R251 VSS.n138 VSS.t13 6.07511
R252 VSS.n11 VSS.t42 3.20134
R253 VSS.n2 VSS.n170 5.65335
R254 VSS.n94 VSS.n89 5.02514
R255 VSS.n207 VSS.n25 5.02514
R256 VSS.n101 VSS.n84 5.02514
R257 VSS.n202 VSS.n31 5.02514
R258 VSS.n104 VSS.n82 5.02514
R259 VSS.n199 VSS.n36 5.02514
R260 VSS.n110 VSS.n79 5.02514
R261 VSS.n192 VSS.n41 5.02514
R262 VSS.n119 VSS.n66 5.02514
R263 VSS.n180 VSS.n48 5.02514
R264 VSS.n126 VSS.n63 5.02514
R265 VSS.n133 VSS.n56 5.02514
R266 VSS.n208 VSS.n24 5.02514
R267 VSS.n206 VSS.n26 5.02514
R268 VSS.n201 VSS.n32 5.02514
R269 VSS.n198 VSS.n37 5.02514
R270 VSS.t19 VSS.n40 5.02514
R271 VSS.n191 VSS.n42 5.02514
R272 VSS.n179 VSS.n49 5.02514
R273 VSS.n132 VSS.n57 5.02514
R274 VSS.n214 VSS.n213 5.02514
R275 VSS.n100 VSS.n85 5.02514
R276 VSS.n105 VSS.n81 5.02514
R277 VSS.n111 VSS.n78 5.02514
R278 VSS.n120 VSS.n65 5.02514
R279 VSS.n127 VSS.n62 5.02514
R280 VSS.n128 VSS.n61 5.02514
R281 VSS.n131 VSS.n58 5.02514
R282 VSS.n177 VSS.n62 5.02514
R283 VSS.n193 VSS.t19 5.02514
R284 VSS.n214 VSS.n90 5.02514
R285 VSS.n93 VSS.n24 5.02514
R286 VSS.n92 VSS.n23 5.02514
R287 VSS.n91 VSS.n22 5.02514
R288 VSS.n227 VSS.n226 4.67815
R289 VSS.n9 VSS.n15 4.41876
R290 VSS.n135 VSS.n93 4.3368
R291 VSS.n2 VSS.n175 4.23094
R292 VSS.n2 VSS.n137 4.23094
R293 VSS.n2 VSS.n165 4.23094
R294 VSS.n2 VSS.n136 3.50296
R295 VSS.n2 VSS.n168 3.37539
R296 VSS.n2 VSS.n139 3.37539
R297 VSS.n2 VSS.n162 3.37539
R298 VSS.n166 VSS.t7 3.14902
R299 VSS.n17 VSS.t37 3.14902
R300 VSS.n169 VSS.t38 3.14902
R301 VSS.n171 VSS.t5 3.14902
R302 VSS.n173 VSS.t1 3.14902
R303 VSS.n10 VSS.t41 3.14902
R304 VSS.n2 VSS.n172 2.80331
R305 VSS.n161 VSS.n160 2.71772
R306 VSS.n218 VSS.t32 2.21091
R307 VSS.n222 VSS.t28 2.21082
R308 VSS.n216 VSS.t34 2.21075
R309 VSS.n107 VSS.t62 2.21075
R310 VSS.n226 VSS.t25 2.21072
R311 VSS.n187 VSS.t60 2.21067
R312 VSS.n186 VSS.t58 2.21054
R313 VSS.n220 VSS.t30 2.21047
R314 VSS.n210 VSS.t66 2.21043
R315 VSS.n20 VSS.t57 2.21039
R316 VSS.n209 VSS.t64 2.21026
R317 VSS.n224 VSS.t26 2.20978
R318 VSS.n20 VSS.t47 2.2031
R319 VSS.n220 VSS.t20 2.20275
R320 VSS.n222 VSS.t18 2.20202
R321 VSS.n210 VSS.t56 2.20174
R322 VSS.n187 VSS.t50 2.20163
R323 VSS.n226 VSS.t15 2.20159
R324 VSS.n186 VSS.t48 2.2015
R325 VSS.n218 VSS.t22 2.20149
R326 VSS.n216 VSS.t24 2.20142
R327 VSS.n209 VSS.t54 2.20136
R328 VSS.n224 VSS.t16 2.20123
R329 VSS.n107 VSS.t52 2.2008
R330 VSS.n212 VSS.n193 1.73893
R331 VSS.n212 VSS.n92 1.73893
R332 VSS.n212 VSS.n94 1.73893
R333 VSS.n212 VSS.n207 1.73893
R334 VSS.n212 VSS.n95 1.73893
R335 VSS.n212 VSS.n96 1.73893
R336 VSS.n212 VSS.n205 1.73893
R337 VSS.n212 VSS.n98 1.73893
R338 VSS.n212 VSS.n204 1.73893
R339 VSS.n212 VSS.n203 1.73893
R340 VSS.n212 VSS.n99 1.73893
R341 VSS.n212 VSS.n101 1.73893
R342 VSS.n212 VSS.n202 1.73893
R343 VSS.n212 VSS.n102 1.73893
R344 VSS.n212 VSS.n103 1.73893
R345 VSS.n212 VSS.n104 1.73893
R346 VSS.n212 VSS.n200 1.73893
R347 VSS.n212 VSS.n106 1.73893
R348 VSS.n212 VSS.n199 1.73893
R349 VSS.n212 VSS.n109 1.73893
R350 VSS.n212 VSS.n110 1.73893
R351 VSS.n212 VSS.n197 1.73893
R352 VSS.n212 VSS.n196 1.73893
R353 VSS.n212 VSS.n112 1.73893
R354 VSS.n212 VSS.n195 1.73893
R355 VSS.n212 VSS.n194 1.73893
R356 VSS.n212 VSS.n192 1.73893
R357 VSS.n212 VSS.n113 1.73893
R358 VSS.n212 VSS.n190 1.73893
R359 VSS.n212 VSS.n189 1.73893
R360 VSS.n212 VSS.n114 1.73893
R361 VSS.n212 VSS.n115 1.73893
R362 VSS.n212 VSS.n185 1.73893
R363 VSS.n212 VSS.n184 1.73893
R364 VSS.n212 VSS.n116 1.73893
R365 VSS.n212 VSS.n183 1.73893
R366 VSS.n212 VSS.n117 1.73893
R367 VSS.n212 VSS.n182 1.73893
R368 VSS.n212 VSS.n118 1.73893
R369 VSS.n212 VSS.n119 1.73893
R370 VSS.n212 VSS.n181 1.73893
R371 VSS.n212 VSS.n180 1.73893
R372 VSS.n212 VSS.n121 1.73893
R373 VSS.n212 VSS.n122 1.73893
R374 VSS.n212 VSS.n123 1.73893
R375 VSS.n212 VSS.n124 1.73893
R376 VSS.n212 VSS.n125 1.73893
R377 VSS.n212 VSS.n126 1.73893
R378 VSS.n212 VSS.n134 1.73893
R379 VSS.n212 VSS.n129 1.73893
R380 VSS.n212 VSS.n133 1.73893
R381 VSS.n212 VSS.n130 1.73893
R382 VSS.n215 VSS.n214 1.73893
R383 VSS.n215 VSS.n88 1.73893
R384 VSS.n215 VSS.n87 1.73893
R385 VSS.n215 VSS.n86 1.73893
R386 VSS.n215 VSS.n85 1.73893
R387 VSS.n215 VSS.n83 1.73893
R388 VSS.n215 VSS.n81 1.73893
R389 VSS.n215 VSS.n80 1.73893
R390 VSS.n215 VSS.n78 1.73893
R391 VSS.n215 VSS.n77 1.73893
R392 VSS.n215 VSS.n76 1.73893
R393 VSS.n215 VSS.n75 1.73893
R394 VSS.n215 VSS.n74 1.73893
R395 VSS.n215 VSS.n73 1.73893
R396 VSS.n215 VSS.n72 1.73893
R397 VSS.n215 VSS.n71 1.73893
R398 VSS.n215 VSS.n70 1.73893
R399 VSS.n215 VSS.n69 1.73893
R400 VSS.n215 VSS.n68 1.73893
R401 VSS.n215 VSS.n67 1.73893
R402 VSS.n215 VSS.n65 1.73893
R403 VSS.n215 VSS.n64 1.73893
R404 VSS.n215 VSS.n62 1.73893
R405 VSS.n215 VSS.n61 1.73893
R406 VSS.n215 VSS.n60 1.73893
R407 VSS.n215 VSS.n22 1.73893
R408 VSS.n215 VSS.n24 1.73893
R409 VSS.n215 VSS.n26 1.73893
R410 VSS.n215 VSS.n27 1.73893
R411 VSS.n215 VSS.n28 1.73893
R412 VSS.n215 VSS.n29 1.73893
R413 VSS.n215 VSS.n30 1.73893
R414 VSS.n215 VSS.n32 1.73893
R415 VSS.n215 VSS.n33 1.73893
R416 VSS.n215 VSS.n34 1.73893
R417 VSS.n215 VSS.n35 1.73893
R418 VSS.n215 VSS.n37 1.73893
R419 VSS.n215 VSS.n38 1.73893
R420 VSS.n215 VSS.n39 1.73893
R421 VSS.n215 VSS.n40 1.73893
R422 VSS.n215 VSS.n42 1.73893
R423 VSS.n215 VSS.n43 1.73893
R424 VSS.n215 VSS.n44 1.73893
R425 VSS.n215 VSS.n45 1.73893
R426 VSS.n215 VSS.n46 1.73893
R427 VSS.n215 VSS.n47 1.73893
R428 VSS.n215 VSS.n49 1.73893
R429 VSS.n215 VSS.n50 1.73893
R430 VSS.n215 VSS.n51 1.73893
R431 VSS.n215 VSS.n52 1.73893
R432 VSS.n215 VSS.n53 1.73893
R433 VSS.n215 VSS.n54 1.73893
R434 VSS.n215 VSS.n55 1.73893
R435 VSS.n215 VSS.n57 1.73893
R436 VSS.n215 VSS.n58 1.73893
R437 VSS.n131 VSS.t14 1.44593
R438 VSS.n177 VSS.n176 1.44593
R439 VSS.n91 VSS.t23 1.44593
R440 VSS.n215 VSS.n21 0.570662
R441 VSS.n212 VSS.n59 0.57056
R442 VSS.n212 VSS.n21 0.57015
R443 VSS.n215 VSS.n59 0.570048
R444 VSS.n7 VSS.n19 0.700468
R445 VSS.n15 VSS.n14 0.0605836
R446 VSS.n224 VSS.n223 0.243424
R447 VSS.n188 VSS.n186 0.243424
R448 VSS.n178 VSS.n20 0.242716
R449 VSS.n226 VSS.n225 0.242681
R450 VSS.n220 VSS.n219 0.24245
R451 VSS.n107 VSS.n97 0.24245
R452 VSS.n222 VSS.n221 0.240796
R453 VSS.n187 VSS.n108 0.240796
R454 VSS.n218 VSS.n217 0.239822
R455 VSS.n211 VSS.n209 0.239822
R456 VSS.n219 VSS.n218 0.227974
R457 VSS.n209 VSS.n97 0.227974
R458 VSS.n223 VSS.n222 0.227001
R459 VSS.n188 VSS.n187 0.227001
R460 VSS.n160 VSS.n13 0.226786
R461 VSS.n217 VSS.n216 0.225646
R462 VSS.n211 VSS.n210 0.225646
R463 VSS.n221 VSS.n220 0.224672
R464 VSS.n108 VSS.n107 0.224672
R465 VSS.n225 VSS.n224 0.223727
R466 VSS.n186 VSS.n178 0.223715
R467 VSS.n212 VSS.n97 0.218846
R468 VSS.n212 VSS.n188 0.218846
R469 VSS.n219 VSS.n215 0.218846
R470 VSS.n223 VSS.n215 0.218846
R471 VSS.n152 VSS.n151 0.21526
R472 VSS.n160 VSS.n7 0.450196
R473 VSS.n212 VSS.n211 0.208386
R474 VSS.n212 VSS.n108 0.208386
R475 VSS.n217 VSS.n215 0.208386
R476 VSS.n221 VSS.n215 0.208386
R477 VSS.n212 VSS.n178 0.208371
R478 VSS.n225 VSS.n215 0.20836
R479 VSS.n143 VSS.n15 0.197741
R480 VSS.n144 VSS.n143 0.197741
R481 VSS.n145 VSS.n144 0.197741
R482 VSS.n146 VSS.n12 0.173833
R483 VSS.n147 VSS.n146 0.173833
R484 VSS.n148 VSS.n147 0.173833
R485 VSS.n149 VSS.n148 0.173833
R486 VSS.n150 VSS.n149 0.173833
R487 VSS.n151 VSS.n150 0.173833
R488 VSS.n3 VSS.t10 18.096
R489 VSS.n159 VSS.n146 0.117414
R490 VSS.n158 VSS.n147 0.117414
R491 VSS.n157 VSS.n148 0.117414
R492 VSS.n156 VSS.n149 0.117414
R493 VSS.n155 VSS.n150 0.117414
R494 VSS.n154 VSS.n151 0.117414
R495 VSS.n14 VSS.n13 14.3176
R496 VSS VSS.n19 0.409071
R497 VSS.n6 VSS.n12 0.0590729
R498 VSS.n143 VSS.n142 0.112386
R499 VSS.n144 VSS.n141 0.112386
R500 VSS.n145 VSS.n140 0.112386
R501 VSS.n145 VSS.n9 0.257009
R502 VSS.n6 VSS.n159 0.118565
R503 VSS.n142 VSS.n14 0.115446
R504 VSS.n140 VSS.n8 0.1149
R505 VSS.n8 VSS.n9 0.0268464
R506 VSS.n172 VSS.n171 0.0927224
R507 VSS.n173 VSS.n172 0.0891245
R508 VSS.n153 VSS.n152 0.088983
R509 VSS.n155 VSS.n154 0.0885
R510 VSS.n156 VSS.n155 0.0885
R511 VSS.n157 VSS.n156 0.0885
R512 VSS.n158 VSS.n157 0.0885
R513 VSS.n159 VSS.n158 0.0885
R514 VSS.n141 VSS.n140 0.0885
R515 VSS.n142 VSS.n141 0.0885
R516 VSS.n139 VSS.n138 0.0814472
R517 VSS.n165 VSS.n164 0.0794206
R518 VSS.n166 VSS.n137 0.0784641
R519 VSS.n163 VSS.n162 0.0776211
R520 VSS.n175 VSS.n173 0.0773061
R521 VSS.n162 VSS.n161 0.0750054
R522 VSS.n165 VSS.n163 0.0725235
R523 VSS.n168 VSS.n166 0.0721359
R524 VSS.n164 VSS.n139 0.0711793
R525 VSS.n138 VSS.n137 0.0686974
R526 VSS.n168 VSS.n167 0.0675776
R527 VSS.n175 VSS.n174 0.061725
R528 VSS.n171 VSS.n170 0.0581825
R529 VSS.n18 VSS.n2 0.0520648
R530 VSS.n154 VSS.n153 0.0489
R531 VSS.n2 VSS.n0 0.0456104
R532 VSS.n11 VSS.n10 0.0351392
R533 VSS.n167 VSS.n17 0.0421087
R534 VSS.n174 VSS.n10 0.0421087
R535 VSS.n17 VSS.n16 0.0271167
R536 VSS.n170 VSS.n169 0.037474
R537 VSS.n2 VSS.n1 0.0361218
R538 VSS.n4 VSS.t6 21.176
R539 a_3900_n11978.n0 a_3900_n11978.t4 53.6901
R540 a_3900_n11978.n3 a_3900_n11978.t1 29.2688
R541 a_3900_n11978.n2 a_3900_n11978.t5 24.2693
R542 a_3900_n11978.n1 a_3900_n11978.t2 24.2693
R543 a_3900_n11978.t0 a_3900_n11978.n3 15.6064
R544 a_3900_n11978.n0 a_3900_n11978.t3 9.21754
R545 a_3900_n11978.n3 a_3900_n11978.n2 1.7693
R546 a_3900_n11978.n2 a_3900_n11978.n1 0.543167
R547 a_3900_n11978.n1 a_3900_n11978.n0 0.320233
R548 a_4400_n11058.n0 a_4400_n11058.t2 27.72
R549 a_4400_n11058.n0 a_4400_n11058.t0 24.1197
R550 a_4400_n11058.t1 a_4400_n11058.n0 9.38813
R551 a_4400_n9272.n0 a_4400_n9272.t2 55.3005
R552 a_4400_n9272.n0 a_4400_n9272.t1 27.8842
R553 a_4400_n9272.t0 a_4400_n9272.n0 7.50485
R554 a_3900_n9272.n0 a_3900_n9272.t1 34.3045
R555 a_3900_n9272.t0 a_3900_n9272.n0 5.85564
R556 a_3900_n9272.t0 a_3900_n9272.n0 5.85498
R557 a_5408_n8844.n2 a_5408_n8844.t2 19.9393
R558 a_5408_n8844.n0 a_5408_n8844.t4 19.6783
R559 a_5408_n8844.n1 a_5408_n8844.t0 17.974
R560 a_5408_n8844.n2 a_5408_n8844.n1 5.04317
R561 a_5408_n8844.n0 a_5408_n8844.t1 4.81727
R562 a_5408_n8844.n1 a_5408_n8844.n0 4.76157
R563 a_5408_n8844.t3 a_5408_n8844.n2 3.15445
R564 a_4788_n10564.n0 a_4788_n10564.t2 30.2902
R565 a_4788_n10564.n0 a_4788_n10564.t0 27.2706
R566 a_4788_n10564.t1 a_4788_n10564.n0 11.5346
C0 vbg_buf vbn_buf 10.0344f
C1 vbg_buf di_en 4.16619f
C2 en_b vbn_buf 0.46819f
C3 a_4400_n10972# VDD 0.03954f
C4 en_b di_en 0.62558f
C5 di_en vbn_buf 0.14079f
C6 vbg_buf VDD 3.90953f
C7 en_b VDD 0.98252f
C8 VDD vbn_buf 0.6955f
C9 vbg_buf a_4400_n10972# 0.03933f
C10 di_en VDD 0.54367f
C11 vbg_buf a_0_n13610# 0.04813f
C12 a_3900_n11892# a_4400_n10972# 0.09924f
C13 a_400_n13910# a_0_n13610# 0.60592f
C14 en_b a_4400_n10972# 0.05029f
C15 vbg_buf a_400_n13910# 0.03483f
C16 a_3900_n11892# vbg_buf 0.27763f
C17 vbg_buf en_b 0.25526f
C18 vbn_buf a_0_n13610# 0.02902f
C19 di_en VSS 3.8453f
C20 en_b VSS 1.90698f
C21 vbg_buf VSS 0.73507p
C22 vbn_buf VSS 0.10817p
C23 VDD VSS 1.72247f
C24 a_4788_n10564.t0 VSS 0.18835f
C25 a_4788_n10564.n0 VSS 2.20174f
C26 a_4788_n10564.t1 VSS 0.33495f
C27 a_5408_n8844.t0 VSS 0.60609f
C28 a_5408_n8844.t1 VSS 0.60603f
C29 a_5408_n8844.n0 VSS 0.71199f
C30 a_5408_n8844.n1 VSS 1.06752f
C31 a_5408_n8844.n2 VSS 0.71251f
C32 a_5408_n8844.t3 VSS 1.14037f
C33 a_3900_n9272.t1 VSS 1.46499f
C34 a_3900_n9272.n0 VSS 1.75426f
C35 a_3900_n9272.t0 VSS 0.45606f
C36 a_4400_n9272.t2 VSS 2.60714f
C37 a_4400_n9272.t1 VSS 0.76776f
C38 a_4400_n9272.n0 VSS 3.57099f
C39 a_4400_n9272.t0 VSS 1.33776f
C40 a_4400_n11058.t2 VSS 0.7582f
C41 a_4400_n11058.n0 VSS 1.17868f
C42 a_4400_n11058.t1 VSS 0.60336f
C43 a_3900_n11978.t4 VSS 2.72609f
C44 a_3900_n11978.t3 VSS 0.72141f
C45 a_3900_n11978.n0 VSS 1.83166f
C46 a_3900_n11978.n1 VSS 0.31693f
C47 a_3900_n11978.n2 VSS 0.51114f
C48 a_3900_n11978.t1 VSS 1.23678f
C49 a_3900_n11978.n3 VSS 1.70837f
C50 a_3900_n11978.t0 VSS 0.3033f
C51 VSS.t62 VSS 2.91645f
C52 VSS.t13 VSS 0.13963f
C53 VSS.t9 VSS 0.07794f
C54 VSS.t3 VSS 0.11389f
C55 VSS.t11 VSS 0.08979f
C56 VSS.t7 VSS 0.21302f
C57 VSS.t5 VSS 0.25354f
C58 VSS.t1 VSS 0.25354f
C59 VSS.t48 VSS 2.92057f
C60 VSS.t50 VSS 2.92057f
C61 VSS.t60 VSS 2.91645f
C62 VSS.t18 VSS 3.2295f
C63 VSS.t28 VSS 3.22498f
C64 VSS.t20 VSS 3.2295f
C65 VSS.t30 VSS 3.22498f
C66 VDD.n0 VSS 0.35884f
C67 VDD.n2 VSS 0.15644f
C68 VDD.n3 VSS 0.39681f
C69 VDD.n4 VSS 0.07013f
C70 VDD.n5 VSS 0.11479f
C71 VDD.n6 VSS 0.09317f
C72 VDD.n7 VSS 0.47641f
C73 VDD.n8 VSS 0.1436f
C74 VDD.n9 VSS 0.09617f
C75 VDD.t6 VSS 0.11571f
C76 VDD.t2 VSS 0.11406f
C77 VDD.t1 VSS 0.28686f
C78 VDD.t3 VSS 0.56434f
C79 VDD.t14 VSS 0.21881f
C80 VDD.t15 VSS 0.21374f
C81 VDD.t4 VSS 0.56241f
C82 VDD.t11 VSS 0.21374f
C83 VDD.t12 VSS 0.21374f
C84 VDD.t5 VSS 0.21482f
C85 VDD.t8 VSS 0.02986f
C86 VDD.t9 VSS 0.02986f
C87 VDD.t0 VSS 6.38813f
C88 VDD.n10 VSS 0.52394f
C89 vbn_buf.n0 VSS 0.12146f
C90 vbn_buf.t1 VSS 2.21675f
C91 vbn_buf.n1 VSS 0.17471f
C92 vbn_buf.t0 VSS 0.15753f
C93 vbn_buf.n2 VSS 0.1186f
C94 vbg_buf.n0 VSS 0.03534f
C95 vbg_buf.n2 VSS 0.03f
C96 vbg_buf.n3 VSS 0.01018f
C97 vbg_buf.n4 VSS 0.03f
C98 vbg_buf.n6 VSS 0.02858f
C99 vbg_buf.n7 VSS 1.49402f
C100 vbg_buf.n8 VSS 3.73841f
C101 vbg_buf.n9 VSS 0.1605f
C102 vbg_buf.n10 VSS 0.03122f
C103 vbg_buf.n11 VSS 0.08816f
C104 vbg_buf.t0 VSS 1.99175f
C105 vbg_buf.n12 VSS 0.11564f
C106 vbg_buf.n13 VSS 0.03824f
C107 vbg_buf.n14 VSS 0.8811f
C108 en_b.n0 VSS 1.64963f
C109 en_b.n1 VSS 1.3155f
C110 en_b.t0 VSS 0.32897f
C111 en_b.t1 VSS 0.20661f
C112 en_b.n2 VSS 0.4478f
C113 en_b.n3 VSS 0.66668f
C114 en_b.n4 VSS 1.06138f
C115 di_en.n0 VSS 3.0544f
.ends
