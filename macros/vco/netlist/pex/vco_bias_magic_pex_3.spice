* PEX produced on Sat Nov  7 10:24:47 PM CET 2026 using /foss/tools/sak/sak-pex.sh with m=3 and s=1 (extresist threshold=1000 mOhm, minres=100 mOhm, mindelay=0 ps)
* NGSPICE file created from vco_bias_pex.ext - technology: ihp-sg13cmos5l

.subckt vco_bias_pex di_en VDD VSS vbg_buf vbn_buf en_b
X0 en_b.t0 di_en.t1 VDD.t4 VDD.t0 sg13_lv_pmos ad=0.34p pd=2.68u as=0.34p ps=2.68u w=1u l=0.13u
X1 en_b.t1 di_en.t0 VSS.t3 VSS.t2 sg13_lv_nmos ad=0.17p pd=1.68u as=0.17p ps=1.68u w=0.5u l=0.13u
X2 a_3900_n11978.t3 a_3900_n11978.t2 VSS.t7 VSS.t6 sg13_lv_nmos ad=0.85p pd=5.68u as=0.85p ps=5.68u w=2.5u l=0.5u
X3 VSS.t49 vbn_buf.t3 VSS.t47 VSS.t19 sg13_lv_nmos ad=1.52p pd=8.38u as=0 ps=0 w=8u l=10u
X4 VSS.t53 vbn_buf.t3 VSS.t51 VSS.t23 sg13_lv_nmos ad=1.52p pd=8.38u as=0 ps=0 w=8u l=10u
X5 VSS.t32 vbg_buf.t1 VSS.t30 VSS.t21 sg13_lv_nmos ad=1.52p pd=8.38u as=0 ps=0 w=8u l=10u
X6 VSS.t36 vbg_buf.t1 VSS.t34 VSS.t25 sg13_lv_nmos ad=1.52p pd=8.38u as=0 ps=0 w=8u l=10u
X7 a_3900_n9272.t1 en_b.t5 VDD.t5 VDD.t0 sg13_lv_pmos ad=0.68p pd=4.68u as=0.68p ps=4.68u w=2u l=0.13u
X8 a_5408_n8844.t2 a_5408_n8844.t1 VDD.t2 VDD.t0 sg13_lv_pmos ad=1.7p pd=10.68u as=1.7p ps=10.68u w=5u l=0.5u
X9 VDD.t15 VDD.t13 VDD.t14 VDD.t0 sg13_lv_pmos ad=1.7p pd=10.68u as=0 ps=0 w=5u l=0.5u
X10 vbn_buf.t1 a_3900_n11978.t4 VSS.t45 rhigh l=32u w=0.5u
X11 VSS.t40 VSS.t37 VSS.t39 VSS.t38 sg13_lv_nmos ad=0.85p pd=5.68u as=0 ps=0 w=2.5u l=0.5u
X12 VSS.t44 VSS.t41 VSS.t43 VSS.t42 sg13_lv_nmos ad=0.85p pd=5.68u as=0 ps=0 w=2.5u l=0.5u
X13 VSS.t61 vbn_buf.t2 VSS.t59 VSS.t21 sg13_lv_nmos ad=1.52p pd=8.38u as=0 ps=0 w=8u l=10u
X14 a_5408_n8844.t3 a_3900_n11978.t5 VSS.t5 VSS.t4 sg13_lv_nmos ad=0.85p pd=5.68u as=0.85p ps=5.68u w=2.5u l=0.5u
X15 VSS.t65 vbn_buf.t2 VSS.t63 VSS.t25 sg13_lv_nmos ad=1.52p pd=8.38u as=0 ps=0 w=8u l=10u
X16 VSS.t28 vbg_buf.t1 VSS.t27 VSS.t16 sg13_lv_nmos ad=2.72p pd=16.68u as=0 ps=0 w=8u l=10u
X17 a_5408_n8844.t0 a_4788_n10564.t2 VDD.t3 VDD.t0 sg13_lv_pmos ad=0.34p pd=2.68u as=0.34p ps=2.68u w=1u l=0.13u
X18 VSS.t22 vbg_buf.t2 VSS.t20 VSS.t21 sg13_lv_nmos ad=1.52p pd=8.38u as=0 ps=0 w=8u l=10u
X19 VSS.t26 vbg_buf.t2 VSS.t24 VSS.t25 sg13_lv_nmos ad=1.52p pd=8.38u as=0 ps=0 w=8u l=10u
X20 VSS.t30 vbg_buf.t1 VSS.t28 VSS.t19 sg13_lv_nmos ad=1.52p pd=8.38u as=0 ps=0 w=8u l=10u
X21 VSS.t34 vbg_buf.t1 VSS.t32 VSS.t23 sg13_lv_nmos ad=1.52p pd=8.38u as=0 ps=0 w=8u l=10u
X22 a_4400_n9272.t1 a_4400_n11058.t2 VSS.t1 rppd l=8.5u w=0.5u
X23 VDD.t12 VDD.t10 VDD.t11 VDD.t0 sg13_lv_pmos ad=1.7p pd=10.68u as=0 ps=0 w=5u l=0.5u
X24 VSS.t51 vbn_buf.t3 VSS.t49 VSS.t21 sg13_lv_nmos ad=1.52p pd=8.38u as=0 ps=0 w=8u l=10u
X25 VSS.t55 vbn_buf.t3 VSS.t53 VSS.t25 sg13_lv_nmos ad=1.52p pd=8.38u as=0 ps=0 w=8u l=10u
X26 a_4400_n11058.t1 a_4400_n11058.t0 VSS.t15 VSS.t14 sg13_lv_nmos ad=0.85p pd=5.68u as=0.85p ps=5.68u w=2.5u l=0.5u
X27 a_4788_n10564.t1 en_b.t6 VDD.t6 VDD.t0 sg13_lv_pmos ad=0.34p pd=2.68u as=0.34p ps=2.68u w=1u l=0.13u
X28 vbn_buf.t0 en_b.t2 VSS.t13 VSS.t12 sg13_lv_nmos ad=0.34p pd=2.68u as=0.34p ps=2.68u w=1u l=0.13u
X29 a_4788_n10564.t0 en_b.t4 VSS.t9 VSS.t8 sg13_lv_nmos ad=0.17p pd=1.68u as=0.17p ps=1.68u w=0.5u l=0.13u
X30 vbg_buf.t0 a_4400_n9272.t2 VSS.t66 rhigh l=32u w=0.5u
X31 VSS.t57 vbn_buf.t2 VSS.t56 VSS.t16 sg13_lv_nmos ad=2.72p pd=16.68u as=0 ps=0 w=8u l=10u
X32 VSS.t18 vbg_buf.t2 VSS.t17 VSS.t16 sg13_lv_nmos ad=2.72p pd=16.68u as=0 ps=0 w=8u l=10u
X33 a_3900_n11978.t1 en_b.t3 VSS.t11 VSS.t10 sg13_lv_nmos ad=0.34p pd=2.68u as=0.34p ps=2.68u w=1u l=0.13u
X34 VSS.t59 vbn_buf.t2 VSS.t57 VSS.t19 sg13_lv_nmos ad=1.52p pd=8.38u as=0 ps=0 w=8u l=10u
X35 VSS.t63 vbn_buf.t2 VSS.t61 VSS.t23 sg13_lv_nmos ad=1.52p pd=8.38u as=0 ps=0 w=8u l=10u
X36 a_3900_n9272.t0 a_3900_n11978.t0 VSS.t0 rppd l=13.1u w=0.5u
X37 a_4400_n9272.t0 a_5408_n8844.t4 VDD.t1 VDD.t0 sg13_lv_pmos ad=1.7p pd=10.68u as=1.7p ps=10.68u w=5u l=0.5u
X38 VSS.t47 vbn_buf.t3 VSS.t46 VSS.t16 sg13_lv_nmos ad=2.72p pd=16.68u as=0 ps=0 w=8u l=10u
X39 VSS.t20 vbg_buf.t2 VSS.t18 VSS.t19 sg13_lv_nmos ad=1.52p pd=8.38u as=0 ps=0 w=8u l=10u
X40 VSS.t24 vbg_buf.t2 VSS.t22 VSS.t23 sg13_lv_nmos ad=1.52p pd=8.38u as=0 ps=0 w=8u l=10u
X41 VDD.t9 VDD.t7 VDD.t8 VDD.t0 sg13_lv_pmos ad=0.34p pd=2.68u as=0 ps=0 w=1u l=0.13u
R0 di_en.n0 di_en.t0 21.6583
R1 di_en.n0 di_en.t1 19.605
R2 di_en di_en.n0 13.9942
R3 en_b.n0 en_b.t1 27.1774
R4 en_b.n4 en_b.t5 24.9608
R5 en_b.n3 en_b.t2 24.8442
R6 en_b.n1 en_b.t6 20.7725
R7 en_b.n1 en_b.t4 20.4909
R8 en_b.n0 en_b.t3 20.4287
R9 en_b.n0 en_b.t0 12.1423
R10 en_b.n2 en_b.n1 5.30277
R11 en_b.n2 en_b.n0 4.5269
R12 en_b en_b.n4 2.33103
R13 en_b.n3 en_b.n2 0.562233
R14 en_b.n4 en_b.n3 0.469833
R15 vbg_buf.n12 vbg_buf.t0 50.4632
R16 vbg_buf.n11 vbg_buf.t2 33.9824
R17 vbg_buf.n11 vbg_buf.t1 28.2977
R18 vbg_buf vbg_buf.n14 5.7205
R19 vbg_buf.n13 vbg_buf.n12 5.5565
R20 vbg_buf.n14 vbg_buf.n6 4.5929
R21 vbg_buf.n0 vbg_buf.n10 4.5005
R22 vbg_buf.n13 vbg_buf.n10 2.2005
R23 vbg_buf.n14 vbg_buf.n10 2.2005
R24 vbg_buf.n12 vbg_buf.n11 0.455167
R25 vbg_buf.n9 vbg_buf.n8 0.0590766
R26 vbg_buf.n7 vbg_buf.n8 6.82308
R27 vbg_buf.n5 vbg_buf.n7 0.274377
R28 vbg_buf.n3 vbg_buf.n5 0.274377
R29 vbg_buf.n8 vbg_buf.n1 0.21526
R30 vbg_buf.n9 vbg_buf.n13 4.88081
R31 vbg_buf.n1 vbg_buf.n3 0.296336
R32 vbg_buf.n6 vbg_buf.n4 0.1765
R33 vbg_buf.n4 vbg_buf.n2 0.1765
R34 vbg_buf.n2 vbg_buf.n0 0.1765
R35 vbg_buf.n6 vbg_buf.n7 0.0345713
R36 vbg_buf.n4 vbg_buf.n5 0.0345713
R37 vbg_buf.n2 vbg_buf.n3 0.0345713
R38 vbg_buf.n0 vbg_buf.n1 0.049383
R39 vbg_buf.n0 vbg_buf.n9 0.118561
R40 vbn_buf.n1 vbn_buf.t1 45.1624
R41 vbn_buf.n0 vbn_buf.t3 34.2391
R42 vbn_buf.n0 vbn_buf.t2 28.5544
R43 vbn_buf.n2 vbn_buf.t0 17.3257
R44 vbn_buf.n2 vbn_buf.n1 13.5293
R45 vbn_buf.n1 vbn_buf.n0 6.81757
R46 vbn_buf vbn_buf.n2 2.55837
R47 VDD.n3 VDD.t13 17.5809
R48 VDD.n0 VDD.t10 17.5809
R49 VDD.n10 VDD.n1 1.2602
R50 VDD.n4 VDD.t14 2.54465
R51 VDD.n2 VDD.t7 15.8062
R52 VDD.n8 VDD.t8 6.07554
R53 VDD.n2 VDD.t9 6.07554
R54 VDD.n5 VDD.t3 6.07554
R55 VDD.n6 VDD.t4 6.07554
R56 VDD.n7 VDD.t6 6.07554
R57 VDD VDD.n7 5.67699
R58 VDD.n1 VDD.n5 0.0656783
R59 VDD.n5 VDD.n6 0.1061
R60 VDD.n8 VDD.t5 3.45404
R61 VDD.n7 VDD.n10 3.37539
R62 VDD.n10 VDD.n0 1.51113
R63 VDD.n10 VDD.n4 1.16155
R64 VDD.n3 VDD.t2 2.36422
R65 VDD.n9 VDD.t1 2.36411
R66 VDD.n3 VDD.t15 2.36403
R67 VDD.n0 VDD.t12 2.36403
R68 VDD.n0 VDD.t11 2.36376
R69 VDD.n10 VDD.t0 0.395849
R70 VDD.n0 VDD.n9 0.222999
R71 VDD.n2 VDD.n8 0.199822
R72 VDD.n9 VDD.n3 0.181347
R73 VDD.n7 VDD.n6 0.152127
R74 VDD.n4 VDD.n3 0.0814646
R75 VDD.n2 VDD.n1 0.0766266
R76 VDD.n0 VDD.n8 0.139213
R77 VSS.n200 VSS.n7 2597.07
R78 VSS.t45 VSS.n199 740.371
R79 VSS.t1 VSS.t0 267.476
R80 VSS.t66 VSS.t45 213.981
R81 VSS.t0 VSS.t66 187.233
R82 VSS.n8 VSS.t1 179.258
R83 VSS.n6 VSS.t4 12.3022
R84 VSS.t42 VSS.n7 10.4922
R85 VSS.t10 VSS.n3 18.096
R86 VSS.n3 VSS.t14 15.2013
R87 VSS.n3 VSS.n8 7.79452
R88 VSS.n3 VSS.t38 18.4888
R89 VSS.t16 VSS.n55 26.5383
R90 VSS.t25 VSS.n19 26.5382
R91 VSS.t8 VSS.n8 11.7783
R92 VSS.n127 VSS.n53 24.5729
R93 VSS.n122 VSS.n59 24.5729
R94 VSS.n133 VSS.n48 24.5729
R95 VSS.n140 VSS.n46 24.5729
R96 VSS.n117 VSS.n69 24.5729
R97 VSS.n146 VSS.n41 24.5729
R98 VSS.n112 VSS.n72 24.5729
R99 VSS.n148 VSS.n38 24.5729
R100 VSS.n109 VSS.n81 24.5729
R101 VSS.n158 VSS.n35 24.5729
R102 VSS.n105 VSS.n84 24.5729
R103 VSS.n101 VSS.n86 24.5729
R104 VSS.n165 VSS.n25 24.5729
R105 VSS.n208 VSS.n90 24.5729
R106 VSS.n202 VSS.n21 24.5729
R107 VSS.t12 VSS.n3 16.0639
R108 VSS.n199 VSS.n123 23.1275
R109 VSS.n201 VSS.n200 20.2366
R110 VSS.t2 VSS.n3 13.4559
R111 VSS.n191 VSS.t9 17.3443
R112 VSS.n193 VSS.t3 17.3443
R113 VSS.n5 VSS.n4 0.0686681
R114 VSS.n0 VSS.t37 16.4809
R115 VSS.n4 VSS.t41 16.4809
R116 VSS.n10 VSS.n9 6.85058
R117 VSS.n183 VSS.n17 13.5948
R118 VSS.n14 VSS.n11 13.5948
R119 VSS.t19 VSS.n66 13.0094
R120 VSS.n161 VSS.t23 13.0094
R121 VSS.n119 VSS.t19 11.564
R122 VSS.t23 VSS.n31 11.564
R123 VSS.n92 VSS.n20 10.0498
R124 VSS.n94 VSS.n24 10.0498
R125 VSS.n95 VSS.n27 10.0498
R126 VSS.n97 VSS.n28 10.0498
R127 VSS.n98 VSS.n29 10.0498
R128 VSS.n102 VSS.n33 10.0498
R129 VSS.n103 VSS.n34 10.0498
R130 VSS.n153 VSS.n37 10.0498
R131 VSS.n110 VSS.n40 10.0498
R132 VSS.n114 VSS.n44 10.0498
R133 VSS.n115 VSS.n45 10.0498
R134 VSS.n124 VSS.n51 10.0498
R135 VSS.n125 VSS.n52 10.0498
R136 VSS.n164 VSS.n88 10.0498
R137 VSS.n163 VSS.n87 10.0498
R138 VSS.n160 VSS.n82 10.0498
R139 VSS.n157 VSS.n79 10.0498
R140 VSS.n156 VSS.n78 10.0498
R141 VSS.n155 VSS.n77 10.0498
R142 VSS.n153 VSS.n76 10.0498
R143 VSS.n152 VSS.n75 10.0498
R144 VSS.n151 VSS.n74 10.0498
R145 VSS.n150 VSS.n73 10.0498
R146 VSS.n142 VSS.n70 10.0498
R147 VSS.n139 VSS.n67 10.0498
R148 VSS.n138 VSS.n64 10.0498
R149 VSS.n137 VSS.n63 10.0498
R150 VSS.n136 VSS.n62 10.0498
R151 VSS.n135 VSS.n60 10.0498
R152 VSS.n128 VSS.n56 10.0498
R153 VSS.n125 VSS.n56 10.0498
R154 VSS.n129 VSS.n52 10.0498
R155 VSS.n129 VSS.n57 10.0498
R156 VSS.n124 VSS.n57 10.0498
R157 VSS.n121 VSS.n50 10.0498
R158 VSS.n131 VSS.n50 10.0498
R159 VSS.n131 VSS.n49 10.0498
R160 VSS.n134 VSS.n60 10.0498
R161 VSS.n135 VSS.n61 10.0498
R162 VSS.n120 VSS.n61 10.0498
R163 VSS.n120 VSS.n62 10.0498
R164 VSS.n136 VSS.n63 10.0498
R165 VSS.n137 VSS.n64 10.0498
R166 VSS.n138 VSS.n65 10.0498
R167 VSS.n118 VSS.n67 10.0498
R168 VSS.n118 VSS.n47 10.0498
R169 VSS.n141 VSS.n68 10.0498
R170 VSS.n116 VSS.n45 10.0498
R171 VSS.n115 VSS.n44 10.0498
R172 VSS.n114 VSS.n43 10.0498
R173 VSS.n142 VSS.n43 10.0498
R174 VSS.n113 VSS.n70 10.0498
R175 VSS.n113 VSS.n42 10.0498
R176 VSS.n147 VSS.n71 10.0498
R177 VSS.n111 VSS.n40 10.0498
R178 VSS.n110 VSS.n39 10.0498
R179 VSS.n149 VSS.n73 10.0498
R180 VSS.n151 VSS.n75 10.0498
R181 VSS.n152 VSS.n76 10.0498
R182 VSS.n154 VSS.n37 10.0498
R183 VSS.n154 VSS.n77 10.0498
R184 VSS.n155 VSS.n78 10.0498
R185 VSS.n156 VSS.n79 10.0498
R186 VSS.n157 VSS.n80 10.0498
R187 VSS.n106 VSS.n36 10.0498
R188 VSS.n159 VSS.n82 10.0498
R189 VSS.n160 VSS.n83 10.0498
R190 VSS.n104 VSS.n34 10.0498
R191 VSS.n103 VSS.n33 10.0498
R192 VSS.n102 VSS.n32 10.0498
R193 VSS.n162 VSS.n85 10.0498
R194 VSS.n100 VSS.n87 10.0498
R195 VSS.n100 VSS.n30 10.0498
R196 VSS.n164 VSS.n30 10.0498
R197 VSS.n99 VSS.n88 10.0498
R198 VSS.n99 VSS.n29 10.0498
R199 VSS.n98 VSS.n28 10.0498
R200 VSS.n97 VSS.n27 10.0498
R201 VSS.n95 VSS.n26 10.0498
R202 VSS.n166 VSS.n89 10.0498
R203 VSS.n207 VSS.n89 10.0498
R204 VSS.n94 VSS.n23 10.0498
R205 VSS VSS.n221 9.6573
R206 VSS.n206 VSS.n91 8.5005
R207 VSS.n206 VSS.n202 8.5005
R208 VSS.n206 VSS.n93 8.5005
R209 VSS.n206 VSS.n201 8.5005
R210 VSS.n206 VSS.n90 8.5005
R211 VSS.n206 VSS.n165 8.5005
R212 VSS.n206 VSS.n101 8.5005
R213 VSS.n206 VSS.n161 8.5005
R214 VSS.n206 VSS.n105 8.5005
R215 VSS.n206 VSS.n158 8.5005
R216 VSS.n206 VSS.n109 8.5005
R217 VSS.n206 VSS.n148 8.5005
R218 VSS.n206 VSS.n112 8.5005
R219 VSS.n206 VSS.n146 8.5005
R220 VSS.n206 VSS.n117 8.5005
R221 VSS.n206 VSS.n140 8.5005
R222 VSS.n206 VSS.n119 8.5005
R223 VSS.n206 VSS.n133 8.5005
R224 VSS.n206 VSS.n122 8.5005
R225 VSS.n206 VSS.n130 8.5005
R226 VSS.n206 VSS.n123 8.5005
R227 VSS.n206 VSS.n127 8.5005
R228 VSS.n206 VSS.n126 8.5005
R229 VSS.n209 VSS.n208 8.5005
R230 VSS.n209 VSS.n86 8.5005
R231 VSS.n209 VSS.n84 8.5005
R232 VSS.n209 VSS.n81 8.5005
R233 VSS.n209 VSS.n72 8.5005
R234 VSS.n209 VSS.n69 8.5005
R235 VSS.n209 VSS.n66 8.5005
R236 VSS.n209 VSS.n59 8.5005
R237 VSS.n209 VSS.n21 8.5005
R238 VSS.n209 VSS.n25 8.5005
R239 VSS.n209 VSS.n31 8.5005
R240 VSS.n209 VSS.n35 8.5005
R241 VSS.n209 VSS.n38 8.5005
R242 VSS.n209 VSS.n41 8.5005
R243 VSS.n209 VSS.n46 8.5005
R244 VSS.n209 VSS.n48 8.5005
R245 VSS.n209 VSS.n53 8.5005
R246 VSS.n221 VSS.n18 7.76695
R247 VSS.n182 VSS.n13 6.86385
R248 VSS.n194 VSS.t11 6.07511
R249 VSS.n168 VSS.t13 6.07511
R250 VSS.n4 VSS.t44 3.20134
R251 VSS.n1 VSS.n0 0.0742225
R252 VSS.n208 VSS.n207 5.02514
R253 VSS.n166 VSS.n25 5.02514
R254 VSS.n162 VSS.n31 5.02514
R255 VSS.n104 VSS.n84 5.02514
R256 VSS.n159 VSS.n35 5.02514
R257 VSS.n106 VSS.n81 5.02514
R258 VSS.n149 VSS.n38 5.02514
R259 VSS.n111 VSS.n72 5.02514
R260 VSS.n147 VSS.n41 5.02514
R261 VSS.n116 VSS.n69 5.02514
R262 VSS.n141 VSS.n46 5.02514
R263 VSS.n134 VSS.n48 5.02514
R264 VSS.n121 VSS.n59 5.02514
R265 VSS.n128 VSS.n53 5.02514
R266 VSS.n202 VSS.n22 5.02514
R267 VSS.n201 VSS.n23 5.02514
R268 VSS.n165 VSS.n26 5.02514
R269 VSS.n161 VSS.n32 5.02514
R270 VSS.n158 VSS.n36 5.02514
R271 VSS.n148 VSS.n39 5.02514
R272 VSS.n146 VSS.n42 5.02514
R273 VSS.n140 VSS.n47 5.02514
R274 VSS.n133 VSS.n49 5.02514
R275 VSS.n127 VSS.n54 5.02514
R276 VSS.n101 VSS.n85 5.02514
R277 VSS.n105 VSS.n83 5.02514
R278 VSS.n109 VSS.n80 5.02514
R279 VSS.n112 VSS.n71 5.02514
R280 VSS.n117 VSS.n68 5.02514
R281 VSS.n119 VSS.n65 5.02514
R282 VSS.n122 VSS.n58 5.02514
R283 VSS.n126 VSS.n54 5.02514
R284 VSS.n123 VSS.n51 5.02514
R285 VSS.n130 VSS.n58 5.02514
R286 VSS.n139 VSS.n66 5.02514
R287 VSS.n150 VSS.t21 5.02514
R288 VSS.t21 VSS.n74 5.02514
R289 VSS.n163 VSS.n86 5.02514
R290 VSS.n90 VSS.n24 5.02514
R291 VSS.n93 VSS.n22 5.02514
R292 VSS.n92 VSS.n21 5.02514
R293 VSS.n91 VSS.n20 5.02514
R294 VSS.n221 VSS.n220 4.67815
R295 VSS.n12 VSS.n16 4.41876
R296 VSS.n200 VSS.n93 4.3368
R297 VSS.n3 VSS.n5 2.08334
R298 VSS.n3 VSS.n167 4.23094
R299 VSS.n3 VSS.n195 4.23094
R300 VSS.n7 VSS.n3 2.70988
R301 VSS.n3 VSS.n1 1.49519
R302 VSS.n3 VSS.n169 3.37539
R303 VSS.n3 VSS.n192 3.37539
R304 VSS.n196 VSS.t15 3.14902
R305 VSS.n0 VSS.t39 3.14902
R306 VSS.n2 VSS.t40 3.14902
R307 VSS.n2 VSS.t5 3.14902
R308 VSS.n198 VSS.t7 3.14902
R309 VSS.n4 VSS.t43 3.14902
R310 VSS.n3 VSS.n197 2.80331
R311 VSS.n191 VSS.n190 2.71772
R312 VSS.n107 VSS.t61 2.21167
R313 VSS.n204 VSS.t65 2.21153
R314 VSS.n18 VSS.t56 2.21141
R315 VSS.n203 VSS.t63 2.21122
R316 VSS.n212 VSS.t34 2.21087
R317 VSS.n143 VSS.t57 2.2108
R318 VSS.n218 VSS.t28 2.21075
R319 VSS.n144 VSS.t59 2.2106
R320 VSS.n220 VSS.t27 2.21047
R321 VSS.n216 VSS.t30 2.21029
R322 VSS.n214 VSS.t32 2.21022
R323 VSS.n210 VSS.t36 2.20981
R324 VSS.n18 VSS.t46 2.20312
R325 VSS.n216 VSS.t20 2.20236
R326 VSS.n214 VSS.t22 2.20234
R327 VSS.n210 VSS.t26 2.2021
R328 VSS.n204 VSS.t55 2.20203
R329 VSS.n218 VSS.t18 2.20193
R330 VSS.n203 VSS.t53 2.20154
R331 VSS.n144 VSS.t49 2.20141
R332 VSS.n212 VSS.t24 2.2014
R333 VSS.n143 VSS.t47 2.20119
R334 VSS.n220 VSS.t17 2.20077
R335 VSS.n107 VSS.t51 2.20064
R336 VSS.n206 VSS.n150 1.73893
R337 VSS.n206 VSS.n92 1.73893
R338 VSS.n206 VSS.n94 1.73893
R339 VSS.n207 VSS.n206 1.73893
R340 VSS.n206 VSS.n166 1.73893
R341 VSS.n206 VSS.n95 1.73893
R342 VSS.n206 VSS.n97 1.73893
R343 VSS.n206 VSS.n98 1.73893
R344 VSS.n206 VSS.n99 1.73893
R345 VSS.n206 VSS.n164 1.73893
R346 VSS.n206 VSS.n100 1.73893
R347 VSS.n206 VSS.n163 1.73893
R348 VSS.n206 VSS.n162 1.73893
R349 VSS.n206 VSS.n102 1.73893
R350 VSS.n206 VSS.n103 1.73893
R351 VSS.n206 VSS.n104 1.73893
R352 VSS.n206 VSS.n160 1.73893
R353 VSS.n206 VSS.n159 1.73893
R354 VSS.n206 VSS.n106 1.73893
R355 VSS.n206 VSS.n157 1.73893
R356 VSS.n206 VSS.n156 1.73893
R357 VSS.n206 VSS.n155 1.73893
R358 VSS.n206 VSS.n154 1.73893
R359 VSS.n206 VSS.n153 1.73893
R360 VSS.n206 VSS.n152 1.73893
R361 VSS.n206 VSS.n151 1.73893
R362 VSS.n206 VSS.n149 1.73893
R363 VSS.n206 VSS.n110 1.73893
R364 VSS.n206 VSS.n111 1.73893
R365 VSS.n206 VSS.n147 1.73893
R366 VSS.n206 VSS.n113 1.73893
R367 VSS.n206 VSS.n142 1.73893
R368 VSS.n206 VSS.n114 1.73893
R369 VSS.n206 VSS.n115 1.73893
R370 VSS.n206 VSS.n116 1.73893
R371 VSS.n206 VSS.n141 1.73893
R372 VSS.n206 VSS.n118 1.73893
R373 VSS.n206 VSS.n139 1.73893
R374 VSS.n206 VSS.n138 1.73893
R375 VSS.n206 VSS.n137 1.73893
R376 VSS.n206 VSS.n136 1.73893
R377 VSS.n206 VSS.n120 1.73893
R378 VSS.n206 VSS.n135 1.73893
R379 VSS.n206 VSS.n134 1.73893
R380 VSS.n206 VSS.n131 1.73893
R381 VSS.n206 VSS.n121 1.73893
R382 VSS.n206 VSS.n124 1.73893
R383 VSS.n206 VSS.n129 1.73893
R384 VSS.n206 VSS.n125 1.73893
R385 VSS.n206 VSS.n128 1.73893
R386 VSS.n209 VSS.n89 1.73893
R387 VSS.n209 VSS.n88 1.73893
R388 VSS.n209 VSS.n87 1.73893
R389 VSS.n209 VSS.n85 1.73893
R390 VSS.n209 VSS.n83 1.73893
R391 VSS.n209 VSS.n82 1.73893
R392 VSS.n209 VSS.n80 1.73893
R393 VSS.n209 VSS.n79 1.73893
R394 VSS.n209 VSS.n78 1.73893
R395 VSS.n209 VSS.n77 1.73893
R396 VSS.n209 VSS.n76 1.73893
R397 VSS.n209 VSS.n75 1.73893
R398 VSS.n209 VSS.n74 1.73893
R399 VSS.n209 VSS.n73 1.73893
R400 VSS.n209 VSS.n71 1.73893
R401 VSS.n209 VSS.n70 1.73893
R402 VSS.n209 VSS.n68 1.73893
R403 VSS.n209 VSS.n67 1.73893
R404 VSS.n209 VSS.n65 1.73893
R405 VSS.n209 VSS.n64 1.73893
R406 VSS.n209 VSS.n63 1.73893
R407 VSS.n209 VSS.n62 1.73893
R408 VSS.n209 VSS.n61 1.73893
R409 VSS.n209 VSS.n60 1.73893
R410 VSS.n209 VSS.n58 1.73893
R411 VSS.n209 VSS.n57 1.73893
R412 VSS.n209 VSS.n56 1.73893
R413 VSS.n209 VSS.n20 1.73893
R414 VSS.n209 VSS.n22 1.73893
R415 VSS.n209 VSS.n23 1.73893
R416 VSS.n209 VSS.n24 1.73893
R417 VSS.n209 VSS.n26 1.73893
R418 VSS.n209 VSS.n27 1.73893
R419 VSS.n209 VSS.n28 1.73893
R420 VSS.n209 VSS.n29 1.73893
R421 VSS.n209 VSS.n30 1.73893
R422 VSS.n209 VSS.n32 1.73893
R423 VSS.n209 VSS.n33 1.73893
R424 VSS.n209 VSS.n34 1.73893
R425 VSS.n209 VSS.n36 1.73893
R426 VSS.n209 VSS.n37 1.73893
R427 VSS.n209 VSS.n39 1.73893
R428 VSS.n209 VSS.n40 1.73893
R429 VSS.n209 VSS.n42 1.73893
R430 VSS.n209 VSS.n43 1.73893
R431 VSS.n209 VSS.n44 1.73893
R432 VSS.n209 VSS.n45 1.73893
R433 VSS.n209 VSS.n47 1.73893
R434 VSS.n209 VSS.n49 1.73893
R435 VSS.n209 VSS.n50 1.73893
R436 VSS.n209 VSS.n51 1.73893
R437 VSS.n209 VSS.n52 1.73893
R438 VSS.n209 VSS.n54 1.73893
R439 VSS.n126 VSS.t16 1.44593
R440 VSS.n199 VSS.n130 1.44593
R441 VSS.n91 VSS.t25 1.44593
R442 VSS.n206 VSS.n19 0.571013
R443 VSS.n209 VSS.n55 0.570672
R444 VSS.n209 VSS.n19 0.5705
R445 VSS.n206 VSS.n55 0.57016
R446 VSS.n10 VSS.n17 0.700468
R447 VSS.n16 VSS.n15 0.0605836
R448 VSS.n218 VSS.n217 0.243424
R449 VSS.n145 VSS.n143 0.243424
R450 VSS.n132 VSS.n18 0.242716
R451 VSS.n220 VSS.n219 0.242681
R452 VSS.n214 VSS.n213 0.24245
R453 VSS.n107 VSS.n96 0.24245
R454 VSS.n216 VSS.n215 0.240796
R455 VSS.n144 VSS.n108 0.240796
R456 VSS.n212 VSS.n211 0.239822
R457 VSS.n205 VSS.n203 0.239822
R458 VSS.n213 VSS.n212 0.227974
R459 VSS.n203 VSS.n96 0.227974
R460 VSS.n217 VSS.n216 0.227001
R461 VSS.n145 VSS.n144 0.227001
R462 VSS.n190 VSS.n14 0.226786
R463 VSS.n211 VSS.n210 0.225646
R464 VSS.n205 VSS.n204 0.225646
R465 VSS.n215 VSS.n214 0.224672
R466 VSS.n108 VSS.n107 0.224672
R467 VSS.n219 VSS.n218 0.223727
R468 VSS.n143 VSS.n132 0.223715
R469 VSS.n206 VSS.n96 0.218846
R470 VSS.n206 VSS.n145 0.218846
R471 VSS.n213 VSS.n209 0.218846
R472 VSS.n217 VSS.n209 0.218846
R473 VSS.n182 VSS.n181 0.21526
R474 VSS.n190 VSS.n10 0.450196
R475 VSS.n206 VSS.n205 0.208386
R476 VSS.n206 VSS.n108 0.208386
R477 VSS.n211 VSS.n209 0.208386
R478 VSS.n215 VSS.n209 0.208386
R479 VSS.n206 VSS.n132 0.208371
R480 VSS.n219 VSS.n209 0.20836
R481 VSS.n173 VSS.n16 0.197741
R482 VSS.n174 VSS.n173 0.197741
R483 VSS.n175 VSS.n174 0.197741
R484 VSS.n176 VSS.n13 0.173833
R485 VSS.n177 VSS.n176 0.173833
R486 VSS.n178 VSS.n177 0.173833
R487 VSS.n179 VSS.n178 0.173833
R488 VSS.n180 VSS.n179 0.173833
R489 VSS.n181 VSS.n180 0.173833
R490 VSS.n189 VSS.n176 0.117414
R491 VSS.n188 VSS.n177 0.117414
R492 VSS.n187 VSS.n178 0.117414
R493 VSS.n186 VSS.n179 0.117414
R494 VSS.n185 VSS.n180 0.117414
R495 VSS.n184 VSS.n181 0.117414
R496 VSS.n15 VSS.n14 14.3176
R497 VSS.n173 VSS.n172 0.112386
R498 VSS.n174 VSS.n171 0.112386
R499 VSS.n175 VSS.n170 0.112386
R500 VSS.n175 VSS.n12 0.257009
R501 VSS.n11 VSS.n12 0.0268464
R502 VSS.n197 VSS.n2 0.0927224
R503 VSS.n198 VSS.n197 0.0891245
R504 VSS.n183 VSS.n182 0.088983
R505 VSS.n185 VSS.n184 0.0885
R506 VSS.n186 VSS.n185 0.0885
R507 VSS.n187 VSS.n186 0.0885
R508 VSS.n188 VSS.n187 0.0885
R509 VSS.n189 VSS.n188 0.0885
R510 VSS.n171 VSS.n170 0.0885
R511 VSS.n172 VSS.n171 0.0885
R512 VSS.n169 VSS.n168 0.0814472
R513 VSS.n195 VSS.n194 0.0794206
R514 VSS.n196 VSS.n167 0.0784641
R515 VSS.n193 VSS.n192 0.0776211
R516 VSS.n5 VSS.n198 0.145414
R517 VSS.n192 VSS.n191 0.0750054
R518 VSS.n195 VSS.n193 0.0725235
R519 VSS.n1 VSS.n196 0.160494
R520 VSS.n194 VSS.n169 0.0711793
R521 VSS.n168 VSS.n167 0.0686974
R522 VSS.n184 VSS.n183 0.0489
R523 VSS.t6 VSS.n6 18.7742
R524 VSS VSS.n17 0.409071
R525 VSS.n0 VSS.n2 0.125228
R526 VSS.n9 VSS.n189 0.118565
R527 VSS.n9 VSS.n13 0.0590729
R528 VSS.n172 VSS.n15 0.115446
R529 VSS.n170 VSS.n11 0.1149
R530 VSS.n3 VSS.n6 0.102266
R531 a_3900_n11978.n0 a_3900_n11978.t4 53.6901
R532 a_3900_n11978.n3 a_3900_n11978.t0 29.2688
R533 a_3900_n11978.n2 a_3900_n11978.t5 24.2693
R534 a_3900_n11978.n1 a_3900_n11978.t2 24.2693
R535 a_3900_n11978.t1 a_3900_n11978.n3 15.6064
R536 a_3900_n11978.n0 a_3900_n11978.t3 9.21754
R537 a_3900_n11978.n3 a_3900_n11978.n2 1.7693
R538 a_3900_n11978.n2 a_3900_n11978.n1 0.543167
R539 a_3900_n11978.n1 a_3900_n11978.n0 0.320233
R540 a_4400_n11058.n0 a_4400_n11058.t2 27.72
R541 a_4400_n11058.n0 a_4400_n11058.t0 24.1197
R542 a_4400_n11058.t1 a_4400_n11058.n0 9.38813
R543 a_4400_n9272.n0 a_4400_n9272.t2 55.3005
R544 a_4400_n9272.n0 a_4400_n9272.t1 27.8842
R545 a_4400_n9272.t0 a_4400_n9272.n0 7.50485
R546 a_3900_n9272.n0 a_3900_n9272.t0 34.3045
R547 a_3900_n9272.t1 a_3900_n9272.n0 5.85564
R548 a_3900_n9272.t1 a_3900_n9272.n0 5.85498
R549 a_5408_n8844.n2 a_5408_n8844.t1 19.9393
R550 a_5408_n8844.n0 a_5408_n8844.t4 19.6783
R551 a_5408_n8844.n1 a_5408_n8844.t0 17.974
R552 a_5408_n8844.n2 a_5408_n8844.n1 5.04317
R553 a_5408_n8844.n0 a_5408_n8844.t3 4.81727
R554 a_5408_n8844.n1 a_5408_n8844.n0 4.76157
R555 a_5408_n8844.t2 a_5408_n8844.n2 3.15445
R556 a_4788_n10564.n0 a_4788_n10564.t2 30.2902
R557 a_4788_n10564.n0 a_4788_n10564.t0 27.2706
R558 a_4788_n10564.t1 a_4788_n10564.n0 11.5346
C0 en_b vbg_buf 0.25526f
C1 vbg_buf a_4400_n10972# 0.03933f
C2 a_400_n13910# vbg_buf 0.03483f
C3 a_0_n13610# vbg_buf 0.04813f
C4 vbn_buf di_en 0.14079f
C5 VDD vbg_buf 3.90953f
C6 vbn_buf en_b 0.46819f
C7 a_3900_n11892# a_4400_n10972# 0.09924f
C8 a_0_n13610# vbn_buf 0.02902f
C9 vbn_buf VDD 0.6955f
C10 en_b di_en 0.62558f
C11 vbn_buf vbg_buf 10.0344f
C12 en_b a_4400_n10972# 0.05029f
C13 a_3900_n11892# vbg_buf 0.27763f
C14 VDD di_en 0.54367f
C15 VDD en_b 0.98252f
C16 VDD a_4400_n10972# 0.03954f
C17 a_0_n13610# a_400_n13910# 0.60592f
C18 vbg_buf di_en 4.16619f
C19 di_en VSS 3.8453f
C20 en_b VSS 1.90698f
C21 vbg_buf VSS 0.73507p
C22 vbn_buf VSS 0.10817p
C23 VDD VSS 1.72247f
C24 a_4788_n10564.t0 VSS 0.18835f
C25 a_4788_n10564.n0 VSS 2.20174f
C26 a_4788_n10564.t1 VSS 0.33495f
C27 a_5408_n8844.t0 VSS 0.60609f
C28 a_5408_n8844.t3 VSS 0.60603f
C29 a_5408_n8844.n0 VSS 0.71199f
C30 a_5408_n8844.n1 VSS 1.06753f
C31 a_5408_n8844.n2 VSS 0.71251f
C32 a_5408_n8844.t2 VSS 1.14037f
C33 a_3900_n9272.t0 VSS 1.46499f
C34 a_3900_n9272.n0 VSS 1.75426f
C35 a_3900_n9272.t1 VSS 0.45606f
C36 a_4400_n9272.t2 VSS 2.60714f
C37 a_4400_n9272.t1 VSS 0.76776f
C38 a_4400_n9272.n0 VSS 3.57099f
C39 a_4400_n9272.t0 VSS 1.33776f
C40 a_4400_n11058.t2 VSS 0.7582f
C41 a_4400_n11058.n0 VSS 1.17868f
C42 a_4400_n11058.t1 VSS 0.60336f
C43 a_3900_n11978.t4 VSS 2.72609f
C44 a_3900_n11978.t3 VSS 0.72141f
C45 a_3900_n11978.n0 VSS 1.83166f
C46 a_3900_n11978.n1 VSS 0.31693f
C47 a_3900_n11978.n2 VSS 0.51114f
C48 a_3900_n11978.t0 VSS 1.23678f
C49 a_3900_n11978.n3 VSS 1.70837f
C50 a_3900_n11978.t1 VSS 0.3033f
C51 VSS.t61 VSS 2.91645f
C52 VSS.t47 VSS 2.92057f
C53 VSS.t49 VSS 2.92057f
C54 VSS.t59 VSS 2.91645f
C55 VSS.t13 VSS 0.13963f
C56 VSS.t9 VSS 0.07794f
C57 VSS.t3 VSS 0.11389f
C58 VSS.t11 VSS 0.08979f
C59 VSS.t15 VSS 0.21302f
C60 VSS.t5 VSS 0.25354f
C61 VSS.t7 VSS 0.25354f
C62 VSS.t20 VSS 3.2295f
C63 VSS.t30 VSS 3.22498f
C64 VSS.t22 VSS 3.2295f
C65 VSS.t32 VSS 3.22498f
C66 VDD.n0 VSS 0.35883f
C67 VDD.n2 VSS 0.15644f
C68 VDD.n3 VSS 0.39682f
C69 VDD.n4 VSS 0.07013f
C70 VDD.n5 VSS 0.11479f
C71 VDD.n6 VSS 0.09317f
C72 VDD.n7 VSS 0.47641f
C73 VDD.n8 VSS 0.1436f
C74 VDD.n9 VSS 0.09617f
C75 VDD.t6 VSS 0.11571f
C76 VDD.t4 VSS 0.11406f
C77 VDD.t3 VSS 0.28686f
C78 VDD.t2 VSS 0.56434f
C79 VDD.t14 VSS 0.21881f
C80 VDD.t15 VSS 0.21374f
C81 VDD.t1 VSS 0.5624f
C82 VDD.t11 VSS 0.21374f
C83 VDD.t12 VSS 0.21374f
C84 VDD.t5 VSS 0.21482f
C85 VDD.t8 VSS 0.02986f
C86 VDD.t9 VSS 0.02986f
C87 VDD.t0 VSS 6.38813f
C88 VDD.n10 VSS 0.52394f
C89 vbn_buf.n0 VSS 0.12146f
C90 vbn_buf.t1 VSS 2.21675f
C91 vbn_buf.n1 VSS 0.17471f
C92 vbn_buf.t0 VSS 0.15753f
C93 vbn_buf.n2 VSS 0.1186f
C94 vbg_buf.n0 VSS 0.03534f
C95 vbg_buf.n2 VSS 0.03f
C96 vbg_buf.n3 VSS 0.01018f
C97 vbg_buf.n4 VSS 0.03f
C98 vbg_buf.n6 VSS 0.02858f
C99 vbg_buf.n7 VSS 1.49402f
C100 vbg_buf.n8 VSS 3.73841f
C101 vbg_buf.n9 VSS 0.1605f
C102 vbg_buf.n10 VSS 0.03122f
C103 vbg_buf.n11 VSS 0.08816f
C104 vbg_buf.t0 VSS 1.99175f
C105 vbg_buf.n12 VSS 0.11564f
C106 vbg_buf.n13 VSS 0.03824f
C107 vbg_buf.n14 VSS 0.8811f
C108 en_b.n0 VSS 1.64963f
C109 en_b.n1 VSS 1.3155f
C110 en_b.t0 VSS 0.32897f
C111 en_b.t1 VSS 0.20661f
C112 en_b.n2 VSS 0.4478f
C113 en_b.n3 VSS 0.66668f
C114 en_b.n4 VSS 1.06138f
C115 di_en.n0 VSS 3.0544f
.ends
