* Capacitances rebuilt per net pair from the C-coupled extraction vco_top_leads_CC.spice (magic#557):
* 4.1057 pF in 116 net pairs, the full-RC run had 4.1574 pF, 0.0 fF of it between pairs without coupling.
* NGSPICE file created from vco_top_leads.ext - technology: ihp-sg13cmos5l

.subckt vco_top_leads ibias_100u di_en vtune VDD vdd_core VSS rf_out_p rf_out_n
+ vco_ind_LA vco_ind_LB vco_ind_LC vco_var_rf_p vco_var_rf_n vco_var_VSS
X0 a_11798_1860.t11 vco_bias_0.vbn_buf.t2 VSS.t71 VSS.t72 sg13_lv_nmos ad=0.95p pd=5.38u as=0.95p ps=5.38u w=5u l=0.5u
X1 rf_out_n.t5 momf3_B.t1 a_11798_1860.t20 VSS.t144 sg13_lv_nmos ad=0.38p pd=2.38u as=0.38p ps=2.38u w=2u l=0.13u
X2 VSS.t130 vco_ind_LA.t5 vco_ind_LB.t1 VSS.t129 sg13_lv_nmos ad=0.38p pd=2.38u as=0.38p ps=2.38u w=2u l=0.13u
X3 rf_out_n.t1 momf3_B.t1 a_11798_1860.t18 VSS.t140 sg13_lv_nmos ad=0.38p pd=2.38u as=0.38p ps=2.38u w=2u l=0.13u
X4 VSS.t18 vco_bias_0.vbg_buf VSS.t17 VSS.t6 sg13_lv_nmos ad=2.72p pd=16.68u as=0 ps=0 w=8u l=10u
X5 VSS.t111 vco_ind_LB.t5 vco_ind_LA.t4 VSS.t110 sg13_lv_nmos ad=0.38p pd=2.38u as=0.38p ps=2.38u w=2u l=0.13u
X6 a_11798_1860.t12 vco_bias_0.vbn_buf.t2 VSS.t74 VSS.t75 sg13_lv_nmos ad=0.95p pd=5.38u as=0.95p ps=5.38u w=5u l=0.5u
X7 VSS.t37 vco_bias_0.vbn_buf.t3 VSS.t35 VSS.t15 sg13_lv_nmos ad=1.52p pd=8.38u as=0 ps=0 w=8u l=10u
X8 a_11798_1860.t23 momf4_A.t1 rf_out_p.t0 VSS.t147 sg13_lv_nmos ad=0.38p pd=2.38u as=0.38p ps=2.38u w=2u l=0.13u
X9 a_11798_1860.t1 vco_bias_0.vbn_buf.t2 VSS.t45 VSS.t48 sg13_lv_nmos ad=0.95p pd=5.38u as=0.95p ps=5.38u w=5u l=0.5u
X10 VSS.t55 vco_bias_0.vbn_buf.t2 a_11798_1860.t4 VSS.t54 sg13_lv_nmos ad=0.95p pd=5.38u as=0.95p ps=5.38u w=5u l=0.5u
X11 a_11798_1860.t2 vco_bias_0.vbn_buf.t2 VSS.t47 VSS.t46 sg13_lv_nmos ad=0.95p pd=5.38u as=0.95p ps=5.38u w=5u l=0.5u
X12 vco_ind_LA.t1 vco_ind_LB.t5 VSS.t105 VSS.t106 sg13_lv_nmos ad=0.38p pd=2.38u as=0.38p ps=2.38u w=2u l=0.13u
X13 VSS.t58 vco_bias_0.vbn_buf.t2 a_11798_1860.t5 VSS.t59 sg13_lv_nmos ad=0.95p pd=5.38u as=0.95p ps=5.38u w=5u l=0.5u
X14 vco_ind_LA.t2 vco_ind_LB.t5 VSS.t100 VSS.t99 sg13_lv_nmos ad=0.38p pd=2.38u as=0.68p ps=4.68u w=2u l=0.13u
X15 a_11798_1860.t9 vco_bias_0.vbn_buf.t2 VSS.t39 VSS.t68 sg13_lv_nmos ad=0.95p pd=5.38u as=0.95p ps=5.38u w=5u l=0.5u
X16 VSS.t124 vco_ind_LA.t5 vco_ind_LB.t3 VSS.t123 sg13_lv_nmos ad=0.38p pd=2.38u as=0.38p ps=2.38u w=2u l=0.13u
X17 a_11798_1860.t26 momf4_A.t1 rf_out_p.t4 VSS.t153 sg13_lv_nmos ad=0.38p pd=2.38u as=0.38p ps=2.38u w=2u l=0.13u
X18 rf_out_p.t2 momf4_A.t1 a_11798_1860.t24 VSS.t150 sg13_lv_nmos ad=0.38p pd=2.38u as=0.38p ps=2.38u w=2u l=0.13u
X19 ibias_100u.t3 ibias_100u.t2 VSS.t158 VSS.t0 sg13_lv_nmos ad=0.85p pd=5.68u as=0.85p ps=5.68u w=2.5u l=0.5u
X20 vco_bias_0.vbn_buf.t0 a_1254_3500.t2 VSS.t27 VSS.t2 sg13_lv_nmos ad=0.34p pd=2.68u as=0.34p ps=2.68u w=1u l=0.13u
X21 VSS.t102 vco_ind_LB.t5 vco_ind_LA.t2 VSS.t101 sg13_lv_nmos ad=0.38p pd=2.38u as=0.38p ps=2.38u w=2u l=0.13u
X22 a_11798_1860.t16 momf3_B.t1 rf_out_n.t0 VSS.t135 sg13_lv_nmos ad=0.38p pd=2.38u as=0.38p ps=2.38u w=2u l=0.13u
X23 VSS.t20 vco_bias_0.vbg_buf VSS.t18 VSS.t9 sg13_lv_nmos ad=1.52p pd=8.38u as=0 ps=0 w=8u l=10u
X24 VSS.t51 vco_bias_0.vbn_buf.t2 a_11798_1860.t2 VSS.t50 sg13_lv_nmos ad=0.95p pd=5.38u as=0.95p ps=5.38u w=5u l=0.5u
X25 a_11798_1860.t21 momf3_B.t1 rf_out_n.t5 VSS.t145 sg13_lv_nmos ad=0.68p pd=4.68u as=0.38p ps=2.38u w=2u l=0.13u
X26 a_1474_1770.t1 a_5428_3064.t0 VSS.t94 rppd l=8.5u w=0.5u
X27 VSS.t39 vco_bias_0.vbn_buf.t2 a_11798_1860.t8 VSS.t38 sg13_lv_nmos ad=0.95p pd=5.38u as=0.95p ps=5.38u w=5u l=0.5u
X28 a_11798_1860.t6 vco_bias_0.vbn_buf.t2 VSS.t58 VSS.t57 sg13_lv_nmos ad=0.95p pd=5.38u as=0.95p ps=5.38u w=5u l=0.5u
X29 a_11798_1860.t19 momf3_B.t1 rf_out_n.t1 VSS.t141 sg13_lv_nmos ad=0.38p pd=2.38u as=0.38p ps=2.38u w=2u l=0.13u
X30 a_11798_1860.t17 momf3_B.t1 rf_out_n.t3 VSS.t137 sg13_lv_nmos ad=0.38p pd=2.38u as=0.38p ps=2.38u w=2u l=0.13u
X31 vco_bias_0.vbg_buf momf4_A.t0 VSS.t95 rhigh l=8u w=0.5u
X32 vco_ind_LB.t2 vco_ind_LA.t5 VSS.t130 VSS.t131 sg13_lv_nmos ad=0.38p pd=2.38u as=0.38p ps=2.38u w=2u l=0.13u
X33 VSS.t87 vco_bias_0.vbn_buf.t4 VSS.t85 VSS.t9 sg13_lv_nmos ad=1.52p pd=8.38u as=0 ps=0 w=8u l=10u
X34 VSS.t91 vco_bias_0.vbn_buf.t4 VSS.t89 VSS.t13 sg13_lv_nmos ad=1.52p pd=8.38u as=0 ps=0 w=8u l=10u
X35 vco_ind_LA.t3 vco_ind_LB.t5 VSS.t111 VSS.t112 sg13_lv_nmos ad=0.38p pd=2.38u as=0.38p ps=2.38u w=2u l=0.13u
X36 rf_out_p.t1 momf4_A.t1 a_11798_1860.t23 VSS.t148 sg13_lv_nmos ad=0.38p pd=2.38u as=0.38p ps=2.38u w=2u l=0.13u
X37 a_1254_3500.t1 di_en.t0 VSS.t117 VSS.t4 sg13_lv_nmos ad=0.17p pd=1.68u as=0.17p ps=1.68u w=0.5u l=0.13u
X38 VSS.t14 vco_bias_0.vbg_buf VSS.t12 VSS.t13 sg13_lv_nmos ad=1.52p pd=8.38u as=0 ps=0 w=8u l=10u
X39 a_11798_1860.t3 vco_bias_0.vbn_buf.t2 VSS.t51 VSS.t52 sg13_lv_nmos ad=0.95p pd=5.38u as=0.95p ps=5.38u w=5u l=0.5u
X40 VSS.t61 vco_bias_0.vbn_buf.t2 a_11798_1860.t6 VSS.t60 sg13_lv_nmos ad=0.95p pd=5.38u as=0.95p ps=5.38u w=5u l=0.5u
X41 a_11798_1860.t28 momf4_A.t1 rf_out_p.t3 VSS.t157 sg13_lv_nmos ad=0.68p pd=4.68u as=0.38p ps=2.38u w=2u l=0.13u
X42 rf_out_p.t5 momf4_A.t1 a_11798_1860.t26 VSS.t154 sg13_lv_nmos ad=0.38p pd=2.38u as=0.38p ps=2.38u w=2u l=0.13u
X43 a_11798_1860.t25 momf4_A.t1 rf_out_p.t2 VSS.t151 sg13_lv_nmos ad=0.38p pd=2.38u as=0.38p ps=2.38u w=2u l=0.13u
X44 VSS.t108 vco_ind_LB.t5 vco_ind_LA.t1 VSS.t107 sg13_lv_nmos ad=0.38p pd=2.38u as=0.38p ps=2.38u w=2u l=0.13u
X45 VSS.t12 vco_bias_0.vbg_buf VSS.t10 VSS.t11 sg13_lv_nmos ad=1.52p pd=8.38u as=0 ps=0 w=8u l=10u
X46 rf_out_n.t3 momf3_B.t1 a_11798_1860.t16 VSS.t136 sg13_lv_nmos ad=0.38p pd=2.38u as=0.38p ps=2.38u w=2u l=0.13u
X47 vco_ind_LB.t4 vco_ind_LA.t5 VSS.t124 VSS.t125 sg13_lv_nmos ad=0.38p pd=2.38u as=0.38p ps=2.38u w=2u l=0.13u
X48 vco_ind_LB.t0 vco_ind_LA.t5 VSS.t119 VSS.t118 sg13_lv_nmos ad=0.38p pd=2.38u as=0.68p ps=4.68u w=2u l=0.13u
X49 a_1474_1770.t0 a_2654_5520.t4 VDD.t3 VDD.t2 sg13_lv_pmos ad=1.7p pd=10.68u as=1.7p ps=10.68u w=5u l=0.5u
X50 VSS.t77 vco_bias_0.vbn_buf.t2 a_11798_1860.t12 VSS.t76 sg13_lv_nmos ad=0.95p pd=5.38u as=0.95p ps=5.38u w=5u l=0.5u
X51 a_11798_1860.t10 vco_bias_0.vbn_buf.t2 VSS.t67 VSS.t66 sg13_lv_nmos ad=0.95p pd=5.38u as=0.95p ps=5.38u w=5u l=0.5u
X52 a_11798_1860.t0 vco_bias_0.vbn_buf.t2 VSS.t43 VSS.t42 sg13_lv_nmos ad=0.95p pd=5.38u as=1.7p ps=10.68u w=5u l=0.5u
X53 vco_ind_LA.t0 vco_ind_LB.t5 VSS.t102 VSS.t103 sg13_lv_nmos ad=0.38p pd=2.38u as=0.38p ps=2.38u w=2u l=0.13u
X54 VDD.t8 rf_out_n.t6 VSS.t97 rppd l=1.65u w=10u
X55 VSS.t31 vco_bias_0.vbn_buf.t3 VSS.t29 VSS.t9 sg13_lv_nmos ad=1.52p pd=8.38u as=0 ps=0 w=8u l=10u
X56 VSS.t121 vco_ind_LA.t5 vco_ind_LB.t0 VSS.t120 sg13_lv_nmos ad=0.38p pd=2.38u as=0.38p ps=2.38u w=2u l=0.13u
X57 VSS.t41 vco_bias_0.vbn_buf.t2 a_11798_1860.t3 VSS.t40 sg13_lv_nmos ad=0.95p pd=5.38u as=0.95p ps=5.38u w=5u l=0.5u
X58 VSS.t35 vco_bias_0.vbn_buf.t3 VSS.t33 VSS.t13 sg13_lv_nmos ad=1.52p pd=8.38u as=0 ps=0 w=8u l=10u
X59 rf_out_n.t2 momf3_B.t1 a_11798_1860.t19 VSS.t142 sg13_lv_nmos ad=0.38p pd=2.38u as=0.38p ps=2.38u w=2u l=0.13u
X60 rf_out_n.t4 momf3_B.t1 a_11798_1860.t17 VSS.t138 sg13_lv_nmos ad=0.38p pd=2.38u as=0.38p ps=2.38u w=2u l=0.13u
X61 VSS.t89 vco_bias_0.vbn_buf.t4 VSS.t87 VSS.t11 sg13_lv_nmos ad=1.52p pd=8.38u as=0 ps=0 w=8u l=10u
X62 VSS.t16 vco_bias_0.vbg_buf VSS.t14 VSS.t15 sg13_lv_nmos ad=1.52p pd=8.38u as=0 ps=0 w=8u l=10u
X63 a_11798_1860.t24 momf4_A.t1 rf_out_p.t1 VSS.t149 sg13_lv_nmos ad=0.38p pd=2.38u as=0.38p ps=2.38u w=2u l=0.13u
X64 rf_out_p.t0 momf4_A.t1 a_11798_1860.t22 VSS.t146 sg13_lv_nmos ad=0.38p pd=2.38u as=0.68p ps=4.68u w=2u l=0.13u
X65 ibias_100u.t0 a_1254_3500.t3 VSS.t3 VSS.t2 sg13_lv_nmos ad=0.34p pd=2.68u as=0.34p ps=2.68u w=1u l=0.13u
X66 VSS.t24 vco_bias_0.vbg_buf VSS.t22 VSS.t13 sg13_lv_nmos ad=1.52p pd=8.38u as=0 ps=0 w=8u l=10u
X67 VSS.t67 vco_bias_0.vbn_buf.t2 a_11798_1860.t9 VSS.t69 sg13_lv_nmos ad=0.95p pd=5.38u as=0.95p ps=5.38u w=5u l=0.5u
X68 VSS.t45 vco_bias_0.vbn_buf.t2 a_11798_1860.t0 VSS.t44 sg13_lv_nmos ad=0.95p pd=5.38u as=0.95p ps=5.38u w=5u l=0.5u
X69 a_11798_1860.t13 vco_bias_0.vbn_buf.t2 VSS.t77 VSS.t78 sg13_lv_nmos ad=0.95p pd=5.38u as=0.95p ps=5.38u w=5u l=0.5u
X70 a_2654_5520.t2 a_1954_3500.t2 VDD.t1 VDD.t0 sg13_lv_pmos ad=0.34p pd=2.68u as=0.34p ps=2.68u w=1u l=0.13u
X71 a_11798_1860.t14 vco_bias_0.vbn_buf.t2 VSS.t80 VSS.t81 sg13_lv_nmos ad=0.95p pd=5.38u as=0.95p ps=5.38u w=5u l=0.5u
X72 VSS.t133 vco_ind_LA.t5 vco_ind_LB.t2 VSS.t132 sg13_lv_nmos ad=0.68p pd=4.68u as=0.38p ps=2.38u w=2u l=0.13u
X73 VSS.t114 vco_ind_LB.t5 vco_ind_LA.t3 VSS.t113 sg13_lv_nmos ad=0.68p pd=4.68u as=0.38p ps=2.38u w=2u l=0.13u
X74 a_1954_3500.t0 a_1254_3500.t4 VSS.t5 VSS.t4 sg13_lv_nmos ad=0.17p pd=1.68u as=0.17p ps=1.68u w=0.5u l=0.13u
X75 a_11798_1860.t27 momf4_A.t1 rf_out_p.t5 VSS.t155 sg13_lv_nmos ad=0.38p pd=2.38u as=0.38p ps=2.38u w=2u l=0.13u
X76 vco_bias_0.vbg_buf momf3_B.t0 VSS.t96 rhigh l=8u w=0.5u
X77 VSS.t22 vco_bias_0.vbg_buf VSS.t20 VSS.t11 sg13_lv_nmos ad=1.52p pd=8.38u as=0 ps=0 w=8u l=10u
X78 a_1254_3500.t0 di_en.t1 VDD.t11 VDD.t10 sg13_lv_pmos ad=0.34p pd=2.68u as=0.34p ps=2.68u w=1u l=0.13u
X79 VSS.t33 vco_bias_0.vbn_buf.t3 VSS.t31 VSS.t11 sg13_lv_nmos ad=1.52p pd=8.38u as=0 ps=0 w=8u l=10u
X80 a_11798_1860.t4 vco_bias_0.vbn_buf.t2 VSS.t41 VSS.t53 sg13_lv_nmos ad=0.95p pd=5.38u as=0.95p ps=5.38u w=5u l=0.5u
X81 a_1474_1770.t2 vco_bias_0.vbg_buf VSS.t115 rhigh l=32u w=0.5u
X82 a_5428_3064.t2 a_5428_3064.t1 VSS.t1 VSS.t0 sg13_lv_nmos ad=0.85p pd=5.68u as=0.85p ps=5.68u w=2.5u l=0.5u
X83 VSS.t63 vco_bias_0.vbn_buf.t2 a_11798_1860.t7 VSS.t65 sg13_lv_nmos ad=0.95p pd=5.38u as=0.95p ps=5.38u w=5u l=0.5u
X84 VSS.t127 vco_ind_LA.t5 vco_ind_LB.t4 VSS.t126 sg13_lv_nmos ad=0.38p pd=2.38u as=0.38p ps=2.38u w=2u l=0.13u
X85 VSS.t80 vco_bias_0.vbn_buf.t2 a_11798_1860.t13 VSS.t79 sg13_lv_nmos ad=0.95p pd=5.38u as=0.95p ps=5.38u w=5u l=0.5u
X86 a_11798_1860.t20 momf3_B.t1 rf_out_n.t2 VSS.t143 sg13_lv_nmos ad=0.38p pd=2.38u as=0.38p ps=2.38u w=2u l=0.13u
X87 a_11798_1860.t18 momf3_B.t1 rf_out_n.t4 VSS.t139 sg13_lv_nmos ad=0.38p pd=2.38u as=0.38p ps=2.38u w=2u l=0.13u
X88 VSS.t83 vco_bias_0.vbn_buf.t2 a_11798_1860.t14 VSS.t82 sg13_lv_nmos ad=1.7p pd=10.68u as=0.95p ps=5.38u w=5u l=0.5u
X89 VSS.t85 vco_bias_0.vbn_buf.t4 VSS.t84 VSS.t6 sg13_lv_nmos ad=2.72p pd=16.68u as=0 ps=0 w=8u l=10u
X90 VSS.t8 vco_bias_0.vbg_buf VSS.t7 VSS.t6 sg13_lv_nmos ad=2.72p pd=16.68u as=0 ps=0 w=8u l=10u
X91 a_2654_5520.t3 ibias_100u.t4 VSS.t159 VSS.t0 sg13_lv_nmos ad=0.85p pd=5.68u as=0.85p ps=5.68u w=2.5u l=0.5u
X92 VSS.t26 vco_bias_0.vbg_buf VSS.t24 VSS.t15 sg13_lv_nmos ad=1.52p pd=8.38u as=0 ps=0 w=8u l=10u
X93 VSS.t105 vco_ind_LB.t5 vco_ind_LA.t0 VSS.t104 sg13_lv_nmos ad=0.38p pd=2.38u as=0.38p ps=2.38u w=2u l=0.13u
X94 ibias_100u.t1 vco_bias_0.vbn_buf.t1 VSS.t116 rhigh l=32u w=0.5u
X95 vco_ind_LB.t1 vco_ind_LA.t5 VSS.t127 VSS.t128 sg13_lv_nmos ad=0.38p pd=2.38u as=0.38p ps=2.38u w=2u l=0.13u
X96 vco_ind_LA.t4 vco_ind_LB.t5 VSS.t108 VSS.t109 sg13_lv_nmos ad=0.38p pd=2.38u as=0.38p ps=2.38u w=2u l=0.13u
X97 vco_ind_LB.t3 vco_ind_LA.t5 VSS.t121 VSS.t122 sg13_lv_nmos ad=0.38p pd=2.38u as=0.38p ps=2.38u w=2u l=0.13u
X98 a_11798_1860.t7 vco_bias_0.vbn_buf.t2 VSS.t61 VSS.t64 sg13_lv_nmos ad=0.95p pd=5.38u as=0.95p ps=5.38u w=5u l=0.5u
X99 VSS.t93 vco_bias_0.vbn_buf.t4 VSS.t91 VSS.t15 sg13_lv_nmos ad=1.52p pd=8.38u as=0 ps=0 w=8u l=10u
X100 VSS.t71 vco_bias_0.vbn_buf.t2 a_11798_1860.t10 VSS.t70 sg13_lv_nmos ad=0.95p pd=5.38u as=0.95p ps=5.38u w=5u l=0.5u
X101 a_11798_1860.t8 vco_bias_0.vbn_buf.t2 VSS.t63 VSS.t62 sg13_lv_nmos ad=0.95p pd=5.38u as=0.95p ps=5.38u w=5u l=0.5u
X102 VSS.t74 vco_bias_0.vbn_buf.t2 a_11798_1860.t11 VSS.t73 sg13_lv_nmos ad=0.95p pd=5.38u as=0.95p ps=5.38u w=5u l=0.5u
X103 rf_out_p.t3 momf4_A.t1 a_11798_1860.t27 VSS.t156 sg13_lv_nmos ad=0.38p pd=2.38u as=0.38p ps=2.38u w=2u l=0.13u
X104 a_2654_5520.t1 a_2654_5520.t0 VDD.t5 VDD.t4 sg13_lv_pmos ad=1.7p pd=10.68u as=1.7p ps=10.68u w=5u l=0.5u
X105 rf_out_p.t4 momf4_A.t1 a_11798_1860.t25 VSS.t152 sg13_lv_nmos ad=0.38p pd=2.38u as=0.38p ps=2.38u w=2u l=0.13u
X106 rf_out_n.t0 momf3_B.t1 a_11798_1860.t15 VSS.t134 sg13_lv_nmos ad=0.38p pd=2.38u as=0.68p ps=4.68u w=2u l=0.13u
X107 VSS.t29 vco_bias_0.vbn_buf.t3 VSS.t28 VSS.t6 sg13_lv_nmos ad=2.72p pd=16.68u as=0 ps=0 w=8u l=10u
X108 VSS.t47 vco_bias_0.vbn_buf.t2 a_11798_1860.t1 VSS.t49 sg13_lv_nmos ad=0.95p pd=5.38u as=0.95p ps=5.38u w=5u l=0.5u
X109 VSS.t10 vco_bias_0.vbg_buf VSS.t8 VSS.t9 sg13_lv_nmos ad=1.52p pd=8.38u as=0 ps=0 w=8u l=10u
X110 a_11798_1860.t5 vco_bias_0.vbn_buf.t2 VSS.t55 VSS.t56 sg13_lv_nmos ad=0.95p pd=5.38u as=0.95p ps=5.38u w=5u l=0.5u
X111 VDD.t9 rf_out_p.t6 VSS.t98 rppd l=1.65u w=10u
X112 a_1954_3500.t1 a_1254_3500.t5 VDD.t7 VDD.t6 sg13_lv_pmos ad=0.34p pd=2.68u as=0.34p ps=2.68u w=1u l=0.13u
C0 momf4_A rf_out_p 1.07875e-15
C1 ibias_100u di_en 2.0785e-16
C2 vco_bias_0.vbg_buf vtune 7.423e-17
C3 momf3_B rf_out_n 1.07875e-15
C4 vco_bias_0.vbn_buf vtune 9.134e-17
C5 vco_bias_0.vbn_buf vco_bias_0.vbg_buf 7.0653e-15
C6 momf3_B a_10100_4160# 7.298e-17
C7 rf_out_p vtune 3.176e-17
C8 rf_out_n vtune 3.176e-17
C9 vco_bias_0.vbn_buf rf_out_p 1.8271e-16
C10 vco_bias_0.vbn_buf rf_out_n 2.1187e-16
C11 VDD a_1560_1770# 2.705e-17
C12 momf3_B a_9400_4966# 3.4e-17
C13 VDD ibias_100u 1.9675e-16
C14 vco_bias_0.vbg_buf di_en 6.389e-17
C15 vco_bias_0.vbn_buf a_10100_4160# 1.643e-17
C16 vco_ind_LB vtune 2.204e-17
C17 a_1160_2070# a_1560_1770# 6.0592e-16
C18 vco_bias_0.vbn_buf di_en 4.954e-17
C19 a_16500_4160# VDD 3.2132e-16
C20 rf_out_n rf_out_p 1.44e-17
C21 vco_ind_LB vco_ind_LC 1.26875e-15
C22 vco_bias_0.vbg_buf vco_ind_LB 3.9533e-16
C23 vco_bias_0.vbn_buf vco_ind_LB 2.155e-17
C24 a_1160_2070# ibias_100u 3.793e-17
C25 VDD momf4_A 1.00428e-15
C26 vco_bias_0.vbg_buf a_9400_4966# 5.066e-17
C27 VDD momf3_B 1.06356e-15
C28 rf_out_n a_10100_4160# 4.7919e-16
C29 vco_ind_LA vtune 1.0861e-16
C30 vco_ind_LA vco_ind_LC 6.395e-16
C31 vco_ind_LA vco_bias_0.vbg_buf 8.1068e-16
C32 vco_ind_LA vco_bias_0.vbn_buf 2.7125e-16
C33 a_16500_4160# momf4_A 7.298e-17
C34 VDD vtune 3.4199e-16
C35 VDD vco_ind_LC 1.62751e-15
C36 VDD vco_bias_0.vbg_buf 7.1134e-16
C37 vco_bias_0.vbg_buf a_1560_1770# 3.564e-17
C38 VDD vco_bias_0.vbn_buf 4.2369e-16
C39 momf3_B momf4_A 1.1754e-16
C40 vco_bias_0.vbn_buf a_1560_1770# 1.263e-17
C41 momf4_A a_19100_4966# 3.4e-17
C42 vco_bias_0.vbg_buf a_6760_4930# 1.207e-17
C43 vco_bias_0.vbn_buf a_6760_4930# 4.276e-17
C44 vco_bias_0.vbn_buf ibias_100u 4.24e-17
C45 a_1160_2070# vco_bias_0.vbn_buf 3.589e-17
C46 VDD rf_out_p 4.468e-16
C47 VDD rf_out_n 4.6067e-16
C48 momf4_A vtune 2.1291e-16
C49 momf3_B vtune 2.2031e-16
C50 vco_ind_LA vco_ind_LB 4.65762e-15
C51 vco_bias_0.vbg_buf momf4_A 2.417e-17
C52 vco_bias_0.vbg_buf momf3_B 2.417e-17
C53 vco_bias_0.vbn_buf momf4_A 5.196e-17
C54 vco_bias_0.vbn_buf momf3_B 6.463e-17
C55 vco_bias_0.vbg_buf a_19100_4966# 3.283e-17
C56 VDD a_10100_4160# 3.5416e-16
C57 a_16500_4160# rf_out_p 4.7919e-16
C58 VDD di_en 2.3778e-16
R0 vco_ind_LC.n102 vco_ind_LC.n46 6.52948
R1 vco_ind_LC.n70 vco_ind_LC.n50 6.52948
R2 vco_ind_LC.n43 vco_ind_LC.n116 6.47038
R3 vco_ind_LC.n48 vco_ind_LC.n129 6.47038
R4 vco_ind_LC.n40 vco_ind_LC.n4 6.09833
R5 vco_ind_LC.n39 vco_ind_LC.n2 6.04788
R6 vdd_core vco_ind_LC.n35 0.9603
R7 vco_ind_LC.n29 vco_ind_LC.n97 0.56175
R8 vco_ind_LC.n29 vco_ind_LC.n119 0.5505
R9 vco_ind_LC.n138 vco_ind_LC.n52 0.5505
R10 vco_ind_LC.n135 vco_ind_LC.n31 0.5505
R11 vco_ind_LC.n132 vco_ind_LC.n31 0.5505
R12 vco_ind_LC.n30 vco_ind_LC.n131 0.5505
R13 vco_ind_LC.n83 vco_ind_LC.n30 0.5505
R14 vco_ind_LC.n127 vco_ind_LC.n34 0.5505
R15 vco_ind_LC.n34 vco_ind_LC.n33 0.5505
R16 vco_ind_LC.n29 vco_ind_LC.n126 0.5505
R17 vco_ind_LC.n123 vco_ind_LC.n29 0.5505
R18 vco_ind_LC.n120 vco_ind_LC.n29 0.5505
R19 vco_ind_LC.n26 vco_ind_LC.n35 0.5505
R20 vco_ind_LC.n36 vco_ind_LC.n22 0.5505
R21 vco_ind_LC.n36 vco_ind_LC.n18 0.5505
R22 vco_ind_LC.n14 vco_ind_LC.n37 0.5505
R23 vco_ind_LC.n12 vco_ind_LC.n37 0.5505
R24 vco_ind_LC.n38 vco_ind_LC.n6 0.5505
R25 vco_ind_LC.n3 vco_ind_LC.n38 0.5505
R26 vco_ind_LC.n112 vco_ind_LC.n101 0.4405
R27 vco_ind_LC.n104 vco_ind_LC.n103 0.4405
R28 vco_ind_LC.n73 vco_ind_LC.n68 0.4405
R29 vco_ind_LC.n72 vco_ind_LC.n71 0.4405
R30 vco_ind_LC.n116 vco_ind_LC.n101 0.4405
R31 vco_ind_LC.n103 vco_ind_LC.n102 0.4405
R32 vco_ind_LC.n129 vco_ind_LC.n68 0.4405
R33 vco_ind_LC.n71 vco_ind_LC.n70 0.4405
R34 vco_ind_LC.n20 vco_ind_LC.n148 0.431732
R35 vco_ind_LC.n139 vco_ind_LC.n7 0.42017
R36 vco_ind_LC.n149 vco_ind_LC.n19 0.431732
R37 vco_ind_LC.n110 vco_ind_LC.n109 0.3635
R38 vco_ind_LC.n109 vco_ind_LC.n99 0.3635
R39 vco_ind_LC.n41 vco_ind_LC.n96 0.3635
R40 vco_ind_LC.n96 vco_ind_LC.n94 0.3635
R41 vco_ind_LC.n90 vco_ind_LC.n88 0.3635
R42 vco_ind_LC.n88 vco_ind_LC.n86 0.3635
R43 vco_ind_LC.n107 vco_ind_LC.n106 0.3635
R44 vco_ind_LC.n106 vco_ind_LC.n98 0.3635
R45 vco_ind_LC.n44 vco_ind_LC.n95 0.3635
R46 vco_ind_LC.n95 vco_ind_LC.n93 0.3635
R47 vco_ind_LC.n89 vco_ind_LC.n87 0.3635
R48 vco_ind_LC.n87 vco_ind_LC.n51 0.420937
R49 vco_ind_LC.n81 vco_ind_LC.n77 0.3635
R50 vco_ind_LC.n81 vco_ind_LC.n80 0.3635
R51 vco_ind_LC.n67 vco_ind_LC.n64 0.3635
R52 vco_ind_LC.n64 vco_ind_LC.n62 0.3635
R53 vco_ind_LC.n58 vco_ind_LC.n56 0.3635
R54 vco_ind_LC.n56 vco_ind_LC.n54 0.3635
R55 vco_ind_LC.n79 vco_ind_LC.n76 0.3635
R56 vco_ind_LC.n79 vco_ind_LC.n78 0.3635
R57 vco_ind_LC.n69 vco_ind_LC.n63 0.3635
R58 vco_ind_LC.n63 vco_ind_LC.n61 0.3635
R59 vco_ind_LC.n57 vco_ind_LC.n55 0.3635
R60 vco_ind_LC.n53 vco_ind_LC.n52 0.0306037
R61 vco_ind_LC.n54 vco_ind_LC.n52 0.351904
R62 vco_ind_LC.n86 vco_ind_LC.n32 0.345969
R63 vco_ind_LC.n29 vco_ind_LC 0.28325
R64 vco_ind_LC.n8 vco_ind_LC.n141 0.333117
R65 vco_ind_LC.n145 vco_ind_LC.n10 0.410055
R66 vco_ind_LC.n148 vco_ind_LC.n24 0.338353
R67 vco_ind_LC.n146 vco_ind_LC.n0 0.337223
R68 vco_ind_LC.n144 vco_ind_LC.n9 0.410055
R69 vco_ind_LC.n23 vco_ind_LC.n149 0.338353
R70 vco_ind_LC.n112 vco_ind_LC.n111 0.276188
R71 vco_ind_LC.n111 vco_ind_LC.n110 0.276188
R72 vco_ind_LC.n117 vco_ind_LC.n99 0.276188
R73 vco_ind_LC.n94 vco_ind_LC.n92 0.276188
R74 vco_ind_LC.n92 vco_ind_LC.n90 0.276188
R75 vco_ind_LC.n105 vco_ind_LC.n104 0.276188
R76 vco_ind_LC.n107 vco_ind_LC.n105 0.276188
R77 vco_ind_LC.n45 vco_ind_LC.n98 0.276188
R78 vco_ind_LC.n93 vco_ind_LC.n91 0.276188
R79 vco_ind_LC.n91 vco_ind_LC.n89 0.276188
R80 vco_ind_LC.n75 vco_ind_LC.n73 0.276188
R81 vco_ind_LC.n77 vco_ind_LC.n75 0.276188
R82 vco_ind_LC.n80 vco_ind_LC.n47 0.276188
R83 vco_ind_LC.n62 vco_ind_LC.n60 0.276188
R84 vco_ind_LC.n60 vco_ind_LC.n58 0.276188
R85 vco_ind_LC.n74 vco_ind_LC.n72 0.276188
R86 vco_ind_LC.n76 vco_ind_LC.n74 0.276188
R87 vco_ind_LC.n78 vco_ind_LC.n49 0.276188
R88 vco_ind_LC.n61 vco_ind_LC.n59 0.276188
R89 vco_ind_LC.n59 vco_ind_LC.n57 0.276188
R90 vco_ind_LC.n39 vco_ind_LC.n20 0.315799
R91 vco_ind_LC.n19 vco_ind_LC.n40 0.315799
R92 vco_ind_LC.n43 vco_ind_LC.n41 0.2645
R93 vco_ind_LC.n46 vco_ind_LC.n44 0.2645
R94 vco_ind_LC.n48 vco_ind_LC.n67 0.2645
R95 vco_ind_LC.n50 vco_ind_LC.n69 0.2645
R96 vco_ind_LC.n141 vco_ind_LC.n2 0.261353
R97 vco_ind_LC.n39 vco_ind_LC.n15 0.261353
R98 vco_ind_LC.n27 vco_ind_LC.n146 0.261353
R99 vco_ind_LC.n139 vco_ind_LC.n4 0.261353
R100 vco_ind_LC.n16 vco_ind_LC.n40 0.261353
R101 vco_ind_LC.n117 vco_ind_LC.n43 0.199188
R102 vco_ind_LC.n46 vco_ind_LC.n45 0.199188
R103 vco_ind_LC.n48 vco_ind_LC.n47 0.199188
R104 vco_ind_LC.n50 vco_ind_LC.n49 0.199188
R105 vco_ind_LC.n38 vco_ind_LC.n138 0.1019
R106 vco_ind_LC.n141 vco_ind_LC.n140 0.101071
R107 vco_ind_LC.n10 vco_ind_LC.n143 0.338353
R108 vco_ind_LC.n11 vco_ind_LC.n145 0.101071
R109 vco_ind_LC.n14 vco_ind_LC.n15 0.0177851
R110 vco_ind_LC.n24 vco_ind_LC.n22 0.0177851
R111 vco_ind_LC.n147 vco_ind_LC.n21 0.101071
R112 vco_ind_LC.n27 vco_ind_LC.n26 0.0177851
R113 vco_ind_LC.n146 vco_ind_LC.n25 0.101071
R114 vco_ind_LC.n140 vco_ind_LC.n139 0.101071
R115 vco_ind_LC.n9 vco_ind_LC.n142 0.338353
R116 vco_ind_LC.n11 vco_ind_LC.n144 0.101071
R117 vco_ind_LC.n14 vco_ind_LC.n16 0.0177851
R118 vco_ind_LC.n23 vco_ind_LC.n22 0.0177851
R119 vco_ind_LC.n150 vco_ind_LC.n21 0.101071
R120 vco_ind_LC.n28 vco_ind_LC.n26 0.0177851
R121 vco_ind_LC.n1 vco_ind_LC.n25 0.00878375
R122 vco_ind_LC.n111 vco_ind_LC.n97 0.101071
R123 vco_ind_LC.n109 vco_ind_LC.n100 0.101071
R124 vco_ind_LC.n118 vco_ind_LC.n117 0.101071
R125 vco_ind_LC.n121 vco_ind_LC.n96 0.101071
R126 vco_ind_LC.n123 vco_ind_LC.n92 0.101071
R127 vco_ind_LC.n125 vco_ind_LC.n88 0.101071
R128 vco_ind_LC.n105 vco_ind_LC.n97 0.101071
R129 vco_ind_LC.n106 vco_ind_LC.n100 0.101071
R130 vco_ind_LC.n118 vco_ind_LC.n45 0.101071
R131 vco_ind_LC.n121 vco_ind_LC.n95 0.101071
R132 vco_ind_LC.n123 vco_ind_LC.n91 0.101071
R133 vco_ind_LC.n125 vco_ind_LC.n87 0.101071
R134 vco_ind_LC.n84 vco_ind_LC.n75 0.101071
R135 vco_ind_LC.n82 vco_ind_LC.n81 0.101071
R136 vco_ind_LC.n131 vco_ind_LC.n47 0.101071
R137 vco_ind_LC.n132 vco_ind_LC.n64 0.101071
R138 vco_ind_LC.n134 vco_ind_LC.n60 0.101071
R139 vco_ind_LC.n136 vco_ind_LC.n56 0.101071
R140 vco_ind_LC.n84 vco_ind_LC.n74 0.101071
R141 vco_ind_LC.n82 vco_ind_LC.n79 0.101071
R142 vco_ind_LC.n131 vco_ind_LC.n49 0.101071
R143 vco_ind_LC.n132 vco_ind_LC.n63 0.101071
R144 vco_ind_LC.n134 vco_ind_LC.n59 0.101071
R145 vco_ind_LC.n136 vco_ind_LC.n55 0.101071
R146 vco_ind_LC.n4 vco_ind_LC.n3 0.0177851
R147 vco_ind_LC.n3 vco_ind_LC.n2 0.0177851
R148 vco_ind_LC.n147 vco_ind_LC.n27 0.410055
R149 vco_ind_LC.n147 vco_ind_LC.n24 0.410055
R150 vco_ind_LC.n148 vco_ind_LC.n17 0.0759286
R151 vco_ind_LC.n20 vco_ind_LC.n18 0.0150741
R152 vco_ind_LC.n15 vco_ind_LC.n145 0.410055
R153 vco_ind_LC.n12 vco_ind_LC.n10 0.0177851
R154 vco_ind_LC.n5 vco_ind_LC.n143 0.0759286
R155 vco_ind_LC.n8 vco_ind_LC.n143 0.49717
R156 vco_ind_LC.n8 vco_ind_LC.n6 0.0106292
R157 vco_ind_LC.n28 vco_ind_LC.n1 0.333291
R158 vco_ind_LC.n150 vco_ind_LC.n28 0.410055
R159 vco_ind_LC.n150 vco_ind_LC.n23 0.410055
R160 vco_ind_LC.n149 vco_ind_LC.n17 0.0759286
R161 vco_ind_LC.n19 vco_ind_LC.n18 0.0150741
R162 vco_ind_LC.n16 vco_ind_LC.n144 0.410055
R163 vco_ind_LC.n12 vco_ind_LC.n9 0.0177851
R164 vco_ind_LC.n7 vco_ind_LC.n6 0.0106292
R165 vco_ind_LC.n7 vco_ind_LC.n142 0.49717
R166 vco_ind_LC.n5 vco_ind_LC.n142 0.0759286
R167 vco_ind_LC.n115 vco_ind_LC.n102 0.0759286
R168 vco_ind_LC.n116 vco_ind_LC.n115 0.0759286
R169 vco_ind_LC.n126 vco_ind_LC.n86 0.0759286
R170 vco_ind_LC.n124 vco_ind_LC.n90 0.0759286
R171 vco_ind_LC.n122 vco_ind_LC.n94 0.0759286
R172 vco_ind_LC.n120 vco_ind_LC.n41 0.0759286
R173 vco_ind_LC.n119 vco_ind_LC.n99 0.0759286
R174 vco_ind_LC.n110 vco_ind_LC.n108 0.0759286
R175 vco_ind_LC.n113 vco_ind_LC.n112 0.0759286
R176 vco_ind_LC.n114 vco_ind_LC.n101 0.0759286
R177 vco_ind_LC.n126 vco_ind_LC.n51 0.00704879
R178 vco_ind_LC.n124 vco_ind_LC.n89 0.0759286
R179 vco_ind_LC.n122 vco_ind_LC.n93 0.0759286
R180 vco_ind_LC.n120 vco_ind_LC.n44 0.0759286
R181 vco_ind_LC.n119 vco_ind_LC.n98 0.0759286
R182 vco_ind_LC.n108 vco_ind_LC.n107 0.0759286
R183 vco_ind_LC.n114 vco_ind_LC.n103 0.0759286
R184 vco_ind_LC.n113 vco_ind_LC.n104 0.0759286
R185 vco_ind_LC.n128 vco_ind_LC.n70 0.0759286
R186 vco_ind_LC.n129 vco_ind_LC.n128 0.0759286
R187 vco_ind_LC.n137 vco_ind_LC.n54 0.0759286
R188 vco_ind_LC.n135 vco_ind_LC.n58 0.0759286
R189 vco_ind_LC.n133 vco_ind_LC.n62 0.0759286
R190 vco_ind_LC.n67 vco_ind_LC.n65 0.0759286
R191 vco_ind_LC.n80 vco_ind_LC.n66 0.0759286
R192 vco_ind_LC.n83 vco_ind_LC.n77 0.0759286
R193 vco_ind_LC.n85 vco_ind_LC.n73 0.0759286
R194 vco_ind_LC.n127 vco_ind_LC.n68 0.0759286
R195 vco_ind_LC.n53 vco_ind_LC.n55 0.420908
R196 vco_ind_LC.n13 vco_ind_LC.n40 0.113018
R197 vco_ind_LC.n13 vco_ind_LC.n39 0.113018
R198 vco_ind_LC.n130 vco_ind_LC.n50 0.112759
R199 vco_ind_LC.n130 vco_ind_LC.n48 0.112759
R200 vco_ind_LC.n46 vco_ind_LC.n42 0.112759
R201 vco_ind_LC.n43 vco_ind_LC.n42 0.112759
R202 vco_ind_LC.n34 vco_ind_LC.n29 0.07925
R203 vco_ind_LC.n135 vco_ind_LC.n57 0.0759286
R204 vco_ind_LC.n133 vco_ind_LC.n61 0.0759286
R205 vco_ind_LC.n69 vco_ind_LC.n65 0.0759286
R206 vco_ind_LC.n78 vco_ind_LC.n66 0.0759286
R207 vco_ind_LC.n83 vco_ind_LC.n76 0.0759286
R208 vco_ind_LC.n127 vco_ind_LC.n71 0.0759286
R209 vco_ind_LC.n85 vco_ind_LC.n72 0.0759286
R210 vco_ind_LC.n128 vco_ind_LC.n33 0.0738333
R211 vco_ind_LC.n21 vco_ind_LC.n26 0.0738333
R212 vco_ind_LC.n22 vco_ind_LC.n21 0.0738333
R213 vco_ind_LC.n18 vco_ind_LC.n17 0.0738333
R214 vco_ind_LC.n11 vco_ind_LC.n14 0.0738333
R215 vco_ind_LC.n5 vco_ind_LC.n12 0.0738333
R216 vco_ind_LC.n6 vco_ind_LC.n5 0.0738333
R217 vco_ind_LC.n140 vco_ind_LC.n3 0.0738333
R218 vco_ind_LC.n36 vco_ind_LC.n35 0.068
R219 vco_ind_LC.n53 vco_ind_LC.n137 0.00733769
R220 vco_ind_LC.n1 vco_ind_LC.n0 0.0325083
R221 vco_ind_LC.n26 vco_ind_LC.n25 0.0371667
R222 vco_ind_LC.n17 vco_ind_LC.n22 0.0371667
R223 vco_ind_LC.n13 vco_ind_LC.n18 0.0371667
R224 vco_ind_LC.n14 vco_ind_LC.n13 0.0371667
R225 vco_ind_LC.n12 vco_ind_LC.n11 0.0371667
R226 vco_ind_LC.n140 vco_ind_LC.n6 0.0371667
R227 vco_ind_LC.n137 vco_ind_LC.n136 0.0371667
R228 vco_ind_LC.n136 vco_ind_LC.n135 0.0371667
R229 vco_ind_LC.n135 vco_ind_LC.n134 0.0371667
R230 vco_ind_LC.n134 vco_ind_LC.n133 0.0371667
R231 vco_ind_LC.n133 vco_ind_LC.n132 0.0371667
R232 vco_ind_LC.n132 vco_ind_LC.n65 0.0371667
R233 vco_ind_LC.n130 vco_ind_LC.n65 0.0371667
R234 vco_ind_LC.n131 vco_ind_LC.n130 0.0371667
R235 vco_ind_LC.n131 vco_ind_LC.n66 0.0371667
R236 vco_ind_LC.n82 vco_ind_LC.n66 0.0371667
R237 vco_ind_LC.n83 vco_ind_LC.n82 0.0371667
R238 vco_ind_LC.n84 vco_ind_LC.n83 0.0371667
R239 vco_ind_LC.n85 vco_ind_LC.n84 0.0371667
R240 vco_ind_LC.n127 vco_ind_LC.n85 0.0371667
R241 vco_ind_LC.n128 vco_ind_LC.n127 0.0371667
R242 vco_ind_LC.n51 vco_ind_LC.n32 0.0371846
R243 vco_ind_LC.n126 vco_ind_LC.n125 0.0371667
R244 vco_ind_LC.n125 vco_ind_LC.n124 0.0371667
R245 vco_ind_LC.n124 vco_ind_LC.n123 0.0371667
R246 vco_ind_LC.n123 vco_ind_LC.n122 0.0371667
R247 vco_ind_LC.n122 vco_ind_LC.n121 0.0371667
R248 vco_ind_LC.n121 vco_ind_LC.n120 0.0371667
R249 vco_ind_LC.n120 vco_ind_LC.n42 0.0371667
R250 vco_ind_LC.n118 vco_ind_LC.n42 0.0371667
R251 vco_ind_LC.n119 vco_ind_LC.n118 0.0371667
R252 vco_ind_LC.n119 vco_ind_LC.n100 0.0371667
R253 vco_ind_LC.n108 vco_ind_LC.n100 0.0371667
R254 vco_ind_LC.n108 vco_ind_LC.n97 0.0371667
R255 vco_ind_LC.n113 vco_ind_LC.n97 0.0371667
R256 vco_ind_LC.n114 vco_ind_LC.n113 0.0371667
R257 vco_ind_LC.n115 vco_ind_LC.n114 0.0371667
R258 vco_ind_LC.n33 vco_ind_LC.n32 0.0614925
R259 vco_ind_LC.n38 vco_ind_LC.n37 0.0455
R260 vco_ind_LC.n37 vco_ind_LC.n36 0.0455
R261 vco_ind_LC.n34 vco_ind_LC.n30 0.0455
R262 vco_ind_LC.n31 vco_ind_LC.n30 0.0455
R263 vco_ind_LC.n138 vco_ind_LC.n31 0.0455
R264 vco_ind_LC.n35 vco_ind_LC.n0 0.580361
R265 ibias_100u.n3 ibias_100u.t1 54.3738
R266 ibias_100u.n0 ibias_100u.t4 34.6784
R267 ibias_100u.n1 ibias_100u.t2 34.2252
R268 ibias_100u.n2 ibias_100u.t0 20.5585
R269 ibias_100u.n0 ibias_100u.t3 14.6093
R270 ibias_100u.n3 ibias_100u.n2 1.7473
R271 ibias_100u ibias_100u.n3 1.2149
R272 ibias_100u.n2 ibias_100u.n1 0.5351
R273 ibias_100u.n1 ibias_100u.n0 0.3173
R274 rf_out_p rf_out_p.n2 7.11117
R275 rf_out_p.n0 rf_out_p.t0 4.77599
R276 rf_out_p.n1 rf_out_p.t3 4.72949
R277 rf_out_p.n1 rf_out_p.t5 4.72949
R278 rf_out_p.n0 rf_out_p.t4 4.72949
R279 rf_out_p.n0 rf_out_p.t2 4.72949
R280 rf_out_p.n0 rf_out_p.t1 4.72949
R281 rf_out_p.n2 rf_out_p.t6 2.40801
R282 rf_out_p.n2 rf_out_p.n1 0.685593
R283 rf_out_p.n1 rf_out_p.n0 0.186531
R284 rf_out_n rf_out_n.n2 7.11117
R285 rf_out_n.n0 rf_out_n.t5 4.77599
R286 rf_out_n.n0 rf_out_n.t2 4.72949
R287 rf_out_n.n0 rf_out_n.t1 4.72949
R288 rf_out_n.n1 rf_out_n.t4 4.72949
R289 rf_out_n.n1 rf_out_n.t3 4.72949
R290 rf_out_n.n1 rf_out_n.t0 4.72949
R291 rf_out_n.n2 rf_out_n.t6 2.40801
R292 rf_out_n.n2 rf_out_n.n1 0.685593
R293 rf_out_n.n1 rf_out_n.n0 0.186531
R294 momf4_A.n0 momf4_A.t0 27.7405
R295 momf4_A momf4_A.n0 2.4825
R296 momf4_A.n0 momf4_A.t1 1.97272
R297 momf3_B.n0 momf3_B.t0 27.7405
R298 momf3_B momf3_B.n0 2.5001
R299 momf3_B.n0 momf3_B.t1 1.97253
R300 di_en.n0 di_en.t1 26.3252
R301 di_en.n0 di_en.t0 24.5065
R302 di_en di_en.n0 10.1632
R303 vco_ind_LA.n0 vco_ind_LA.t3 4.75718
R304 vco_ind_LA.n1 vco_ind_LA.t2 4.81938
R305 vco_ind_LA.n0 vco_ind_LA.t4 4.72949
R306 vco_ind_LA.n0 vco_ind_LA.t1 4.72949
R307 vco_ind_LA.n0 vco_ind_LA.t0 4.72949
R308 vco_ind_LA.n3 vco_ind_LA.t5 4.17444
R309 vco_var_rf_p momf3_A 3.16545
R310 vco_ind_LA.n2 vco_ind_LA.n1 0.225881
R311 vco_var_rf_p vco_ind_LA.n2 0.95618
R312 vco_ind_LA.n3 vco_ind_LA 0.304536
R313 vco_ind_LA.n0 vco_ind_LA.n1 0.0646573
R314 vco_ind_LA.n2 vco_ind_LA.n3 0.119752
R315 vco_ind_LB.n0 vco_ind_LB.t0 4.75718
R316 vco_ind_LB.n1 vco_ind_LB.t2 4.81949
R317 vco_ind_LB.n0 vco_ind_LB.t1 4.72949
R318 vco_ind_LB.n0 vco_ind_LB.t4 4.72949
R319 vco_ind_LB.n0 vco_ind_LB.t3 4.72949
R320 vco_ind_LB.n3 vco_ind_LB.t5 4.00826
R321 vco_var_rf_n momf4_B 3.3235
R322 vco_ind_LB.n2 vco_ind_LB.n1 0.2259
R323 vco_var_rf_n vco_ind_LB.n2 0.798132
R324 vco_ind_LB.n3 vco_ind_LB 0.316669
R325 vco_ind_LB.n0 vco_ind_LB.n1 0.0645602
R326 vco_ind_LB.n2 vco_ind_LB.n3 0.112813
R327 VDD VDD.n9 17.9801
R328 VDD VDD.n8 17.071
R329 VDD.n7 VDD.t10 17.0005
R330 VDD.n5 VDD.t6 17.0005
R331 VDD.n3 VDD.t0 17.0005
R332 VDD.n1 VDD.t4 11.3356
R333 VDD.n0 VDD.t2 11.3356
R334 VDD.n7 VDD.t11 6.19097
R335 VDD.n5 VDD.t7 6.19097
R336 VDD.n3 VDD.t1 6.19097
R337 VDD.n9 VDD.t9 4.22454
R338 VDD.n0 VDD.t3 2.44351
R339 VDD.n1 VDD.t5 2.4425
R340 VDD.n2 VDD.n0 1.42463
R341 VDD.n4 VDD.n2 0.851625
R342 VDD.n8 VDD.n7 0.751488
R343 VDD.n6 VDD.n5 0.751488
R344 VDD.n4 VDD.n3 0.751488
R345 VDD.n9 VDD.t8 0.517741
R346 VDD.n8 VDD.n6 0.370375
R347 VDD.n6 VDD.n4 0.370375
R348 VDD.n2 VDD.n1 0.143127
R349 VSS.n397 VSS.n396 2420.69
R350 VSS.n397 VSS.n395 1880.72
R351 VSS.t4 VSS.n397 900.284
R352 VSS.t98 VSS.t95 302.199
R353 VSS.n408 VSS.t116 287.356
R354 VSS.t116 VSS.t115 141.554
R355 VSS.n407 VSS.n390 141.554
R356 VSS.n458 VSS.t98 106.594
R357 VSS.n408 VSS.n407 71.2493
R358 VSS.t0 VSS.t2 70.7775
R359 VSS.n399 VSS.n390 47.1851
R360 VSS.n399 VSS.t0 33.0298
R361 VSS.n429 VSS.n87 24.5426
R362 VSS.t2 VSS.t4 23.5928
R363 VSS.n395 VSS.n245 21.2135
R364 VSS.n355 VSS.t6 20.1728
R365 VSS.n398 VSS.t117 17.4597
R366 VSS.n400 VSS.t5 17.4597
R367 VSS.n462 VSS.n461 17.0005
R368 VSS.n462 VSS.n41 17.0005
R369 VSS.n462 VSS.n57 17.0005
R370 VSS.n462 VSS.n42 17.0005
R371 VSS.n462 VSS.n56 17.0005
R372 VSS.n462 VSS.n43 17.0005
R373 VSS.n462 VSS.n55 17.0005
R374 VSS.n462 VSS.n44 17.0005
R375 VSS.n462 VSS.n54 17.0005
R376 VSS.n462 VSS.n45 17.0005
R377 VSS.n462 VSS.n53 17.0005
R378 VSS.n462 VSS.n46 17.0005
R379 VSS.n462 VSS.n52 17.0005
R380 VSS.n462 VSS.n47 17.0005
R381 VSS.n462 VSS.n49 17.0005
R382 VSS.n462 VSS.n48 17.0005
R383 VSS.n453 VSS.n452 17.0005
R384 VSS.n452 VSS.n118 17.0005
R385 VSS.n452 VSS.n132 17.0005
R386 VSS.n452 VSS.n119 17.0005
R387 VSS.n452 VSS.n131 17.0005
R388 VSS.n452 VSS.n120 17.0005
R389 VSS.n452 VSS.n130 17.0005
R390 VSS.n452 VSS.n121 17.0005
R391 VSS.n452 VSS.n129 17.0005
R392 VSS.n452 VSS.n122 17.0005
R393 VSS.n452 VSS.n128 17.0005
R394 VSS.n452 VSS.n123 17.0005
R395 VSS.n452 VSS.n127 17.0005
R396 VSS.n452 VSS.n124 17.0005
R397 VSS.n452 VSS.n126 17.0005
R398 VSS.n452 VSS.n125 17.0005
R399 VSS.n459 VSS.n458 17.0005
R400 VSS.n459 VSS.n60 17.0005
R401 VSS.n459 VSS.n117 17.0005
R402 VSS.n459 VSS.n61 17.0005
R403 VSS.n459 VSS.n116 17.0005
R404 VSS.n459 VSS.n62 17.0005
R405 VSS.n459 VSS.n115 17.0005
R406 VSS.n459 VSS.n63 17.0005
R407 VSS.n459 VSS.n114 17.0005
R408 VSS.n459 VSS.n64 17.0005
R409 VSS.n459 VSS.n113 17.0005
R410 VSS.n459 VSS.n65 17.0005
R411 VSS.n459 VSS.n112 17.0005
R412 VSS.n459 VSS.n66 17.0005
R413 VSS.n459 VSS.n111 17.0005
R414 VSS.n459 VSS.n67 17.0005
R415 VSS.n459 VSS.n110 17.0005
R416 VSS.n459 VSS.n68 17.0005
R417 VSS.n459 VSS.n109 17.0005
R418 VSS.n459 VSS.n69 17.0005
R419 VSS.n459 VSS.n106 17.0005
R420 VSS.n459 VSS.n73 17.0005
R421 VSS.n459 VSS.n99 17.0005
R422 VSS.n459 VSS.n75 17.0005
R423 VSS.n459 VSS.n97 17.0005
R424 VSS.n459 VSS.n76 17.0005
R425 VSS.n460 VSS.n459 17.0005
R426 VSS.n459 VSS.n77 17.0005
R427 VSS.n459 VSS.n96 17.0005
R428 VSS.n459 VSS.n78 17.0005
R429 VSS.n459 VSS.n95 17.0005
R430 VSS.n459 VSS.n79 17.0005
R431 VSS.n459 VSS.n94 17.0005
R432 VSS.n459 VSS.n80 17.0005
R433 VSS.n459 VSS.n93 17.0005
R434 VSS.n459 VSS.n81 17.0005
R435 VSS.n459 VSS.n92 17.0005
R436 VSS.n459 VSS.n82 17.0005
R437 VSS.n459 VSS.n91 17.0005
R438 VSS.n459 VSS.n83 17.0005
R439 VSS.n459 VSS.n90 17.0005
R440 VSS.n459 VSS.n87 17.0005
R441 VSS.n399 VSS.n398 17.0005
R442 VSS.n400 VSS.n399 17.0005
R443 VSS.n394 VSS.n390 17.0005
R444 VSS.n393 VSS.n390 17.0005
R445 VSS.n89 VSS.t48 15.1814
R446 VSS.t79 VSS.n454 15.1814
R447 VSS.n408 VSS.n321 14.4993
R448 VSS.t64 VSS.n72 14.4488
R449 VSS.n72 VSS.t65 14.4488
R450 VSS.t81 VSS.n58 14.1496
R451 VSS.n88 VSS.t44 14.1489
R452 VSS.t44 VSS.n84 12.6844
R453 VSS.n455 VSS.t81 12.6837
R454 VSS.n396 VSS.n330 12.6082
R455 VSS.n320 VSS.n276 12.4547
R456 VSS.n414 VSS.n203 12.4547
R457 VSS.n302 VSS.n288 12.4547
R458 VSS.n424 VSS.n195 12.4547
R459 VSS.n426 VSS.n192 12.4547
R460 VSS.n295 VSS.n293 12.4547
R461 VSS.t60 VSS.n100 12.2509
R462 VSS.n105 VSS.t62 12.2509
R463 VSS.t42 VSS.n87 12.0884
R464 VSS.n458 VSS.t82 12.0884
R465 VSS.n101 VSS.t60 11.9518
R466 VSS.t62 VSS.n71 11.9511
R467 VSS.t15 VSS.n290 11.7221
R468 VSS.t94 VSS.n312 11.3558
R469 VSS.n372 VSS.t9 11.3474
R470 VSS.n407 VSS.n392 11.3338
R471 VSS.n407 VSS.n391 11.3338
R472 VSS.n407 VSS.n406 11.3338
R473 VSS.t145 VSS.t57 10.8064
R474 VSS.t38 VSS.t146 10.8064
R475 VSS.n420 VSS.t96 10.6232
R476 VSS.t56 VSS.n75 10.6232
R477 VSS.n109 VSS.t69 10.6232
R478 VSS.t9 VSS.n336 10.0867
R479 VSS.n449 VSS.n448 9.75612
R480 VSS.t65 VSS.n71 9.75399
R481 VSS.n101 VSS.t64 9.7533
R482 VSS.t142 VSS.n98 9.5037
R483 VSS.n74 VSS.t144 9.5037
R484 VSS.t147 VSS.n70 9.5037
R485 VSS.n107 VSS.t149 9.5037
R486 VSS.n97 VSS.t54 9.15801
R487 VSS.t66 VSS.n68 9.15801
R488 VSS.n455 VSS.t79 9.02139
R489 VSS.t48 VSS.n84 9.0207
R490 VSS.n89 VSS.n48 8.95425
R491 VSS.n454 VSS.n453 8.95425
R492 VSS.n396 VSS.n378 8.82588
R493 VSS.n433 VSS.n429 8.5005
R494 VSS.n433 VSS.n295 8.5005
R495 VSS.n433 VSS.n428 8.5005
R496 VSS.n433 VSS.n296 8.5005
R497 VSS.n433 VSS.n426 8.5005
R498 VSS.n433 VSS.n299 8.5005
R499 VSS.n433 VSS.n424 8.5005
R500 VSS.n433 VSS.n302 8.5005
R501 VSS.n433 VSS.n420 8.5005
R502 VSS.n433 VSS.n308 8.5005
R503 VSS.n433 VSS.n414 8.5005
R504 VSS.n433 VSS.n312 8.5005
R505 VSS.n433 VSS.n413 8.5005
R506 VSS.n433 VSS.n320 8.5005
R507 VSS.n433 VSS.n409 8.5005
R508 VSS.n436 VSS.n293 8.5005
R509 VSS.n436 VSS.n290 8.5005
R510 VSS.n436 VSS.n288 8.5005
R511 VSS.n436 VSS.n281 8.5005
R512 VSS.n436 VSS.n276 8.5005
R513 VSS.n436 VSS.n192 8.5005
R514 VSS.n436 VSS.n195 8.5005
R515 VSS.n436 VSS.n197 8.5005
R516 VSS.n436 VSS.n203 8.5005
R517 VSS.n433 VSS.n321 8.5005
R518 VSS.n433 VSS.n389 8.5005
R519 VSS.n433 VSS.n322 8.5005
R520 VSS.n433 VSS.n388 8.5005
R521 VSS.n433 VSS.n323 8.5005
R522 VSS.n433 VSS.n387 8.5005
R523 VSS.n433 VSS.n324 8.5005
R524 VSS.n433 VSS.n386 8.5005
R525 VSS.n433 VSS.n325 8.5005
R526 VSS.n433 VSS.n385 8.5005
R527 VSS.n433 VSS.n326 8.5005
R528 VSS.n433 VSS.n384 8.5005
R529 VSS.n433 VSS.n327 8.5005
R530 VSS.n433 VSS.n383 8.5005
R531 VSS.n433 VSS.n328 8.5005
R532 VSS.n433 VSS.n379 8.5005
R533 VSS.n433 VSS.n329 8.5005
R534 VSS.n433 VSS.n378 8.5005
R535 VSS.n433 VSS.n330 8.5005
R536 VSS.n433 VSS.n377 8.5005
R537 VSS.n433 VSS.n331 8.5005
R538 VSS.n433 VSS.n376 8.5005
R539 VSS.n433 VSS.n332 8.5005
R540 VSS.n433 VSS.n375 8.5005
R541 VSS.n433 VSS.n333 8.5005
R542 VSS.n433 VSS.n374 8.5005
R543 VSS.n433 VSS.n334 8.5005
R544 VSS.n433 VSS.n373 8.5005
R545 VSS.n433 VSS.n335 8.5005
R546 VSS.n433 VSS.n372 8.5005
R547 VSS.n433 VSS.n336 8.5005
R548 VSS.n433 VSS.n371 8.5005
R549 VSS.n433 VSS.n337 8.5005
R550 VSS.n433 VSS.n370 8.5005
R551 VSS.n433 VSS.n338 8.5005
R552 VSS.n433 VSS.n369 8.5005
R553 VSS.n433 VSS.n339 8.5005
R554 VSS.n433 VSS.n368 8.5005
R555 VSS.n433 VSS.n340 8.5005
R556 VSS.n433 VSS.n367 8.5005
R557 VSS.n433 VSS.n341 8.5005
R558 VSS.n433 VSS.n366 8.5005
R559 VSS.n433 VSS.n342 8.5005
R560 VSS.n433 VSS.n365 8.5005
R561 VSS.n433 VSS.n343 8.5005
R562 VSS.n433 VSS.n363 8.5005
R563 VSS.n433 VSS.n344 8.5005
R564 VSS.n433 VSS.n362 8.5005
R565 VSS.n433 VSS.n345 8.5005
R566 VSS.n433 VSS.n361 8.5005
R567 VSS.n433 VSS.n346 8.5005
R568 VSS.n433 VSS.n360 8.5005
R569 VSS.n433 VSS.n347 8.5005
R570 VSS.n433 VSS.n359 8.5005
R571 VSS.n433 VSS.n348 8.5005
R572 VSS.n433 VSS.n358 8.5005
R573 VSS.n433 VSS.n349 8.5005
R574 VSS.n433 VSS.n357 8.5005
R575 VSS.n433 VSS.n350 8.5005
R576 VSS.n433 VSS.n356 8.5005
R577 VSS.n433 VSS.n351 8.5005
R578 VSS.n433 VSS.n355 8.5005
R579 VSS.n433 VSS.n352 8.5005
R580 VSS.n433 VSS.n354 8.5005
R581 VSS.n433 VSS.n353 8.5005
R582 VSS VSS.n449 8.10482
R583 VSS.n83 VSS.n49 8.05911
R584 VSS.n82 VSS.n52 8.05911
R585 VSS.n92 VSS.n46 8.05911
R586 VSS.n93 VSS.n45 8.05911
R587 VSS.n80 VSS.n54 8.05911
R588 VSS.n95 VSS.n43 8.05911
R589 VSS.n128 VSS.n65 8.05911
R590 VSS.n121 VSS.n114 8.05911
R591 VSS.n130 VSS.n63 8.05911
R592 VSS.n131 VSS.n62 8.05911
R593 VSS.n119 VSS.n116 8.05911
R594 VSS.n118 VSS.n117 8.05911
R595 VSS.n448 VSS.n189 7.76695
R596 VSS.n389 VSS.n213 7.76511
R597 VSS.n377 VSS.n222 7.76511
R598 VSS.n371 VSS.n228 7.76511
R599 VSS.n352 VSS.n247 7.76511
R600 VSS.n329 VSS.n267 7.76444
R601 VSS.n335 VSS.n262 7.76444
R602 VSS.n356 VSS.n243 7.76444
R603 VSS.n354 VSS.n244 7.76444
R604 VSS.n450 VSS.n38 7.56743
R605 VSS.n451 VSS.n4 7.56743
R606 VSS.n88 VSS.t42 7.55619
R607 VSS.t82 VSS.n58 7.55549
R608 VSS.t140 VSS.n75 7.50966
R609 VSS.n99 VSS.t142 7.50966
R610 VSS.t144 VSS.n73 7.50966
R611 VSS.n106 VSS.t147 7.50966
R612 VSS.t149 VSS.n69 7.50966
R613 VSS.n109 VSS.t151 7.50966
R614 VSS.n428 VSS.t97 7.32651
R615 VSS.n297 VSS.n191 7.18966
R616 VSS.n300 VSS.n194 7.18966
R617 VSS.n305 VSS.n200 7.18966
R618 VSS.n307 VSS.n202 7.18966
R619 VSS.n310 VSS.n205 7.18966
R620 VSS.n311 VSS.n206 7.18966
R621 VSS.n315 VSS.n209 7.18966
R622 VSS.n316 VSS.n210 7.18966
R623 VSS.n317 VSS.n211 7.18966
R624 VSS.n423 VSS.n286 7.18966
R625 VSS.n422 VSS.n285 7.18966
R626 VSS.n421 VSS.n284 7.18966
R627 VSS.n418 VSS.n283 7.18966
R628 VSS.n417 VSS.n282 7.18966
R629 VSS.n416 VSS.n280 7.18966
R630 VSS.n411 VSS.n278 7.18966
R631 VSS.n410 VSS.n277 7.18966
R632 VSS.n319 VSS.n212 7.18966
R633 VSS.n410 VSS.n212 7.18966
R634 VSS.n411 VSS.n277 7.18966
R635 VSS.n318 VSS.n278 7.18966
R636 VSS.n318 VSS.n211 7.18966
R637 VSS.n317 VSS.n210 7.18966
R638 VSS.n316 VSS.n209 7.18966
R639 VSS.n315 VSS.n208 7.18966
R640 VSS.n412 VSS.n208 7.18966
R641 VSS.n412 VSS.n207 7.18966
R642 VSS.n311 VSS.n205 7.18966
R643 VSS.n310 VSS.n279 7.18966
R644 VSS.n309 VSS.n279 7.18966
R645 VSS.n309 VSS.n204 7.18966
R646 VSS.n415 VSS.n280 7.18966
R647 VSS.n307 VSS.n201 7.18966
R648 VSS.n417 VSS.n201 7.18966
R649 VSS.n306 VSS.n282 7.18966
R650 VSS.n306 VSS.n200 7.18966
R651 VSS.n305 VSS.n199 7.18966
R652 VSS.n418 VSS.n199 7.18966
R653 VSS.n304 VSS.n283 7.18966
R654 VSS.n304 VSS.n198 7.18966
R655 VSS.n419 VSS.n198 7.18966
R656 VSS.n421 VSS.n285 7.18966
R657 VSS.n422 VSS.n286 7.18966
R658 VSS.n423 VSS.n287 7.18966
R659 VSS.n301 VSS.n196 7.18966
R660 VSS.n425 VSS.n289 7.18966
R661 VSS.n300 VSS.n289 7.18966
R662 VSS.n298 VSS.n193 7.18966
R663 VSS.n427 VSS.n291 7.18966
R664 VSS.n297 VSS.n291 7.18966
R665 VSS.n435 VSS.n434 7.18966
R666 VSS.n435 VSS.n294 7.18966
R667 VSS.n294 VSS.n190 7.18966
R668 VSS.n408 VSS.t11 6.93473
R669 VSS.t135 VSS.n55 6.77706
R670 VSS.t137 VSS.n42 6.77706
R671 VSS.n461 VSS.t139 6.77706
R672 VSS.n125 VSS.t152 6.77706
R673 VSS.n127 VSS.t154 6.77706
R674 VSS.n122 VSS.t156 6.77706
R675 VSS.t13 VSS.n281 6.59391
R676 VSS.n389 VSS.n214 6.57401
R677 VSS.n322 VSS.n274 6.57401
R678 VSS.n388 VSS.n215 6.57401
R679 VSS.n323 VSS.n273 6.57401
R680 VSS.n387 VSS.n216 6.57401
R681 VSS.n324 VSS.n272 6.57401
R682 VSS.n386 VSS.n217 6.57401
R683 VSS.n325 VSS.n271 6.57401
R684 VSS.n385 VSS.n218 6.57401
R685 VSS.n326 VSS.n270 6.57401
R686 VSS.n384 VSS.n219 6.57401
R687 VSS.n327 VSS.n269 6.57401
R688 VSS.n383 VSS.n220 6.57401
R689 VSS.n328 VSS.n268 6.57401
R690 VSS.n379 VSS.n221 6.57401
R691 VSS.n377 VSS.n223 6.57401
R692 VSS.n331 VSS.n266 6.57401
R693 VSS.n376 VSS.n224 6.57401
R694 VSS.n332 VSS.n265 6.57401
R695 VSS.n375 VSS.n225 6.57401
R696 VSS.n333 VSS.n264 6.57401
R697 VSS.n374 VSS.n226 6.57401
R698 VSS.n334 VSS.n263 6.57401
R699 VSS.n373 VSS.n227 6.57401
R700 VSS.n371 VSS.n229 6.57401
R701 VSS.n337 VSS.n261 6.57401
R702 VSS.n370 VSS.n230 6.57401
R703 VSS.n338 VSS.n260 6.57401
R704 VSS.n369 VSS.n231 6.57401
R705 VSS.n339 VSS.n259 6.57401
R706 VSS.n368 VSS.n232 6.57401
R707 VSS.n340 VSS.n258 6.57401
R708 VSS.n367 VSS.n233 6.57401
R709 VSS.n341 VSS.n257 6.57401
R710 VSS.n366 VSS.n234 6.57401
R711 VSS.n342 VSS.n256 6.57401
R712 VSS.n365 VSS.n235 6.57401
R713 VSS.n343 VSS.n255 6.57401
R714 VSS.n363 VSS.n236 6.57401
R715 VSS.n344 VSS.n254 6.57401
R716 VSS.n362 VSS.n237 6.57401
R717 VSS.n345 VSS.n253 6.57401
R718 VSS.n361 VSS.n238 6.57401
R719 VSS.n346 VSS.n252 6.57401
R720 VSS.n360 VSS.n239 6.57401
R721 VSS.n347 VSS.n251 6.57401
R722 VSS.n359 VSS.n240 6.57401
R723 VSS.n348 VSS.n250 6.57401
R724 VSS.n358 VSS.n241 6.57401
R725 VSS.n349 VSS.n249 6.57401
R726 VSS.n357 VSS.n242 6.57401
R727 VSS.n350 VSS.n248 6.57401
R728 VSS.n352 VSS.n246 6.57401
R729 VSS.n354 VSS.n246 6.57401
R730 VSS.n356 VSS.n248 6.57401
R731 VSS.n350 VSS.n242 6.57401
R732 VSS.n357 VSS.n249 6.57401
R733 VSS.n349 VSS.n241 6.57401
R734 VSS.n358 VSS.n250 6.57401
R735 VSS.n348 VSS.n240 6.57401
R736 VSS.n359 VSS.n251 6.57401
R737 VSS.n347 VSS.n239 6.57401
R738 VSS.n360 VSS.n252 6.57401
R739 VSS.n346 VSS.n238 6.57401
R740 VSS.n361 VSS.n253 6.57401
R741 VSS.n345 VSS.n237 6.57401
R742 VSS.n362 VSS.n254 6.57401
R743 VSS.n344 VSS.n236 6.57401
R744 VSS.n363 VSS.n255 6.57401
R745 VSS.n343 VSS.n235 6.57401
R746 VSS.n365 VSS.n256 6.57401
R747 VSS.n342 VSS.n234 6.57401
R748 VSS.n366 VSS.n257 6.57401
R749 VSS.n341 VSS.n233 6.57401
R750 VSS.n367 VSS.n258 6.57401
R751 VSS.n340 VSS.n232 6.57401
R752 VSS.n368 VSS.n259 6.57401
R753 VSS.n339 VSS.n231 6.57401
R754 VSS.n369 VSS.n260 6.57401
R755 VSS.n338 VSS.n230 6.57401
R756 VSS.n370 VSS.n261 6.57401
R757 VSS.n337 VSS.n229 6.57401
R758 VSS.n335 VSS.n227 6.57401
R759 VSS.n373 VSS.n263 6.57401
R760 VSS.n334 VSS.n226 6.57401
R761 VSS.n374 VSS.n264 6.57401
R762 VSS.n333 VSS.n225 6.57401
R763 VSS.n375 VSS.n265 6.57401
R764 VSS.n332 VSS.n224 6.57401
R765 VSS.n376 VSS.n266 6.57401
R766 VSS.n331 VSS.n223 6.57401
R767 VSS.n329 VSS.n221 6.57401
R768 VSS.n379 VSS.n268 6.57401
R769 VSS.n328 VSS.n220 6.57401
R770 VSS.n383 VSS.n269 6.57401
R771 VSS.n327 VSS.n219 6.57401
R772 VSS.n384 VSS.n270 6.57401
R773 VSS.n326 VSS.n218 6.57401
R774 VSS.n385 VSS.n271 6.57401
R775 VSS.n325 VSS.n217 6.57401
R776 VSS.n386 VSS.n272 6.57401
R777 VSS.n324 VSS.n216 6.57401
R778 VSS.n387 VSS.n273 6.57401
R779 VSS.n323 VSS.n215 6.57401
R780 VSS.n388 VSS.n274 6.57401
R781 VSS.n322 VSS.n214 6.57401
R782 VSS.n32 VSS.n30 6.5067
R783 VSS.n36 VSS.n34 6.5067
R784 VSS.n459 VSS.n454 6.22218
R785 VSS.n459 VSS.n107 6.22218
R786 VSS.n459 VSS.n70 6.22218
R787 VSS.n459 VSS.n105 6.22218
R788 VSS.n459 VSS.n72 6.22218
R789 VSS.n459 VSS.n100 6.22218
R790 VSS.n459 VSS.n74 6.22218
R791 VSS.n459 VSS.n98 6.22218
R792 VSS.n459 VSS.n89 6.22218
R793 VSS.n394 VSS.t3 6.19054
R794 VSS.n393 VSS.t27 6.19054
R795 VSS.n28 VSS.n26 6.04071
R796 VSS.n308 VSS.t13 5.86131
R797 VSS.n98 VSS.t141 5.84069
R798 VSS.t143 VSS.n74 5.84069
R799 VSS.n100 VSS.t145 5.84069
R800 VSS.t146 VSS.n105 5.84069
R801 VSS.n70 VSS.t148 5.84069
R802 VSS.t150 VSS.n107 5.84069
R803 VSS.t59 VSS.t143 5.67816
R804 VSS.t148 VSS.t68 5.67816
R805 VSS.n462 VSS.n22 2.7974
R806 VSS.n21 VSS.n22 0.0585658
R807 VSS.n14 VSS.n15 0.0585658
R808 VSS.n462 VSS.n14 2.7974
R809 VSS.n19 VSS.n20 0.0585658
R810 VSS.n452 VSS.n19 2.7974
R811 VSS.n452 VSS.n18 5.65086
R812 VSS.n452 VSS.n10 5.65086
R813 VSS.n99 VSS.t59 5.49501
R814 VSS.t68 VSS.n69 5.49501
R815 VSS.n436 VSS.n214 5.21449
R816 VSS.n436 VSS.n274 5.21449
R817 VSS.n436 VSS.n215 5.21449
R818 VSS.n436 VSS.n273 5.21449
R819 VSS.n436 VSS.n216 5.21449
R820 VSS.n436 VSS.n272 5.21449
R821 VSS.n436 VSS.n217 5.21449
R822 VSS.n436 VSS.n271 5.21449
R823 VSS.n436 VSS.n218 5.21449
R824 VSS.n436 VSS.n270 5.21449
R825 VSS.n436 VSS.n219 5.21449
R826 VSS.n436 VSS.n269 5.21449
R827 VSS.n436 VSS.n220 5.21449
R828 VSS.n436 VSS.n268 5.21449
R829 VSS.n436 VSS.n221 5.21449
R830 VSS.n436 VSS.n223 5.21449
R831 VSS.n436 VSS.n266 5.21449
R832 VSS.n436 VSS.n224 5.21449
R833 VSS.n436 VSS.n265 5.21449
R834 VSS.n436 VSS.n225 5.21449
R835 VSS.n436 VSS.n264 5.21449
R836 VSS.n436 VSS.n226 5.21449
R837 VSS.n436 VSS.n263 5.21449
R838 VSS.n436 VSS.n227 5.21449
R839 VSS.n436 VSS.n229 5.21449
R840 VSS.n436 VSS.n261 5.21449
R841 VSS.n436 VSS.n230 5.21449
R842 VSS.n436 VSS.n260 5.21449
R843 VSS.n436 VSS.n231 5.21449
R844 VSS.n436 VSS.n259 5.21449
R845 VSS.n436 VSS.n232 5.21449
R846 VSS.n436 VSS.n258 5.21449
R847 VSS.n436 VSS.n233 5.21449
R848 VSS.n436 VSS.n257 5.21449
R849 VSS.n436 VSS.n234 5.21449
R850 VSS.n436 VSS.n256 5.21449
R851 VSS.n436 VSS.n235 5.21449
R852 VSS.n436 VSS.n255 5.21449
R853 VSS.n436 VSS.n236 5.21449
R854 VSS.n436 VSS.n254 5.21449
R855 VSS.n436 VSS.n237 5.21449
R856 VSS.n436 VSS.n253 5.21449
R857 VSS.n436 VSS.n238 5.21449
R858 VSS.n436 VSS.n252 5.21449
R859 VSS.n436 VSS.n239 5.21449
R860 VSS.n436 VSS.n251 5.21449
R861 VSS.n436 VSS.n240 5.21449
R862 VSS.n436 VSS.n250 5.21449
R863 VSS.n436 VSS.n241 5.21449
R864 VSS.n436 VSS.n249 5.21449
R865 VSS.n436 VSS.n242 5.21449
R866 VSS.n436 VSS.n248 5.21449
R867 VSS.n436 VSS.n246 5.21449
R868 VSS.t97 VSS.n296 5.12871
R869 VSS.n91 VSS.t101 4.94556
R870 VSS.n94 VSS.t107 4.94556
R871 VSS.n78 VSS.t110 4.94556
R872 VSS.n460 VSS.t113 4.94556
R873 VSS.n97 VSS.t140 4.94556
R874 VSS.t151 VSS.n68 4.94556
R875 VSS.t118 VSS.n67 4.94556
R876 VSS.t122 VSS.n112 4.94556
R877 VSS.t125 VSS.n64 4.94556
R878 VSS.t131 VSS.n61 4.94556
R879 VSS.t49 VSS.n48 4.7624
R880 VSS.n453 VSS.t78 4.7624
R881 VSS.n448 VSS.n447 4.67815
R882 VSS.n83 VSS.n47 4.3961
R883 VSS.n92 VSS.n53 4.3961
R884 VSS.n81 VSS.n45 4.3961
R885 VSS.n80 VSS.n44 4.3961
R886 VSS.n94 VSS.n55 4.3961
R887 VSS.n78 VSS.n42 4.3961
R888 VSS.n77 VSS.n41 4.3961
R889 VSS.n461 VSS.n460 4.3961
R890 VSS.n125 VSS.n67 4.3961
R891 VSS.n126 VSS.n111 4.3961
R892 VSS.n127 VSS.n112 4.3961
R893 VSS.n122 VSS.n64 4.3961
R894 VSS.n129 VSS.n114 4.3961
R895 VSS.n130 VSS.n115 4.3961
R896 VSS.n120 VSS.n62 4.3961
R897 VSS.n132 VSS.n117 4.3961
R898 VSS.n462 VSS.n51 4.22744
R899 VSS.n452 VSS.n24 4.22744
R900 VSS.n409 VSS.n408 4.0298
R901 VSS.n91 VSS.t46 4.0298
R902 VSS.t53 VSS.n57 4.0298
R903 VSS.n77 VSS.t53 4.0298
R904 VSS.t70 VSS.n111 4.0298
R905 VSS.n124 VSS.t70 4.0298
R906 VSS.t76 VSS.n61 4.0298
R907 VSS.n321 VSS.n213 3.88288
R908 VSS.n330 VSS.n222 3.88288
R909 VSS.n336 VSS.n228 3.88288
R910 VSS.n355 VSS.n247 3.88288
R911 VSS.n353 VSS.n244 3.88272
R912 VSS.n351 VSS.n243 3.88272
R913 VSS.n372 VSS.n262 3.88272
R914 VSS.n378 VSS.n267 3.88272
R915 VSS.t50 VSS.t104 3.84665
R916 VSS.t128 VSS.t75 3.84665
R917 vco_var_VSS VSS.n464 3.80194
R918 VSS.n434 VSS.n293 3.59508
R919 VSS.n427 VSS.n192 3.59508
R920 VSS.n298 VSS.n290 3.59508
R921 VSS.n425 VSS.n195 3.59508
R922 VSS.n301 VSS.n288 3.59508
R923 VSS.n419 VSS.n197 3.59508
R924 VSS.n415 VSS.n203 3.59508
R925 VSS.n319 VSS.n276 3.59508
R926 VSS.n429 VSS.n190 3.59508
R927 VSS.n426 VSS.n193 3.59508
R928 VSS.n424 VSS.n196 3.59508
R929 VSS.n414 VSS.n204 3.59508
R930 VSS.n413 VSS.n207 3.59508
R931 VSS.n295 VSS.n292 3.59508
R932 VSS.n302 VSS.n287 3.59508
R933 VSS.n320 VSS.n275 3.59508
R934 VSS.n409 VSS.n275 3.59508
R935 VSS.n312 VSS.n206 3.59508
R936 VSS.n416 VSS.n281 3.59508
R937 VSS.n308 VSS.n202 3.59508
R938 VSS.n420 VSS.n284 3.59508
R939 VSS.n299 VSS.n194 3.59508
R940 VSS.n296 VSS.n191 3.59508
R941 VSS.n428 VSS.n292 3.59508
R942 VSS.n464 VSS.n463 3.57733
R943 VSS.n20 VSS.n23 3.57193
R944 VSS.n395 VSS.n353 3.46761
R945 VSS.n25 VSS.t121 3.45423
R946 VSS.n17 VSS.t124 3.45423
R947 VSS.n18 VSS.t127 3.45423
R948 VSS.n16 VSS.t130 3.45423
R949 VSS.n50 VSS.t102 3.45423
R950 VSS.n13 VSS.t105 3.45423
R951 VSS.n15 VSS.t108 3.45423
R952 VSS.n21 VSS.t111 3.45423
R953 VSS.n10 VSS.t119 3.45313
R954 VSS.n20 VSS.t133 3.45313
R955 VSS.n39 VSS.t100 3.45313
R956 VSS.n134 VSS.t114 3.45313
R957 VSS.n459 VSS.n457 3.38758
R958 VSS.n459 VSS.n3 1.11025
R959 VSS.n459 VSS.n9 1.67243
R960 VSS.n9 VSS.n8 0.0452147
R961 VSS.n459 VSS.n1 1.11047
R962 VSS.n459 VSS.n12 1.67243
R963 VSS.n12 VSS.n11 0.0452147
R964 VSS.n459 VSS.n86 3.38758
R965 VSS.n139 VSS.n25 3.3755
R966 VSS.n138 VSS.n137 3.3755
R967 VSS.n136 VSS.n133 3.3755
R968 VSS.n135 VSS.n40 3.3755
R969 VSS.n463 VSS.n21 3.3755
R970 VSS.n90 VSS.t49 3.2972
R971 VSS.t40 VSS.n56 3.2972
R972 VSS.t54 VSS.n76 3.2972
R973 VSS.n110 VSS.t66 3.2972
R974 VSS.n123 VSS.t72 3.2972
R975 VSS.t78 VSS.n60 3.2972
R976 VSS.n392 VSS.t158 3.22826
R977 VSS.n391 VSS.t159 3.22826
R978 VSS.n406 VSS.t1 3.22826
R979 VSS.t99 VSS.n49 3.11405
R980 VSS.t101 VSS.n47 3.11405
R981 VSS.t103 VSS.n46 3.11405
R982 VSS.t104 VSS.n53 3.11405
R983 VSS.t106 VSS.n54 3.11405
R984 VSS.t109 VSS.n43 3.11405
R985 VSS.t112 VSS.n57 3.11405
R986 VSS.n124 VSS.t120 3.11405
R987 VSS.n128 VSS.t123 3.11405
R988 VSS.n121 VSS.t126 3.11405
R989 VSS.n120 VSS.t128 3.11405
R990 VSS.n131 VSS.t129 3.11405
R991 VSS.n132 VSS.t131 3.11405
R992 VSS.n118 VSS.t132 3.11405
R993 VSS.n436 VSS.n213 3.08004
R994 VSS.n436 VSS.n222 3.08004
R995 VSS.n436 VSS.n228 3.08004
R996 VSS.n436 VSS.n247 3.08004
R997 VSS.n436 VSS.n267 3.07985
R998 VSS.n436 VSS.n262 3.07985
R999 VSS.n436 VSS.n243 3.07985
R1000 VSS.n436 VSS.n244 3.07985
R1001 VSS.n459 VSS.n59 2.81806
R1002 VSS.n459 VSS.n104 2.81806
R1003 VSS.n459 VSS.n2 2.81806
R1004 VSS.n459 VSS.n58 2.62983
R1005 VSS.n459 VSS.n455 2.62983
R1006 VSS.n459 VSS.n71 2.62983
R1007 VSS.n459 VSS.n101 2.62983
R1008 VSS.n459 VSS.n84 2.62983
R1009 VSS.n459 VSS.n88 2.62983
R1010 VSS.t110 VSS.t136 2.5646
R1011 VSS.t113 VSS.t138 2.5646
R1012 VSS.t153 VSS.t118 2.5646
R1013 VSS.t155 VSS.t122 2.5646
R1014 VSS.n433 VSS.n294 2.45396
R1015 VSS.n434 VSS.n433 2.45396
R1016 VSS.n433 VSS.n297 2.45396
R1017 VSS.n433 VSS.n427 2.45396
R1018 VSS.n433 VSS.n298 2.45396
R1019 VSS.n433 VSS.n300 2.45396
R1020 VSS.n433 VSS.n425 2.45396
R1021 VSS.n433 VSS.n301 2.45396
R1022 VSS.n433 VSS.n423 2.45396
R1023 VSS.n433 VSS.n422 2.45396
R1024 VSS.n433 VSS.n421 2.45396
R1025 VSS.n433 VSS.n419 2.45396
R1026 VSS.n433 VSS.n304 2.45396
R1027 VSS.n433 VSS.n418 2.45396
R1028 VSS.n433 VSS.n305 2.45396
R1029 VSS.n433 VSS.n306 2.45396
R1030 VSS.n433 VSS.n417 2.45396
R1031 VSS.n433 VSS.n307 2.45396
R1032 VSS.n433 VSS.n416 2.45396
R1033 VSS.n433 VSS.n415 2.45396
R1034 VSS.n433 VSS.n309 2.45396
R1035 VSS.n433 VSS.n310 2.45396
R1036 VSS.n433 VSS.n311 2.45396
R1037 VSS.n433 VSS.n412 2.45396
R1038 VSS.n433 VSS.n315 2.45396
R1039 VSS.n433 VSS.n316 2.45396
R1040 VSS.n433 VSS.n317 2.45396
R1041 VSS.n433 VSS.n318 2.45396
R1042 VSS.n433 VSS.n411 2.45396
R1043 VSS.n433 VSS.n410 2.45396
R1044 VSS.n433 VSS.n319 2.45396
R1045 VSS.n436 VSS.n435 2.45396
R1046 VSS.n436 VSS.n292 2.45396
R1047 VSS.n436 VSS.n291 2.45396
R1048 VSS.n436 VSS.n289 2.45396
R1049 VSS.n436 VSS.n287 2.45396
R1050 VSS.n436 VSS.n286 2.45396
R1051 VSS.n436 VSS.n285 2.45396
R1052 VSS.n436 VSS.n284 2.45396
R1053 VSS.n436 VSS.n283 2.45396
R1054 VSS.n436 VSS.n282 2.45396
R1055 VSS.n436 VSS.n280 2.45396
R1056 VSS.n436 VSS.n279 2.45396
R1057 VSS.n436 VSS.n278 2.45396
R1058 VSS.n436 VSS.n277 2.45396
R1059 VSS.n436 VSS.n275 2.45396
R1060 VSS.n436 VSS.n190 2.45396
R1061 VSS.n436 VSS.n191 2.45396
R1062 VSS.n436 VSS.n193 2.45396
R1063 VSS.n436 VSS.n194 2.45396
R1064 VSS.n436 VSS.n196 2.45396
R1065 VSS.n436 VSS.n198 2.45396
R1066 VSS.n436 VSS.n199 2.45396
R1067 VSS.n436 VSS.n200 2.45396
R1068 VSS.n436 VSS.n201 2.45396
R1069 VSS.n436 VSS.n202 2.45396
R1070 VSS.n436 VSS.n204 2.45396
R1071 VSS.n436 VSS.n205 2.45396
R1072 VSS.n436 VSS.n206 2.45396
R1073 VSS.n436 VSS.n207 2.45396
R1074 VSS.n436 VSS.n208 2.45396
R1075 VSS.n436 VSS.n209 2.45396
R1076 VSS.n436 VSS.n210 2.45396
R1077 VSS.n436 VSS.n211 2.45396
R1078 VSS.n436 VSS.n212 2.45396
R1079 VSS.n86 VSS.t43 2.40146
R1080 VSS.n457 VSS.t83 2.40092
R1081 VSS.n2 VSS.t47 2.3605
R1082 VSS.n38 VSS.t41 2.36044
R1083 VSS.n102 VSS.t61 2.36035
R1084 VSS.n6 VSS.t77 2.36016
R1085 VSS.n456 VSS.t80 2.36
R1086 VSS.n1 VSS.t55 2.35954
R1087 VSS.n103 VSS.t63 2.35952
R1088 VSS.n85 VSS.t45 2.35939
R1089 VSS.n7 VSS.t74 2.35921
R1090 VSS.n4 VSS.t71 2.35898
R1091 VSS.n11 VSS.t51 2.35895
R1092 VSS.n5 VSS.t58 2.35887
R1093 VSS.n108 VSS.t67 2.3588
R1094 VSS.n8 VSS.t39 2.35874
R1095 VSS.n431 VSS.t37 2.21217
R1096 VSS.n439 VSS.t24 2.21138
R1097 VSS.n447 VSS.t17 2.21103
R1098 VSS.n313 VSS.t33 2.21075
R1099 VSS.n441 VSS.t22 2.21073
R1100 VSS.n380 VSS.t29 2.21071
R1101 VSS.n381 VSS.t31 2.21071
R1102 VSS.n445 VSS.t18 2.21054
R1103 VSS.n430 VSS.t35 2.21016
R1104 VSS.n437 VSS.t26 2.21012
R1105 VSS.n189 VSS.t28 2.21003
R1106 VSS.n443 VSS.t20 2.20978
R1107 VSS.n189 VSS.t84 2.20312
R1108 VSS.n439 VSS.t14 2.20289
R1109 VSS.n441 VSS.t12 2.20254
R1110 VSS.n380 VSS.t85 2.20244
R1111 VSS.n445 VSS.t8 2.20231
R1112 VSS.n430 VSS.t91 2.20186
R1113 VSS.n381 VSS.t87 2.20153
R1114 VSS.n431 VSS.t93 2.20144
R1115 VSS.n443 VSS.t10 2.20124
R1116 VSS.n447 VSS.t7 2.20122
R1117 VSS.n437 VSS.t16 2.20121
R1118 VSS.n313 VSS.t89 2.20029
R1119 VSS.t96 VSS.n197 1.832
R1120 VSS.n90 VSS.t99 1.28255
R1121 VSS.n82 VSS.t103 1.28255
R1122 VSS.n93 VSS.t106 1.28255
R1123 VSS.t52 VSS.t134 1.28255
R1124 VSS.t107 VSS.t52 1.28255
R1125 VSS.n79 VSS.t135 1.28255
R1126 VSS.n79 VSS.t109 1.28255
R1127 VSS.n96 VSS.t137 1.28255
R1128 VSS.n96 VSS.t112 1.28255
R1129 VSS.n76 VSS.t139 1.28255
R1130 VSS.t152 VSS.n110 1.28255
R1131 VSS.t120 VSS.n66 1.28255
R1132 VSS.t154 VSS.n66 1.28255
R1133 VSS.t123 VSS.n113 1.28255
R1134 VSS.t156 VSS.n113 1.28255
R1135 VSS.t73 VSS.t125 1.28255
R1136 VSS.t157 VSS.t73 1.28255
R1137 VSS.t126 VSS.n63 1.28255
R1138 VSS.t129 VSS.n116 1.28255
R1139 VSS.t132 VSS.n60 1.28255
R1140 VSS.t6 VSS.n351 1.26127
R1141 VSS.n413 VSS.t94 1.0994
R1142 VSS.n81 VSS.t50 1.0994
R1143 VSS.n95 VSS.t40 1.0994
R1144 VSS.t72 VSS.n65 1.0994
R1145 VSS.t75 VSS.n115 1.0994
R1146 VSS.n436 VSS.n245 0.777302
R1147 VSS.n433 VSS.n245 0.776673
R1148 VSS.n299 VSS.t15 0.733101
R1149 VSS.t134 VSS.n44 0.549951
R1150 VSS.t136 VSS.n56 0.549951
R1151 VSS.t138 VSS.n41 0.549951
R1152 VSS.t141 VSS.t56 0.549951
R1153 VSS.t69 VSS.t150 0.549951
R1154 VSS.n126 VSS.t153 0.549951
R1155 VSS.n123 VSS.t155 0.549951
R1156 VSS.n129 VSS.t157 0.549951
R1157 VSS.n406 VSS.n405 0.513002
R1158 VSS.n398 VSS.n188 0.479883
R1159 VSS.n401 VSS.n400 0.479883
R1160 VSS.n156 VSS.n155 0.4405
R1161 VSS.n150 VSS.n149 0.4405
R1162 VSS.n144 VSS.n143 0.4405
R1163 VSS.n155 VSS.n30 0.4405
R1164 VSS.n149 VSS.n34 0.4405
R1165 VSS.n143 VSS.n142 0.4405
R1166 VSS.n402 VSS.n394 0.411981
R1167 VSS.n405 VSS.n393 0.411981
R1168 VSS.n401 VSS.n188 0.370375
R1169 VSS.n402 VSS.n401 0.370375
R1170 VSS.n403 VSS.n402 0.370375
R1171 VSS.n0 VSS.n451 0.162668
R1172 VSS.t46 VSS.n52 0.3668
R1173 VSS.t57 VSS.n73 0.3668
R1174 VSS.n106 VSS.t38 0.3668
R1175 VSS.n119 VSS.t76 0.3668
R1176 VSS.n160 VSS.n159 0.3635
R1177 VSS.n159 VSS.n158 0.3635
R1178 VSS.n154 VSS.n153 0.3635
R1179 VSS.n153 VSS.n152 0.3635
R1180 VSS.n148 VSS.n147 0.3635
R1181 VSS.n147 VSS.n146 0.3635
R1182 VSS.n136 VSS.n135 0.337235
R1183 VSS.n137 VSS.n136 0.337235
R1184 VSS.n404 VSS.n403 0.3195
R1185 VSS.n405 VSS.n404 0.3195
R1186 VSS.n29 VSS.n28 0.0682217
R1187 VSS.n33 VSS.n32 0.0680996
R1188 VSS.n37 VSS.n36 0.0680996
R1189 VSS.n27 VSS.n148 0.276447
R1190 VSS.n146 VSS.n145 0.276447
R1191 VSS.n145 VSS.n144 0.276447
R1192 VSS.n142 VSS.n141 0.276447
R1193 VSS.n140 VSS.n26 0.276447
R1194 VSS.n31 VSS.n160 0.276188
R1195 VSS.n158 VSS.n157 0.276188
R1196 VSS.n157 VSS.n156 0.276188
R1197 VSS.n35 VSS.n154 0.276188
R1198 VSS.n152 VSS.n151 0.276188
R1199 VSS.n151 VSS.n150 0.276188
R1200 VSS.n449 VSS.n188 0.248
R1201 VSS.n445 VSS.n444 0.243424
R1202 VSS.n382 VSS.n380 0.243424
R1203 VSS.n364 VSS.n189 0.242716
R1204 VSS.n447 VSS.n446 0.242681
R1205 VSS.n441 VSS.n440 0.24245
R1206 VSS.n313 VSS.n303 0.24245
R1207 VSS.n135 VSS.n134 0.241827
R1208 VSS.n137 VSS.n10 0.241827
R1209 VSS.n443 VSS.n442 0.240796
R1210 VSS.n381 VSS.n314 0.240796
R1211 VSS.n439 VSS.n438 0.239822
R1212 VSS.n432 VSS.n430 0.239822
R1213 VSS.n440 VSS.n439 0.227974
R1214 VSS.n430 VSS.n303 0.227974
R1215 VSS.n444 VSS.n443 0.227001
R1216 VSS.n382 VSS.n381 0.227001
R1217 VSS.n438 VSS.n437 0.225646
R1218 VSS.n432 VSS.n431 0.225646
R1219 VSS.n442 VSS.n441 0.224672
R1220 VSS.n314 VSS.n313 0.224672
R1221 VSS.n446 VSS.n445 0.223727
R1222 VSS.n380 VSS.n364 0.223715
R1223 VSS.n433 VSS.n303 0.218846
R1224 VSS.n440 VSS.n436 0.218846
R1225 VSS.n433 VSS.n382 0.218846
R1226 VSS.n444 VSS.n436 0.218846
R1227 VSS.n433 VSS.n432 0.208386
R1228 VSS.n433 VSS.n314 0.208386
R1229 VSS.n438 VSS.n436 0.208386
R1230 VSS.n442 VSS.n436 0.208386
R1231 VSS.n433 VSS.n364 0.208371
R1232 VSS.n446 VSS.n436 0.20836
R1233 VSS.n28 VSS.n27 0.199447
R1234 VSS.n141 VSS.n140 0.199447
R1235 VSS.n32 VSS.n31 0.199188
R1236 VSS.n36 VSS.n35 0.199188
R1237 VSS.n23 VSS.n0 0.362654
R1238 VSS.n23 VSS.n139 0.161968
R1239 VSS.n403 VSS.n392 0.143127
R1240 VSS.n404 VSS.n391 0.143127
R1241 VSS.n463 VSS.n40 0.121601
R1242 VSS.n133 VSS.n40 0.121601
R1243 VSS.n138 VSS.n133 0.121601
R1244 VSS.n139 VSS.n138 0.121601
R1245 VSS.n33 VSS.n23 6.4329
R1246 VSS.n37 VSS.n168 0.873355
R1247 VSS.n29 VSS.n176 1.36641
R1248 VSS.n177 VSS.n29 0.110483
R1249 VSS.n161 VSS.n31 0.101071
R1250 VSS.n163 VSS.n159 0.101071
R1251 VSS.n165 VSS.n157 0.101071
R1252 VSS.n169 VSS.n35 0.101071
R1253 VSS.n171 VSS.n153 0.101071
R1254 VSS.n173 VSS.n151 0.101071
R1255 VSS.n177 VSS.n27 0.101071
R1256 VSS.n179 VSS.n147 0.101071
R1257 VSS.n181 VSS.n145 0.101071
R1258 VSS.n185 VSS.n141 0.101071
R1259 VSS.n186 VSS.n140 0.101071
R1260 VSS.n187 VSS.n186 0.0885
R1261 VSS.n186 VSS.n185 0.0885
R1262 VSS.n185 VSS.n184 0.0885
R1263 VSS.n184 VSS.n183 0.0885
R1264 VSS.n183 VSS.n182 0.0885
R1265 VSS.n182 VSS.n181 0.0885
R1266 VSS.n181 VSS.n180 0.0885
R1267 VSS.n180 VSS.n179 0.0885
R1268 VSS.n179 VSS.n178 0.0885
R1269 VSS.n178 VSS.n177 0.0885
R1270 VSS.n176 VSS.n175 0.0885
R1271 VSS.n175 VSS.n174 0.0885
R1272 VSS.n174 VSS.n173 0.0885
R1273 VSS.n173 VSS.n172 0.0885
R1274 VSS.n172 VSS.n171 0.0885
R1275 VSS.n171 VSS.n170 0.0885
R1276 VSS.n170 VSS.n169 0.0885
R1277 VSS.n168 VSS.n167 0.0885
R1278 VSS.n167 VSS.n166 0.0885
R1279 VSS.n166 VSS.n165 0.0885
R1280 VSS.n165 VSS.n164 0.0885
R1281 VSS.n164 VSS.n163 0.0885
R1282 VSS.n163 VSS.n162 0.0885
R1283 VSS.n162 VSS.n161 0.0885
R1284 VSS.n464 VSS.n39 0.0846837
R1285 VSS.n21 VSS.n15 0.0779076
R1286 VSS.n450 VSS 0.27725
R1287 VSS.n22 VSS.n134 0.0974748
R1288 VSS.n1 VSS.n5 0.134323
R1289 VSS.n4 VSS.n7 0.133313
R1290 VSS.n19 VSS.n16 0.0585658
R1291 VSS.n18 VSS.n16 0.116817
R1292 VSS.n18 VSS.n17 0.116817
R1293 VSS.n14 VSS.n13 0.0585658
R1294 VSS.n50 VSS.n13 0.116817
R1295 VSS.n25 VSS.n10 0.116817
R1296 VSS.n168 VSS.n30 0.0759286
R1297 VSS.n167 VSS.n155 0.0759286
R1298 VSS.n166 VSS.n156 0.0759286
R1299 VSS.n164 VSS.n158 0.0759286
R1300 VSS.n162 VSS.n160 0.0759286
R1301 VSS.n176 VSS.n34 0.0759286
R1302 VSS.n175 VSS.n149 0.0759286
R1303 VSS.n174 VSS.n150 0.0759286
R1304 VSS.n172 VSS.n152 0.0759286
R1305 VSS.n170 VSS.n154 0.0759286
R1306 VSS.n187 VSS.n26 0.0759286
R1307 VSS.n184 VSS.n142 0.0759286
R1308 VSS.n183 VSS.n143 0.0759286
R1309 VSS.n182 VSS.n144 0.0759286
R1310 VSS.n180 VSS.n146 0.0759286
R1311 VSS.n178 VSS.n148 0.0759286
R1312 VSS.n51 VSS.n39 0.0594056
R1313 VSS.n25 VSS.n24 0.0594056
R1314 VSS.n51 VSS.n50 0.0586497
R1315 VSS.n17 VSS.n24 0.0586497
R1316 VSS.n451 VSS.n450 0.0545
R1317 VSS.n11 VSS.n2 0.0539757
R1318 VSS.n103 VSS.n8 0.0529665
R1319 VSS.n7 VSS.n6 0.0527701
R1320 VSS.n457 VSS.n456 0.0519573
R1321 VSS.n102 VSS.n5 0.0517609
R1322 VSS.n86 VSS.n85 0.0507518
R1323 VSS.n104 VSS.n102 0.0480833
R1324 VSS.n456 VSS.n59 0.0474161
R1325 VSS.n6 VSS.n59 0.0470742
R1326 VSS.n108 VSS.n3 0.078073
R1327 VSS.n4 VSS.n3 0.0161352
R1328 VSS.n104 VSS.n103 0.0464069
R1329 VSS.n161 VSS.n33 0.110444
R1330 VSS.n169 VSS.n37 0.110444
R1331 VSS.n85 VSS.n2 0.0939903
R1332 VSS.n38 VSS.n1 0.0937261
R1333 VSS.n108 VSS.n9 0.0884022
R1334 VSS.n12 VSS.n38 0.0873931
R1335 VSS.n187 VSS.n0 4.03921
R1336 a_11798_1860.n0 a_11798_1860.n4 9.42143
R1337 a_11798_1860.n1 a_11798_1860.n12 9.42143
R1338 a_11798_1860.n1 a_11798_1860.n5 9.42143
R1339 a_11798_1860.n1 a_11798_1860.n6 9.42143
R1340 a_11798_1860.n2 a_11798_1860.n9 9.42143
R1341 a_11798_1860.n2 a_11798_1860.n7 9.42143
R1342 a_11798_1860.n4 a_11798_1860.t15 3.60374
R1343 a_11798_1860.n5 a_11798_1860.t21 3.60255
R1344 a_11798_1860.n6 a_11798_1860.t22 3.60255
R1345 a_11798_1860.n7 a_11798_1860.t28 3.60255
R1346 a_11798_1860.n4 a_11798_1860.t16 3.45423
R1347 a_11798_1860.n13 a_11798_1860.t17 3.45423
R1348 a_11798_1860.n11 a_11798_1860.t19 3.45423
R1349 a_11798_1860.n5 a_11798_1860.t20 3.45423
R1350 a_11798_1860.n12 a_11798_1860.t18 3.45423
R1351 a_11798_1860.n6 a_11798_1860.t23 3.45423
R1352 a_11798_1860.n10 a_11798_1860.t24 3.45423
R1353 a_11798_1860.n8 a_11798_1860.t26 3.45423
R1354 a_11798_1860.n7 a_11798_1860.t27 3.45423
R1355 a_11798_1860.n9 a_11798_1860.t25 3.45423
R1356 a_11798_1860.t14 a_11798_1860.n3 2.61386
R1357 a_11798_1860.n0 a_11798_1860.t0 2.61061
R1358 a_11798_1860.n3 a_11798_1860.t13 2.56233
R1359 a_11798_1860.n3 a_11798_1860.t12 2.56233
R1360 a_11798_1860.n2 a_11798_1860.t11 2.56233
R1361 a_11798_1860.n1 a_11798_1860.t7 2.5622
R1362 a_11798_1860.n1 a_11798_1860.t8 2.56207
R1363 a_11798_1860.n2 a_11798_1860.t10 2.56173
R1364 a_11798_1860.n0 a_11798_1860.t2 2.56173
R1365 a_11798_1860.n1 a_11798_1860.t5 2.5617
R1366 a_11798_1860.n1 a_11798_1860.t9 2.56161
R1367 a_11798_1860.n1 a_11798_1860.t6 2.5616
R1368 a_11798_1860.n0 a_11798_1860.t3 2.56159
R1369 a_11798_1860.n1 a_11798_1860.t4 2.56146
R1370 a_11798_1860.n0 a_11798_1860.t1 2.5613
R1371 a_11798_1860.n2 a_11798_1860.n1 0.245563
R1372 a_11798_1860.n8 a_11798_1860.n7 0.225083
R1373 a_11798_1860.n6 a_11798_1860.n10 0.225083
R1374 a_11798_1860.n11 a_11798_1860.n5 0.225083
R1375 a_11798_1860.n4 a_11798_1860.n13 0.225083
R1376 a_11798_1860.n1 a_11798_1860.n0 0.196551
R1377 a_11798_1860.n13 a_11798_1860.n12 0.1875
R1378 a_11798_1860.n12 a_11798_1860.n11 0.1875
R1379 a_11798_1860.n10 a_11798_1860.n9 0.1875
R1380 a_11798_1860.n9 a_11798_1860.n8 0.1875
R1381 a_11798_1860.n3 a_11798_1860.n2 0.147538
R1382 a_5428_3064.n0 a_5428_3064.t0 36.3628
R1383 a_5428_3064.n0 a_5428_3064.t1 35.246
R1384 a_5428_3064.t2 a_5428_3064.n0 15.3137
R1385 a_1474_1770.n0 a_1474_1770.t2 60.5214
R1386 a_1474_1770.n0 a_1474_1770.t1 33.8343
R1387 a_1474_1770.n1 a_1474_1770.n0 12.0028
R1388 a_1474_1770.t0 a_1474_1770.n1 2.87353
R1389 a_1474_1770.t0 a_1474_1770.n1 2.86853
R1390 a_1954_3500.n0 a_1954_3500.t2 44.3673
R1391 a_1954_3500.n0 a_1954_3500.t0 27.0418
R1392 a_1954_3500.t1 a_1954_3500.n0 12.2034
R1393 a_1254_3500.n0 a_1254_3500.t2 36.0512
R1394 a_1254_3500.n0 a_1254_3500.t3 33.7412
R1395 a_1254_3500.n3 a_1254_3500.t1 26.8072
R1396 a_1254_3500.n1 a_1254_3500.t5 26.0905
R1397 a_1254_3500.n1 a_1254_3500.t4 24.7412
R1398 a_1254_3500.t0 a_1254_3500.n3 12.4381
R1399 a_1254_3500.n3 a_1254_3500.n2 9.512
R1400 a_1254_3500.n2 a_1254_3500.n1 9.0005
R1401 a_1254_3500.n2 a_1254_3500.n0 0.7705
R1402 a_2654_5520.n1 a_2654_5520.t4 36.3944
R1403 a_2654_5520.n0 a_2654_5520.t0 34.4012
R1404 a_2654_5520.n0 a_2654_5520.t2 22.0391
R1405 a_2654_5520.n2 a_2654_5520.n1 9.0005
R1406 a_2654_5520.n2 a_2654_5520.t3 5.84394
R1407 a_2654_5520.t1 a_2654_5520.n2 4.67685
R1408 a_2654_5520.n1 a_2654_5520.n0 0.3173
R1409 vco_bias_0.vbn_buf.n3 vco_bias_0.vbn_buf.t1 55.3125
R1410 vco_bias_0.vbn_buf.n1 vco_bias_0.vbn_buf.t4 34.2391
R1411 vco_bias_0.vbn_buf.n1 vco_bias_0.vbn_buf.t3 28.5544
R1412 vco_bias_0.vbn_buf.n2 vco_bias_0.vbn_buf.n1 23.0981
R1413 vco_bias_0.vbn_buf.n0 vco_bias_0.vbn_buf.t2 21.7736
R1414 vco_bias_0.vbn_buf.n2 vco_bias_0.vbn_buf.t0 21.4968
R1415 vco_bias_0.vbn_buf vco_bias_0.vbn_buf.n0 20.8275
R1416 vco_bias_0.vbn_buf.n3 vco_bias_0.vbn_buf.n2 3.1069
R1417 vco_bias_0.vbn_buf vco_bias_0.vbn_buf.n3 1.2149
R1418 vco_bias_0.vbn_buf.n0 vco_bias_0.vbn_buf 0.1105
C59 vtune VSS 2.62544e-15
C60 vco_ind_LC VSS 3.68761e-12
C61 vdd_core VSS 6.19658e-17
C62 ibias_100u VSS 1.96578e-15
C63 rf_out_p VSS 1.97476e-15
C64 rf_out_n VSS 1.94669e-15
C65 momf4_A VSS 3.40409e-15
C66 momf3_B VSS 3.30326e-15
C67 di_en VSS 7.88829e-16
C68 vco_ind_LA VSS 9.87797e-15
C69 momf3_A VSS 2.69002e-16
C70 vco_var_rf_p VSS 1.42287e-15
C71 vco_ind_LB VSS 1.45101e-14
C72 momf4_B VSS 3.13055e-16
C73 vco_var_rf_n VSS 1.68807e-15
C74 VDD VSS 3.7091e-14
C75 vco_bias_0.vbg_buf VSS 1.1255e-13 ; **FLOATING
C76 vco_bias_0.vbn_buf VSS 1.08549e-13 ; **FLOATING
C77 vco_bias_0.vbn_buf.t2 VSS 1.4391e-15 ; **FLOATING
C78 vco_bias_0.vbn_buf.n0 VSS 9.77717e-17 ; **FLOATING
C79 vco_bias_0.vbn_buf.t4 VSS 6.42018e-15 ; **FLOATING
C80 vco_bias_0.vbn_buf.t3 VSS 6.41132e-15 ; **FLOATING
C81 vco_bias_0.vbn_buf.n1 VSS 2.02124e-16 ; **FLOATING
C82 vco_bias_0.vbn_buf.t0 VSS 2.26027e-17 ; **FLOATING
C83 vco_bias_0.vbn_buf.n2 VSS 1.8774e-16 ; **FLOATING
C84 vco_bias_0.vbn_buf.t1 VSS 1.73618e-15 ; **FLOATING
C85 vco_bias_0.vbn_buf.n3 VSS 1.04482e-16 ; **FLOATING
C86 a_2654_5520.t3 VSS 1.34445e-16 ; **FLOATING
C87 a_2654_5520.t4 VSS 3.44894e-16 ; **FLOATING
C88 a_2654_5520.t2 VSS 1.24713e-16 ; **FLOATING
C89 a_2654_5520.t0 VSS 3.28981e-16 ; **FLOATING
C90 a_2654_5520.n0 VSS 4.37302e-16 ; **FLOATING
C91 a_2654_5520.n1 VSS 4.61358e-16 ; **FLOATING
C92 a_2654_5520.n2 VSS 3.59889e-16 ; **FLOATING
C93 a_2654_5520.t1 VSS 2.70398e-16 ; **FLOATING
C94 a_1254_3500.t1 VSS 2.85412e-17 ; **FLOATING
C95 a_1254_3500.t2 VSS 1.39009e-16 ; **FLOATING
C96 a_1254_3500.t3 VSS 1.13976e-16 ; **FLOATING
C97 a_1254_3500.n0 VSS 8.30834e-16 ; **FLOATING
C98 a_1254_3500.t5 VSS 8.72469e-17 ; **FLOATING
C99 a_1254_3500.t4 VSS 6.70561e-17 ; **FLOATING
C100 a_1254_3500.n1 VSS 4.46695e-16 ; **FLOATING
C101 a_1254_3500.n2 VSS 2.20385e-16 ; **FLOATING
C102 a_1254_3500.n3 VSS 4.06692e-16 ; **FLOATING
C103 a_1254_3500.t0 VSS 8.52449e-17 ; **FLOATING
C104 a_1954_3500.t0 VSS 2.36015e-17 ; **FLOATING
C105 a_1954_3500.t2 VSS 1.85568e-16 ; **FLOATING
C106 a_1954_3500.n0 VSS 5.48222e-16 ; **FLOATING
C107 a_1954_3500.t1 VSS 6.36391e-17 ; **FLOATING
C108 a_1474_1770.t1 VSS 4.39397e-16 ; **FLOATING
C109 a_1474_1770.t2 VSS 1.58149e-15 ; **FLOATING
C110 a_1474_1770.n0 VSS 1.83146e-15 ; **FLOATING
C111 a_1474_1770.n1 VSS 3.50213e-16 ; **FLOATING
C112 a_1474_1770.t0 VSS 2.36062e-16 ; **FLOATING
C113 a_5428_3064.t0 VSS 5.62261e-16 ; **FLOATING
C114 a_5428_3064.t1 VSS 3.37964e-16 ; **FLOATING
C115 a_5428_3064.n0 VSS 1.18869e-15 ; **FLOATING
C116 a_5428_3064.t2 VSS 3.87975e-16 ; **FLOATING
C117 a_11798_1860.n0 VSS 1.59937e-15 ; **FLOATING
C118 a_11798_1860.n1 VSS 2.75467e-15 ; **FLOATING
C119 a_11798_1860.n2 VSS 1.1238e-15 ; **FLOATING
C120 a_11798_1860.n3 VSS 1.05905e-15 ; **FLOATING
C121 a_11798_1860.n4 VSS 1.10992e-16 ; **FLOATING
C122 a_11798_1860.n5 VSS 1.10992e-16 ; **FLOATING
C123 a_11798_1860.n6 VSS 1.10992e-16 ; **FLOATING
C124 a_11798_1860.n7 VSS 1.10992e-16 ; **FLOATING
C125 a_11798_1860.t28 VSS 5.21287e-17 ; **FLOATING
C126 a_11798_1860.t25 VSS 5.57833e-17 ; **FLOATING
C127 a_11798_1860.t26 VSS 5.57833e-17 ; **FLOATING
C128 a_11798_1860.t27 VSS 5.57833e-17 ; **FLOATING
C129 a_11798_1860.n8 VSS 6.23103e-17 ; **FLOATING
C130 a_11798_1860.n9 VSS 6.52068e-17 ; **FLOATING
C131 a_11798_1860.t23 VSS 5.57833e-17 ; **FLOATING
C132 a_11798_1860.t24 VSS 5.57833e-17 ; **FLOATING
C133 a_11798_1860.n10 VSS 6.23103e-17 ; **FLOATING
C134 a_11798_1860.t22 VSS 5.21287e-17 ; **FLOATING
C135 a_11798_1860.t21 VSS 5.21287e-17 ; **FLOATING
C136 a_11798_1860.t18 VSS 5.57833e-17 ; **FLOATING
C137 a_11798_1860.t19 VSS 5.57833e-17 ; **FLOATING
C138 a_11798_1860.t20 VSS 5.57833e-17 ; **FLOATING
C139 a_11798_1860.n11 VSS 6.23103e-17 ; **FLOATING
C140 a_11798_1860.n12 VSS 6.52068e-17 ; **FLOATING
C141 a_11798_1860.t16 VSS 5.57833e-17 ; **FLOATING
C142 a_11798_1860.t17 VSS 5.57833e-17 ; **FLOATING
C143 a_11798_1860.n13 VSS 6.23103e-17 ; **FLOATING
C144 a_11798_1860.t15 VSS 5.21287e-17 ; **FLOATING
C145 a_11798_1860.t0 VSS 1.681e-16 ; **FLOATING
C146 a_11798_1860.t1 VSS 1.63544e-16 ; **FLOATING
C147 a_11798_1860.t2 VSS 1.63544e-16 ; **FLOATING
C148 a_11798_1860.t3 VSS 1.63544e-16 ; **FLOATING
C149 a_11798_1860.t4 VSS 1.63544e-16 ; **FLOATING
C150 a_11798_1860.t5 VSS 1.63544e-16 ; **FLOATING
C151 a_11798_1860.t6 VSS 1.63544e-16 ; **FLOATING
C152 a_11798_1860.t7 VSS 1.63544e-16 ; **FLOATING
C153 a_11798_1860.t8 VSS 1.63544e-16 ; **FLOATING
C154 a_11798_1860.t9 VSS 1.63544e-16 ; **FLOATING
C155 a_11798_1860.t10 VSS 1.63544e-16 ; **FLOATING
C156 a_11798_1860.t11 VSS 1.63544e-16 ; **FLOATING
C157 a_11798_1860.t12 VSS 1.63544e-16 ; **FLOATING
C158 a_11798_1860.t13 VSS 1.63544e-16 ; **FLOATING
C159 a_11798_1860.t14 VSS 1.68068e-16 ; **FLOATING
C160 VDD.t2 VSS 2.01406e-16 ; **FLOATING
C161 VDD.t3 VSS 3.28788e-17 ; **FLOATING
C162 VDD.n0 VSS 1.12735e-16 ; **FLOATING
C163 VDD.t4 VSS 2.01406e-16 ; **FLOATING
C164 VDD.t5 VSS 3.28788e-17 ; **FLOATING
C165 VDD.n1 VSS 4.15376e-17 ; **FLOATING
C166 VDD.n2 VSS 1.2543e-16 ; **FLOATING
C167 VDD.t0 VSS 7.07241e-17 ; **FLOATING
C168 VDD.n3 VSS 5.19444e-17 ; **FLOATING
C169 VDD.n4 VSS 9.48216e-17 ; **FLOATING
C170 VDD.t6 VSS 7.07241e-17 ; **FLOATING
C171 VDD.n5 VSS 5.19444e-17 ; **FLOATING
C172 VDD.n6 VSS 7.31176e-17 ; **FLOATING
C173 VDD.t10 VSS 7.07241e-17 ; **FLOATING
C174 VDD.n7 VSS 5.19444e-17 ; **FLOATING
C175 VDD.n8 VSS 1.67563e-16 ; **FLOATING
C176 VDD.t9 VSS 1.07656e-15 ; **FLOATING
C177 VDD.t8 VSS 7.15925e-16 ; **FLOATING
C178 VDD.n9 VSS 9.4539e-16 ; **FLOATING
C179 vco_ind_LB.n0 VSS 1.30449e-16 ; **FLOATING
C180 vco_ind_LB.n1 VSS 2.72011e-17 ; **FLOATING
C181 vco_ind_LB.n2 VSS 8.07529e-16 ; **FLOATING
C182 vco_ind_LB.n3 VSS 7.27671e-16 ; **FLOATING
C183 vco_ind_LB.t5 VSS 3.86789e-16 ; **FLOATING
C184 vco_ind_LB.t4 VSS 1.52377e-17 ; **FLOATING
C185 vco_ind_LB.t3 VSS 1.52377e-17 ; **FLOATING
C186 vco_ind_LB.t0 VSS 1.5357e-17 ; **FLOATING
C187 vco_ind_LB.t2 VSS 1.5715e-17 ; **FLOATING
C188 vco_ind_LB.t1 VSS 1.52377e-17 ; **FLOATING
C189 vco_ind_LA.n0 VSS 1.18197e-16 ; **FLOATING
C190 vco_ind_LA.n1 VSS 2.46444e-17 ; **FLOATING
C191 vco_ind_LA.n2 VSS 9.90678e-16 ; **FLOATING
C192 vco_ind_LA.t5 VSS 2.42949e-16 ; **FLOATING
C193 vco_ind_LA.n3 VSS 7.17206e-16 ; **FLOATING
C194 vco_ind_LA.t2 VSS 1.42354e-17 ; **FLOATING
C195 vco_ind_LA.t4 VSS 1.38087e-17 ; **FLOATING
C196 vco_ind_LA.t3 VSS 1.39171e-17 ; **FLOATING
C197 vco_ind_LA.t1 VSS 1.38087e-17 ; **FLOATING
C198 vco_ind_LA.t0 VSS 1.38087e-17 ; **FLOATING
C199 di_en.t1 VSS 5.29034e-17 ; **FLOATING
C200 di_en.t0 VSS 3.86604e-17 ; **FLOATING
C201 di_en.n0 VSS 2.71397e-16 ; **FLOATING
C202 momf3_B.t0 VSS 3.663e-16 ; **FLOATING
C203 momf3_B.t1 VSS 4.13202e-16 ; **FLOATING
C204 momf3_B.n0 VSS 1.04836e-15 ; **FLOATING
C205 momf4_A.t0 VSS 3.9605e-16 ; **FLOATING
C206 momf4_A.t1 VSS 4.10218e-16 ; **FLOATING
C207 momf4_A.n0 VSS 1.03468e-15 ; **FLOATING
C208 rf_out_n.n0 VSS 3.1584e-16 ; **FLOATING
C209 rf_out_n.n1 VSS 3.91199e-16 ; **FLOATING
C210 rf_out_n.t6 VSS 7.86145e-16 ; **FLOATING
C211 rf_out_n.t5 VSS 5.0759e-17 ; **FLOATING
C212 rf_out_n.t2 VSS 5.00081e-17 ; **FLOATING
C213 rf_out_n.t1 VSS 5.00081e-17 ; **FLOATING
C214 rf_out_n.t4 VSS 5.00081e-17 ; **FLOATING
C215 rf_out_n.t3 VSS 5.00081e-17 ; **FLOATING
C216 rf_out_n.t0 VSS 5.00081e-17 ; **FLOATING
C217 rf_out_n.n2 VSS 3.82241e-16 ; **FLOATING
C218 rf_out_p.n0 VSS 4.36367e-16 ; **FLOATING
C219 rf_out_p.n1 VSS 2.71901e-16 ; **FLOATING
C220 rf_out_p.t6 VSS 7.9592e-16 ; **FLOATING
C221 rf_out_p.t0 VSS 5.08465e-17 ; **FLOATING
C222 rf_out_p.t1 VSS 5.00924e-17 ; **FLOATING
C223 rf_out_p.t2 VSS 5.00924e-17 ; **FLOATING
C224 rf_out_p.t4 VSS 5.00924e-17 ; **FLOATING
C225 rf_out_p.t5 VSS 5.00924e-17 ; **FLOATING
C226 rf_out_p.t3 VSS 5.00924e-17 ; **FLOATING
C227 rf_out_p.n2 VSS 3.82901e-16 ; **FLOATING
C228 ibias_100u.t4 VSS 1.72205e-16 ; **FLOATING
C229 ibias_100u.t3 VSS 1.81613e-16 ; **FLOATING
C230 ibias_100u.n0 VSS 2.21645e-16 ; **FLOATING
C231 ibias_100u.t2 VSS 1.70586e-16 ; **FLOATING
C232 ibias_100u.n1 VSS 1.41175e-16 ; **FLOATING
C233 ibias_100u.t0 VSS 8.43e-17 ; **FLOATING
C234 ibias_100u.n2 VSS 2.07529e-16 ; **FLOATING
C235 ibias_100u.t1 VSS 1.3532e-15 ; **FLOATING
C236 ibias_100u.n3 VSS 3.99234e-16 ; **FLOATING
C237 vco_ind_LC.n0 VSS 3.53919e-17 ; **FLOATING
C238 vco_ind_LC.n2 VSS 1.26208e-16 ; **FLOATING
C239 vco_ind_LC.n4 VSS 1.2529e-16 ; **FLOATING
C240 vco_ind_LC.n29 VSS 1.1015e-16 ; **FLOATING
C241 vco_ind_LC.n30 VSS 1.44404e-17 ; **FLOATING
C242 vco_ind_LC.n31 VSS 1.44404e-17 ; **FLOATING
C243 vco_ind_LC.n32 VSS 2.40773e-17 ; **FLOATING
C244 vco_ind_LC.n34 VSS 1.44404e-17 ; **FLOATING
C245 vco_ind_LC.n35 VSS 4.32612e-17 ; **FLOATING
C246 vco_ind_LC.n36 VSS 1.44404e-17 ; **FLOATING
C247 vco_ind_LC.n37 VSS 1.44404e-17 ; **FLOATING
C248 vco_ind_LC.n38 VSS 2.78322e-17 ; **FLOATING
C249 vco_ind_LC.n39 VSS 2.59507e-16 ; **FLOATING
C250 vco_ind_LC.n40 VSS 2.60426e-16 ; **FLOATING
C251 vco_ind_LC.n43 VSS 2.73139e-16 ; **FLOATING
C252 vco_ind_LC.n46 VSS 2.74107e-16 ; **FLOATING
C253 vco_ind_LC.n48 VSS 2.73139e-16 ; **FLOATING
C254 vco_ind_LC.n50 VSS 2.74107e-16 ; **FLOATING
C255 vco_ind_LC.n52 VSS 3.0928e-17 ; **FLOATING
C256 vco_ind_LC.n70 VSS 1.17221e-16 ; **FLOATING
C257 vco_ind_LC.n102 VSS 1.17221e-16 ; **FLOATING
C258 vco_ind_LC.n116 VSS 1.18199e-16 ; **FLOATING
C259 vco_ind_LC.n129 VSS 1.18199e-16 ; **FLOATING
C260 vco_ind_LC.n138 VSS 2.11013e-17 ; **FLOATING
Cpexcaps0 VDD a_1254_3500.n0 2.5114e-16
Cpexcaps1 a_2654_5520.n0 vco_bias_0.vbg_buf 2.279e-16
Cpexcaps2 a_11798_1860.n0 rf_out_n 2.93481e-15
Cpexcaps3 a_5428_3064.n0 a_6760_4930# 6.026e-17
Cpexcaps4 a_1474_1770.n0 a_5428_3064.n0 6.9174e-16
Cpexcaps5 a_1254_3500.n0 a_2654_5520.n0 1.486e-16
Cpexcaps6 a_2654_5520.n0 ibias_100u 7.0174e-16
Cpexcaps7 a_11798_1860.n0 rf_out_p 2.93481e-15
Cpexcaps8 a_1254_3500.n0 vco_bias_0.vbn_buf 2.0161e-16
Cpexcaps9 a_1254_3500.n0 di_en 3.8176e-16
Cpexcaps10 a_1254_3500.n0 vco_bias_0.vbg_buf 1.0514e-16
Cpexcaps11 a_1160_2070# a_1474_1770.n0 2.728e-17
Cpexcaps12 VDD a_1474_1770.n0 3.0901e-16
Cpexcaps13 a_1254_3500.n0 ibias_100u 7.4091e-16
Cpexcaps14 a_1474_1770.n0 a_1560_1770# 3.564e-17
Cpexcaps15 a_1474_1770.n0 a_2654_5520.n0 1.58315e-15
Cpexcaps16 VDD a_1954_3500.n0 2.499e-16
Cpexcaps17 a_1474_1770.n0 vco_bias_0.vbn_buf 5.6919e-16
Cpexcaps18 a_11798_1860.n0 vtune 3.5352e-16
Cpexcaps19 a_11798_1860.n0 momf3_B 4.2594e-16
Cpexcaps20 a_1474_1770.n0 vco_bias_0.vbg_buf 5.405e-17
Cpexcaps21 a_1954_3500.n0 a_2654_5520.n0 1.9776e-16
Cpexcaps22 a_1954_3500.n0 vco_bias_0.vbn_buf 8.537e-17
Cpexcaps23 a_1254_3500.n0 a_1474_1770.n0 1.6094e-16
Cpexcaps24 a_1474_1770.n0 ibias_100u 4.1864e-16
Cpexcaps25 a_1954_3500.n0 vco_bias_0.vbg_buf 9.645e-17
Cpexcaps26 a_1254_3500.n0 a_1954_3500.n0 6.8546e-16
Cpexcaps27 a_1954_3500.n0 ibias_100u 3.3716e-16
Cpexcaps28 a_1474_1770.n0 a_6760_4930# 3.094e-17
Cpexcaps29 a_2654_5520.n0 a_5428_3064.n0 1.7543e-16
Cpexcaps30 a_5428_3064.n0 vco_bias_0.vbn_buf 1.33114e-15
Cpexcaps31 a_1474_1770.n0 a_1954_3500.n0 1.0623e-16
Cpexcaps32 a_5428_3064.n0 vco_bias_0.vbg_buf 5.862e-17
Cpexcaps33 a_1254_3500.n0 a_5428_3064.n0 1.008e-17
Cpexcaps34 VDD a_2654_5520.n0 1.33799e-15
Cpexcaps35 a_11798_1860.n0 vco_bias_0.vbn_buf 6.1891e-15
Cpexcaps36 a_2654_5520.n0 vco_bias_0.vbn_buf 2.9456e-16
Cpexcaps37 a_11798_1860.n0 momf4_A 4.2594e-16
* MoM caps cut out of the extraction (drop_subcells.py --cut), back as PDK devices by momf_lpe.py
* momf3: cap_cmomf w=10.0u l=18.6u Metal2 to Metal4 in vco_buf, Palace order 3 volume metal, open-short at 10 and 20 GHz, cs from Magic C-coupled
Rmomf3a momf3_A momf3_ra 0.4488
Lmomf3a momf3_ra momf3_a 2.4495e-12
Xmomf3 momf3_a momf3_b cap_cmomf w=10.0e-6 l=18.6e-6 mmin=2 mmax=4 subblock=0 m=1 mm_ok=1
Lmomf3b momf3_b momf3_rb 2.4495e-12
Rmomf3b momf3_rb momf3_B 0.4488
Cmomf3a momf3_a VSS 4.866e-15
Cmomf3b momf3_b VSS 4.866e-15
* momf4: cap_cmomf w=10.0u l=18.6u Metal2 to Metal4 in vco_buf, Palace order 3 volume metal, open-short at 10 and 20 GHz, cs from Magic C-coupled
Rmomf4a momf4_A momf4_ra 0.4488
Lmomf4a momf4_ra momf4_a 2.4495e-12
Xmomf4 momf4_a momf4_b cap_cmomf w=10.0e-6 l=18.6e-6 mmin=2 mmax=4 subblock=0 m=1 mm_ok=1
Lmomf4b momf4_b momf4_rb 2.4495e-12
Rmomf4b momf4_rb momf4_B 0.4488
Cmomf4a momf4_a VSS 4.866e-15
Cmomf4b momf4_b VSS 4.866e-15
.ends
