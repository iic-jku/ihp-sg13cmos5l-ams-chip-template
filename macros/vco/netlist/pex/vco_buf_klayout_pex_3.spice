* NGSPICE file created from vco_buf_pex.ext - technology: ihp-sg13cmos5l

.subckt vco_buf_pex vbn_buf vbg_buf VDD VSS rf_p rf_n rf_out_p rf_out_n
X0 a_n2502_n1000# vbn_buf VSS VSS.t32 sg13_lv_nmos ad=0.95p pd=5.38u as=0.95p ps=5.38u w=5u l=0.5u
X1 a_n2502_n1000# vbn_buf VSS VSS.t34 sg13_lv_nmos ad=0.95p pd=5.38u as=0.95p ps=5.38u w=5u l=0.5u
X2 VSS vbn_buf a_n2502_n1000# VSS.t47 sg13_lv_nmos ad=0.95p pd=5.38u as=0.95p ps=5.38u w=5u l=0.5u
X3 VSS vbn_buf a_n2502_n1000# VSS.t49 sg13_lv_nmos ad=0.95p pd=5.38u as=0.95p ps=5.38u w=5u l=0.5u
X4 a_n2502_n1000# a_n4900_2020# rf_out_n VSS.t21 sg13_lv_nmos ad=0.38p pd=2.38u as=0.38p ps=2.38u w=2u l=0.13u
X5 a_n2502_n1000# vbn_buf VSS VSS.t48 sg13_lv_nmos ad=0.95p pd=5.38u as=0.95p ps=5.38u w=5u l=0.5u
X6 a_n2502_n1000# a_n4900_2020# rf_out_n VSS.t19 sg13_lv_nmos ad=0.38p pd=2.38u as=0.38p ps=2.38u w=2u l=0.13u
X7 rf_out_n a_n4900_2020# a_n2502_n1000# VSS.t20 sg13_lv_nmos ad=0.38p pd=2.38u as=0.38p ps=2.38u w=2u l=0.13u
X8 VSS vbn_buf a_n2502_n1000# VSS.t31 sg13_lv_nmos ad=0.95p pd=5.38u as=0.95p ps=5.38u w=5u l=0.5u
X9 a_n2502_n1000# vbn_buf VSS VSS.t40 sg13_lv_nmos ad=0.95p pd=5.38u as=0.95p ps=5.38u w=5u l=0.5u
X10 a_n2502_n1000# vbn_buf VSS VSS.t50 sg13_lv_nmos ad=0.95p pd=5.38u as=0.95p ps=5.38u w=5u l=0.5u
X11 rf_out_n a_n4900_2020# a_n2502_n1000# VSS.t18 sg13_lv_nmos ad=0.38p pd=2.38u as=0.38p ps=2.38u w=2u l=0.13u
X12 rf_out_p a_368_464# a_n2502_n1000# VSS.t1 sg13_lv_nmos ad=0.38p pd=2.38u as=0.68p ps=4.68u w=2u l=0.13u
X13 rf_out_n a_n4900_2020# a_n2502_n1000# VSS.t16 sg13_lv_nmos ad=0.38p pd=2.38u as=0.38p ps=2.38u w=2u l=0.13u
X14 a_n2502_n1000# a_n4900_2020# rf_out_n VSS.t17 sg13_lv_nmos ad=0.38p pd=2.38u as=0.38p ps=2.38u w=2u l=0.13u
X15 a_n2502_n1000# a_368_464# rf_out_p VSS.t2 sg13_lv_nmos ad=0.38p pd=2.38u as=0.38p ps=2.38u w=2u l=0.13u
X16 a_n2502_n1000# vbn_buf VSS VSS.t30 sg13_lv_nmos ad=0.95p pd=5.38u as=0.95p ps=5.38u w=5u l=0.5u
X17 VSS vbn_buf a_n2502_n1000# VSS.t39 sg13_lv_nmos ad=0.95p pd=5.38u as=0.95p ps=5.38u w=5u l=0.5u
X18 VSS vbn_buf a_n2502_n1000# VSS.t51 sg13_lv_nmos ad=0.95p pd=5.38u as=0.95p ps=5.38u w=5u l=0.5u
X19 a_n2502_n1000# a_n4900_2020# rf_out_n VSS.t15 sg13_lv_nmos ad=0.38p pd=2.38u as=0.38p ps=2.38u w=2u l=0.13u
X20 rf_out_p a_368_464# a_n2502_n1000# VSS.t3 sg13_lv_nmos ad=0.38p pd=2.38u as=0.38p ps=2.38u w=2u l=0.13u
X21 a_n2502_n1000# a_368_464# rf_out_p VSS.t4 sg13_lv_nmos ad=0.38p pd=2.38u as=0.38p ps=2.38u w=2u l=0.13u
X22 a_n2502_n1000# vbn_buf VSS VSS.t42 sg13_lv_nmos ad=0.95p pd=5.38u as=0.95p ps=5.38u w=5u l=0.5u
X23 rf_out_n a_n4900_2020# a_n2502_n1000# VSS.t14 sg13_lv_nmos ad=0.38p pd=2.38u as=0.68p ps=4.68u w=2u l=0.13u
X24 a_n2502_n1000# vbn_buf VSS VSS.t38 sg13_lv_nmos ad=0.95p pd=5.38u as=0.95p ps=5.38u w=5u l=0.5u
X25 a_n2502_n1000# vbn_buf VSS VSS.t52 sg13_lv_nmos ad=0.95p pd=5.38u as=0.95p ps=5.38u w=5u l=0.5u
X26 rf_out_p a_368_464# a_n2502_n1000# VSS.t5 sg13_lv_nmos ad=0.38p pd=2.38u as=0.38p ps=2.38u w=2u l=0.13u
X27 vbg_buf a_n4900_2020# VSS.t0 rhigh l=8u w=0.5u
X28 vbg_buf a_368_464# VSS.t13 rhigh l=8u w=0.5u
X29 VDD rf_out_p VSS.t13 rppd l=1.65u w=10u
X30 a_n2502_n1000# a_368_464# rf_out_p VSS.t6 sg13_lv_nmos ad=0.38p pd=2.38u as=0.38p ps=2.38u w=2u l=0.13u
X31 VDD rf_out_n VSS.t0 rppd l=1.65u w=10u
X32 rf_out_p a_368_464# a_n2502_n1000# VSS.t7 sg13_lv_nmos ad=0.38p pd=2.38u as=0.38p ps=2.38u w=2u l=0.13u
X33 VSS vbn_buf a_n2502_n1000# VSS.t37 sg13_lv_nmos ad=0.95p pd=5.38u as=0.95p ps=5.38u w=5u l=0.5u
X34 a_n2502_n1000# vbn_buf VSS VSS.t28 sg13_lv_nmos ad=0.95p pd=5.38u as=0.95p ps=5.38u w=5u l=0.5u
X35 VSS vbn_buf a_n2502_n1000# VSS.t35 sg13_lv_nmos ad=0.95p pd=5.38u as=0.95p ps=5.38u w=5u l=0.5u
X36 a_n2502_n1000# vbn_buf VSS VSS.t44 sg13_lv_nmos ad=0.95p pd=5.38u as=0.95p ps=5.38u w=5u l=0.5u
X37 a_n2502_n1000# vbn_buf VSS VSS.t46 sg13_lv_nmos ad=0.95p pd=5.38u as=0.95p ps=5.38u w=5u l=0.5u
X38 a_n2502_n1000# a_n4900_2020# rf_out_n VSS.t25 sg13_lv_nmos ad=0.68p pd=4.68u as=0.38p ps=2.38u w=2u l=0.13u
X39 a_n2502_n1000# a_368_464# rf_out_p VSS.t8 sg13_lv_nmos ad=0.38p pd=2.38u as=0.38p ps=2.38u w=2u l=0.13u
X40 a_n2502_n1000# vbn_buf VSS VSS.t36 sg13_lv_nmos ad=0.95p pd=5.38u as=0.95p ps=5.38u w=5u l=0.5u
X41 rf_out_n a_n4900_2020# a_n2502_n1000# VSS.t24 sg13_lv_nmos ad=0.38p pd=2.38u as=0.38p ps=2.38u w=2u l=0.13u
X42 rf_out_p a_368_464# a_n2502_n1000# VSS.t9 sg13_lv_nmos ad=0.38p pd=2.38u as=0.38p ps=2.38u w=2u l=0.13u
X43 VSS vbn_buf a_n2502_n1000# VSS.t27 sg13_lv_nmos ad=0.95p pd=5.38u as=0.95p ps=5.38u w=5u l=0.5u
X44 VSS vbn_buf a_n2502_n1000# VSS.t29 sg13_lv_nmos ad=0.95p pd=5.38u as=0.95p ps=5.38u w=5u l=0.5u
X45 VSS vbn_buf a_n2502_n1000# VSS.t43 sg13_lv_nmos ad=0.95p pd=5.38u as=0.95p ps=5.38u w=5u l=0.5u
X46 VSS vbn_buf a_n2502_n1000# VSS.t45 sg13_lv_nmos ad=0.95p pd=5.38u as=0.95p ps=5.38u w=5u l=0.5u
X47 a_n2502_n1000# vbn_buf VSS VSS.t54 sg13_lv_nmos ad=0.95p pd=5.38u as=0.95p ps=5.38u w=5u l=0.5u
X48 a_n2502_n1000# a_n4900_2020# rf_out_n VSS.t23 sg13_lv_nmos ad=0.38p pd=2.38u as=0.38p ps=2.38u w=2u l=0.13u
X49 a_n2502_n1000# a_368_464# rf_out_p VSS.t10 sg13_lv_nmos ad=0.38p pd=2.38u as=0.38p ps=2.38u w=2u l=0.13u
X50 rf_out_n a_n4900_2020# a_n2502_n1000# VSS.t22 sg13_lv_nmos ad=0.38p pd=2.38u as=0.38p ps=2.38u w=2u l=0.13u
X51 rf_out_p a_368_464# a_n2502_n1000# VSS.t11 sg13_lv_nmos ad=0.38p pd=2.38u as=0.38p ps=2.38u w=2u l=0.13u
X52 a_n2502_n1000# a_368_464# rf_out_p VSS.t12 sg13_lv_nmos ad=0.68p pd=4.68u as=0.38p ps=2.38u w=2u l=0.13u
X53 VSS vbn_buf a_n2502_n1000# VSS.t33 sg13_lv_nmos ad=0.95p pd=5.38u as=0.95p ps=5.38u w=5u l=0.5u
X54 VSS vbn_buf a_n2502_n1000# VSS.t53 sg13_lv_nmos ad=0.95p pd=5.38u as=0.95p ps=5.38u w=5u l=0.5u
X55 a_n2502_n1000# vbn_buf VSS VSS.t26 sg13_lv_nmos ad=0.95p pd=5.38u as=1.7p ps=10.68u w=5u l=0.5u
X56 VSS vbn_buf a_n2502_n1000# VSS.t41 sg13_lv_nmos ad=0.95p pd=5.38u as=0.95p ps=5.38u w=5u l=0.5u
X57 VSS vbn_buf a_n2502_n1000# VSS.t55 sg13_lv_nmos ad=1.7p pd=10.68u as=0.95p ps=5.38u w=5u l=0.5u
C0 rf_n vbg_buf 1.35113f
C1 rf_n a_368_464# 0.15264p
C2 a_n2502_n1000# a_368_464# 0.42263f
C3 rf_out_n VDD 0.19202f
C4 vbn_buf a_n2502_n1000# 6.1891f
C5 rf_out_n a_n4200_1300# 0.47919f
C6 a_4800_2106# vbg_buf 0.03283f
C7 rf_out_n vbn_buf 0.21042f
C8 a_4800_2106# a_368_464# 0.04847f
C9 a_n4900_2106# a_n4900_2020# 0.04847f
C10 rf_out_n a_n2502_n1000# 2.93304f
C11 rf_n a_4800_2106# 0.0801f
C12 a_n4900_2106# vbg_buf 0.03283f
C13 VDD a_n4900_2020# 1.26121f
C14 vbg_buf a_n4900_2020# 0.04106f
C15 rf_out_p VDD 0.19202f
C16 rf_p a_n4900_2106# 0.0801f
C17 a_n4200_1300# a_n4900_2020# 0.15006f
C18 rf_out_p a_2200_1300# 0.47919f
C19 a_368_464# a_n4900_2020# 0.14854f
C20 vbn_buf a_n4900_2020# 0.05139f
C21 rf_p a_n4900_2020# 0.15264p
C22 rf_out_p a_368_464# 0.74832f
C23 rf_out_p vbn_buf 0.18157f
C24 VDD a_n4200_1300# 0.32132f
C25 VDD a_2200_1300# 0.32132f
C26 VDD a_368_464# 1.26121f
C27 a_368_464# vbg_buf 0.04106f
C28 VDD rf_p 0.04217f
C29 rf_p vbg_buf 1.35591f
C30 a_n4200_1300# vbn_buf 0.01619f
C31 a_2200_1300# a_368_464# 0.15006f
C32 vbn_buf a_368_464# 0.05139f
C33 a_n2502_n1000# a_n4900_2020# 0.42263f
C34 rf_out_p a_n2502_n1000# 2.93304f
C35 rf_out_n a_n4900_2020# 0.74832f
C36 rf_out_n rf_out_p 0.0144f
C37 VDD rf_n 0.04217f
R0 VSS.n19 VSS.t31 38.4392
R1 VSS.t50 VSS.n2 38.4392
R2 VSS.n22 VSS.t28 36.4993
R3 VSS.t53 VSS.n39 36.4993
R4 VSS.t40 VSS.n11 34.5594
R5 VSS.n11 VSS.t41 34.5594
R6 VSS.t29 VSS.n22 32.6196
R7 VSS.n39 VSS.t52 32.6196
R8 VSS.t26 VSS.t0 32.0083
R9 VSS.t13 VSS.t55 32.0083
R10 VSS.t30 VSS.n19 30.6797
R11 VSS.n2 VSS.t51 30.6797
R12 VSS.t54 VSS.n0 29.648
R13 VSS.n21 VSS.t27 29.6471
R14 VSS.n24 VSS.t15 29.5834
R15 VSS.t17 VSS.n16 29.5834
R16 VSS.n26 VSS.t19 29.5834
R17 VSS.t7 VSS.n6 29.5834
R18 VSS.n37 VSS.t9 29.5834
R19 VSS.t11 VSS.n3 29.5834
R20 VSS.t39 VSS.n30 28.7398
R21 VSS.n32 VSS.t42 28.7398
R22 VSS.t25 VSS.t38 28.6135
R23 VSS.t43 VSS.t1 28.6135
R24 VSS.t36 VSS.n13 28.1285
R25 VSS.n34 VSS.t45 28.1285
R26 VSS.t27 VSS.n20 25.7682
R27 VSS.n40 VSS.t54 25.7674
R28 VSS.n38 VSS.t12 24.3133
R29 VSS.t14 VSS.n18 24.3125
R30 VSS.n27 VSS.t35 24.2488
R31 VSS.t46 VSS.n7 24.2488
R32 VSS.n31 VSS.t39 23.8284
R33 VSS.t42 VSS.n10 23.8275
R34 VSS.n25 VSS.t34 22.3089
R35 VSS.t47 VSS.n5 22.3089
R36 VSS.t51 VSS.n1 21.8885
R37 VSS.n23 VSS.t30 21.8876
R38 VSS.t22 VSS.n28 21.4653
R39 VSS.n12 VSS.t24 21.4653
R40 VSS.t2 VSS.n9 21.4653
R41 VSS.n33 VSS.t4 21.4653
R42 VSS.n23 VSS.t29 19.9486
R43 VSS.t52 VSS.n1 19.9478
R44 VSS.t16 VSS.n16 19.8841
R45 VSS.n26 VSS.t18 19.8841
R46 VSS.t20 VSS.n13 19.8841
R47 VSS.n29 VSS.t22 19.8841
R48 VSS.t24 VSS.t38 19.8841
R49 VSS.t43 VSS.t2 19.8841
R50 VSS.t4 VSS.n8 19.8841
R51 VSS.n34 VSS.t6 19.8841
R52 VSS.t8 VSS.n6 19.8841
R53 VSS.n37 VSS.t10 19.8841
R54 VSS.t41 VSS.n10 18.0088
R55 VSS.n31 VSS.t40 18.0079
R56 VSS VSS.t43 17.9704
R57 VSS VSS.t38 17.9704
R58 VSS VSS.t13 17.0005
R59 VSS VSS.n3 17.0005
R60 VSS VSS.n37 17.0005
R61 VSS VSS.n5 17.0005
R62 VSS VSS.n36 17.0005
R63 VSS VSS.n6 17.0005
R64 VSS VSS.n35 17.0005
R65 VSS VSS.n7 17.0005
R66 VSS VSS.n34 17.0005
R67 VSS VSS.n8 17.0005
R68 VSS VSS.n29 17.0005
R69 VSS VSS.n13 17.0005
R70 VSS VSS.n27 17.0005
R71 VSS VSS.n14 17.0005
R72 VSS VSS.n26 17.0005
R73 VSS VSS.n15 17.0005
R74 VSS VSS.n25 17.0005
R75 VSS VSS.n16 17.0005
R76 VSS VSS.n24 17.0005
R77 VSS VSS.t0 17.0005
R78 VSS.n24 VSS.t32 16.4893
R79 VSS.t49 VSS.n3 16.4893
R80 VSS.n40 VSS.t53 16.0689
R81 VSS.t28 VSS.n20 16.068
R82 VSS.t37 VSS.t23 15.0344
R83 VSS.t3 VSS.t44 15.0344
R84 VSS.n29 VSS.t37 14.5495
R85 VSS.t44 VSS.n8 14.5495
R86 VSS.t31 VSS.n18 14.129
R87 VSS.n38 VSS.t50 14.1282
R88 VSS.t18 VSS.n15 13.0946
R89 VSS.n27 VSS.t20 13.0946
R90 VSS.t6 VSS.n7 13.0946
R91 VSS.n36 VSS.t8 13.0946
R92 VSS.n21 VSS.t26 12.1892
R93 VSS.t55 VSS.n0 12.1883
R94 VSS.t15 VSS.n17 11.766
R95 VSS.n28 VSS.t21 11.766
R96 VSS.t23 VSS.n12 11.766
R97 VSS.n30 VSS.t25 11.766
R98 VSS.t1 VSS.n32 11.766
R99 VSS.n9 VSS.t3 11.766
R100 VSS.t5 VSS.n33 11.766
R101 VSS.n4 VSS.t11 11.766
R102 VSS.n17 VSS.t33 11.2811
R103 VSS.t48 VSS.n4 11.2811
R104 VSS.t34 VSS.n15 10.6698
R105 VSS.n36 VSS.t47 10.6698
R106 VSS.t33 VSS.t16 10.1848
R107 VSS.t10 VSS.t48 10.1848
R108 VSS.t35 VSS.n14 8.72989
R109 VSS.n35 VSS.t46 8.72989
R110 VSS VSS.n39 4.31587
R111 VSS VSS.n2 4.31587
R112 VSS VSS.n4 4.31587
R113 VSS VSS.n33 4.31587
R114 VSS VSS.n9 4.31587
R115 VSS VSS.n32 4.31587
R116 VSS VSS.n11 4.31587
R117 VSS VSS.n30 4.31587
R118 VSS VSS.n12 4.31587
R119 VSS VSS.n28 4.31587
R120 VSS VSS.n17 4.31587
R121 VSS VSS.n19 4.31587
R122 VSS VSS.n22 4.31587
R123 VSS.t32 VSS.t14 3.39526
R124 VSS.n25 VSS.t17 3.39526
R125 VSS.t19 VSS.n14 3.39526
R126 VSS.n35 VSS.t7 3.39526
R127 VSS.t9 VSS.n5 3.39526
R128 VSS.t12 VSS.t49 3.39526
R129 VSS.t21 VSS.t36 1.4554
R130 VSS.t45 VSS.t5 1.4554
R131 VSS VSS.n0 1.17171
R132 VSS VSS.n1 1.17171
R133 VSS VSS.n38 1.17171
R134 VSS VSS.n10 1.17171
R135 VSS VSS.n31 1.17171
R136 VSS VSS.n18 1.17171
R137 VSS VSS.n23 1.17171
R138 VSS VSS.n20 1.17171
R139 VSS VSS.n21 1.17171
R140 VSS VSS.n40 1.17171
C38 rf_n VSS 5.22531f
C39 rf_p VSS 5.2201f
C40 vbn_buf VSS 16.9534f
C41 rf_out_p VSS 3.62324f
C42 rf_out_n VSS 3.60129f
C43 VDD VSS 7.65478f
C44 vbg_buf VSS 4.79055f
C45 a_n2502_n1000# VSS 10.9203f ; **FLOATING
C46 a_368_464# VSS 8.72846f ; **FLOATING
C47 a_n4900_2020# VSS 8.7283f ; **FLOATING
.ends
