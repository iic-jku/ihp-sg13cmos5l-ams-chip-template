* NGSPICE file created from vco_core_leads.ext - technology: ihp-sg13cmos5l

.subckt vco_core_leads vdd_core VSS vtune rf_p rf_n
X0 rf_p rf_n VSS.t18 VSS.t21 sg13_lv_nmos ad=0.38p pd=2.38u as=0.38p ps=2.38u w=2u l=0.13u
X1 VSS.t18 rf_n rf_p VSS.t17 sg13_lv_nmos ad=0.38p pd=2.38u as=0.38p ps=2.38u w=2u l=0.13u
X2 VSS.t23 rf_n rf_p VSS.t25 sg13_lv_nmos ad=0.68p pd=4.68u as=0.38p ps=2.38u w=2u l=0.13u
X3 rf_n rf_p VSS.t1 VSS.t5 sg13_lv_nmos ad=0.38p pd=2.38u as=0.38p ps=2.38u w=2u l=0.13u
X4 rf_n rf_p VSS.t10 VSS.t11 sg13_lv_nmos ad=0.38p pd=2.38u as=0.38p ps=2.38u w=2u l=0.13u
X5 rf_n rf_p VSS.t1 VSS.t0 sg13_lv_nmos ad=0.38p pd=2.38u as=0.68p ps=4.68u w=2u l=0.13u
X6 VSS.t1 rf_p rf_n VSS.t2 sg13_lv_nmos ad=0.38p pd=2.38u as=0.38p ps=2.38u w=2u l=0.13u
X7 rf_p rf_n VSS.t14 VSS.t16 sg13_lv_nmos ad=0.38p pd=2.38u as=0.38p ps=2.38u w=2u l=0.13u
X8 rf_p rf_n VSS.t23 VSS.t24 sg13_lv_nmos ad=0.38p pd=2.38u as=0.38p ps=2.38u w=2u l=0.13u
X9 VSS.t18 rf_n rf_p VSS.t20 sg13_lv_nmos ad=0.38p pd=2.38u as=0.38p ps=2.38u w=2u l=0.13u
X10 VSS.t7 rf_p rf_n VSS.t6 sg13_lv_nmos ad=0.38p pd=2.38u as=0.38p ps=2.38u w=2u l=0.13u
X11 VSS.t10 rf_p rf_n VSS.t12 sg13_lv_nmos ad=0.68p pd=4.68u as=0.38p ps=2.38u w=2u l=0.13u
X12 rf_n rf_p VSS.t1 VSS.t3 sg13_lv_nmos ad=0.38p pd=2.38u as=0.38p ps=2.38u w=2u l=0.13u
X13 rf_n rf_p VSS.t7 VSS.t8 sg13_lv_nmos ad=0.38p pd=2.38u as=0.38p ps=2.38u w=2u l=0.13u
X14 rf_p rf_n VSS.t14 VSS.t13 sg13_lv_nmos ad=0.38p pd=2.38u as=0.68p ps=4.68u w=2u l=0.13u
X15 VSS.t14 rf_n rf_p VSS.t15 sg13_lv_nmos ad=0.38p pd=2.38u as=0.38p ps=2.38u w=2u l=0.13u
X16 VSS.t23 rf_n rf_p VSS.t22 sg13_lv_nmos ad=0.38p pd=2.38u as=0.38p ps=2.38u w=2u l=0.13u
X17 rf_p rf_n VSS.t18 VSS.t19 sg13_lv_nmos ad=0.38p pd=2.38u as=0.38p ps=2.38u w=2u l=0.13u
X18 VSS.t1 rf_p rf_n VSS.t4 sg13_lv_nmos ad=0.38p pd=2.38u as=0.38p ps=2.38u w=2u l=0.13u
X19 VSS.t10 rf_p rf_n VSS.t9 sg13_lv_nmos ad=0.38p pd=2.38u as=0.38p ps=2.38u w=2u l=0.13u
C0 rf_n vdd_core 0.69708f
C1 vtune rf_p 0.07659f
C2 rf_n rf_p 1.31418f
C3 rf_p vdd_core 0.70685f
R0 VSS.n43 VSS.n42 417.568
R1 VSS.n42 VSS.n41 17.0005
R2 VSS.n41 VSS.n26 17.0005
R3 VSS.n41 VSS.n32 17.0005
R4 VSS.n41 VSS.n28 17.0005
R5 VSS.n41 VSS.n30 17.0005
R6 VSS.n48 VSS.n22 17.0005
R7 VSS.n48 VSS.n47 17.0005
R8 VSS.n48 VSS.n24 17.0005
R9 VSS.n48 VSS.n45 17.0005
R10 VSS.n48 VSS.n43 17.0005
R11 VSS.n30 VSS.t15 10.3383
R12 VSS.n30 VSS.t16 10.3383
R13 VSS.t17 VSS.n28 10.3383
R14 VSS.t19 VSS.n28 10.3383
R15 VSS.n32 VSS.t20 10.3383
R16 VSS.n32 VSS.t21 10.3383
R17 VSS.t22 VSS.n26 10.3383
R18 VSS.t24 VSS.n26 10.3383
R19 VSS.n42 VSS.t25 10.3383
R20 VSS.t0 VSS.n43 10.3383
R21 VSS.n45 VSS.t2 10.3383
R22 VSS.n45 VSS.t3 10.3383
R23 VSS.t4 VSS.n24 10.3383
R24 VSS.t5 VSS.n24 10.3383
R25 VSS.n47 VSS.t6 10.3383
R26 VSS.n47 VSS.t8 10.3383
R27 VSS.t9 VSS.n22 10.3383
R28 VSS.t11 VSS.n22 10.3383
R29 VSS.t12 VSS.t11 9.56144
R30 VSS.t15 VSS.t13 9.56085
R31 VSS.t16 VSS.n29 8.35079
R32 VSS.n29 VSS.t17 8.35079
R33 VSS.n31 VSS.t19 8.35079
R34 VSS.t20 VSS.n31 8.35079
R35 VSS.t21 VSS.n27 8.35079
R36 VSS.n27 VSS.t22 8.35079
R37 VSS.n33 VSS.t24 8.35079
R38 VSS.n33 VSS.t25 8.35079
R39 VSS.n44 VSS.t0 8.35079
R40 VSS.t2 VSS.n44 8.35079
R41 VSS.t3 VSS.n25 8.35079
R42 VSS.n25 VSS.t4 8.35079
R43 VSS.n46 VSS.t5 8.35079
R44 VSS.t6 VSS.n46 8.35079
R45 VSS.t8 VSS.n23 8.35079
R46 VSS.n23 VSS.t9 8.35079
R47 VSS.n39 VSS.t14 7.11282
R48 VSS.n4 VSS.t10 6.7505
R49 VSS.n35 VSS.t1 6.7505
R50 VSS.n37 VSS.n36 6.7505
R51 VSS.n38 VSS.n34 6.7505
R52 VSS.n0 VSS.n40 6.7505
R53 VSS.n39 VSS.t23 6.7505
R54 VSS.n3 VSS.n10 6.58119
R55 VSS.n7 VSS.n11 6.58119
R56 VSS.n41 VSS.n33 6.04908
R57 VSS.n41 VSS.n27 6.04908
R58 VSS.n41 VSS.n31 6.04908
R59 VSS.n41 VSS.n29 6.04908
R60 VSS.n48 VSS.n23 6.04908
R61 VSS.n48 VSS.n46 6.04908
R62 VSS.n48 VSS.n25 6.04908
R63 VSS.n48 VSS.n44 6.04908
R64 VSS.n1 VSS.t23 0.240654
R65 VSS.t7 VSS.t1 0.240975
R66 VSS.n48 VSS.t12 3.96286
R67 VSS.n41 VSS.t13 3.96274
R68 VSS.t7 VSS.n48 0.96758
R69 VSS.n41 VSS.n1 0.967348
R70 VSS.n18 VSS.n17 0.4405
R71 VSS.n13 VSS.n12 0.4405
R72 VSS.n17 VSS.n10 0.4405
R73 VSS.n12 VSS.n11 0.4405
R74 VSS.n2 VSS.n21 0.3635
R75 VSS.n21 VSS.n20 0.3635
R76 VSS.n6 VSS.n16 0.3635
R77 VSS.n16 VSS.n15 0.3635
R78 VSS.n0 VSS.n34 0.337235
R79 VSS.n36 VSS.n34 0.337235
R80 VSS.n36 VSS.t1 0.281071
R81 VSS.t23 VSS.n0 0.280736
R82 VSS.n3 VSS.n2 0.318597
R83 VSS.n20 VSS.n19 0.276188
R84 VSS.n19 VSS.n18 0.276188
R85 VSS.n7 VSS.n6 0.318597
R86 VSS.n15 VSS.n14 0.276188
R87 VSS.n14 VSS.n13 0.276188
R88 VSS.t14 VSS.t18 0.227584
R89 VSS.n35 VSS.n4 0.161968
R90 VSS.n40 VSS.n39 0.121601
R91 VSS.n40 VSS.n38 0.121601
R92 VSS.n38 VSS.n37 0.121601
R93 VSS.n37 VSS.n35 0.121601
R94 VSS.n5 VSS.n4 6.4329
R95 VSS.n9 VSS.n8 0.873355
R96 VSS.t18 VSS.n1 0.0531086
R97 VSS.t7 VSS.t10 0.279497
R98 VSS.n5 VSS.n3 0.0384491
R99 VSS.n50 VSS.n21 0.101071
R100 VSS.n52 VSS.n19 0.101071
R101 VSS.n9 VSS.n7 0.0384491
R102 VSS.n56 VSS.n16 0.101071
R103 VSS.n58 VSS.n14 0.101071
R104 VSS.n61 VSS.n60 0.0885
R105 VSS.n60 VSS.n59 0.0885
R106 VSS.n59 VSS.n58 0.0885
R107 VSS.n58 VSS.n57 0.0885
R108 VSS.n57 VSS.n56 0.0885
R109 VSS.n56 VSS.n55 0.0885
R110 VSS.n55 VSS.n9 0.0885
R111 VSS.n8 VSS.n54 0.0885
R112 VSS.n54 VSS.n53 0.0885
R113 VSS.n53 VSS.n52 0.0885
R114 VSS.n52 VSS.n51 0.0885
R115 VSS.n51 VSS.n50 0.0885
R116 VSS.n50 VSS.n49 0.0885
R117 VSS.n49 VSS.n5 0.0885
R118 VSS.n8 VSS.n10 0.0759286
R119 VSS.n54 VSS.n17 0.0759286
R120 VSS.n53 VSS.n18 0.0759286
R121 VSS.n51 VSS.n20 0.0759286
R122 VSS.n49 VSS.n2 0.0759286
R123 VSS.n61 VSS.n11 0.0759286
R124 VSS.n60 VSS.n12 0.0759286
R125 VSS.n59 VSS.n13 0.0759286
R126 VSS.n57 VSS.n15 0.0759286
R127 VSS.n55 VSS.n6 0.0759286
R128 VSS.n4 VSS.n61 6.59136
R129 VSS VSS.n0 0.0005
C4 vtune VSS 0.80051f
C5 vdd_core VSS 3.68926p
C6 rf_p VSS 9.23217f
C7 rf_n VSS 9.8507f
.ends
