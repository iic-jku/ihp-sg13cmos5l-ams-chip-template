** sch_path: /foss/designs/ihp-sg13cmos5l-ams-chip-template/macros/vco/schematic/xschem/vco_ind.sch
.subckt vco_ind la lb lc VSS
*.PININFO la:B lc:B lb:B VSS:B
LL1 la lb VSS inductor w=4e-6 s=4e-6 d=50e-6 nr_r=2
.ends
