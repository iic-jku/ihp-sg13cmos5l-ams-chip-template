** sch_path: /foss/designs/ihp-sg13cmos5l-ams-chip-template/macros/vco/schematic/xschem/vco_core.sch
.subckt vco_core vdd_core VSS vtune rf_p rf_n
*.PININFO vdd_core:B VSS:B vtune:I rf_p:B rf_n:B
CCct1a1 vdd_core VSS cap_cmomf w=19e-6 l=26e-6
Cct1a2 vdd_core VSS cap_cmomf w=19e-6 l=26e-6
xvar rf_p rf_n vtune VSS vco_var
MM1 rf_p rf_n VSS VSS sg13_lv_nmos w=20u l=0.13u ng=10
MM2 rf_n rf_p VSS VSS sg13_lv_nmos w=20u l=0.13u ng=10
CCct2a vdd_core VSS cap_cmomf w=25.5e-6 l=19e-6
CCct1b1 VSS vdd_core cap_cmomf w=19e-6 l=26e-6
Cct1b2 VSS vdd_core cap_cmomf w=19e-6 l=26e-6
CCct2b VSS vdd_core cap_cmomf w=25.5e-6 l=19e-6
.ends

* expanding   symbol:  vco_var.sym # of pins=4
** sym_path: /foss/designs/ihp-sg13cmos5l-ams-chip-template/macros/vco/schematic/xschem/vco_var.sym
** sch_path: /foss/designs/ihp-sg13cmos5l-ams-chip-template/macros/vco/schematic/xschem/vco_var.sch
.subckt vco_var rf_p rf_n vtune VSS
*.PININFO vtune:I rf_p:B rf_n:B VSS:B
CCvar1 rf_p vtune rf_n VSS sg13_hv_svaricap w=3.74u l=0.3u Nx=8
CCvar2 rf_p vtune rf_n VSS sg13_hv_svaricap w=3.74u l=0.3u Nx=8
CCvar3 rf_p vtune rf_n VSS sg13_hv_svaricap w=3.74u l=0.3u Nx=8
.ends
