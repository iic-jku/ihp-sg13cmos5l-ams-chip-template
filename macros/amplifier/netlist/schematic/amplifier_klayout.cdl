** sch_path: /mnt/c/Users/si150/eda/designs/heichips26-analog-workshop/amplifier/schematic/xschem/amplifier.sch
.subckt amplifier VDD vin vout VSS
*.PININFO vin:I VDD:B VSS:B vout:B
x1 VDD vin vout VSS inverter
RR1 vin vout 74.233k $SUB=VSS $[rhigh] w=0.5e-6 l=25e-6 b=0
.ends

* expanding   symbol:  inverter.sym # of pins=4
** sym_path: /mnt/c/Users/si150/eda/designs/heichips26-analog-workshop/amplifier/schematic/xschem/inverter.sym
** sch_path: /mnt/c/Users/si150/eda/designs/heichips26-analog-workshop/amplifier/schematic/xschem/inverter.sch
.subckt inverter VDD vin vout VSS
*.PININFO vin:I VDD:B VSS:B vout:B
MMdummy1 VSS VSS VSS VSS sg13_lv_nmos w=2.0u l=1.0u ng=2
MMdummy2 VDD VDD VDD VDD sg13_lv_pmos w=12.0u l=1.0u ng=2
MM1 vout vin VSS VSS sg13_lv_nmos w=20.0u l=1.0u ng=20
MM2 vout vin VDD VDD sg13_lv_pmos w=120.0u l=1.0u ng=20
.ends
