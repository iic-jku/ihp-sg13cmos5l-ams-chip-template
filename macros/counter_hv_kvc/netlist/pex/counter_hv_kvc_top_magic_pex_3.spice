* PEX produced on Sat Nov  7 03:37:43 PM CET 2026 using /foss/tools/sak/sak-pex.sh with m=3 and s=1 (extresist threshold=10000 mOhm, minres=1000 mOhm, mindelay=1 ps)
* NGSPICE file created from counter_hv_kvc_top_pex.ext - technology: ihp-sg13cmos5l

.subckt counter_hv_kvc_top_pex VDD VSS clock_i reset_n_i enable_i
+ counter_value_o[0] counter_value_o[1] counter_value_o[2] counter_value_o[3]
+ counter_value_o[4] counter_value_o[5] counter_value_o[6] counter_value_o[7]
X0 VSS.t187 VSS.t187 sg13g2_hv_tiehi_4.L_HI VSS.t188 sg13_hv_nmos ad=0.2516p pd=2.16u as=0.2516p ps=2.16u w=0.74u l=0.45u
X1 VDD.t250 sg13g2_hv_buf_16_0.A a_10100_10155# VDD.t10 sg13_hv_pmos ad=0.5111p pd=3.07u as=0.5111p ps=3.07u w=2.69u l=0.45u
X2 VSS.t47 a_7681_7412# a_7847_7412# VSS.t229 sg13_hv_nmos ad=39.42122p pd=85.45u as=0.2516p ps=2.16u w=0.74u l=0.45u
X3 a_5595_11572# sg13g2_hv_tiehi_5.L_HI VSS.t197 VSS.t356 sg13_hv_nmos ad=52.5f pd=0.67u as=79.8f ps=0.8u w=0.42u l=0.45u
X4 sg13g2_hv_o21ai_1_0.B1 a_28293_7386# VDD.t9 VDD.t0 sg13_hv_pmos ad=0.9146p pd=6.06u as=0.5111p ps=3.07u w=2.69u l=0.45u
X5 sg13g2_hv_or3_1_3.X a_23497_8772# VSS.t12 VSS.t55 sg13_hv_nmos ad=0.2516p pd=2.16u as=0.19315p ps=1.28u w=0.74u l=0.45u
X6 sg13g2_hv_nand3_1_0.Y sg13g2_hv_nand2b_1_0.B a_7864_11068# VSS.t389 sg13_hv_nmos ad=0.2516p pd=2.16u as=0.1406p ps=1.12u w=0.74u l=0.45u
X7 VDD.t3 a_5305_11792# a_5250_12109# VDD.t3 sg13_hv_pmos ad=4.05678p pd=25.945u as=0.22472p ps=1.455u w=1.01u l=0.45u
X8 VSS.t12 VDD.t312 VSS.t12 VSS.t131 sg13_hv_nmos ad=0.1428p pd=1.52u as=0 ps=0 w=0.42u l=1u
X9 a_30553_8936# a_30059_8793# a_30843_8716# VSS.t84 sg13_hv_nmos ad=0.3528p pd=2.52u as=52.5f ps=0.67u w=0.42u l=0.45u
X10 a_18145_11551# sg13g2_hv_dfrbpq_1_0.CLK VDD.t3 VDD.t3 sg13_hv_pmos ad=0.98185p pd=6.11u as=3.84325p ps=24.58u w=2.69u l=0.45u
X11 VDD.t148 VSS.t130 VDD.t147 VDD.t0 sg13_hv_pmos ad=0.816p pd=5.48u as=0 ps=0 w=2.4u l=1u
X12 VDD.t24 VSS.t59 VDD.t23 VDD.t3 sg13_hv_pmos ad=0.816p pd=5.48u as=0 ps=0 w=2.4u l=1u
X13 VSS.t211 a_30553_8936# a_29901_8793# VSS.t241 sg13_hv_nmos ad=79.8f pd=0.8u as=0.1428p ps=1.52u w=0.42u l=0.45u
X14 VSS.t189 VSS.t189 sg13g2_hv_tiehi_5.L_HI VSS.t190 sg13_hv_nmos ad=0.2516p pd=2.16u as=0.2516p ps=2.16u w=0.74u l=0.45u
X15 a_30459_11572# sg13g2_hv_dfrbpq_1_4.RESET_B VSS.t45 VSS.t44 sg13_hv_nmos ad=52.5f pd=0.67u as=79.8f ps=0.8u w=0.42u l=0.45u
X16 VSS.t7 a_27083_8259# a_28293_7386# VSS.t6 sg13_hv_nmos ad=0.1406p pd=1.12u as=0.2516p ps=2.16u w=0.74u l=0.45u
X17 a_9337_7966# a_8843_8259# a_9627_8336# VSS.t239 sg13_hv_nmos ad=0.3528p pd=2.52u as=52.5f ps=0.67u w=0.42u l=0.45u
X18 sg13g2_hv_dfrbpq_1_0.CLK a_24334_10242# VDD.t172 VDD.t10 sg13_hv_pmos ad=0.5111p pd=3.07u as=0.5111p ps=3.07u w=2.69u l=0.45u
X19 VSS.t1 sg13g2_hv_nand4_1_0.Y a_14233_11648# VSS.t321 sg13_hv_nmos ad=0.1371p pd=1.12u as=0.2176p ps=1.96u w=0.64u l=0.45u
X20 a_19746_12109# a_18311_11694# a_19307_11649# VDD.t3 sg13_hv_pmos ad=0.22472p pd=1.455u as=0.93082p ps=3.45u w=1.01u l=0.45u
X21 a_6902_7309# a_7681_7412# a_7621_7498# VDD.t0 sg13_hv_pmos ad=0.1919p pd=1.39u as=0.1515p ps=1.31u w=1.01u l=0.45u
X22 a_10100_10155# sg13g2_hv_buf_16_0.A VDD.t252 VDD.t10 sg13_hv_pmos ad=0.5111p pd=3.07u as=0.5111p ps=3.07u w=2.69u l=0.45u
X23 VSS.t203 sg13g2_hv_o21ai_1_1.B1 a_37384_13098# VSS.t242 sg13_hv_nmos ad=0.14875p pd=1.16u as=0.187p ps=1.78u w=0.55u l=0.45u
X24 VDD.t128 sg13g2_hv_o21ai_1_1.B1 a_37384_13098# VDD.t3 sg13_hv_pmos ad=0.50752p pd=3.11u as=0.6851p ps=4.71u w=2.015u l=0.45u
X25 VSS.t143 a_10100_10155# sg13g2_hv_dfrbpq_1_1.CLK VSS.t145 sg13_hv_nmos ad=0.1406p pd=1.12u as=0.1406p ps=1.12u w=0.74u l=0.45u
X26 a_11329_11551# sg13g2_hv_dfrbpq_1_1.CLK VSS.t50 VSS.t273 sg13_hv_nmos ad=0.2516p pd=2.16u as=24.76835p ps=68.72u w=0.74u l=0.45u
X27 VSS.t265 a_12985_11792# a_12333_11649# VSS.t264 sg13_hv_nmos ad=79.8f pd=0.8u as=0.1428p ps=1.52u w=0.42u l=0.45u
X28 VSS.t270 a_17326_10242# sg13g2_hv_buf_16_0.A VSS.t367 sg13_hv_nmos ad=0.1406p pd=1.12u as=0.1406p ps=1.12u w=0.74u l=0.45u
X29 VSS.t1 a_14233_11648# sg13g2_hv_or3_1_1.C VSS.t291 sg13_hv_nmos ad=0.2516p pd=2.16u as=0.1406p ps=1.12u w=0.74u l=0.45u
X30 sg13g2_hv_a21oi_1_4.Y sg13g2_hv_a21oi_1_1.B1.t3 a_24821_12068# VDD.t3 sg13_hv_pmos ad=0.9146p pd=6.06u as=0.5111p ps=3.07u w=2.69u l=0.45u
X31 VDD.t119 sg13g2_hv_nand2b_1_0.B a_5115_7520# VDD.t0 sg13_hv_pmos ad=0.52782p pd=3.1u as=0.6851p ps=4.71u w=2.015u l=0.45u
X32 VSS.t193 VSS.t193 sg13g2_hv_tiehi_2.L_HI VSS.t194 sg13_hv_nmos ad=0.2516p pd=2.16u as=0.2516p ps=2.16u w=0.74u l=0.45u
X33 VDD.t237 sg13g2_hv_or3_1_3.A sg13g2_hv_a21oi_1_5.A1 VDD.t10 sg13_hv_pmos ad=0.9146p pd=6.06u as=0.5111p ps=3.07u w=2.69u l=0.45u
X34 a_8812_12068# sg13g2_hv_nand4_1_0.C VDD.t132 VDD.t3 sg13_hv_pmos ad=0.34297p pd=2.945u as=0.69405p ps=3.265u w=2.69u l=0.45u
X35 a_12930_12109# a_11495_11694# a_12491_11649# VDD.t3 sg13_hv_pmos ad=0.22472p pd=1.455u as=0.93082p ps=3.45u w=1.01u l=0.45u
X36 sg13g2_hv_a21oi_1_4.Y sg13g2_hv_o21ai_1_1.Y a_24979_11650# VSS.t263 sg13_hv_nmos ad=0.1406p pd=1.12u as=0.1406p ps=1.12u w=0.74u l=0.45u
X37 VDD.t145 VSS.t113 VDD.t144 VDD.t3 sg13_hv_pmos ad=0.816p pd=5.48u as=0 ps=0 w=2.4u l=1u
X38 VSS.t161 a_19307_11649# a_20517_12068# VSS.t160 sg13_hv_nmos ad=0.1406p pd=1.12u as=0.2516p ps=2.16u w=0.74u l=0.45u
X39 a_22396_11632# sg13g2_hv_or3_1_1.B a_22230_11632# VSS.t285 sg13_hv_nmos ad=0.1406p pd=1.12u as=0.1406p ps=1.12u w=0.74u l=0.45u
X40 sg13g2_hv_a21oi_1_5.A1 sg13g2_hv_nand3_1_1.Y a_23604_10194# VDD.t10 sg13_hv_pmos ad=0.5111p pd=3.07u as=0.5111p ps=3.07u w=2.69u l=0.45u
X41 a_22230_11632# sg13g2_hv_nand3_1_1.A sg13g2_hv_nand4_1_1.Y VSS.t381 sg13_hv_nmos ad=0.1406p pd=1.12u as=0.2516p ps=2.16u w=0.74u l=0.45u
X42 a_28313_11585# a_28679_11694# a_27734_11795# VSS.t401 sg13_hv_nmos ad=0.2373p pd=1.97u as=79.8f ps=0.8u w=0.42u l=0.45u
X43 VDD.t176 a_24334_10242# sg13g2_hv_dfrbpq_1_0.CLK VDD.t10 sg13_hv_pmos ad=0.5111p pd=3.07u as=0.5111p ps=3.07u w=2.69u l=0.45u
X44 VSS.t14 VDD.t318 VSS.t14 VSS.t122 sg13_hv_nmos ad=0.1428p pd=1.52u as=0 ps=0 w=0.42u l=1u
X45 a_3589_12292# a_2960_12117# VDD.t28 VDD.t3 sg13_hv_pmos ad=0.1515p pd=1.31u as=0.77207p ps=2.7u w=1.01u l=0.45u
X46 a_25921_7412# sg13g2_hv_dfrbpq_1_0.CLK VDD.t0 VDD.t0 sg13_hv_pmos ad=0.98185p pd=6.11u as=4.91987p ps=31.75u w=2.69u l=0.45u
X47 sg13g2_hv_buf_16_0.A a_17326_10242# VDD.t271 VDD.t10 sg13_hv_pmos ad=0.5111p pd=3.07u as=0.5111p ps=3.07u w=2.69u l=0.45u
X48 VDD.t67 enable_i a_1192_5950# VDD.t0 sg13_hv_pmos ad=0.50752p pd=3.11u as=0.6851p ps=4.71u w=2.015u l=0.45u
X49 VSS.t161 a_17326_10242# sg13g2_hv_buf_16_0.A VSS.t379 sg13_hv_nmos ad=0.2516p pd=2.16u as=0.1406p ps=1.12u w=0.74u l=0.45u
X50 VSS.t82 sg13g2_hv_tiehi_5.L_HI a_2596_11572# VSS.t357 sg13_hv_nmos ad=0.2458p pd=1.735u as=60.89999f ps=0.71u w=0.42u l=0.45u
X51 a_15514_8764# sg13g2_hv_or3_1_1.A VSS.t21 VSS.t397 sg13_hv_nmos ad=0.2516p pd=2.16u as=0.1406p ps=1.12u w=0.74u l=0.45u
X52 a_15680_9260# sg13g2_hv_or3_1_1.C sg13g2_hv_a21oi_1_2.A1 VDD.t10 sg13_hv_pmos ad=0.5111p pd=3.07u as=0.5111p ps=3.07u w=2.69u l=0.45u
X53 a_27824_12117# a_28679_11694# a_29675_11649# VSS.t402 sg13_hv_nmos ad=0.41132p pd=2.84u as=0.2971p ps=1.69u w=0.74u l=0.45u
X54 a_15043_8026# sg13g2_hv_or3_1_1.C a_15629_7443# VDD.t0 sg13_hv_pmos ad=0.816p pd=5.48u as=0.456p ps=2.78u w=2.4u l=0.45u
X55 a_2621_11072# a_2522_10879# sg13g2_hv_xnor2_1_1.Y VSS.t72 sg13_hv_nmos ad=0.3515p pd=1.69u as=0.2516p ps=2.16u w=0.74u l=0.45u
X56 a_17326_10242# clock_i VDD.t241 VDD.t10 sg13_hv_pmos ad=0.5111p pd=3.07u as=0.9146p ps=6.06u w=2.69u l=0.45u
X57 VDD.t99 VSS.t125 VDD.t97 VDD.t10 sg13_hv_pmos ad=0.456p pd=2.78u as=0 ps=0 w=2.4u l=1u
X58 VDD.t80 a_10100_10155# sg13g2_hv_dfrbpq_1_1.CLK VDD.t10 sg13_hv_pmos ad=0.5111p pd=3.07u as=0.5111p ps=3.07u w=2.69u l=0.45u
X59 a_24710_8336# sg13g2_hv_a21oi_1_0.Y VDD.t7 VDD.t0 sg13_hv_pmos ad=0.303p pd=1.61u as=0.3434p ps=2.7u w=1.01u l=0.45u
X60 VSS.t41 a_24334_10242# sg13g2_hv_dfrbpq_1_0.CLK VSS.t256 sg13_hv_nmos ad=0.1406p pd=1.12u as=0.1406p ps=1.12u w=0.74u l=0.45u
X61 VSS.t33 sg13g2_hv_buf_16_0.A a_24334_10242# VSS.t349 sg13_hv_nmos ad=0.1406p pd=1.12u as=0.1406p ps=1.12u w=0.74u l=0.45u
X62 sg13g2_hv_or3_1_3.A a_31269_9212# VSS.t75 VSS.t74 sg13_hv_nmos ad=0.2516p pd=2.16u as=0.1406p ps=1.12u w=0.74u l=0.45u
X63 VDD.t275 a_17326_10242# sg13g2_hv_buf_16_0.A VDD.t10 sg13_hv_pmos ad=0.5111p pd=3.07u as=0.5111p ps=3.07u w=2.69u l=0.45u
X64 a_2870_11795# a_3649_11551# a_3589_12292# VDD.t3 sg13_hv_pmos ad=0.1919p pd=1.39u as=0.1515p ps=1.31u w=1.01u l=0.45u
X65 VSS.t29 sg13g2_hv_a21oi_1_1.B1.t2 sg13g2_hv_a21oi_1_5.Y VSS.t341 sg13_hv_nmos ad=0.2516p pd=2.16u as=0.1406p ps=1.12u w=0.74u l=0.45u
X66 VDD.t206 sg13g2_hv_or3_1_1.B sg13g2_hv_nand3_1_1.Y VDD.t10 sg13_hv_pmos ad=0.5111p pd=3.07u as=0.5111p ps=3.07u w=2.69u l=0.45u
X67 VDD.t141 VSS.t43 VDD.t140 VDD.t10 sg13_hv_pmos ad=0.816p pd=5.48u as=0 ps=0 w=2.4u l=1u
X68 VDD.t114 a_29675_11649# a_30885_12068# VDD.t3 sg13_hv_pmos ad=0.5111p pd=3.07u as=0.92805p ps=6.07u w=2.69u l=0.45u
X69 VDD.t51 sg13g2_hv_o21ai_1_0.B1 a_21709_7443# VDD.t0 sg13_hv_pmos ad=1.32122p pd=3.73u as=0.378p ps=2.715u w=2.4u l=0.45u
X70 VSS.t125 VDD.t316 VSS.t125 VSS.t126 sg13_hv_nmos ad=79.8f pd=0.8u as=0 ps=0 w=0.42u l=1u
X71 VDD.t107 VSS.t101 VDD.t106 VDD.t3 sg13_hv_pmos ad=0.816p pd=5.48u as=0 ps=0 w=2.4u l=1u
X72 sg13g2_hv_and2_1_0.B a_8327_12110# a_8654_11628# VSS.t34 sg13_hv_nmos ad=0.2516p pd=2.16u as=0.3515p ps=1.69u w=0.74u l=0.45u
X73 VSS.t27 sg13g2_hv_dfrbpq_1_7.RESET_B a_27844_8716# VSS.t213 sg13_hv_nmos ad=0.2458p pd=1.735u as=60.89999f ps=0.71u w=0.42u l=0.45u
X74 sg13g2_hv_or3_1_3.X a_23497_8772# VDD.t40 VDD.t10 sg13_hv_pmos ad=1.345p pd=6.38u as=1.32122p ps=3.73u w=2.69u l=0.45u
X75 sg13g2_hv_nand4_1_0.Y sg13g2_hv_nand2b_1_0.B a_7646_11632# VSS.t388 sg13_hv_nmos ad=0.2516p pd=2.16u as=0.1406p ps=1.12u w=0.74u l=0.45u
X76 a_24334_10242# sg13g2_hv_buf_16_0.A VDD.t256 VDD.t10 sg13_hv_pmos ad=0.5111p pd=3.07u as=0.5111p ps=3.07u w=2.69u l=0.45u
X77 a_15893_12068# sg13g2_hv_nand2_1_1.Y VDD.t188 VDD.t3 sg13_hv_pmos ad=0.5111p pd=3.07u as=0.5111p ps=3.07u w=2.69u l=0.45u
X78 VDD.t31 sg13g2_hv_dfrbpq_1_4.RESET_B a_27302_11572# VDD.t3 sg13_hv_pmos ad=1.2686p pd=5.2u as=0.303p ps=1.61u w=1.01u l=0.45u
X79 a_27460_11572# sg13g2_hv_a21oi_1_4.Y a_27302_11572# VSS.t268 sg13_hv_nmos ad=60.89999f pd=0.71u as=0.1428p ps=1.52u w=0.42u l=0.45u
X80 VDD.t84 a_10100_10155# sg13g2_hv_dfrbpq_1_1.CLK VDD.t10 sg13_hv_pmos ad=0.5111p pd=3.07u as=0.5111p ps=3.07u w=2.69u l=0.45u
X81 a_23497_8772# sg13g2_hv_or3_1_1.C VSS.t12 VSS.t11 sg13_hv_nmos ad=0.286p pd=1.59u as=0.1045p ps=0.93u w=0.55u l=0.45u
X82 VDD.t3 a_30169_11792# a_30114_12109# VDD.t3 sg13_hv_pmos ad=4.05678p pd=25.945u as=0.22472p ps=1.455u w=1.01u l=0.45u
X83 sg13g2_hv_dfrbpq_1_0.CLK a_24334_10242# VSS.t41 VSS.t259 sg13_hv_nmos ad=0.1406p pd=1.12u as=0.1406p ps=1.12u w=0.74u l=0.45u
X84 a_17326_10242# clock_i VSS.t14 VSS.t336 sg13_hv_nmos ad=0.1406p pd=1.12u as=0.1406p ps=1.12u w=0.74u l=0.45u
X85 sg13g2_hv_dfrbpq_1_1.CLK a_10100_10155# VDD.t82 VDD.t10 sg13_hv_pmos ad=0.5111p pd=3.07u as=0.5111p ps=3.07u w=2.69u l=0.45u
X86 VDD.t202 VSS.t107 VDD.t201 VDD.t3 sg13_hv_pmos ad=0.816p pd=5.48u as=0 ps=0 w=2.4u l=1u
X87 sg13g2_hv_tiehi_3.L_HI VSS.t53 VSS.t53 VSS.t185 sg13_hv_nmos ad=0.2516p pd=2.16u as=0.2516p ps=2.16u w=0.74u l=0.45u
X88 a_17456_12117# a_17366_11795# VDD.t111 VDD.t3 sg13_hv_pmos ad=1.056p pd=5.68u as=1.2686p ps=5.2u w=2.4u l=0.45u
X89 VSS.t107 a_12588_13011# counter_value_o[2] VSS.t322 sg13_hv_nmos ad=0.14875p pd=1.16u as=0.2886p ps=2.26u w=0.74u l=0.45u
X90 VDD.t131 a_12588_13011# counter_value_o[2] VDD.t3 sg13_hv_pmos ad=0.50752p pd=3.11u as=1.00875p ps=6.13u w=2.69u l=0.45u
X91 VDD.t57 sg13g2_hv_xnor2_1_1.A a_3041_10242# VDD.t10 sg13_hv_pmos ad=0.69405p pd=3.265u as=0.34297p ps=2.945u w=2.69u l=0.45u
X92 a_4773_8216# sg13g2_hv_nand2b_1_0.B VSS.t176 VSS.t392 sg13_hv_nmos ad=0.1406p pd=1.12u as=0.14505p ps=1.15u w=0.74u l=0.45u
X93 a_28897_8695# sg13g2_hv_dfrbpq_1_0.CLK VDD.t10 VDD.t10 sg13_hv_pmos ad=0.98185p pd=6.11u as=12.1183p ps=79.89u w=2.69u l=0.45u
X94 VDD.t109 VSS.t119 VDD.t108 VDD.t3 sg13_hv_pmos ad=0.816p pd=5.48u as=0 ps=0 w=2.4u l=1u
X95 VDD.t159 VSS.t12 VDD.t158 VDD.t0 sg13_hv_pmos ad=0.816p pd=5.48u as=0 ps=0 w=2.4u l=1u
X96 a_10640_12117# a_10550_11795# VDD.t38 VDD.t3 sg13_hv_pmos ad=1.056p pd=5.68u as=1.2686p ps=5.2u w=2.4u l=0.45u
X97 a_29675_11649# a_28513_11551# a_29517_11649# VSS.t318 sg13_hv_nmos ad=0.2971p pd=1.69u as=0.1428p ps=1.52u w=0.42u l=0.45u
X98 VDD.t182 a_24334_10242# sg13g2_hv_dfrbpq_1_0.CLK VDD.t10 sg13_hv_pmos ad=0.5111p pd=3.07u as=0.5111p ps=3.07u w=2.69u l=0.45u
X99 VDD.t169 sg13g2_hv_buf_16_0.A a_24334_10242# VDD.t10 sg13_hv_pmos ad=0.5111p pd=3.07u as=0.5111p ps=3.07u w=2.69u l=0.45u
X100 a_10989_11585# sg13g2_hv_tiehi_3.L_HI VSS.t143 VSS.t280 sg13_hv_nmos ad=52.5f pd=0.67u as=0.252p ps=2.04u w=0.42u l=0.45u
X101 a_16262_8336# sg13g2_hv_a21oi_1_2.Y VDD.t154 VDD.t0 sg13_hv_pmos ad=0.303p pd=1.61u as=0.3434p ps=2.7u w=1.01u l=0.45u
X102 sg13g2_hv_nand3_1_0.Y sg13g2_hv_buf_1_0.X VDD.t117 VDD.t10 sg13_hv_pmos ad=0.5111p pd=3.07u as=0.9146p ps=6.06u w=2.69u l=0.45u
X103 VSS.t53 a_10100_10155# sg13g2_hv_dfrbpq_1_1.CLK VSS.t140 sg13_hv_nmos ad=0.1406p pd=1.12u as=0.1406p ps=1.12u w=0.74u l=0.45u
X104 a_5445_8216# sg13g2_hv_buf_1_0.X VSS.t87 VSS.t172 sg13_hv_nmos ad=0.1406p pd=1.12u as=0.14505p ps=1.15u w=0.74u l=0.45u
X105 a_28208_9261# a_29063_8838# a_30059_8793# VSS.t205 sg13_hv_nmos ad=0.41132p pd=2.84u as=0.2971p ps=1.69u w=0.74u l=0.45u
X106 a_27577_7966# a_27083_8259# a_27867_8336# VSS.t5 sg13_hv_nmos ad=0.3528p pd=2.52u as=52.5f ps=0.67u w=0.42u l=0.45u
X107 a_25861_7498# a_25232_7395# VDD.t20 VDD.t0 sg13_hv_pmos ad=0.1515p pd=1.31u as=0.77207p ps=2.7u w=1.01u l=0.45u
X108 VSS.t340 clock_i a_17326_10242# VSS.t339 sg13_hv_nmos ad=0.1406p pd=1.12u as=0.1406p ps=1.12u w=0.74u l=0.45u
X109 a_17945_11585# a_17456_12117# a_17805_11585# VSS.t157 sg13_hv_nmos ad=0.2877p pd=2.21u as=52.5f ps=0.67u w=0.42u l=0.45u
X110 a_5250_12109# a_3815_11694# a_4811_11649# VDD.t3 sg13_hv_pmos ad=0.22472p pd=1.455u as=0.93082p ps=3.45u w=1.01u l=0.45u
X111 a_7481_8323# a_6992_7395# a_7341_8323# VSS.t36 sg13_hv_nmos ad=0.2877p pd=2.21u as=52.5f ps=0.67u w=0.42u l=0.45u
X112 a_25142_7309# a_25921_7412# a_25861_7498# VDD.t0 sg13_hv_pmos ad=0.1919p pd=1.39u as=0.1515p ps=1.31u w=1.01u l=0.45u
X113 a_21543_7443# sg13g2_hv_o21ai_1_0.A2 a_21385_7443# VDD.t0 sg13_hv_pmos ad=0.456p pd=2.78u as=0.816p ps=5.48u w=2.4u l=0.45u
X114 VSS.t113 VDD.t324 VSS.t113 VSS.t112 sg13_hv_nmos ad=0.1428p pd=1.52u as=0 ps=0 w=0.42u l=1u
X115 VDD.t214 VSS.t10 VDD.t213 VDD.t10 sg13_hv_pmos ad=0.816p pd=5.48u as=0 ps=0 w=2.4u l=1u
X116 a_22421_7386# sg13g2_hv_o21ai_1_0.Y VDD.t12 VDD.t0 sg13_hv_pmos ad=0.5111p pd=3.07u as=0.5111p ps=3.07u w=2.69u l=0.45u
X117 VSS.t270 a_17326_10242# sg13g2_hv_buf_16_0.A VSS.t375 sg13_hv_nmos ad=0.1406p pd=1.12u as=0.1406p ps=1.12u w=0.74u l=0.45u
X118 VDD.t104 VSS.t14 VDD.t103 VDD.t10 sg13_hv_pmos ad=0.816p pd=5.48u as=0 ps=0 w=2.4u l=1u
X119 a_10100_10155# sg13g2_hv_buf_16_0.A VSS.t265 VSS.t344 sg13_hv_nmos ad=0.1406p pd=1.12u as=0.1406p ps=1.12u w=0.74u l=0.45u
X120 VSS.t47 a_17473_7412# a_17639_7412# VSS.t236 sg13_hv_nmos ad=39.42122p pd=85.45u as=0.2516p ps=2.16u w=0.74u l=0.45u
X121 a_28697_8729# a_28208_9261# a_28557_8729# VSS.t8 sg13_hv_nmos ad=0.2877p pd=2.21u as=52.5f ps=0.67u w=0.42u l=0.45u
X122 VDD.t165 sg13g2_hv_o21ai_1_1.B1 sg13g2_hv_o21ai_1_1.Y VDD.t3 sg13_hv_pmos ad=0.9146p pd=6.06u as=0.5111p ps=3.07u w=2.69u l=0.45u
X123 VSS.t10 sg13g2_hv_a21oi_1_1.B1.t1 sg13g2_hv_a21oi_1_0.Y VSS.t403 sg13_hv_nmos ad=0.2516p pd=2.16u as=0.1406p ps=1.12u w=0.74u l=0.45u
X124 a_5813_7386# sg13g2_hv_nand2b_1_0.Y VDD.t39 VDD.t0 sg13_hv_pmos ad=0.5111p pd=3.07u as=0.5111p ps=3.07u w=2.69u l=0.45u
X125 VDD.t87 sg13g2_hv_tiehi_4.L_HI a_17366_11795# VDD.t3 sg13_hv_pmos ad=0.77207p pd=2.7u as=0.3535p ps=2.72u w=1.01u l=0.45u
X126 VSS.t62 sg13g2_hv_a21oi_1_1.B1 sg13g2_hv_dfrbpq_1_1.D VSS.t325 sg13_hv_nmos ad=0.2516p pd=2.16u as=0.1406p ps=1.12u w=0.74u l=0.45u
X127 VDD.t41 a_5115_7520# sg13g2_hv_nand2b_1_1.Y VDD.t0 sg13_hv_pmos ad=0.9146p pd=6.06u as=0.5111p ps=3.07u w=2.69u l=0.45u
X128 a_28513_11551# sg13g2_hv_dfrbpq_1_0.CLK VSS.t50 VSS.t49 sg13_hv_nmos ad=0.2516p pd=2.16u as=24.76835p ps=68.72u w=0.74u l=0.45u
X129 VDD.t0 a_7681_7412# a_7847_7412# VDD.t0 sg13_hv_pmos ad=4.91987p pd=31.75u as=0.92805p ps=6.07u w=2.69u l=0.45u
X130 a_12985_11792# sg13g2_hv_tiehi_3.L_HI VDD.t3 VDD.t3 sg13_hv_pmos ad=0.47975p pd=1.96u as=4.05678p ps=25.945u w=1.01u l=0.45u
X131 VDD.t0 a_9337_7966# a_9282_7681# VDD.t0 sg13_hv_pmos ad=4.91987p pd=31.75u as=0.22472p ps=1.455u w=1.01u l=0.45u
X132 VDD.t143 VSS.t68 sg13g2_hv_dfrbpq_1_4.RESET_B VDD.t3 sg13_hv_pmos ad=0.9146p pd=6.06u as=0.9146p ps=6.06u w=2.69u l=0.45u
X133 VSS.t59 VDD.t322 VSS.t59 VSS.t116 sg13_hv_nmos ad=0.1428p pd=1.52u as=0 ps=0 w=0.42u l=1u
X134 a_19129_7966# a_18635_8259# a_19419_8336# VSS.t198 sg13_hv_nmos ad=0.3528p pd=2.52u as=52.5f ps=0.67u w=0.42u l=0.45u
X135 a_2438_11572# sg13g2_hv_and2_1_1.X VDD.t6 VDD.t3 sg13_hv_pmos ad=0.303p pd=1.61u as=0.3434p ps=2.7u w=1.01u l=0.45u
X136 sg13g2_hv_or3_1_1.B a_19845_7386# VDD.t126 VDD.t0 sg13_hv_pmos ad=0.9146p pd=6.06u as=0.5111p ps=3.07u w=2.69u l=0.45u
X137 sg13g2_hv_o21ai_1_0.B1 a_28293_7386# VSS.t7 VSS.t137 sg13_hv_nmos ad=0.2516p pd=2.16u as=0.1406p ps=1.12u w=0.74u l=0.45u
X138 sg13g2_hv_dfrbpq_1_0.CLK a_24334_10242# VDD.t178 VDD.t10 sg13_hv_pmos ad=0.5111p pd=3.07u as=0.5111p ps=3.07u w=2.69u l=0.45u
X139 VSS.t101 a_2604_13011# counter_value_o[0] VSS.t324 sg13_hv_nmos ad=0.14875p pd=1.16u as=0.2886p ps=2.26u w=0.74u l=0.45u
X140 VDD.t231 a_2604_13011# counter_value_o[0] VDD.t3 sg13_hv_pmos ad=0.50752p pd=3.11u as=1.00875p ps=6.13u w=2.69u l=0.45u
X141 VDD.t97 VSS.t125 VDD.t96 VDD.t10 sg13_hv_pmos ad=0.816p pd=5.48u as=0 ps=0 w=2.4u l=1u
X142 a_15514_8764# sg13g2_hv_or3_1_1.B sg13g2_hv_a21oi_1_2.A1 VSS.t286 sg13_hv_nmos ad=0.1406p pd=1.12u as=0.2516p ps=2.16u w=0.74u l=0.45u
X143 a_20820_7338# sg13g2_hv_or3_1_1.C VDD.t17 VDD.t0 sg13_hv_pmos ad=0.5111p pd=3.07u as=0.9146p ps=6.06u w=2.69u l=0.45u
X144 a_8843_8259# a_7681_7412# a_8685_8259# VSS.t230 sg13_hv_nmos ad=0.2971p pd=1.69u as=0.1428p ps=1.52u w=0.42u l=0.45u
X145 a_10276_11572# sg13g2_hv_and2_1_0.X a_10118_11572# VSS.t2 sg13_hv_nmos ad=60.89999f pd=0.71u as=0.1428p ps=1.52u w=0.42u l=0.45u
X146 a_16694_7309# a_17473_7412# a_17413_7498# VDD.t0 sg13_hv_pmos ad=0.1919p pd=1.39u as=0.1515p ps=1.31u w=1.01u l=0.45u
X147 a_6470_8336# a_7847_7412# a_6902_7309# VDD.t0 sg13_hv_pmos ad=0.3434p pd=2.7u as=0.1919p ps=1.39u w=1.01u l=0.45u
X148 VSS.t183 VSS.t183 sg13g2_hv_dfrbpq_1_7.RESET_B VSS.t184 sg13_hv_nmos ad=0.2516p pd=2.16u as=0.2516p ps=2.16u w=0.74u l=0.45u
X149 VDD.t38 sg13g2_hv_tiehi_3.L_HI a_10118_11572# VDD.t3 sg13_hv_pmos ad=1.2686p pd=5.2u as=0.303p ps=1.61u w=1.01u l=0.45u
X150 a_28313_11585# a_27824_12117# a_28173_11585# VSS.t386 sg13_hv_nmos ad=0.2877p pd=2.21u as=52.5f ps=0.67u w=0.42u l=0.45u
X151 a_21810_8776# sg13g2_hv_o21ai_1_0.B1 VSS.t10 VSS.t66 sg13_hv_nmos ad=0.1406p pd=1.12u as=0.2886p ps=2.26u w=0.74u l=0.45u
X152 a_2604_13011# sg13g2_hv_nand2b_1_0.B VSS.t101 VSS.t387 sg13_hv_nmos ad=0.187p pd=1.78u as=0.14875p ps=1.16u w=0.55u l=0.45u
X153 a_2604_13011# sg13g2_hv_nand2b_1_0.B VDD.t231 VDD.t3 sg13_hv_pmos ad=0.6851p pd=4.71u as=0.50752p ps=3.11u w=2.015u l=0.45u
X154 VSS.t45 a_29675_11649# a_30885_12068# VSS.t170 sg13_hv_nmos ad=0.1406p pd=1.12u as=0.2516p ps=2.16u w=0.74u l=0.45u
X155 sg13g2_hv_nand2b_1_2.Y sg13g2_hv_or3_1_1.A VDD.t14 VDD.t3 sg13_hv_pmos ad=0.5111p pd=3.07u as=0.52782p ps=3.1u w=2.69u l=0.45u
X156 a_17805_11585# sg13g2_hv_tiehi_4.L_HI VSS.t14 VSS.t326 sg13_hv_nmos ad=52.5f pd=0.67u as=0.252p ps=2.04u w=0.42u l=0.45u
X157 sg13g2_hv_a21oi_1_4.A2 a_23785_11628# VSS.t33 VSS.t80 sg13_hv_nmos ad=0.2516p pd=2.16u as=0.19315p ps=1.28u w=0.74u l=0.45u
X158 a_12588_13011# sg13g2_hv_nand4_1_0.C VSS.t107 VSS.t206 sg13_hv_nmos ad=0.187p pd=1.78u as=0.14875p ps=1.16u w=0.55u l=0.45u
X159 a_12588_13011# sg13g2_hv_nand4_1_0.C VDD.t131 VDD.t3 sg13_hv_pmos ad=0.6851p pd=4.71u as=0.50752p ps=3.11u w=2.015u l=0.45u
X160 a_18145_11551# sg13g2_hv_dfrbpq_1_0.CLK VSS.t50 VSS.t51 sg13_hv_nmos ad=0.2516p pd=2.16u as=24.76835p ps=68.72u w=0.74u l=0.45u
X161 a_25232_7395# a_25142_7309# VSS.t29 VSS.t232 sg13_hv_nmos ad=0.2516p pd=2.16u as=0.2458p ps=1.735u w=0.74u l=0.45u
X162 VSS.t101 VDD.t329 VSS.t101 VSS.t100 sg13_hv_nmos ad=0.1428p pd=1.52u as=0 ps=0 w=0.42u l=1u
X163 VDD.t188 sg13g2_hv_nand2b_1_2.Y a_15893_12068# VDD.t3 sg13_hv_pmos ad=0.5111p pd=3.07u as=0.9146p ps=6.06u w=2.69u l=0.45u
X164 VDD.t244 clock_i a_17326_10242# VDD.t10 sg13_hv_pmos ad=0.5111p pd=3.07u as=0.5111p ps=3.07u w=2.69u l=0.45u
X165 a_8654_11628# sg13g2_hv_nand3_1_0.Y VSS.t79 VSS.t272 sg13_hv_nmos ad=0.3515p pd=1.69u as=0.406p ps=1.875u w=0.74u l=0.45u
X166 a_17366_11795# a_18145_11551# a_16934_11572# VSS.t359 sg13_hv_nmos ad=79.8f pd=0.8u as=0.1581p ps=1.71u w=0.42u l=0.45u
X167 VSS.t21 sg13g2_hv_or3_1_1.B a_15043_8026# VSS.t287 sg13_hv_nmos ad=0.1045p pd=0.93u as=0.286p ps=1.59u w=0.55u l=0.45u
X168 a_24691_8794# sg13g2_hv_or3_1_3.X VSS.t12 VSS.t90 sg13_hv_nmos ad=0.1406p pd=1.12u as=0.2516p ps=2.16u w=0.74u l=0.45u
X169 a_5971_8194# sg13g2_hv_nand2b_1_1.Y VSS.t87 VSS.t86 sg13_hv_nmos ad=0.1406p pd=1.12u as=0.2516p ps=2.16u w=0.74u l=0.45u
X170 a_28697_8729# a_29063_8838# a_28118_8939# VSS.t204 sg13_hv_nmos ad=0.2373p pd=1.97u as=79.8f ps=0.8u w=0.42u l=0.45u
X171 sg13g2_hv_buf_16_0.A a_17326_10242# VDD.t277 VDD.t10 sg13_hv_pmos ad=0.5111p pd=3.07u as=0.5111p ps=3.07u w=2.69u l=0.45u
X172 VDD.t11 sg13g2_hv_dfrbpq_1_7.RESET_B a_28118_8939# VDD.t10 sg13_hv_pmos ad=0.77207p pd=2.7u as=0.3535p ps=2.72u w=1.01u l=0.45u
X173 VDD.t0 a_8843_8259# a_9337_7966# VDD.t0 sg13_hv_pmos ad=4.91987p pd=31.75u as=0.47975p ps=1.96u w=1.01u l=0.45u
X174 sg13g2_hv_a21oi_1_5.A1 sg13g2_hv_or3_1_3.A a_23446_11080# VSS.t332 sg13_hv_nmos ad=0.2516p pd=2.16u as=0.1406p ps=1.12u w=0.74u l=0.45u
X175 sg13g2_hv_a21oi_1_1.B1 sg13g2_hv_buf_1_9.X VSS.t59 VSS.t58 sg13_hv_nmos ad=0.2516p pd=2.16u as=0.2516p ps=2.16u w=0.74u l=0.45u
X176 VDD.t307 sg13g2_hv_or3_1_1.A a_15680_9260# VDD.t10 sg13_hv_pmos ad=0.9146p pd=6.06u as=0.5111p ps=3.07u w=2.69u l=0.45u
X177 sg13g2_hv_and2_1_1.X a_1773_11050# VDD.t136 VDD.t10 sg13_hv_pmos ad=0.9146p pd=6.06u as=0.46047p ps=3.07u w=2.69u l=0.45u
X178 a_23446_11080# sg13g2_hv_nand3_1_1.Y VSS.t16 VSS.t216 sg13_hv_nmos ad=0.1406p pd=1.12u as=0.1406p ps=1.12u w=0.74u l=0.45u
X179 VSS.t107 VDD.t327 VSS.t107 VSS.t106 sg13_hv_nmos ad=0.1428p pd=1.52u as=0 ps=0 w=0.42u l=1u
X180 VSS.t87 sg13g2_hv_nand2b_1_0.B a_5115_7520# VSS.t391 sg13_hv_nmos ad=0.14505p pd=1.15u as=0.187p ps=1.78u w=0.55u l=0.45u
X181 a_27564_13011# sg13g2_hv_o21ai_1_0.B1 VSS.t68 VSS.t67 sg13_hv_nmos ad=0.187p pd=1.78u as=0.14875p ps=1.16u w=0.55u l=0.45u
X182 a_27564_13011# sg13g2_hv_o21ai_1_0.B1 VDD.t49 VDD.t3 sg13_hv_pmos ad=0.6851p pd=4.71u as=0.50752p ps=3.11u w=2.015u l=0.45u
X183 a_16784_7395# a_17639_7412# a_18635_8259# VSS.t96 sg13_hv_nmos ad=0.41132p pd=2.84u as=0.2971p ps=1.69u w=0.74u l=0.45u
X184 a_16784_7395# a_16694_7309# VDD.t63 VDD.t0 sg13_hv_pmos ad=1.056p pd=5.68u as=1.2686p ps=5.2u w=2.4u l=0.45u
X185 VSS.t62 sg13g2_hv_tiehi_1.L_HI a_6628_8336# VSS.t65 sg13_hv_nmos ad=0.2458p pd=1.735u as=60.89999f ps=0.71u w=0.42u l=0.45u
X186 VDD.t289 sg13g2_hv_nand3_1_1.A sg13g2_hv_or3_1_1.A VDD.t10 sg13_hv_pmos ad=0.9146p pd=6.06u as=0.9146p ps=6.06u w=2.69u l=0.45u
X187 VSS.t79 sg13g2_hv_and2_1_0.B a_8747_11050# VSS.t158 sg13_hv_nmos ad=0.1331p pd=1.12u as=0.1216p ps=1.02u w=0.64u l=0.45u
X188 VSS.t68 VSS.t68 sg13g2_hv_dfrbpq_1_4.RESET_B VSS.t181 sg13_hv_nmos ad=0.2516p pd=2.16u as=0.2516p ps=2.16u w=0.74u l=0.45u
X189 a_10100_10155# sg13g2_hv_buf_16_0.A VDD.t86 VDD.t10 sg13_hv_pmos ad=0.5111p pd=3.07u as=0.5111p ps=3.07u w=2.69u l=0.45u
X190 sg13g2_hv_dfrbpq_1_1.CLK a_10100_10155# VDD.t72 VDD.t10 sg13_hv_pmos ad=0.5111p pd=3.07u as=0.5111p ps=3.07u w=2.69u l=0.45u
X191 VSS.t164 sg13g2_hv_or3_1_1.B a_22408_13098# VSS.t284 sg13_hv_nmos ad=0.14875p pd=1.16u as=0.187p ps=1.78u w=0.55u l=0.45u
X192 sg13g2_hv_nand2_1_2.Y sg13g2_hv_buf_1_0.X VDD.t116 VDD.t10 sg13_hv_pmos ad=0.5111p pd=3.07u as=0.9146p ps=6.06u w=2.69u l=0.45u
X193 sg13g2_hv_buf_16_0.A a_17326_10242# VDD.t246 VDD.t10 sg13_hv_pmos ad=0.5111p pd=3.07u as=0.5111p ps=3.07u w=2.69u l=0.45u
X194 VDD.t105 sg13g2_hv_or3_1_1.B a_22408_13098# VDD.t3 sg13_hv_pmos ad=0.50752p pd=3.11u as=0.6851p ps=4.71u w=2.015u l=0.45u
X195 VSS.t197 a_5305_11792# a_4653_11649# VSS.t196 sg13_hv_nmos ad=79.8f pd=0.8u as=0.1428p ps=1.52u w=0.42u l=0.45u
X196 VDD.t149 a_8843_8259# a_10053_7386# VDD.t0 sg13_hv_pmos ad=0.5111p pd=3.07u as=0.92805p ps=6.07u w=2.69u l=0.45u
X197 VDD.t288 sg13g2_hv_nand3_1_1.A sg13g2_hv_nand2_1_1.Y VDD.t10 sg13_hv_pmos ad=0.9146p pd=6.06u as=0.5111p ps=3.07u w=2.69u l=0.45u
X198 a_7864_11068# sg13g2_hv_xnor2_1_1.A a_7698_11068# VSS.t312 sg13_hv_nmos ad=0.1406p pd=1.12u as=0.1406p ps=1.12u w=0.74u l=0.45u
X199 VSS.t21 sg13g2_hv_a21oi_1_2.A2 a_14593_8194# VSS.t302 sg13_hv_nmos ad=0.2516p pd=2.16u as=0.1406p ps=1.12u w=0.74u l=0.45u
X200 VSS.t43 a_24334_10242# sg13g2_hv_dfrbpq_1_0.CLK VSS.t262 sg13_hv_nmos ad=0.2516p pd=2.16u as=0.1406p ps=1.12u w=0.74u l=0.45u
X201 VDD.t86 a_10100_10155# sg13g2_hv_dfrbpq_1_1.CLK VDD.t10 sg13_hv_pmos ad=0.5111p pd=3.07u as=0.5111p ps=3.07u w=2.69u l=0.45u
X202 VSS.t14 sg13g2_hv_a21oi_1_1.B1.t4 sg13g2_hv_a21oi_1_3.Y VSS.t73 sg13_hv_nmos ad=0.2516p pd=2.16u as=0.1406p ps=1.12u w=0.74u l=0.45u
X203 sg13g2_hv_nand2_1_1.Y sg13g2_hv_or3_1_1.C VDD.t16 VDD.t10 sg13_hv_pmos ad=0.5111p pd=3.07u as=0.9146p ps=6.06u w=2.69u l=0.45u
X204 VDD.t122 sg13g2_hv_a21oi_1_2.A1 a_14427_7386# VDD.t0 sg13_hv_pmos ad=0.5111p pd=3.07u as=0.5111p ps=3.07u w=2.69u l=0.45u
X205 sg13g2_hv_or3_1_3.A a_31269_9212# VDD.t54 VDD.t10 sg13_hv_pmos ad=0.9146p pd=6.06u as=0.5111p ps=3.07u w=2.69u l=0.45u
X206 a_8327_12110# sg13g2_hv_nand4_1_0.C VDD.t129 VDD.t3 sg13_hv_pmos ad=0.95713p pd=2.965u as=2.12582p ps=6.14u w=2.015u l=0.45u
X207 a_10118_11572# a_11495_11694# a_10550_11795# VDD.t3 sg13_hv_pmos ad=0.3434p pd=2.7u as=0.1919p ps=1.39u w=1.01u l=0.45u
X208 VDD.t102 VSS.t14 VDD.t101 VDD.t3 sg13_hv_pmos ad=0.816p pd=5.48u as=0 ps=0 w=2.4u l=1u
X209 VDD.t172 a_24334_10242# sg13g2_hv_dfrbpq_1_0.CLK VDD.t10 sg13_hv_pmos ad=0.5111p pd=3.07u as=0.5111p ps=3.07u w=2.69u l=0.45u
X210 VDD.t111 sg13g2_hv_tiehi_4.L_HI a_16934_11572# VDD.t3 sg13_hv_pmos ad=1.2686p pd=5.2u as=0.303p ps=1.61u w=1.01u l=0.45u
X211 a_17092_11572# sg13g2_hv_a21oi_1_3.Y a_16934_11572# VSS.t293 sg13_hv_nmos ad=60.89999f pd=0.71u as=0.1428p ps=1.52u w=0.42u l=0.45u
X212 a_25721_8323# a_25232_7395# a_25581_8323# VSS.t234 sg13_hv_nmos ad=0.2877p pd=2.21u as=52.5f ps=0.67u w=0.42u l=0.45u
X213 VDD.t126 a_18635_8259# a_19845_7386# VDD.t0 sg13_hv_pmos ad=0.5111p pd=3.07u as=0.92805p ps=6.07u w=2.69u l=0.45u
X214 VSS.t64 a_9337_7966# a_8685_8259# VSS.t97 sg13_hv_nmos ad=79.8f pd=0.8u as=0.1428p ps=1.52u w=0.42u l=0.45u
X215 sg13g2_hv_dfrbpq_1_0.CLK a_24334_10242# VDD.t170 VDD.t10 sg13_hv_pmos ad=0.5111p pd=3.07u as=0.5111p ps=3.07u w=2.69u l=0.45u
X216 a_27824_12117# a_27734_11795# VDD.t31 VDD.t3 sg13_hv_pmos ad=1.056p pd=5.68u as=1.2686p ps=5.2u w=2.4u l=0.45u
X217 sg13g2_hv_buf_16_0.A a_17326_10242# VDD.t279 VDD.t10 sg13_hv_pmos ad=0.5111p pd=3.07u as=0.5111p ps=3.07u w=2.69u l=0.45u
X218 VDD.t252 sg13g2_hv_buf_16_0.A a_10100_10155# VDD.t10 sg13_hv_pmos ad=0.5111p pd=3.07u as=0.5111p ps=3.07u w=2.69u l=0.45u
X219 a_3527_11050# sg13g2_hv_nand2_1_2.Y a_2522_10879# VSS.t83 sg13_hv_nmos ad=0.304p pd=1.59u as=0.4608p ps=2.72u w=0.64u l=0.45u
X220 sg13g2_hv_dfrbpq_1_1.CLK a_10100_10155# VSS.t143 VSS.t144 sg13_hv_nmos ad=0.1406p pd=1.12u as=0.1406p ps=1.12u w=0.74u l=0.45u
X221 sg13g2_hv_buf_16_0.A a_17326_10242# VSS.t270 VSS.t366 sg13_hv_nmos ad=0.1406p pd=1.12u as=0.1406p ps=1.12u w=0.74u l=0.45u
X222 sg13g2_hv_nand3_1_0.Y sg13g2_hv_nand2b_1_0.B VDD.t223 VDD.t10 sg13_hv_pmos ad=0.9146p pd=6.06u as=0.5111p ps=3.07u w=2.69u l=0.45u
X223 sg13g2_hv_or3_1_1.C a_14233_11648# VSS.t1 VSS.t290 sg13_hv_nmos ad=0.1406p pd=1.12u as=0.1371p ps=1.12u w=0.74u l=0.45u
X224 VSS.t82 sg13g2_hv_nand2_1_2.Y a_2621_11072# VSS.t81 sg13_hv_nmos ad=0.406p pd=1.875u as=0.3515p ps=1.69u w=0.74u l=0.45u
X225 a_24821_12068# sg13g2_hv_o21ai_1_1.Y VDD.t185 VDD.t3 sg13_hv_pmos ad=0.5111p pd=3.07u as=0.5111p ps=3.07u w=2.69u l=0.45u
X226 a_30169_11792# a_29675_11649# a_30459_11572# VSS.t169 sg13_hv_nmos ad=0.3528p pd=2.52u as=52.5f ps=0.67u w=0.42u l=0.45u
X227 VDD.t30 VSS.t115 VDD.t29 VDD.t3 sg13_hv_pmos ad=0.816p pd=5.48u as=0 ps=0 w=2.4u l=1u
X228 sg13g2_hv_nand2b_1_0.Y a_4443_7520# a_4773_8216# VSS.t300 sg13_hv_nmos ad=0.333p pd=2.38u as=0.1406p ps=1.12u w=0.74u l=0.45u
X229 sg13g2_hv_o21ai_1_1.Y sg13g2_hv_o21ai_1_1.B1 a_23062_11620# VSS.t243 sg13_hv_nmos ad=0.2516p pd=2.16u as=0.1406p ps=1.12u w=0.74u l=0.45u
X230 sg13g2_hv_tiehi_0.L_HI VSS.t12 VSS.t12 VSS.t179 sg13_hv_nmos ad=0.2516p pd=2.16u as=0.2516p ps=2.16u w=0.74u l=0.45u
X231 VDD.t21 sg13g2_hv_tiehi_0.L_HI a_24710_8336# VDD.t0 sg13_hv_pmos ad=1.2686p pd=5.2u as=0.303p ps=1.61u w=1.01u l=0.45u
X232 a_11129_11585# a_10640_12117# a_10989_11585# VSS.t277 sg13_hv_nmos ad=0.2877p pd=2.21u as=52.5f ps=0.67u w=0.42u l=0.45u
X233 a_19307_11649# a_18145_11551# a_19149_11649# VSS.t361 sg13_hv_nmos ad=0.2971p pd=1.69u as=0.1428p ps=1.52u w=0.42u l=0.45u
X234 VSS.t355 reset_n_i a_1192_10242# VSS.t354 sg13_hv_nmos ad=0.14875p pd=1.16u as=0.187p ps=1.78u w=0.55u l=0.45u
X235 VSS.t120 VDD.t320 VSS.t119 VSS.t118 sg13_hv_nmos ad=0.1428p pd=1.52u as=0 ps=0 w=0.42u l=1u
X236 a_22579_8194# sg13g2_hv_a21oi_1_0.A2 VSS.t10 VSS.t9 sg13_hv_nmos ad=0.1406p pd=1.12u as=0.2516p ps=2.16u w=0.74u l=0.45u
X237 VDD.t10 a_30553_8936# a_30498_9253# VDD.t10 sg13_hv_pmos ad=12.1183p pd=79.89u as=0.22472p ps=1.455u w=1.01u l=0.45u
X238 sg13g2_hv_nand2_1_2.Y sg13g2_hv_nand2b_1_0.B a_2810_8772# VSS.t390 sg13_hv_nmos ad=0.2516p pd=2.16u as=0.1406p ps=1.12u w=0.74u l=0.45u
X239 sg13g2_hv_dfrbpq_1_0.CLK a_24334_10242# VDD.t174 VDD.t10 sg13_hv_pmos ad=0.5111p pd=3.07u as=0.5111p ps=3.07u w=2.69u l=0.45u
X240 VDD.t92 VSS.t109 VDD.t91 VDD.t3 sg13_hv_pmos ad=0.816p pd=5.48u as=0 ps=0 w=2.4u l=1u
X241 VDD.t261 reset_n_i a_1192_10242# VDD.t10 sg13_hv_pmos ad=0.50752p pd=3.11u as=0.6851p ps=4.71u w=2.015u l=0.45u
X242 sg13g2_hv_a21oi_1_0.A2 a_21385_7443# VDD.t51 VDD.t0 sg13_hv_pmos ad=1.345p pd=6.38u as=1.32122p ps=3.73u w=2.69u l=0.45u
X243 sg13g2_hv_dfrbpq_1_1.CLK a_10100_10155# VSS.t143 VSS.t148 sg13_hv_nmos ad=0.1406p pd=1.12u as=0.1406p ps=1.12u w=0.74u l=0.45u
X244 VDD.t174 a_24334_10242# sg13g2_hv_dfrbpq_1_0.CLK VDD.t10 sg13_hv_pmos ad=0.5111p pd=3.07u as=0.5111p ps=3.07u w=2.69u l=0.45u
X245 a_12491_11649# a_11329_11551# a_12333_11649# VSS.t219 sg13_hv_nmos ad=0.2971p pd=1.69u as=0.1428p ps=1.52u w=0.42u l=0.45u
X246 VDD.t0 a_27577_7966# a_27522_7681# VDD.t0 sg13_hv_pmos ad=4.91987p pd=31.75u as=0.22472p ps=1.455u w=1.01u l=0.45u
X247 sg13g2_hv_buf_16_0.A a_17326_10242# VSS.t161 VSS.t378 sg13_hv_nmos ad=0.1406p pd=1.12u as=0.1406p ps=1.12u w=0.74u l=0.45u
X248 sg13g2_hv_buf_16_0.A a_17326_10242# VSS.t270 VSS.t370 sg13_hv_nmos ad=0.1406p pd=1.12u as=0.1406p ps=1.12u w=0.74u l=0.45u
X249 VSS.t265 sg13g2_hv_buf_16_0.A a_10100_10155# VSS.t347 sg13_hv_nmos ad=0.2516p pd=2.16u as=0.1406p ps=1.12u w=0.74u l=0.45u
X250 VSS.t143 a_10100_10155# sg13g2_hv_dfrbpq_1_1.CLK VSS.t147 sg13_hv_nmos ad=0.1406p pd=1.12u as=0.1406p ps=1.12u w=0.74u l=0.45u
X251 VDD.t248 VSS.t103 VDD.t247 VDD.t3 sg13_hv_pmos ad=0.816p pd=5.48u as=0 ps=0 w=2.4u l=1u
X252 VDD.t3 a_11329_11551# a_11495_11694# VDD.t3 sg13_hv_pmos ad=4.05678p pd=25.945u as=0.92805p ps=6.07u w=2.69u l=0.45u
X253 VSS.t270 a_17326_10242# sg13g2_hv_buf_16_0.A VSS.t369 sg13_hv_nmos ad=0.1406p pd=1.12u as=0.1406p ps=1.12u w=0.74u l=0.45u
X254 VDD.t40 sg13g2_hv_or3_1_3.A a_23821_9213# VDD.t10 sg13_hv_pmos ad=1.32122p pd=3.73u as=0.378p ps=2.715u w=2.4u l=0.45u
X255 VSS.t161 a_17326_10242# sg13g2_hv_buf_16_0.A VSS.t377 sg13_hv_nmos ad=0.1406p pd=1.12u as=0.1406p ps=1.12u w=0.74u l=0.45u
X256 a_28897_8695# sg13g2_hv_dfrbpq_1_0.CLK VSS.t47 VSS.t48 sg13_hv_nmos ad=0.2516p pd=2.16u as=33.78962p ps=73.245u w=0.74u l=0.45u
X257 a_28837_9436# a_28208_9261# VDD.t11 VDD.t10 sg13_hv_pmos ad=0.1515p pd=1.31u as=0.77207p ps=2.7u w=1.01u l=0.45u
X258 a_17273_8323# a_16784_7395# a_17133_8323# VSS.t35 sg13_hv_nmos ad=0.2877p pd=2.21u as=52.5f ps=0.67u w=0.42u l=0.45u
X259 a_21709_7443# sg13g2_hv_or3_1_1.C a_21543_7443# VDD.t0 sg13_hv_pmos ad=0.378p pd=2.715u as=0.456p ps=2.78u w=2.4u l=0.45u
X260 sg13g2_hv_and2_1_0.X a_8589_11050# VDD.t55 VDD.t10 sg13_hv_pmos ad=0.9146p pd=6.06u as=0.46047p ps=3.07u w=2.69u l=0.45u
X261 sg13g2_hv_nand2b_1_2.Y a_15195_11666# a_15525_11628# VSS.t138 sg13_hv_nmos ad=0.333p pd=2.38u as=0.1406p ps=1.12u w=0.74u l=0.45u
X262 sg13g2_hv_dfrbpq_1_0.CLK a_24334_10242# VSS.t41 VSS.t255 sg13_hv_nmos ad=0.1406p pd=1.12u as=0.1406p ps=1.12u w=0.74u l=0.45u
X263 a_24334_10242# sg13g2_hv_buf_16_0.A VSS.t16 VSS.t348 sg13_hv_nmos ad=0.1406p pd=1.12u as=0.2516p ps=2.16u w=0.74u l=0.45u
X264 a_16934_11572# a_18311_11694# a_17366_11795# VDD.t3 sg13_hv_pmos ad=0.3434p pd=2.7u as=0.1919p ps=1.39u w=1.01u l=0.45u
X265 VSS.t10 VDD.t314 VSS.t10 VSS.t128 sg13_hv_nmos ad=0.1428p pd=1.52u as=0 ps=0 w=0.42u l=1u
X266 counter_value_o[4] a_22408_13098# VSS.t164 VSS.t163 sg13_hv_nmos ad=0.2886p pd=2.26u as=0.14875p ps=1.16u w=0.74u l=0.45u
X267 a_2960_12117# a_2870_11795# VDD.t100 VDD.t3 sg13_hv_pmos ad=1.056p pd=5.68u as=1.2686p ps=5.2u w=2.4u l=0.45u
X268 VDD.t63 sg13g2_hv_tiehi_2.L_HI a_16262_8336# VDD.t0 sg13_hv_pmos ad=1.2686p pd=5.2u as=0.303p ps=1.61u w=1.01u l=0.45u
X269 counter_value_o[4] a_22408_13098# VDD.t105 VDD.t3 sg13_hv_pmos ad=1.00875p pd=6.13u as=0.50752p ps=3.11u w=2.69u l=0.45u
X270 a_7646_11632# sg13g2_hv_xnor2_1_1.A a_7480_11632# VSS.t309 sg13_hv_nmos ad=0.1406p pd=1.12u as=0.1406p ps=1.12u w=0.74u l=0.45u
X271 VDD.t3 a_28513_11551# a_28679_11694# VDD.t3 sg13_hv_pmos ad=4.05678p pd=25.945u as=0.92805p ps=6.07u w=2.69u l=0.45u
X272 VSS.t45 a_30169_11792# a_29517_11649# VSS.t171 sg13_hv_nmos ad=79.8f pd=0.8u as=0.1428p ps=1.52u w=0.42u l=0.45u
X273 VDD.t0 a_17473_7412# a_17639_7412# VDD.t0 sg13_hv_pmos ad=4.91987p pd=31.75u as=0.92805p ps=6.07u w=2.69u l=0.45u
X274 VDD.t0 a_19129_7966# a_19074_7681# VDD.t0 sg13_hv_pmos ad=4.91987p pd=31.75u as=0.22472p ps=1.455u w=1.01u l=0.45u
X275 a_27686_8716# a_29063_8838# a_28118_8939# VDD.t10 sg13_hv_pmos ad=0.3434p pd=2.7u as=0.1919p ps=1.39u w=1.01u l=0.45u
X276 a_2960_12117# a_3815_11694# a_4811_11649# VSS.t314 sg13_hv_nmos ad=0.41132p pd=2.84u as=0.2971p ps=1.69u w=0.74u l=0.45u
X277 a_9337_7966# sg13g2_hv_tiehi_1.L_HI VDD.t0 VDD.t0 sg13_hv_pmos ad=0.47975p pd=1.96u as=4.91987p ps=31.75u w=1.01u l=0.45u
X278 a_7480_11632# sg13g2_hv_nand4_1_0.C a_7314_11632# VSS.t207 sg13_hv_nmos ad=0.1406p pd=1.12u as=0.1406p ps=1.12u w=0.74u l=0.45u
X279 a_8843_8259# a_7681_7412# a_6992_7395# VDD.t0 sg13_hv_pmos ad=0.93082p pd=3.45u as=1.896p ps=6.38u w=2.4u l=0.45u
X280 VDD.t10 a_28897_8695# a_29063_8838# VDD.t10 sg13_hv_pmos ad=12.1183p pd=79.89u as=0.92805p ps=6.07u w=2.69u l=0.45u
X281 VSS.t41 a_24334_10242# sg13g2_hv_dfrbpq_1_0.CLK VSS.t258 sg13_hv_nmos ad=0.1406p pd=1.12u as=0.1406p ps=1.12u w=0.74u l=0.45u
X282 VSS.t29 sg13g2_hv_tiehi_0.L_HI a_24868_8336# VSS.t28 sg13_hv_nmos ad=0.2458p pd=1.735u as=60.89999f ps=0.71u w=0.42u l=0.45u
X283 a_18635_8259# a_17473_7412# a_18477_8259# VSS.t237 sg13_hv_nmos ad=0.2971p pd=1.69u as=0.1428p ps=1.52u w=0.42u l=0.45u
X284 sg13g2_hv_a21oi_1_2.A1 sg13g2_hv_or3_1_1.B VDD.t205 VDD.t10 sg13_hv_pmos ad=0.5111p pd=3.07u as=0.9146p ps=6.06u w=2.69u l=0.45u
X285 VSS.t47 a_25921_7412# a_26087_7412# VSS.t226 sg13_hv_nmos ad=39.42122p pd=85.45u as=0.2516p ps=2.16u w=0.74u l=0.45u
X286 counter_value_o[7] a_37384_13098# VSS.t203 VSS.t202 sg13_hv_nmos ad=0.2886p pd=2.26u as=0.14875p ps=1.16u w=0.74u l=0.45u
X287 a_16262_8336# a_17639_7412# a_16694_7309# VDD.t0 sg13_hv_pmos ad=0.3434p pd=2.7u as=0.1919p ps=1.39u w=1.01u l=0.45u
X288 counter_value_o[7] a_37384_13098# VDD.t128 VDD.t3 sg13_hv_pmos ad=1.00875p pd=6.13u as=0.50752p ps=3.11u w=2.69u l=0.45u
X289 sg13g2_hv_xnor2_1_1.Y a_2522_10879# VDD.t53 VDD.t10 sg13_hv_pmos ad=1.27775p pd=3.64u as=2.43445p ps=7.19u w=2.69u l=0.45u
X290 VDD.t2 VSS.t134 VDD.t1 VDD.t0 sg13_hv_pmos ad=0.456p pd=2.78u as=0 ps=0 w=2.4u l=1u
X291 sg13g2_hv_or3_1_1.B a_19845_7386# VSS.t200 VSS.t220 sg13_hv_nmos ad=0.2516p pd=2.16u as=0.1406p ps=1.12u w=0.74u l=0.45u
X292 VSS.t308 a_7596_13011# counter_value_o[1] VSS.t323 sg13_hv_nmos ad=0.14875p pd=1.16u as=0.2886p ps=2.26u w=0.74u l=0.45u
X293 VDD.t222 a_7596_13011# counter_value_o[1] VDD.t3 sg13_hv_pmos ad=0.50752p pd=3.11u as=1.00875p ps=6.13u w=2.69u l=0.45u
X294 a_3649_11551# sg13g2_hv_dfrbpq_1_1.CLK VDD.t3 VDD.t3 sg13_hv_pmos ad=0.98185p pd=6.11u as=3.84325p ps=24.58u w=2.69u l=0.45u
X295 VSS.t134 VDD.t311 VSS.t134 VSS.t135 sg13_hv_nmos ad=79.8f pd=0.8u as=0 ps=0 w=0.42u l=1u
X296 a_23655_9213# sg13g2_hv_nand3_1_1.Y a_23497_8772# VDD.t10 sg13_hv_pmos ad=0.456p pd=2.78u as=0.816p ps=5.48u w=2.4u l=0.45u
X297 a_27734_11795# a_28513_11551# a_27302_11572# VSS.t316 sg13_hv_nmos ad=79.8f pd=0.8u as=0.1581p ps=1.71u w=0.42u l=0.45u
X298 VSS.t10 sg13g2_hv_or3_1_1.C a_20662_8224# VSS.t17 sg13_hv_nmos ad=0.1406p pd=1.12u as=0.2516p ps=2.16u w=0.74u l=0.45u
X299 a_25721_8323# a_26087_7412# a_25142_7309# VSS.t303 sg13_hv_nmos ad=0.2373p pd=1.97u as=79.8f ps=0.8u w=0.42u l=0.45u
X300 sg13g2_hv_a21oi_1_2.Y sg13g2_hv_a21oi_1_1.B1 VSS.t21 VSS.t222 sg13_hv_nmos ad=0.1406p pd=1.12u as=0.2516p ps=2.16u w=0.74u l=0.45u
X301 VDD.t76 a_10100_10155# sg13g2_hv_dfrbpq_1_1.CLK VDD.t10 sg13_hv_pmos ad=0.5111p pd=3.07u as=0.5111p ps=3.07u w=2.69u l=0.45u
X302 a_15476_7443# sg13g2_hv_or3_1_1.A VDD.t127 VDD.t0 sg13_hv_pmos ad=0.378p pd=2.715u as=1.32122p ps=3.73u w=2.4u l=0.45u
X303 sg13g2_hv_a21oi_1_5.Y sg13g2_hv_a21oi_1_1.B1.t2 a_24533_9212# VDD.t10 sg13_hv_pmos ad=0.9146p pd=6.06u as=0.5111p ps=3.07u w=2.69u l=0.45u
X304 VDD.t271 a_17326_10242# sg13g2_hv_buf_16_0.A VDD.t10 sg13_hv_pmos ad=0.5111p pd=3.07u as=0.5111p ps=3.07u w=2.69u l=0.45u
X305 VSS.t187 a_17580_13011# counter_value_o[3] VSS.t195 sg13_hv_nmos ad=0.14875p pd=1.16u as=0.2886p ps=2.26u w=0.74u l=0.45u
X306 VDD.t123 a_17580_13011# counter_value_o[3] VDD.t3 sg13_hv_pmos ad=0.50752p pd=3.11u as=1.00875p ps=6.13u w=2.69u l=0.45u
X307 VDD.t3 a_12491_11649# a_12985_11792# VDD.t3 sg13_hv_pmos ad=4.05678p pd=25.945u as=0.47975p ps=1.96u w=1.01u l=0.45u
X308 VSS.t115 sg13g2_hv_xnor2_1_1.Y a_1931_11050# VSS.t214 sg13_hv_nmos ad=0.1331p pd=1.12u as=0.1216p ps=1.02u w=0.64u l=0.45u
X309 VDD.t52 sg13g2_hv_o21ai_1_0.B1 sg13g2_hv_o21ai_1_0.Y VDD.t0 sg13_hv_pmos ad=0.9146p pd=6.06u as=0.5111p ps=3.07u w=2.69u l=0.45u
X310 VDD.t0 a_18635_8259# a_19129_7966# VDD.t0 sg13_hv_pmos ad=4.91987p pd=31.75u as=0.47975p ps=1.96u w=1.01u l=0.45u
X311 sg13g2_hv_nand3_1_1.Y sg13g2_hv_nand3_1_1.A a_21976_8776# VSS.t385 sg13_hv_nmos ad=0.2516p pd=2.16u as=0.1406p ps=1.12u w=0.74u l=0.45u
X312 a_21018_8772# sg13g2_hv_nand3_1_1.A sg13g2_hv_o21ai_1_0.A2 VSS.t384 sg13_hv_nmos ad=0.1406p pd=1.12u as=0.2516p ps=2.16u w=0.74u l=0.45u
X313 VSS.t27 a_27577_7966# a_26925_8259# VSS.t26 sg13_hv_nmos ad=79.8f pd=0.8u as=0.1428p ps=1.52u w=0.42u l=0.45u
X314 a_6992_7395# a_7847_7412# a_8843_8259# VSS.t297 sg13_hv_nmos ad=0.41132p pd=2.84u as=0.2971p ps=1.69u w=0.74u l=0.45u
X315 a_24979_11650# sg13g2_hv_a21oi_1_4.A2 VSS.t33 VSS.t394 sg13_hv_nmos ad=0.1406p pd=1.12u as=0.2516p ps=2.16u w=0.74u l=0.45u
X316 VSS.t99 enable_i a_1192_5950# VSS.t292 sg13_hv_nmos ad=0.14875p pd=1.16u as=0.187p ps=1.78u w=0.55u l=0.45u
X317 sg13g2_hv_nand4_1_0.Y sg13g2_hv_buf_1_0.X VDD.t118 VDD.t3 sg13_hv_pmos ad=0.5111p pd=3.07u as=0.9146p ps=6.06u w=2.69u l=0.45u
X318 a_27302_11572# a_28679_11694# a_27734_11795# VDD.t3 sg13_hv_pmos ad=0.3434p pd=2.7u as=0.1919p ps=1.39u w=1.01u l=0.45u
X319 VSS.t92 sg13g2_hv_tiehi_2.L_HI a_16420_8336# VSS.t93 sg13_hv_nmos ad=0.2458p pd=1.735u as=60.89999f ps=0.71u w=0.42u l=0.45u
X320 VSS.t79 sg13g2_hv_nand4_1_0.C a_8654_11628# VSS.t209 sg13_hv_nmos ad=0.406p pd=1.875u as=0.2516p ps=2.16u w=0.74u l=0.45u
X321 a_28208_9261# a_28118_8939# VDD.t133 VDD.t10 sg13_hv_pmos ad=1.056p pd=5.68u as=1.2686p ps=5.2u w=2.4u l=0.45u
X322 VDD.t283 a_17326_10242# sg13g2_hv_buf_16_0.A VDD.t10 sg13_hv_pmos ad=0.95495p pd=6.09u as=0.5111p ps=3.07u w=2.69u l=0.45u
X323 a_24109_12069# sg13g2_hv_or3_1_1.C a_23943_12069# VDD.t3 sg13_hv_pmos ad=0.378p pd=2.715u as=0.456p ps=2.78u w=2.4u l=0.45u
X324 sg13g2_hv_o21ai_1_1.Y sg13g2_hv_nand4_1_1.Y a_23220_12116# VDD.t3 sg13_hv_pmos ad=0.5111p pd=3.07u as=0.5111p ps=3.07u w=2.69u l=0.45u
X325 VSS.t10 sg13g2_hv_or3_1_1.B a_21018_8772# VSS.t288 sg13_hv_nmos ad=0.2516p pd=2.16u as=0.1406p ps=1.12u w=0.74u l=0.45u
X326 VSS.t109 VDD.t326 VSS.t109 VSS.t108 sg13_hv_nmos ad=0.1428p pd=1.52u as=0 ps=0 w=0.42u l=1u
X327 a_13275_11572# sg13g2_hv_tiehi_3.L_HI VSS.t265 VSS.t279 sg13_hv_nmos ad=52.5f pd=0.67u as=79.8f ps=0.8u w=0.42u l=0.45u
X328 VDD.t196 sg13g2_hv_tiehi_3.L_HI a_10550_11795# VDD.t3 sg13_hv_pmos ad=0.77207p pd=2.7u as=0.3535p ps=2.72u w=1.01u l=0.45u
X329 VSS.t330 sg13g2_hv_or3_1_3.A a_22562_11632# VSS.t329 sg13_hv_nmos ad=0.2516p pd=2.16u as=0.1406p ps=1.12u w=0.74u l=0.45u
X330 a_22562_11632# sg13g2_hv_o21ai_1_0.B1 a_22396_11632# VSS.t69 sg13_hv_nmos ad=0.1406p pd=1.12u as=0.1406p ps=1.12u w=0.74u l=0.45u
X331 VDD.t178 a_24334_10242# sg13g2_hv_dfrbpq_1_0.CLK VDD.t10 sg13_hv_pmos ad=0.5111p pd=3.07u as=0.5111p ps=3.07u w=2.69u l=0.45u
X332 a_17456_12117# a_17366_11795# VSS.t14 VSS.t167 sg13_hv_nmos ad=0.2516p pd=2.16u as=0.2458p ps=1.735u w=0.74u l=0.45u
X333 VSS.t224 a_8843_8259# a_10053_7386# VSS.t240 sg13_hv_nmos ad=0.1406p pd=1.12u as=0.2516p ps=2.16u w=0.74u l=0.45u
X334 a_30843_8716# sg13g2_hv_dfrbpq_1_7.RESET_B VSS.t211 VSS.t210 sg13_hv_nmos ad=52.5f pd=0.67u as=79.8f ps=0.8u w=0.42u l=0.45u
X335 VDD.t256 sg13g2_hv_buf_16_0.A a_24334_10242# VDD.t10 sg13_hv_pmos ad=0.5111p pd=3.07u as=0.5111p ps=3.07u w=2.69u l=0.45u
X336 VSS.t14 VDD.t321 VSS.t14 VSS.t117 sg13_hv_nmos ad=0.1428p pd=1.52u as=0 ps=0 w=0.42u l=1u
X337 a_28118_8939# a_28897_8695# a_27686_8716# VSS.t281 sg13_hv_nmos ad=79.8f pd=0.8u as=0.1581p ps=1.71u w=0.42u l=0.45u
X338 VSS.t143 a_10100_10155# sg13g2_hv_dfrbpq_1_1.CLK VSS.t151 sg13_hv_nmos ad=0.1406p pd=1.12u as=0.1406p ps=1.12u w=0.74u l=0.45u
X339 VSS.t89 a_19129_7966# a_18477_8259# VSS.t88 sg13_hv_nmos ad=79.8f pd=0.8u as=0.1428p ps=1.52u w=0.42u l=0.45u
X340 a_9627_8336# sg13g2_hv_tiehi_1.L_HI VSS.t64 VSS.t63 sg13_hv_nmos ad=52.5f pd=0.67u as=79.8f ps=0.8u w=0.42u l=0.45u
X341 VSS.t270 a_17326_10242# sg13g2_hv_buf_16_0.A VSS.t373 sg13_hv_nmos ad=0.1406p pd=1.12u as=0.1406p ps=1.12u w=0.74u l=0.45u
X342 VSS.t14 clock_i a_17326_10242# VSS.t335 sg13_hv_nmos ad=0.1406p pd=1.12u as=0.1406p ps=1.12u w=0.74u l=0.45u
X343 a_3449_11585# a_3815_11694# a_2870_11795# VSS.t313 sg13_hv_nmos ad=0.2373p pd=1.97u as=79.8f ps=0.8u w=0.42u l=0.45u
X344 a_2522_10879# sg13g2_hv_nand2_1_2.Y VDD.t57 VDD.t10 sg13_hv_pmos ad=0.95713p pd=2.965u as=0.69405p ps=3.265u w=2.015u l=0.45u
X345 sg13g2_hv_dfrbpq_1_1.CLK a_10100_10155# VSS.t143 VSS.t150 sg13_hv_nmos ad=0.1406p pd=1.12u as=0.1406p ps=1.12u w=0.74u l=0.45u
X346 sg13g2_hv_buf_16_0.A a_17326_10242# VSS.t270 VSS.t372 sg13_hv_nmos ad=0.1406p pd=1.12u as=0.1406p ps=1.12u w=0.74u l=0.45u
X347 VSS.t115 VDD.t323 VSS.t115 VSS.t114 sg13_hv_nmos ad=0.1428p pd=1.52u as=0 ps=0 w=0.42u l=1u
X348 a_23785_11628# sg13g2_hv_or3_1_1.C VSS.t16 VSS.t15 sg13_hv_nmos ad=0.286p pd=1.59u as=0.1045p ps=0.93u w=0.55u l=0.45u
X349 VSS.t200 a_18635_8259# a_19845_7386# VSS.t199 sg13_hv_nmos ad=0.1406p pd=1.12u as=0.2516p ps=2.16u w=0.74u l=0.45u
X350 a_6628_8336# sg13g2_hv_dfrbpq_1_1.D a_6470_8336# VSS.t305 sg13_hv_nmos ad=60.89999f pd=0.71u as=0.1428p ps=1.52u w=0.42u l=0.45u
X351 VDD.t132 sg13g2_hv_nand3_1_0.Y a_8327_12110# VDD.t3 sg13_hv_pmos ad=0.69405p pd=3.265u as=0.95713p ps=2.965u w=2.015u l=0.45u
X352 a_24334_10242# sg13g2_hv_buf_16_0.A VSS.t33 VSS.t352 sg13_hv_nmos ad=0.1406p pd=1.12u as=0.1406p ps=1.12u w=0.74u l=0.45u
X353 sg13g2_hv_dfrbpq_1_0.CLK a_24334_10242# VDD.t180 VDD.t10 sg13_hv_pmos ad=0.5111p pd=3.07u as=0.5111p ps=3.07u w=2.69u l=0.45u
X354 a_17326_10242# clock_i VDD.t242 VDD.t10 sg13_hv_pmos ad=0.5111p pd=3.07u as=0.5111p ps=3.07u w=2.69u l=0.45u
X355 VDD.t33 sg13g2_hv_dfrbpq_1_4.RESET_B a_27734_11795# VDD.t3 sg13_hv_pmos ad=0.77207p pd=2.7u as=0.3535p ps=2.72u w=1.01u l=0.45u
X356 VSS.t33 sg13g2_hv_buf_16_0.A a_24334_10242# VSS.t351 sg13_hv_nmos ad=0.1406p pd=1.12u as=0.1406p ps=1.12u w=0.74u l=0.45u
X357 sg13g2_hv_dfrbpq_1_1.CLK a_10100_10155# VSS.t154 VSS.t155 sg13_hv_nmos ad=0.1406p pd=1.12u as=0.1406p ps=1.12u w=0.74u l=0.45u
X358 sg13g2_hv_dfrbpq_1_1.CLK a_10100_10155# VSS.t53 VSS.t139 sg13_hv_nmos ad=0.1406p pd=1.12u as=0.2516p ps=2.16u w=0.74u l=0.45u
X359 a_7681_7412# sg13g2_hv_dfrbpq_1_1.CLK VSS.t47 VSS.t274 sg13_hv_nmos ad=0.2516p pd=2.16u as=33.78962p ps=73.245u w=0.74u l=0.45u
X360 a_7596_13011# sg13g2_hv_xnor2_1_1.A VSS.t308 VSS.t307 sg13_hv_nmos ad=0.187p pd=1.78u as=0.14875p ps=1.16u w=0.55u l=0.45u
X361 a_7596_13011# sg13g2_hv_xnor2_1_1.A VDD.t222 VDD.t3 sg13_hv_pmos ad=0.6851p pd=4.71u as=0.50752p ps=3.11u w=2.015u l=0.45u
X362 a_10550_11795# a_11329_11551# a_10118_11572# VSS.t217 sg13_hv_nmos ad=79.8f pd=0.8u as=0.1581p ps=1.71u w=0.42u l=0.45u
X363 VDD.t146 VSS.t191 sg13g2_hv_tiehi_1.L_HI VDD.t0 sg13_hv_pmos ad=0.9146p pd=6.06u as=0.9146p ps=6.06u w=2.69u l=0.45u
X364 VSS.t295 sg13g2_hv_or3_1_3.A a_32392_13098# VSS.t331 sg13_hv_nmos ad=0.14875p pd=1.16u as=0.187p ps=1.78u w=0.55u l=0.45u
X365 VDD.t212 sg13g2_hv_or3_1_3.A a_32392_13098# VDD.t3 sg13_hv_pmos ad=0.50752p pd=3.11u as=0.6851p ps=4.71u w=2.015u l=0.45u
X366 VDD.t48 sg13g2_hv_or3_1_1.B sg13g2_hv_nand4_1_1.Y VDD.t3 sg13_hv_pmos ad=0.5111p pd=3.07u as=0.5111p ps=3.07u w=2.69u l=0.45u
X367 VSS.t311 sg13g2_hv_xnor2_1_1.A a_3527_11050# VSS.t310 sg13_hv_nmos ad=0.2272p pd=1.99u as=0.304p ps=1.59u w=0.64u l=0.45u
X368 VDD.t1 VSS.t133 VDD.t93 VDD.t0 sg13_hv_pmos ad=0.816p pd=5.48u as=0 ps=0 w=2.4u l=1u
X369 a_30059_8793# a_28897_8695# a_28208_9261# VDD.t10 sg13_hv_pmos ad=0.93082p pd=3.45u as=1.896p ps=6.38u w=2.4u l=0.45u
X370 VDD.t26 sg13g2_hv_tiehi_2.L_HI a_16694_7309# VDD.t0 sg13_hv_pmos ad=0.77207p pd=2.7u as=0.3535p ps=2.72u w=1.01u l=0.45u
X371 sg13g2_hv_nand4_1_0.C a_13701_12068# VDD.t4 VDD.t3 sg13_hv_pmos ad=0.9146p pd=6.06u as=0.5111p ps=3.07u w=2.69u l=0.45u
X372 sg13g2_hv_nand4_1_1.Y sg13g2_hv_nand3_1_1.A VDD.t284 VDD.t3 sg13_hv_pmos ad=0.5111p pd=3.07u as=0.9146p ps=6.06u w=2.69u l=0.45u
X373 a_6902_7309# a_7681_7412# a_6470_8336# VSS.t228 sg13_hv_nmos ad=79.8f pd=0.8u as=0.1581p ps=1.71u w=0.42u l=0.45u
X374 a_6992_7395# a_6902_7309# VSS.t62 VSS.t136 sg13_hv_nmos ad=0.2516p pd=2.16u as=0.2458p ps=1.735u w=0.74u l=0.45u
X375 a_28208_9261# a_28118_8939# VSS.t27 VSS.t221 sg13_hv_nmos ad=0.2516p pd=2.16u as=0.2458p ps=1.735u w=0.74u l=0.45u
X376 a_8747_11050# sg13g2_hv_buf_1_9.X a_8589_11050# VSS.t60 sg13_hv_nmos ad=0.1216p pd=1.02u as=0.2176p ps=1.96u w=0.64u l=0.45u
X377 VDD.t4 a_12491_11649# a_13701_12068# VDD.t3 sg13_hv_pmos ad=0.5111p pd=3.07u as=0.92805p ps=6.07u w=2.69u l=0.45u
X378 VSS.t134 VDD.t311 VSS.t133 VSS.t132 sg13_hv_nmos ad=0.1428p pd=1.52u as=0 ps=0 w=0.42u l=1u
X379 VDD.t72 a_10100_10155# sg13g2_hv_dfrbpq_1_1.CLK VDD.t10 sg13_hv_pmos ad=0.5111p pd=3.07u as=0.5111p ps=3.07u w=2.69u l=0.45u
X380 a_30114_12109# a_28679_11694# a_29675_11649# VDD.t3 sg13_hv_pmos ad=0.22472p pd=1.455u as=0.93082p ps=3.45u w=1.01u l=0.45u
X381 VSS.t33 a_24334_10242# sg13g2_hv_dfrbpq_1_0.CLK VSS.t248 sg13_hv_nmos ad=0.1406p pd=1.12u as=0.1406p ps=1.12u w=0.74u l=0.45u
X382 sg13g2_hv_a21oi_1_3.Y sg13g2_hv_a21oi_1_1.B1.t4 a_15893_12068# VDD.t3 sg13_hv_pmos ad=0.9146p pd=6.06u as=0.5111p ps=3.07u w=2.69u l=0.45u
X383 VDD.t246 clock_i a_17326_10242# VDD.t10 sg13_hv_pmos ad=0.5111p pd=3.07u as=0.5111p ps=3.07u w=2.69u l=0.45u
X384 sg13g2_hv_dfrbpq_1_0.CLK a_24334_10242# VSS.t41 VSS.t261 sg13_hv_nmos ad=0.1406p pd=1.12u as=0.1406p ps=1.12u w=0.74u l=0.45u
X385 sg13g2_hv_dfrbpq_1_0.CLK a_24334_10242# VSS.t33 VSS.t247 sg13_hv_nmos ad=0.1406p pd=1.12u as=0.1406p ps=1.12u w=0.74u l=0.45u
X386 a_1931_11050# sg13g2_hv_buf_1_9.X a_1773_11050# VSS.t57 sg13_hv_nmos ad=0.1216p pd=1.02u as=0.2176p ps=1.96u w=0.64u l=0.45u
X387 VSS.t50 a_11329_11551# a_11495_11694# VSS.t218 sg13_hv_nmos ad=28.89642p pd=80.17u as=0.2516p ps=2.16u w=0.74u l=0.45u
X388 a_3449_11585# a_2960_12117# a_3309_11585# VSS.t39 sg13_hv_nmos ad=0.2877p pd=2.21u as=52.5f ps=0.67u w=0.42u l=0.45u
X389 VDD.t247 VSS.t105 VDD.t302 VDD.t3 sg13_hv_pmos ad=0.456p pd=2.78u as=0 ps=0 w=2.4u l=1u
X390 a_27302_11572# sg13g2_hv_a21oi_1_4.Y VDD.t189 VDD.t3 sg13_hv_pmos ad=0.303p pd=1.61u as=0.3434p ps=2.7u w=1.01u l=0.45u
X391 a_25232_7395# a_25142_7309# VDD.t21 VDD.t0 sg13_hv_pmos ad=1.056p pd=5.68u as=1.2686p ps=5.2u w=2.4u l=0.45u
X392 a_19129_7966# sg13g2_hv_tiehi_2.L_HI VDD.t0 VDD.t0 sg13_hv_pmos ad=0.47975p pd=1.96u as=4.91987p ps=31.75u w=1.01u l=0.45u
X393 VDD.t62 sg13g2_hv_or3_1_3.X a_24533_9212# VDD.t10 sg13_hv_pmos ad=0.5111p pd=3.07u as=0.9146p ps=6.06u w=2.69u l=0.45u
X394 a_4811_11649# a_3649_11551# a_4653_11649# VSS.t407 sg13_hv_nmos ad=0.2971p pd=1.69u as=0.1428p ps=1.52u w=0.42u l=0.45u
X395 a_18635_8259# a_17473_7412# a_16784_7395# VDD.t0 sg13_hv_pmos ad=0.93082p pd=3.45u as=1.896p ps=6.38u w=2.4u l=0.45u
X396 VDD.t279 a_17326_10242# sg13g2_hv_buf_16_0.A VDD.t10 sg13_hv_pmos ad=0.5111p pd=3.07u as=0.5111p ps=3.07u w=2.69u l=0.45u
X397 a_10100_10155# sg13g2_hv_buf_16_0.A VDD.t250 VDD.t10 sg13_hv_pmos ad=0.5111p pd=3.07u as=0.5111p ps=3.07u w=2.69u l=0.45u
X398 VSS.t143 a_10100_10155# sg13g2_hv_dfrbpq_1_1.CLK VSS.t142 sg13_hv_nmos ad=0.1406p pd=1.12u as=0.1406p ps=1.12u w=0.74u l=0.45u
X399 VDD.t223 sg13g2_hv_xnor2_1_1.A sg13g2_hv_nand3_1_0.Y VDD.t10 sg13_hv_pmos ad=0.5111p pd=3.07u as=0.5111p ps=3.07u w=2.69u l=0.45u
X400 a_27686_8716# sg13g2_hv_a21oi_1_5.Y VDD.t216 VDD.t10 sg13_hv_pmos ad=0.303p pd=1.61u as=0.3434p ps=2.7u w=1.01u l=0.45u
X401 VSS.t270 a_17326_10242# sg13g2_hv_buf_16_0.A VSS.t365 sg13_hv_nmos ad=0.1406p pd=1.12u as=0.1406p ps=1.12u w=0.74u l=0.45u
X402 a_23943_12069# sg13g2_hv_nand4_1_1.Y a_23785_11628# VDD.t3 sg13_hv_pmos ad=0.456p pd=2.78u as=0.816p ps=5.48u w=2.4u l=0.45u
X403 VDD.t28 sg13g2_hv_tiehi_5.L_HI a_2870_11795# VDD.t3 sg13_hv_pmos ad=0.77207p pd=2.7u as=0.3535p ps=2.72u w=1.01u l=0.45u
X404 a_23062_11620# sg13g2_hv_nand4_1_1.Y VSS.t16 VSS.t37 sg13_hv_nmos ad=0.1406p pd=1.12u as=0.1406p ps=1.12u w=0.74u l=0.45u
X405 VDD.t110 VSS.t183 sg13g2_hv_dfrbpq_1_7.RESET_B VDD.t10 sg13_hv_pmos ad=0.9146p pd=6.06u as=0.9146p ps=6.06u w=2.69u l=0.45u
X406 VDD.t294 sg13g2_hv_nand2b_1_0.B sg13g2_hv_nand4_1_0.Y VDD.t3 sg13_hv_pmos ad=0.9146p pd=6.06u as=0.5111p ps=3.07u w=2.69u l=0.45u
X407 VDD.t3 a_19307_11649# a_19801_11792# VDD.t3 sg13_hv_pmos ad=4.05678p pd=25.945u as=0.47975p ps=1.96u w=1.01u l=0.45u
X408 VSS.t50 a_28513_11551# a_28679_11694# VSS.t317 sg13_hv_nmos ad=28.89642p pd=80.17u as=0.2516p ps=2.16u w=0.74u l=0.45u
X409 VDD.t0 a_25921_7412# a_26087_7412# VDD.t0 sg13_hv_pmos ad=4.91987p pd=31.75u as=0.92805p ps=6.07u w=2.69u l=0.45u
X410 VSS.t14 sg13g2_hv_tiehi_4.L_HI a_17092_11572# VSS.t327 sg13_hv_nmos ad=0.2458p pd=1.735u as=60.89999f ps=0.71u w=0.42u l=0.45u
X411 sg13g2_hv_dfrbpq_1_1.CLK a_10100_10155# VSS.t143 VSS.t146 sg13_hv_nmos ad=0.1406p pd=1.12u as=0.1406p ps=1.12u w=0.74u l=0.45u
X412 VSS.t47 a_28897_8695# a_29063_8838# VSS.t282 sg13_hv_nmos ad=39.42122p pd=85.45u as=0.2516p ps=2.16u w=0.74u l=0.45u
X413 a_27083_8259# a_25921_7412# a_26925_8259# VSS.t227 sg13_hv_nmos ad=0.2971p pd=1.69u as=0.1428p ps=1.52u w=0.42u l=0.45u
X414 sg13g2_hv_nand2b_1_1.Y a_5115_7520# a_5445_8216# VSS.t56 sg13_hv_nmos ad=0.333p pd=2.38u as=0.1406p ps=1.12u w=0.74u l=0.45u
X415 a_27844_8716# sg13g2_hv_a21oi_1_5.Y a_27686_8716# VSS.t301 sg13_hv_nmos ad=60.89999f pd=0.71u as=0.1428p ps=1.52u w=0.42u l=0.45u
X416 VSS.t21 a_15043_8026# sg13g2_hv_a21oi_1_2.A2 VSS.t201 sg13_hv_nmos ad=0.19315p pd=1.28u as=0.2516p ps=2.16u w=0.74u l=0.45u
X417 a_28118_8939# a_28897_8695# a_28837_9436# VDD.t10 sg13_hv_pmos ad=0.1919p pd=1.39u as=0.1515p ps=1.31u w=1.01u l=0.45u
X418 sg13g2_hv_a21oi_1_1.B1.t0 sg13g2_hv_buf_1_9.X VDD.t43 VDD.t10 sg13_hv_pmos ad=0.9146p pd=6.06u as=0.9146p ps=6.06u w=2.69u l=0.45u
X419 a_3309_11585# sg13g2_hv_tiehi_5.L_HI VSS.t82 VSS.t358 sg13_hv_nmos ad=52.5f pd=0.67u as=0.252p ps=2.04u w=0.42u l=0.45u
X420 VSS.t16 sg13g2_hv_nand4_1_1.Y a_23785_11628# VSS.t38 sg13_hv_nmos ad=0.1045p pd=0.93u as=0.187p ps=1.78u w=0.55u l=0.45u
X421 a_3041_10242# sg13g2_hv_nand2_1_2.Y sg13g2_hv_xnor2_1_1.Y VDD.t10 sg13_hv_pmos ad=0.34297p pd=2.945u as=1.27775p ps=3.64u w=2.69u l=0.45u
X422 a_7341_8323# sg13g2_hv_tiehi_1.L_HI VSS.t62 VSS.t61 sg13_hv_nmos ad=52.5f pd=0.67u as=0.252p ps=2.04u w=0.42u l=0.45u
X423 a_3649_11551# sg13g2_hv_dfrbpq_1_1.CLK VSS.t50 VSS.t275 sg13_hv_nmos ad=0.2516p pd=2.16u as=24.76835p ps=68.72u w=0.74u l=0.45u
X424 a_15525_11628# sg13g2_hv_or3_1_1.A VSS.t19 VSS.t398 sg13_hv_nmos ad=0.1406p pd=1.12u as=0.14505p ps=1.15u w=0.74u l=0.45u
X425 sg13g2_hv_o21ai_1_0.Y sg13g2_hv_o21ai_1_0.B1 a_20662_8224# VSS.t70 sg13_hv_nmos ad=0.2516p pd=2.16u as=0.1406p ps=1.12u w=0.74u l=0.45u
X426 a_17366_11795# a_18145_11551# a_18085_12292# VDD.t3 sg13_hv_pmos ad=0.1919p pd=1.39u as=0.1515p ps=1.31u w=1.01u l=0.45u
X427 a_17326_10242# clock_i VSS.t14 VSS.t338 sg13_hv_nmos ad=0.1406p pd=1.12u as=0.1406p ps=1.12u w=0.74u l=0.45u
X428 VDD.t14 sg13g2_hv_or3_1_1.C a_15195_11666# VDD.t3 sg13_hv_pmos ad=0.52782p pd=3.1u as=0.6851p ps=4.71u w=2.015u l=0.45u
X429 sg13g2_hv_a21oi_1_0.Y sg13g2_hv_a21oi_1_1.B1.t1 a_22421_7386# VDD.t0 sg13_hv_pmos ad=0.9146p pd=6.06u as=0.5111p ps=3.07u w=2.69u l=0.45u
X430 sg13g2_hv_dfrbpq_1_1.D sg13g2_hv_a21oi_1_1.B1 a_5813_7386# VDD.t0 sg13_hv_pmos ad=0.9146p pd=6.06u as=0.5111p ps=3.07u w=2.69u l=0.45u
X431 a_8187_11670# sg13g2_hv_nand4_1_0.C VSS.t79 VSS.t208 sg13_hv_nmos ad=0.304p pd=1.59u as=0.2272p ps=1.99u w=0.64u l=0.45u
X432 sg13g2_hv_xnor2_1_1.A a_6021_12068# VDD.t168 VDD.t3 sg13_hv_pmos ad=0.9146p pd=6.06u as=0.5111p ps=3.07u w=2.69u l=0.45u
X433 a_27824_12117# a_27734_11795# VSS.t41 VSS.t266 sg13_hv_nmos ad=0.2516p pd=2.16u as=0.2458p ps=1.735u w=0.74u l=0.45u
X434 VDD.t168 a_4811_11649# a_6021_12068# VDD.t3 sg13_hv_pmos ad=0.5111p pd=3.07u as=0.92805p ps=6.07u w=2.69u l=0.45u
X435 sg13g2_hv_nand4_1_0.C a_13701_12068# VSS.t1 VSS.t0 sg13_hv_nmos ad=0.2516p pd=2.16u as=0.1406p ps=1.12u w=0.74u l=0.45u
X436 VDD.t3 a_4811_11649# a_5305_11792# VDD.t3 sg13_hv_pmos ad=4.05678p pd=25.945u as=0.47975p ps=1.96u w=1.01u l=0.45u
X437 VDD.t184 a_24334_10242# sg13g2_hv_dfrbpq_1_0.CLK VDD.t10 sg13_hv_pmos ad=0.95495p pd=6.09u as=0.5111p ps=3.07u w=2.69u l=0.45u
X438 a_10118_11572# sg13g2_hv_and2_1_0.X VDD.t5 VDD.t3 sg13_hv_pmos ad=0.303p pd=1.61u as=0.3434p ps=2.7u w=1.01u l=0.45u
X439 VSS.t1 a_12491_11649# a_13701_12068# VSS.t396 sg13_hv_nmos ad=0.1406p pd=1.12u as=0.2516p ps=2.16u w=0.74u l=0.45u
X440 sg13g2_hv_o21ai_1_0.Y sg13g2_hv_o21ai_1_0.A2 a_20820_7338# VDD.t0 sg13_hv_pmos ad=0.5111p pd=3.07u as=0.5111p ps=3.07u w=2.69u l=0.45u
X441 VSS.t265 sg13g2_hv_buf_16_0.A a_10100_10155# VSS.t343 sg13_hv_nmos ad=0.1406p pd=1.12u as=0.1406p ps=1.12u w=0.74u l=0.45u
X442 VDD.t3 a_19801_11792# a_19746_12109# VDD.t3 sg13_hv_pmos ad=4.05678p pd=25.945u as=0.22472p ps=1.455u w=1.01u l=0.45u
X443 a_25142_7309# a_25921_7412# a_24710_8336# VSS.t225 sg13_hv_nmos ad=79.8f pd=0.8u as=0.1581p ps=1.71u w=0.42u l=0.45u
X444 a_19419_8336# sg13g2_hv_tiehi_2.L_HI VSS.t89 VSS.t94 sg13_hv_nmos ad=52.5f pd=0.67u as=79.8f ps=0.8u w=0.42u l=0.45u
X445 a_21976_8776# sg13g2_hv_or3_1_1.B a_21810_8776# VSS.t289 sg13_hv_nmos ad=0.1406p pd=1.12u as=0.1406p ps=1.12u w=0.74u l=0.45u
X446 a_19307_11649# a_18145_11551# a_17456_12117# VDD.t3 sg13_hv_pmos ad=0.93082p pd=3.45u as=1.896p ps=6.38u w=2.4u l=0.45u
X447 a_23604_10194# sg13g2_hv_or3_1_1.C VDD.t13 VDD.t10 sg13_hv_pmos ad=0.5111p pd=3.07u as=0.9146p ps=6.06u w=2.69u l=0.45u
X448 a_15629_7443# sg13g2_hv_or3_1_1.B a_15476_7443# VDD.t0 sg13_hv_pmos ad=0.456p pd=2.78u as=0.378p ps=2.715u w=2.4u l=0.45u
X449 VDD.t3 a_18145_11551# a_18311_11694# VDD.t3 sg13_hv_pmos ad=4.05678p pd=25.945u as=0.92805p ps=6.07u w=2.69u l=0.45u
X450 VDD.t209 a_14233_11648# sg13g2_hv_or3_1_1.C VDD.t3 sg13_hv_pmos ad=1.76195p pd=6.69u as=0.5111p ps=3.07u w=2.69u l=0.45u
X451 sg13g2_hv_buf_1_9.X a_1192_10242# VSS.t355 VSS.t400 sg13_hv_nmos ad=0.2886p pd=2.26u as=0.14875p ps=1.16u w=0.74u l=0.45u
X452 VSS.t75 a_30059_8793# a_31269_9212# VSS.t85 sg13_hv_nmos ad=0.1406p pd=1.12u as=0.2516p ps=2.16u w=0.74u l=0.45u
X453 a_12491_11649# a_11329_11551# a_10640_12117# VDD.t3 sg13_hv_pmos ad=0.93082p pd=3.45u as=1.896p ps=6.38u w=2.4u l=0.45u
X454 sg13g2_hv_a21oi_1_5.Y sg13g2_hv_a21oi_1_5.A1 a_24691_8794# VSS.t315 sg13_hv_nmos ad=0.1406p pd=1.12u as=0.1406p ps=1.12u w=0.74u l=0.45u
X455 sg13g2_hv_dfrbpq_1_0.CLK a_24334_10242# VSS.t33 VSS.t251 sg13_hv_nmos ad=0.1406p pd=1.12u as=0.1406p ps=1.12u w=0.74u l=0.45u
X456 sg13g2_hv_dfrbpq_1_1.CLK a_10100_10155# VDD.t74 VDD.t10 sg13_hv_pmos ad=0.5111p pd=3.07u as=0.5111p ps=3.07u w=2.69u l=0.45u
X457 a_19074_7681# a_17639_7412# a_18635_8259# VDD.t0 sg13_hv_pmos ad=0.22472p pd=1.455u as=0.93082p ps=3.45u w=1.01u l=0.45u
X458 sg13g2_hv_buf_16_0.A a_17326_10242# VDD.t269 VDD.t10 sg13_hv_pmos ad=0.5111p pd=3.07u as=0.5111p ps=3.07u w=2.69u l=0.45u
X459 VDD.t240 VSS.t21 VDD.t239 VDD.t10 sg13_hv_pmos ad=0.816p pd=5.48u as=0 ps=0 w=2.4u l=1u
X460 sg13g2_hv_buf_1_9.X a_1192_10242# VDD.t261 VDD.t10 sg13_hv_pmos ad=1.00875p pd=6.13u as=0.50752p ps=3.11u w=2.69u l=0.45u
X461 VDD.t39 sg13g2_hv_nand2b_1_1.Y a_5813_7386# VDD.t0 sg13_hv_pmos ad=0.5111p pd=3.07u as=0.9146p ps=6.06u w=2.69u l=0.45u
X462 a_10100_10155# sg13g2_hv_buf_16_0.A VSS.t265 VSS.t346 sg13_hv_nmos ad=0.1406p pd=1.12u as=0.1406p ps=1.12u w=0.74u l=0.45u
X463 VDD.t185 sg13g2_hv_a21oi_1_4.A2 a_24821_12068# VDD.t3 sg13_hv_pmos ad=0.5111p pd=3.07u as=0.9146p ps=6.06u w=2.69u l=0.45u
X464 a_15043_8026# sg13g2_hv_or3_1_1.C VSS.t21 VSS.t22 sg13_hv_nmos ad=0.187p pd=1.78u as=0.1045p ps=0.93u w=0.55u l=0.45u
X465 sg13g2_hv_nand3_1_1.Y sg13g2_hv_o21ai_1_0.B1 VDD.t50 VDD.t10 sg13_hv_pmos ad=0.5111p pd=3.07u as=0.9146p ps=6.06u w=2.69u l=0.45u
X466 a_17473_7412# sg13g2_hv_dfrbpq_1_1.CLK VSS.t47 VSS.t276 sg13_hv_nmos ad=0.2516p pd=2.16u as=33.78962p ps=73.245u w=0.74u l=0.45u
X467 VDD.t27 sg13g2_hv_tiehi_1.L_HI a_6902_7309# VDD.t0 sg13_hv_pmos ad=0.77207p pd=2.7u as=0.3535p ps=2.72u w=1.01u l=0.45u
X468 sg13g2_hv_nand3_1_1.A a_20517_12068# VDD.t90 VDD.t3 sg13_hv_pmos ad=0.9146p pd=6.06u as=0.5111p ps=3.07u w=2.69u l=0.45u
X469 VDD.t121 VSS.t193 sg13g2_hv_tiehi_2.L_HI VDD.t0 sg13_hv_pmos ad=0.9146p pd=6.06u as=0.9146p ps=6.06u w=2.69u l=0.45u
X470 VDD.t219 sg13g2_hv_xnor2_1_1.A a_2522_10879# VDD.t10 sg13_hv_pmos ad=2.12582p pd=6.14u as=0.95713p ps=2.965u w=2.015u l=0.45u
X471 VSS.t79 VDD.t319 VSS.t79 VSS.t121 sg13_hv_nmos ad=0.1428p pd=1.52u as=0 ps=0 w=0.42u l=1u
X472 VSS.t12 sg13g2_hv_nand3_1_1.Y a_23497_8772# VSS.t215 sg13_hv_nmos ad=0.1045p pd=0.93u as=0.187p ps=1.78u w=0.55u l=0.45u
X473 a_7681_7412# sg13g2_hv_dfrbpq_1_1.CLK VDD.t0 VDD.t0 sg13_hv_pmos ad=0.98185p pd=6.11u as=4.5919p ps=29.635u w=2.69u l=0.45u
X474 sg13g2_hv_dfrbpq_1_1.CLK a_10100_10155# VDD.t78 VDD.t10 sg13_hv_pmos ad=0.5111p pd=3.07u as=0.5111p ps=3.07u w=2.69u l=0.45u
X475 sg13g2_hv_and2_1_0.B sg13g2_hv_nand3_1_0.Y a_8812_12068# VDD.t3 sg13_hv_pmos ad=1.27775p pd=3.64u as=0.34297p ps=2.945u w=2.69u l=0.45u
X476 a_18085_12292# a_17456_12117# VDD.t87 VDD.t3 sg13_hv_pmos ad=0.1515p pd=1.31u as=0.77207p ps=2.7u w=1.01u l=0.45u
X477 a_16694_7309# a_17473_7412# a_16262_8336# VSS.t235 sg13_hv_nmos ad=79.8f pd=0.8u as=0.1581p ps=1.71u w=0.42u l=0.45u
X478 sg13g2_hv_buf_1_0.X a_1192_5950# VDD.t67 VDD.t0 sg13_hv_pmos ad=1.00875p pd=6.13u as=0.50752p ps=3.11u w=2.69u l=0.45u
X479 a_16784_7395# a_16694_7309# VSS.t92 VSS.t238 sg13_hv_nmos ad=0.2516p pd=2.16u as=0.2458p ps=1.735u w=0.74u l=0.45u
X480 a_7481_8323# a_7847_7412# a_6902_7309# VSS.t296 sg13_hv_nmos ad=0.2373p pd=1.97u as=79.8f ps=0.8u w=0.42u l=0.45u
X481 sg13g2_hv_buf_16_0.A a_17326_10242# VDD.t273 VDD.t10 sg13_hv_pmos ad=0.5111p pd=3.07u as=0.5111p ps=3.07u w=2.69u l=0.45u
X482 VDD.t55 sg13g2_hv_and2_1_0.B a_8589_11050# VDD.t10 sg13_hv_pmos ad=0.46047p pd=3.07u as=0.38285p ps=2.395u w=2.015u l=0.45u
X483 VDD.t292 sg13g2_hv_nand2b_1_0.B sg13g2_hv_nand2_1_2.Y VDD.t10 sg13_hv_pmos ad=0.9146p pd=6.06u as=0.5111p ps=3.07u w=2.69u l=0.45u
X484 sg13g2_hv_buf_16_0.A a_17326_10242# VDD.t281 VDD.t10 sg13_hv_pmos ad=0.5111p pd=3.07u as=0.5111p ps=3.07u w=2.69u l=0.45u
X485 VDD.t254 sg13g2_hv_buf_16_0.A a_10100_10155# VDD.t10 sg13_hv_pmos ad=0.9146p pd=6.06u as=0.5111p ps=3.07u w=2.69u l=0.45u
X486 sg13g2_hv_nand2b_1_0.B a_10053_7386# VDD.t149 VDD.t0 sg13_hv_pmos ad=0.9146p pd=6.06u as=0.5111p ps=3.07u w=2.69u l=0.45u
X487 VSS.t41 a_24334_10242# sg13g2_hv_dfrbpq_1_0.CLK VSS.t254 sg13_hv_nmos ad=0.1406p pd=1.12u as=0.1406p ps=1.12u w=0.74u l=0.45u
X488 VDD.t78 a_10100_10155# sg13g2_hv_dfrbpq_1_1.CLK VDD.t10 sg13_hv_pmos ad=0.5111p pd=3.07u as=0.5111p ps=3.07u w=2.69u l=0.45u
X489 a_30498_9253# a_29063_8838# a_30059_8793# VDD.t10 sg13_hv_pmos ad=0.22472p pd=1.455u as=0.93082p ps=3.45u w=1.01u l=0.45u
X490 VDD.t273 a_17326_10242# sg13g2_hv_buf_16_0.A VDD.t10 sg13_hv_pmos ad=0.5111p pd=3.07u as=0.5111p ps=3.07u w=2.69u l=0.45u
X491 VDD.t281 a_17326_10242# sg13g2_hv_buf_16_0.A VDD.t10 sg13_hv_pmos ad=0.5111p pd=3.07u as=0.5111p ps=3.07u w=2.69u l=0.45u
X492 sg13g2_hv_buf_16_0.A a_17326_10242# VSS.t270 VSS.t368 sg13_hv_nmos ad=0.1406p pd=1.12u as=0.1406p ps=1.12u w=0.74u l=0.45u
X493 a_19801_11792# sg13g2_hv_tiehi_4.L_HI VDD.t3 VDD.t3 sg13_hv_pmos ad=0.47975p pd=1.96u as=4.05678p ps=25.945u w=1.01u l=0.45u
X494 a_14427_7386# sg13g2_hv_a21oi_1_2.A2 VDD.t122 VDD.t0 sg13_hv_pmos ad=0.9146p pd=6.06u as=0.5111p ps=3.07u w=2.69u l=0.45u
X495 a_15043_8026# sg13g2_hv_or3_1_1.A VSS.t21 VSS.t399 sg13_hv_nmos ad=0.286p pd=1.59u as=0.19315p ps=1.28u w=0.55u l=0.45u
X496 a_16934_11572# sg13g2_hv_a21oi_1_3.Y VDD.t211 VDD.t3 sg13_hv_pmos ad=0.303p pd=1.61u as=0.3434p ps=2.7u w=1.01u l=0.45u
X497 VSS.t10 sg13g2_hv_o21ai_1_0.B1 a_21385_7443# VSS.t71 sg13_hv_nmos ad=0.19315p pd=1.28u as=0.286p ps=1.59u w=0.55u l=0.45u
X498 a_6470_8336# sg13g2_hv_dfrbpq_1_1.D VDD.t218 VDD.t0 sg13_hv_pmos ad=0.303p pd=1.61u as=0.3434p ps=2.7u w=1.01u l=0.45u
X499 sg13g2_hv_buf_1_0.X a_1192_5950# VSS.t99 VSS.t98 sg13_hv_nmos ad=0.2886p pd=2.26u as=0.14875p ps=1.16u w=0.74u l=0.45u
X500 sg13g2_hv_dfrbpq_1_0.CLK a_24334_10242# VDD.t176 VDD.t10 sg13_hv_pmos ad=0.5111p pd=3.07u as=0.5111p ps=3.07u w=2.69u l=0.45u
X501 a_24334_10242# sg13g2_hv_buf_16_0.A VDD.t255 VDD.t10 sg13_hv_pmos ad=0.5111p pd=3.07u as=0.9146p ps=6.06u w=2.69u l=0.45u
X502 a_12985_11792# a_12491_11649# a_13275_11572# VSS.t395 sg13_hv_nmos ad=0.3528p pd=2.52u as=52.5f ps=0.67u w=0.42u l=0.45u
X503 a_17326_10242# clock_i VSS.t14 VSS.t334 sg13_hv_nmos ad=0.1406p pd=1.12u as=0.2516p ps=2.16u w=0.74u l=0.45u
X504 a_2870_11795# a_3649_11551# a_2438_11572# VSS.t405 sg13_hv_nmos ad=79.8f pd=0.8u as=0.1581p ps=1.71u w=0.42u l=0.45u
X505 a_10640_12117# a_10550_11795# VSS.t53 VSS.t52 sg13_hv_nmos ad=0.2516p pd=2.16u as=0.2458p ps=1.735u w=0.74u l=0.45u
X506 VDD.t127 a_15043_8026# sg13g2_hv_a21oi_1_2.A2 VDD.t0 sg13_hv_pmos ad=1.32122p pd=3.73u as=1.345p ps=6.38u w=2.69u l=0.45u
X507 VSS.t143 a_10100_10155# sg13g2_hv_dfrbpq_1_1.CLK VSS.t149 sg13_hv_nmos ad=0.1406p pd=1.12u as=0.1406p ps=1.12u w=0.74u l=0.45u
X508 VSS.t270 a_17326_10242# sg13g2_hv_buf_16_0.A VSS.t371 sg13_hv_nmos ad=0.1406p pd=1.12u as=0.1406p ps=1.12u w=0.74u l=0.45u
X509 sg13g2_hv_o21ai_1_1.B1 a_30885_12068# VDD.t114 VDD.t3 sg13_hv_pmos ad=0.9146p pd=6.06u as=0.5111p ps=3.07u w=2.69u l=0.45u
X510 sg13g2_hv_nand2b_1_0.Y sg13g2_hv_nand2b_1_0.B VDD.t120 VDD.t0 sg13_hv_pmos ad=0.5111p pd=3.07u as=0.52782p ps=3.1u w=2.69u l=0.45u
X511 a_28453_12292# a_27824_12117# VDD.t33 VDD.t3 sg13_hv_pmos ad=0.1515p pd=1.31u as=0.77207p ps=2.7u w=1.01u l=0.45u
X512 sg13g2_hv_xnor2_1_1.A a_6021_12068# VSS.t59 VSS.t393 sg13_hv_nmos ad=0.2516p pd=2.16u as=0.1406p ps=1.12u w=0.74u l=0.45u
X513 VDD.t12 sg13g2_hv_a21oi_1_0.A2 a_22421_7386# VDD.t0 sg13_hv_pmos ad=0.5111p pd=3.07u as=0.9146p ps=6.06u w=2.69u l=0.45u
X514 VDD.t180 a_24334_10242# sg13g2_hv_dfrbpq_1_0.CLK VDD.t10 sg13_hv_pmos ad=0.5111p pd=3.07u as=0.5111p ps=3.07u w=2.69u l=0.45u
X515 VSS.t59 a_4811_11649# a_6021_12068# VSS.t246 sg13_hv_nmos ad=0.1406p pd=1.12u as=0.2516p ps=2.16u w=0.74u l=0.45u
X516 VSS.t19 sg13g2_hv_or3_1_1.C a_15195_11666# VSS.t18 sg13_hv_nmos ad=0.14505p pd=1.15u as=0.187p ps=1.78u w=0.55u l=0.45u
X517 sg13g2_hv_a21oi_1_0.Y sg13g2_hv_o21ai_1_0.Y a_22579_8194# VSS.t404 sg13_hv_nmos ad=0.1406p pd=1.12u as=0.1406p ps=1.12u w=0.74u l=0.45u
X518 a_27577_7966# sg13g2_hv_tiehi_0.L_HI VDD.t0 VDD.t0 sg13_hv_pmos ad=0.47975p pd=1.96u as=4.91987p ps=31.75u w=1.01u l=0.45u
X519 a_30553_8936# sg13g2_hv_dfrbpq_1_7.RESET_B VDD.t10 VDD.t10 sg13_hv_pmos ad=0.47975p pd=1.96u as=12.1183p ps=79.89u w=1.01u l=0.45u
X520 a_24334_10242# sg13g2_hv_buf_16_0.A VSS.t33 VSS.t350 sg13_hv_nmos ad=0.1406p pd=1.12u as=0.1406p ps=1.12u w=0.74u l=0.45u
X521 sg13g2_hv_dfrbpq_1_1.D sg13g2_hv_nand2b_1_0.Y a_5971_8194# VSS.t54 sg13_hv_nmos ad=0.1406p pd=1.12u as=0.1406p ps=1.12u w=0.74u l=0.45u
X522 VSS.t154 a_10100_10155# sg13g2_hv_dfrbpq_1_1.CLK VSS.t153 sg13_hv_nmos ad=0.1406p pd=1.12u as=0.1406p ps=1.12u w=0.74u l=0.45u
X523 sg13g2_hv_tiehi_3.L_HI VSS.t53 VDD.t25 VDD.t3 sg13_hv_pmos ad=0.9146p pd=6.06u as=0.9146p ps=6.06u w=2.69u l=0.45u
X524 sg13g2_hv_dfrbpq_1_1.CLK a_10100_10155# VSS.t143 VSS.t152 sg13_hv_nmos ad=0.1406p pd=1.12u as=0.1406p ps=1.12u w=0.74u l=0.45u
X525 VSS.t10 sg13g2_hv_o21ai_1_0.A2 a_21385_7443# VSS.t299 sg13_hv_nmos ad=0.1045p pd=0.93u as=0.187p ps=1.78u w=0.55u l=0.45u
X526 a_17580_13011# sg13g2_hv_nand3_1_1.A VSS.t187 VSS.t380 sg13_hv_nmos ad=0.187p pd=1.78u as=0.14875p ps=1.16u w=0.55u l=0.45u
X527 a_5305_11792# sg13g2_hv_tiehi_5.L_HI VDD.t3 VDD.t3 sg13_hv_pmos ad=0.47975p pd=1.96u as=4.05678p ps=25.945u w=1.01u l=0.45u
X528 sg13g2_hv_nand2b_1_1.Y sg13g2_hv_buf_1_0.X VDD.t119 VDD.t0 sg13_hv_pmos ad=0.5111p pd=3.07u as=0.52782p ps=3.1u w=2.69u l=0.45u
X529 a_17580_13011# sg13g2_hv_nand3_1_1.A VDD.t123 VDD.t3 sg13_hv_pmos ad=0.6851p pd=4.71u as=0.50752p ps=3.11u w=2.015u l=0.45u
X530 a_2621_11072# sg13g2_hv_xnor2_1_1.A VSS.t82 VSS.t306 sg13_hv_nmos ad=0.2516p pd=2.16u as=0.406p ps=1.875u w=0.74u l=0.45u
X531 VDD.t133 sg13g2_hv_dfrbpq_1_7.RESET_B a_27686_8716# VDD.t10 sg13_hv_pmos ad=1.2686p pd=5.2u as=0.303p ps=1.61u w=1.01u l=0.45u
X532 VDD.t120 sg13g2_hv_buf_1_0.X a_4443_7520# VDD.t0 sg13_hv_pmos ad=0.52782p pd=3.1u as=0.6851p ps=4.71u w=2.015u l=0.45u
X533 VDD.t208 sg13g2_hv_nand4_1_0.Y a_14233_11648# VDD.t3 sg13_hv_pmos ad=0.50095p pd=3.07u as=0.816p ps=5.48u w=2.4u l=0.45u
X534 VDD.t100 sg13g2_hv_tiehi_5.L_HI a_2438_11572# VDD.t3 sg13_hv_pmos ad=1.2686p pd=5.2u as=0.303p ps=1.61u w=1.01u l=0.45u
X535 a_2596_11572# sg13g2_hv_and2_1_1.X a_2438_11572# VSS.t3 sg13_hv_nmos ad=60.89999f pd=0.71u as=0.1428p ps=1.52u w=0.42u l=0.45u
X536 a_27734_11795# a_28513_11551# a_28453_12292# VDD.t3 sg13_hv_pmos ad=0.1919p pd=1.39u as=0.1515p ps=1.31u w=1.01u l=0.45u
X537 a_30169_11792# sg13g2_hv_dfrbpq_1_4.RESET_B VDD.t3 VDD.t3 sg13_hv_pmos ad=0.47975p pd=1.96u as=4.05678p ps=25.945u w=1.01u l=0.45u
X538 a_17133_8323# sg13g2_hv_tiehi_2.L_HI VSS.t92 VSS.t91 sg13_hv_nmos ad=52.5f pd=0.67u as=0.252p ps=2.04u w=0.42u l=0.45u
X539 a_7621_7498# a_6992_7395# VDD.t27 VDD.t0 sg13_hv_pmos ad=0.1515p pd=1.31u as=0.77207p ps=2.7u w=1.01u l=0.45u
X540 VDD.t3 a_3649_11551# a_3815_11694# VDD.t3 sg13_hv_pmos ad=4.05678p pd=25.945u as=0.92805p ps=6.07u w=2.69u l=0.45u
X541 VSS.t41 a_24334_10242# sg13g2_hv_dfrbpq_1_0.CLK VSS.t260 sg13_hv_nmos ad=0.1406p pd=1.12u as=0.1406p ps=1.12u w=0.74u l=0.45u
X542 VSS.t33 sg13g2_hv_buf_16_0.A a_24334_10242# VSS.t353 sg13_hv_nmos ad=0.1406p pd=1.12u as=0.1406p ps=1.12u w=0.74u l=0.45u
X543 a_23220_12116# sg13g2_hv_or3_1_1.C VDD.t15 VDD.t3 sg13_hv_pmos ad=0.5111p pd=3.07u as=0.9146p ps=6.06u w=2.69u l=0.45u
X544 VDD.t22 a_8327_12110# sg13g2_hv_and2_1_0.B VDD.t3 sg13_hv_pmos ad=2.43445p pd=7.19u as=1.27775p ps=3.64u w=2.69u l=0.45u
X545 VDD.t3 a_12985_11792# a_12930_12109# VDD.t3 sg13_hv_pmos ad=4.05678p pd=25.945u as=0.22472p ps=1.455u w=1.01u l=0.45u
X546 sg13g2_hv_o21ai_1_0.A2 sg13g2_hv_nand3_1_1.A VDD.t287 VDD.t10 sg13_hv_pmos ad=0.5111p pd=3.07u as=0.9146p ps=6.06u w=2.69u l=0.45u
X547 VSS.t33 sg13g2_hv_a21oi_1_1.B1.t3 sg13g2_hv_a21oi_1_4.Y VSS.t32 sg13_hv_nmos ad=0.2516p pd=2.16u as=0.1406p ps=1.12u w=0.74u l=0.45u
X548 sg13g2_hv_nand3_1_1.A a_20517_12068# VSS.t161 VSS.t362 sg13_hv_nmos ad=0.2516p pd=2.16u as=0.1406p ps=1.12u w=0.74u l=0.45u
X549 a_25232_7395# a_26087_7412# a_27083_8259# VSS.t304 sg13_hv_nmos ad=0.41132p pd=2.84u as=0.2971p ps=1.69u w=0.74u l=0.45u
X550 VDD.t20 sg13g2_hv_tiehi_0.L_HI a_25142_7309# VDD.t0 sg13_hv_pmos ad=0.77207p pd=2.7u as=0.3535p ps=2.72u w=1.01u l=0.45u
X551 VDD.t304 VSS.t79 VDD.t303 VDD.t10 sg13_hv_pmos ad=0.816p pd=5.48u as=0 ps=0 w=2.4u l=1u
X552 VSS.t33 sg13g2_hv_o21ai_1_1.B1 a_23785_11628# VSS.t244 sg13_hv_nmos ad=0.19315p pd=1.28u as=0.286p ps=1.59u w=0.55u l=0.45u
X553 VDD.t95 VSS.t111 VDD.t94 VDD.t3 sg13_hv_pmos ad=0.816p pd=5.48u as=0 ps=0 w=2.4u l=1u
X554 a_29675_11649# a_28513_11551# a_27824_12117# VDD.t3 sg13_hv_pmos ad=0.93082p pd=3.45u as=1.896p ps=6.38u w=2.4u l=0.45u
X555 sg13g2_hv_and2_1_1.X a_1773_11050# VSS.t115 VSS.t363 sg13_hv_nmos ad=0.2516p pd=2.16u as=0.1331p ps=1.12u w=0.74u l=0.45u
X556 VDD.t207 sg13g2_hv_or3_1_1.B sg13g2_hv_o21ai_1_0.A2 VDD.t10 sg13_hv_pmos ad=0.9146p pd=6.06u as=0.5111p ps=3.07u w=2.69u l=0.45u
X557 sg13g2_hv_nand4_1_0.Y sg13g2_hv_xnor2_1_1.A VDD.t130 VDD.t3 sg13_hv_pmos ad=0.5111p pd=3.07u as=0.5111p ps=3.07u w=2.69u l=0.45u
X558 a_9282_7681# a_7847_7412# a_8843_8259# VDD.t0 sg13_hv_pmos ad=0.22472p pd=1.455u as=0.93082p ps=3.45u w=1.01u l=0.45u
X559 a_6992_7395# a_6902_7309# VDD.t46 VDD.t0 sg13_hv_pmos ad=1.056p pd=5.68u as=1.2686p ps=5.2u w=2.4u l=0.45u
X560 VDD.t130 sg13g2_hv_nand4_1_0.C sg13g2_hv_nand4_1_0.Y VDD.t3 sg13_hv_pmos ad=0.5111p pd=3.07u as=0.5111p ps=3.07u w=2.69u l=0.45u
X561 VDD.t82 a_10100_10155# sg13g2_hv_dfrbpq_1_1.CLK VDD.t10 sg13_hv_pmos ad=0.5111p pd=3.07u as=0.5111p ps=3.07u w=2.69u l=0.45u
X562 a_20662_8224# sg13g2_hv_o21ai_1_0.A2 VSS.t10 VSS.t298 sg13_hv_nmos ad=0.1406p pd=1.12u as=0.1406p ps=1.12u w=0.74u l=0.45u
X563 VDD.t9 a_27083_8259# a_28293_7386# VDD.t0 sg13_hv_pmos ad=0.5111p pd=3.07u as=0.92805p ps=6.07u w=2.69u l=0.45u
X564 VDD.t277 a_17326_10242# sg13g2_hv_buf_16_0.A VDD.t10 sg13_hv_pmos ad=0.5111p pd=3.07u as=0.5111p ps=3.07u w=2.69u l=0.45u
X565 VDD.t242 clock_i a_17326_10242# VDD.t10 sg13_hv_pmos ad=0.5111p pd=3.07u as=0.5111p ps=3.07u w=2.69u l=0.45u
X566 a_8327_12110# sg13g2_hv_nand3_1_0.Y a_8187_11670# VSS.t271 sg13_hv_nmos ad=0.4608p pd=2.72u as=0.304p ps=1.59u w=0.64u l=0.45u
X567 a_11329_11551# sg13g2_hv_dfrbpq_1_1.CLK VDD.t3 VDD.t3 sg13_hv_pmos ad=0.98185p pd=6.11u as=3.84325p ps=24.58u w=2.69u l=0.45u
X568 a_23821_9213# sg13g2_hv_or3_1_1.C a_23655_9213# VDD.t10 sg13_hv_pmos ad=0.378p pd=2.715u as=0.456p ps=2.78u w=2.4u l=0.45u
X569 sg13g2_hv_dfrbpq_1_0.CLK a_24334_10242# VSS.t41 VSS.t257 sg13_hv_nmos ad=0.1406p pd=1.12u as=0.1406p ps=1.12u w=0.74u l=0.45u
X570 sg13g2_hv_dfrbpq_1_1.CLK a_10100_10155# VDD.t80 VDD.t10 sg13_hv_pmos ad=0.5111p pd=3.07u as=0.5111p ps=3.07u w=2.69u l=0.45u
X571 a_14427_7386# sg13g2_hv_a21oi_1_1.B1 sg13g2_hv_a21oi_1_2.Y VDD.t0 sg13_hv_pmos ad=0.5111p pd=3.07u as=0.9146p ps=6.06u w=2.69u l=0.45u
X572 VDD.t54 a_30059_8793# a_31269_9212# VDD.t10 sg13_hv_pmos ad=0.5111p pd=3.07u as=0.92805p ps=6.07u w=2.69u l=0.45u
X573 sg13g2_hv_buf_16_0.A a_17326_10242# VDD.t275 VDD.t10 sg13_hv_pmos ad=0.5111p pd=3.07u as=0.5111p ps=3.07u w=2.69u l=0.45u
X574 a_11269_12292# a_10640_12117# VDD.t196 VDD.t3 sg13_hv_pmos ad=0.1515p pd=1.31u as=0.77207p ps=2.7u w=1.01u l=0.45u
X575 a_27083_8259# a_25921_7412# a_25232_7395# VDD.t0 sg13_hv_pmos ad=0.93082p pd=3.45u as=1.896p ps=6.38u w=2.4u l=0.45u
X576 a_2438_11572# a_3815_11694# a_2870_11795# VDD.t3 sg13_hv_pmos ad=0.3434p pd=2.7u as=0.1919p ps=1.39u w=1.01u l=0.45u
X577 VDD.t136 sg13g2_hv_xnor2_1_1.Y a_1773_11050# VDD.t10 sg13_hv_pmos ad=0.46047p pd=3.07u as=0.38285p ps=2.395u w=2.015u l=0.45u
X578 a_14593_8194# sg13g2_hv_a21oi_1_2.A1 sg13g2_hv_a21oi_1_2.Y VSS.t178 sg13_hv_nmos ad=0.1406p pd=1.12u as=0.1406p ps=1.12u w=0.74u l=0.45u
X579 VSS.t16 sg13g2_hv_or3_1_1.C a_23446_11080# VSS.t24 sg13_hv_nmos ad=0.1406p pd=1.12u as=0.2516p ps=2.16u w=0.74u l=0.45u
X580 VSS.t53 sg13g2_hv_tiehi_3.L_HI a_10276_11572# VSS.t278 sg13_hv_nmos ad=0.2458p pd=1.735u as=60.89999f ps=0.71u w=0.42u l=0.45u
X581 a_27867_8336# sg13g2_hv_tiehi_0.L_HI VSS.t27 VSS.t31 sg13_hv_nmos ad=52.5f pd=0.67u as=79.8f ps=0.8u w=0.42u l=0.45u
X582 VSS.t21 VDD.t315 VSS.t21 VSS.t127 sg13_hv_nmos ad=0.1428p pd=1.52u as=0 ps=0 w=0.42u l=1u
X583 sg13g2_hv_o21ai_1_1.B1 a_30885_12068# VSS.t45 VSS.t319 sg13_hv_nmos ad=0.2516p pd=2.16u as=0.1406p ps=1.12u w=0.74u l=0.45u
X584 counter_value_o[6] a_32392_13098# VSS.t295 VSS.t294 sg13_hv_nmos ad=0.2886p pd=2.26u as=0.14875p ps=1.16u w=0.74u l=0.45u
X585 a_24334_10242# sg13g2_hv_buf_16_0.A VDD.t258 VDD.t10 sg13_hv_pmos ad=0.5111p pd=3.07u as=0.5111p ps=3.07u w=2.69u l=0.45u
X586 counter_value_o[6] a_32392_13098# VDD.t212 VDD.t3 sg13_hv_pmos ad=1.00875p pd=6.13u as=0.50752p ps=3.11u w=2.69u l=0.45u
X587 VSS.t50 a_18145_11551# a_18311_11694# VSS.t360 sg13_hv_nmos ad=28.89642p pd=80.17u as=0.2516p ps=2.16u w=0.74u l=0.45u
X588 VDD.t258 sg13g2_hv_buf_16_0.A a_24334_10242# VDD.t10 sg13_hv_pmos ad=0.5111p pd=3.07u as=0.5111p ps=3.07u w=2.69u l=0.45u
X589 a_17473_7412# sg13g2_hv_dfrbpq_1_1.CLK VDD.t0 VDD.t0 sg13_hv_pmos ad=0.98185p pd=6.11u as=4.5919p ps=29.635u w=2.69u l=0.45u
X590 a_24868_8336# sg13g2_hv_a21oi_1_0.Y a_24710_8336# VSS.t4 sg13_hv_nmos ad=60.89999f pd=0.71u as=0.1428p ps=1.52u w=0.42u l=0.45u
X591 sg13g2_hv_dfrbpq_1_1.CLK a_10100_10155# VDD.t84 VDD.t10 sg13_hv_pmos ad=0.5111p pd=3.07u as=0.5111p ps=3.07u w=2.69u l=0.45u
X592 sg13g2_hv_a21oi_1_3.Y sg13g2_hv_nand2_1_1.Y a_16051_11650# VSS.t320 sg13_hv_nmos ad=0.1406p pd=1.12u as=0.1406p ps=1.12u w=0.74u l=0.45u
X593 a_7698_11068# sg13g2_hv_buf_1_0.X VSS.t59 VSS.t173 sg13_hv_nmos ad=0.1406p pd=1.12u as=0.2886p ps=2.26u w=0.74u l=0.45u
X594 sg13g2_hv_dfrbpq_1_1.CLK a_10100_10155# VDD.t71 VDD.t10 sg13_hv_pmos ad=0.5111p pd=3.07u as=0.95495p ps=6.09u w=2.69u l=0.45u
X595 a_17273_8323# a_17639_7412# a_16694_7309# VSS.t95 sg13_hv_nmos ad=0.2373p pd=1.97u as=79.8f ps=0.8u w=0.42u l=0.45u
X596 VSS.t14 clock_i a_17326_10242# VSS.t337 sg13_hv_nmos ad=0.1406p pd=1.12u as=0.1406p ps=1.12u w=0.74u l=0.45u
X597 a_30059_8793# a_28897_8695# a_29901_8793# VSS.t283 sg13_hv_nmos ad=0.2971p pd=1.69u as=0.1428p ps=1.52u w=0.42u l=0.45u
X598 sg13g2_hv_buf_16_0.A a_17326_10242# VSS.t270 VSS.t374 sg13_hv_nmos ad=0.1406p pd=1.12u as=0.1406p ps=1.12u w=0.74u l=0.45u
X599 a_10550_11795# a_11329_11551# a_11269_12292# VDD.t3 sg13_hv_pmos ad=0.1919p pd=1.39u as=0.1515p ps=1.31u w=1.01u l=0.45u
X600 VSS.t191 VSS.t191 sg13g2_hv_tiehi_1.L_HI VSS.t192 sg13_hv_nmos ad=0.2516p pd=2.16u as=0.2516p ps=2.16u w=0.74u l=0.45u
X601 a_28557_8729# sg13g2_hv_dfrbpq_1_7.RESET_B VSS.t7 VSS.t212 sg13_hv_nmos ad=52.5f pd=0.67u as=0.252p ps=2.04u w=0.42u l=0.45u
X602 sg13g2_hv_nand3_1_1.Y sg13g2_hv_nand3_1_1.A VDD.t206 VDD.t10 sg13_hv_pmos ad=0.9146p pd=6.06u as=0.5111p ps=3.07u w=2.69u l=0.45u
X603 a_25921_7412# sg13g2_hv_dfrbpq_1_0.CLK VSS.t47 VSS.t46 sg13_hv_nmos ad=0.2516p pd=2.16u as=33.78962p ps=73.245u w=0.74u l=0.45u
X604 a_19801_11792# a_19307_11649# a_20091_11572# VSS.t159 sg13_hv_nmos ad=0.3528p pd=2.52u as=52.5f ps=0.67u w=0.42u l=0.45u
X605 VDD.t170 a_24334_10242# sg13g2_hv_dfrbpq_1_0.CLK VDD.t10 sg13_hv_pmos ad=0.5111p pd=3.07u as=0.5111p ps=3.07u w=2.69u l=0.45u
X606 a_4811_11649# a_3649_11551# a_2960_12117# VDD.t3 sg13_hv_pmos ad=0.93082p pd=3.45u as=1.896p ps=6.38u w=2.4u l=0.45u
X607 sg13g2_hv_nand2b_1_0.B a_10053_7386# VSS.t224 VSS.t223 sg13_hv_nmos ad=0.2516p pd=2.16u as=0.1406p ps=1.12u w=0.74u l=0.45u
X608 VSS.t270 a_19801_11792# a_19149_11649# VSS.t269 sg13_hv_nmos ad=79.8f pd=0.8u as=0.1428p ps=1.52u w=0.42u l=0.45u
X609 a_2810_8772# sg13g2_hv_buf_1_0.X VSS.t125 VSS.t177 sg13_hv_nmos ad=0.1406p pd=1.12u as=0.2516p ps=2.16u w=0.74u l=0.45u
X610 sg13g2_hv_dfrbpq_1_0.CLK a_24334_10242# VDD.t182 VDD.t10 sg13_hv_pmos ad=0.5111p pd=3.07u as=0.5111p ps=3.07u w=2.69u l=0.45u
X611 sg13g2_hv_dfrbpq_1_0.CLK a_24334_10242# VDD.t169 VDD.t10 sg13_hv_pmos ad=0.5111p pd=3.07u as=0.5111p ps=3.07u w=2.69u l=0.45u
X612 sg13g2_hv_dfrbpq_1_1.CLK a_10100_10155# VSS.t53 VSS.t141 sg13_hv_nmos ad=0.1406p pd=1.12u as=0.1406p ps=1.12u w=0.74u l=0.45u
X613 VSS.t21 sg13g2_hv_or3_1_1.C a_15514_8764# VSS.t20 sg13_hv_nmos ad=0.1406p pd=1.12u as=0.1406p ps=1.12u w=0.74u l=0.45u
X614 a_10100_10155# sg13g2_hv_buf_16_0.A VSS.t154 VSS.t342 sg13_hv_nmos ad=0.1406p pd=1.12u as=0.1406p ps=1.12u w=0.74u l=0.45u
X615 sg13g2_hv_buf_16_0.A a_17326_10242# VSS.t340 VSS.t364 sg13_hv_nmos ad=0.1406p pd=1.12u as=0.1406p ps=1.12u w=0.74u l=0.45u
X616 sg13g2_hv_nand2_1_1.Y sg13g2_hv_nand3_1_1.A a_16250_11072# VSS.t383 sg13_hv_nmos ad=0.2516p pd=2.16u as=0.1406p ps=1.12u w=0.74u l=0.45u
X617 sg13g2_hv_tiehi_0.L_HI VSS.t12 VDD.t160 VDD.t0 sg13_hv_pmos ad=0.9146p pd=6.06u as=0.9146p ps=6.06u w=2.69u l=0.45u
X618 VSS.t154 a_10100_10155# sg13g2_hv_dfrbpq_1_1.CLK VSS.t156 sg13_hv_nmos ad=0.1406p pd=1.12u as=0.1406p ps=1.12u w=0.74u l=0.45u
X619 VSS.t68 a_27564_13011# counter_value_o[5] VSS.t168 sg13_hv_nmos ad=0.14875p pd=1.16u as=0.2886p ps=2.26u w=0.74u l=0.45u
X620 VSS.t130 VDD.t313 VSS.t130 VSS.t129 sg13_hv_nmos ad=0.1428p pd=1.52u as=0 ps=0 w=0.42u l=1u
X621 a_16250_11072# sg13g2_hv_or3_1_1.C VSS.t14 VSS.t13 sg13_hv_nmos ad=0.1406p pd=1.12u as=0.2516p ps=2.16u w=0.74u l=0.45u
X622 VDD.t49 a_27564_13011# counter_value_o[5] VDD.t3 sg13_hv_pmos ad=0.50752p pd=3.11u as=1.00875p ps=6.13u w=2.69u l=0.45u
X623 a_11129_11585# a_11495_11694# a_10550_11795# VSS.t165 sg13_hv_nmos ad=0.2373p pd=1.97u as=79.8f ps=0.8u w=0.42u l=0.45u
X624 VSS.t16 sg13g2_hv_or3_1_1.C a_23062_11620# VSS.t23 sg13_hv_nmos ad=0.1406p pd=1.12u as=0.2516p ps=2.16u w=0.74u l=0.45u
X625 VSS.t14 sg13g2_hv_nand3_1_1.A sg13g2_hv_or3_1_1.A VSS.t382 sg13_hv_nmos ad=0.2516p pd=2.16u as=0.2516p ps=2.16u w=0.74u l=0.45u
X626 a_17456_12117# a_18311_11694# a_19307_11649# VSS.t77 sg13_hv_nmos ad=0.41132p pd=2.84u as=0.2971p ps=1.69u w=0.74u l=0.45u
X627 VDD.t235 sg13g2_hv_or3_1_3.A sg13g2_hv_nand4_1_1.Y VDD.t3 sg13_hv_pmos ad=0.9146p pd=6.06u as=0.5111p ps=3.07u w=2.69u l=0.45u
X628 VDD.t215 a_4443_7520# sg13g2_hv_nand2b_1_0.Y VDD.t0 sg13_hv_pmos ad=0.9146p pd=6.06u as=0.5111p ps=3.07u w=2.69u l=0.45u
X629 sg13g2_hv_nand4_1_1.Y sg13g2_hv_o21ai_1_0.B1 VDD.t48 VDD.t3 sg13_hv_pmos ad=0.5111p pd=3.07u as=0.5111p ps=3.07u w=2.69u l=0.45u
X630 sg13g2_hv_and2_1_0.X a_8589_11050# VSS.t79 VSS.t78 sg13_hv_nmos ad=0.2516p pd=2.16u as=0.1331p ps=1.12u w=0.74u l=0.45u
X631 sg13g2_hv_or3_1_1.C a_14233_11648# VDD.t208 VDD.t3 sg13_hv_pmos ad=0.5111p pd=3.07u as=0.50095p ps=3.07u w=2.69u l=0.45u
X632 a_16420_8336# sg13g2_hv_a21oi_1_2.Y a_16262_8336# VSS.t233 sg13_hv_nmos ad=60.89999f pd=0.71u as=0.1428p ps=1.52u w=0.42u l=0.45u
X633 VSS.t33 a_24334_10242# sg13g2_hv_dfrbpq_1_0.CLK VSS.t250 sg13_hv_nmos ad=0.1406p pd=1.12u as=0.1406p ps=1.12u w=0.74u l=0.45u
X634 VDD.t74 a_10100_10155# sg13g2_hv_dfrbpq_1_1.CLK VDD.t10 sg13_hv_pmos ad=0.5111p pd=3.07u as=0.5111p ps=3.07u w=2.69u l=0.45u
X635 VDD.t269 a_17326_10242# sg13g2_hv_buf_16_0.A VDD.t10 sg13_hv_pmos ad=0.5111p pd=3.07u as=0.5111p ps=3.07u w=2.69u l=0.45u
X636 a_10640_12117# a_11495_11694# a_12491_11649# VSS.t166 sg13_hv_nmos ad=0.41132p pd=2.84u as=0.2971p ps=1.69u w=0.74u l=0.45u
X637 sg13g2_hv_dfrbpq_1_0.CLK a_24334_10242# VSS.t33 VSS.t249 sg13_hv_nmos ad=0.1406p pd=1.12u as=0.1406p ps=1.12u w=0.74u l=0.45u
X638 sg13g2_hv_buf_16_0.A a_17326_10242# VSS.t270 VSS.t376 sg13_hv_nmos ad=0.1406p pd=1.12u as=0.1406p ps=1.12u w=0.74u l=0.45u
X639 VSS.t265 sg13g2_hv_buf_16_0.A a_10100_10155# VSS.t345 sg13_hv_nmos ad=0.1406p pd=1.12u as=0.1406p ps=1.12u w=0.74u l=0.45u
X640 a_24710_8336# a_26087_7412# a_25142_7309# VDD.t0 sg13_hv_pmos ad=0.3434p pd=2.7u as=0.1919p ps=1.39u w=1.01u l=0.45u
X641 VDD.t46 sg13g2_hv_tiehi_1.L_HI a_6470_8336# VDD.t0 sg13_hv_pmos ad=1.2686p pd=5.2u as=0.303p ps=1.61u w=1.01u l=0.45u
X642 VDD.t90 a_19307_11649# a_20517_12068# VDD.t3 sg13_hv_pmos ad=0.5111p pd=3.07u as=0.92805p ps=6.07u w=2.69u l=0.45u
X643 a_21385_7443# sg13g2_hv_or3_1_1.C VSS.t10 VSS.t25 sg13_hv_nmos ad=0.286p pd=1.59u as=0.1045p ps=0.93u w=0.55u l=0.45u
X644 VSS.t111 VDD.t325 VSS.t111 VSS.t110 sg13_hv_nmos ad=0.1428p pd=1.52u as=0 ps=0 w=0.42u l=1u
X645 a_28173_11585# sg13g2_hv_dfrbpq_1_4.RESET_B VSS.t43 VSS.t42 sg13_hv_nmos ad=52.5f pd=0.67u as=0.252p ps=2.04u w=0.42u l=0.45u
X646 VSS.t103 VDD.t328 VSS.t105 VSS.t104 sg13_hv_nmos ad=79.8f pd=0.8u as=0 ps=0 w=0.42u l=1u
X647 VDD.t138 VSS.t187 sg13g2_hv_tiehi_4.L_HI VDD.t3 sg13_hv_pmos ad=0.9146p pd=6.06u as=0.9146p ps=6.06u w=2.69u l=0.45u
X648 a_5305_11792# a_4811_11649# a_5595_11572# VSS.t245 sg13_hv_nmos ad=0.3528p pd=2.52u as=52.5f ps=0.67u w=0.42u l=0.45u
X649 a_20091_11572# sg13g2_hv_tiehi_4.L_HI VSS.t270 VSS.t328 sg13_hv_nmos ad=52.5f pd=0.67u as=79.8f ps=0.8u w=0.42u l=0.45u
X650 a_8589_11050# sg13g2_hv_buf_1_9.X VDD.t42 VDD.t10 sg13_hv_pmos ad=0.38285p pd=2.395u as=0.6851p ps=4.71u w=2.015u l=0.45u
X651 a_2960_12117# a_2870_11795# VSS.t82 VSS.t162 sg13_hv_nmos ad=0.2516p pd=2.16u as=0.2458p ps=1.735u w=0.74u l=0.45u
X652 sg13g2_hv_dfrbpq_1_0.CLK a_24334_10242# VSS.t41 VSS.t253 sg13_hv_nmos ad=0.1406p pd=1.12u as=0.1406p ps=1.12u w=0.74u l=0.45u
X653 sg13g2_hv_dfrbpq_1_1.CLK a_10100_10155# VDD.t76 VDD.t10 sg13_hv_pmos ad=0.5111p pd=3.07u as=0.5111p ps=3.07u w=2.69u l=0.45u
X654 a_17413_7498# a_16784_7395# VDD.t26 VDD.t0 sg13_hv_pmos ad=0.1515p pd=1.31u as=0.77207p ps=2.7u w=1.01u l=0.45u
X655 a_27522_7681# a_26087_7412# a_27083_8259# VDD.t0 sg13_hv_pmos ad=0.22472p pd=1.455u as=0.93082p ps=3.45u w=1.01u l=0.45u
X656 VSS.t41 a_24334_10242# sg13g2_hv_dfrbpq_1_0.CLK VSS.t252 sg13_hv_nmos ad=0.1406p pd=1.12u as=0.1406p ps=1.12u w=0.74u l=0.45u
X657 VDD.t10 a_30059_8793# a_30553_8936# VDD.t10 sg13_hv_pmos ad=12.1183p pd=79.89u as=0.47975p ps=1.96u w=1.01u l=0.45u
X658 VSS.t125 VDD.t316 VSS.t125 VSS.t124 sg13_hv_nmos ad=0.1428p pd=1.52u as=0 ps=0 w=0.42u l=1u
X659 VDD.t0 a_27083_8259# a_27577_7966# VDD.t0 sg13_hv_pmos ad=4.91987p pd=31.75u as=0.47975p ps=1.96u w=1.01u l=0.45u
X660 a_1773_11050# sg13g2_hv_buf_1_9.X VDD.t44 VDD.t10 sg13_hv_pmos ad=0.38285p pd=2.395u as=0.6851p ps=4.71u w=2.015u l=0.45u
X661 VDD.t70 a_15195_11666# sg13g2_hv_nand2b_1_2.Y VDD.t3 sg13_hv_pmos ad=0.9146p pd=6.06u as=0.5111p ps=3.07u w=2.69u l=0.45u
X662 VDD.t301 VSS.t189 sg13g2_hv_tiehi_5.L_HI VDD.t3 sg13_hv_pmos ad=0.9146p pd=6.06u as=0.9146p ps=6.06u w=2.69u l=0.45u
X663 a_7314_11632# sg13g2_hv_buf_1_0.X VSS.t59 VSS.t174 sg13_hv_nmos ad=0.1406p pd=1.12u as=0.2516p ps=2.16u w=0.74u l=0.45u
X664 sg13g2_hv_a21oi_1_4.A2 a_23785_11628# VDD.t56 VDD.t3 sg13_hv_pmos ad=1.345p pd=6.38u as=1.32122p ps=3.73u w=2.69u l=0.45u
X665 a_24533_9212# sg13g2_hv_a21oi_1_5.A1 VDD.t62 VDD.t10 sg13_hv_pmos ad=0.5111p pd=3.07u as=0.5111p ps=3.07u w=2.69u l=0.45u
X666 VSS.t43 VDD.t317 VSS.t43 VSS.t42 sg13_hv_nmos ad=0.1428p pd=1.52u as=0 ps=0 w=0.42u l=1u
X667 VSS.t176 sg13g2_hv_buf_1_0.X a_4443_7520# VSS.t175 sg13_hv_nmos ad=0.14505p pd=1.15u as=0.187p ps=1.78u w=0.55u l=0.45u
X668 a_17326_10242# clock_i VDD.t244 VDD.t10 sg13_hv_pmos ad=0.5111p pd=3.07u as=0.5111p ps=3.07u w=2.69u l=0.45u
X669 a_17945_11585# a_18311_11694# a_17366_11795# VSS.t76 sg13_hv_nmos ad=0.2373p pd=1.97u as=79.8f ps=0.8u w=0.42u l=0.45u
X670 a_25581_8323# sg13g2_hv_tiehi_0.L_HI VSS.t29 VSS.t30 sg13_hv_nmos ad=52.5f pd=0.67u as=0.252p ps=2.04u w=0.42u l=0.45u
X671 VSS.t103 VDD.t328 VSS.t103 VSS.t102 sg13_hv_nmos ad=0.1428p pd=1.52u as=0 ps=0 w=0.42u l=1u
X672 a_16051_11650# sg13g2_hv_nand2b_1_2.Y VSS.t14 VSS.t267 sg13_hv_nmos ad=0.1406p pd=1.12u as=0.2516p ps=2.16u w=0.74u l=0.45u
X673 VSS.t12 sg13g2_hv_or3_1_3.A a_23497_8772# VSS.t333 sg13_hv_nmos ad=0.19315p pd=1.28u as=0.286p ps=1.59u w=0.55u l=0.45u
X674 VSS.t50 a_3649_11551# a_3815_11694# VSS.t406 sg13_hv_nmos ad=28.89642p pd=80.17u as=0.2516p ps=2.16u w=0.74u l=0.45u
X675 VDD.t56 sg13g2_hv_o21ai_1_1.B1 a_24109_12069# VDD.t3 sg13_hv_pmos ad=1.32122p pd=3.73u as=0.378p ps=2.715u w=2.4u l=0.45u
X676 sg13g2_hv_a21oi_1_0.A2 a_21385_7443# VSS.t10 VSS.t231 sg13_hv_nmos ad=0.2516p pd=2.16u as=0.19315p ps=1.28u w=0.74u l=0.45u
X677 a_28513_11551# sg13g2_hv_dfrbpq_1_0.CLK VDD.t3 VDD.t3 sg13_hv_pmos ad=0.98185p pd=6.11u as=3.84325p ps=24.58u w=2.69u l=0.45u
X678 VDD.t3 a_29675_11649# a_30169_11792# VDD.t3 sg13_hv_pmos ad=4.05678p pd=25.945u as=0.47975p ps=1.96u w=1.01u l=0.45u
X679 VSS.t41 sg13g2_hv_dfrbpq_1_4.RESET_B a_27460_11572# VSS.t40 sg13_hv_nmos ad=0.2458p pd=1.735u as=60.89999f ps=0.71u w=0.42u l=0.45u
R0 VDD.n12 VDD.t218 17.8424
R1 VDD.n70 VDD.t154 17.8424
R2 VDD.n215 VDD.t7 17.8424
R3 VDD.n224 VDD.t216 17.8424
R4 VDD.n98 VDD.t189 17.8424
R5 VDD.n27 VDD.t211 17.8424
R6 VDD.n109 VDD.t5 17.8424
R7 VDD.n4 VDD.t6 17.8424
R8 VDD.n19 VDD.t261 17.6582
R9 VDD.n179 VDD.t208 17.5843
R10 VDD.n51 VDD.t67 18.111
R11 VDD.n263 VDD.t215 17.5399
R12 VDD.n31 VDD.t41 17.5399
R13 VDD.n31 VDD.t39 17.5399
R14 VDD.n71 VDD.t12 17.5399
R15 VDD.n227 VDD.t62 17.5399
R16 VDD.n210 VDD.t49 17.5399
R17 VDD.n214 VDD.t212 17.5399
R18 VDD.n202 VDD.t128 17.5399
R19 VDD.n100 VDD.t185 17.5399
R20 VDD.n187 VDD.t188 17.5399
R21 VDD.n185 VDD.t70 17.5399
R22 VDD.n125 VDD.t131 17.5399
R23 VDD.n11 VDD.t222 17.5399
R24 VDD.n7 VDD.t231 17.5399
R25 VDD.n25 VDD.t123 17.5399
R26 VDD.n192 VDD.t105 17.5399
R27 VDD.n22 VDD.t122 17.5399
R28 VDD.n13 VDD.t27 17.3281
R29 VDD.n258 VDD.t26 17.3281
R30 VDD.n23 VDD.t20 17.462
R31 VDD.n212 VDD.t33 17.3281
R32 VDD.n119 VDD.t196 17.3281
R33 VDD.n7 VDD.t28 17.3281
R34 VDD.n188 VDD.t87 17.3281
R35 VDD.n222 VDD.t11 17.3281
R36 VDD.t0 VDD.n48 2.79308
R37 VDD.n31 VDD.n32 0.165262
R38 VDD.n45 VDD.t0 5.63073
R39 VDD.n53 VDD.t0 4.19923
R40 VDD.n12 VDD.t46 17.0005
R41 VDD.n40 VDD.n39 0.103969
R42 VDD.n70 VDD.t63 17.0005
R43 VDD.n48 VDD.n47 0.0730448
R44 VDD.n215 VDD.t21 17.0005
R45 VDD.n252 VDD.t10 17.0005
R46 VDD.n248 VDD.t10 17.0005
R47 VDD.n228 VDD.t10 17.0005
R48 VDD.n2 VDD.t10 0.82708
R49 VDD.n35 VDD.n34 0.123918
R50 VDD.n129 VDD.t10 17.0005
R51 VDD.n135 VDD.t10 17.0005
R52 VDD.n173 VDD.t10 17.0005
R53 VDD.n148 VDD.t10 17.0005
R54 VDD.n224 VDD.t133 17.0005
R55 VDD.t3 VDD.n193 17.0005
R56 VDD.n98 VDD.t31 17.0005
R57 VDD.n29 VDD.n30 0.180735
R58 VDD.n65 VDD.t3 5.65453
R59 VDD.n27 VDD.t111 17.0005
R60 VDD.n109 VDD.t38 17.0005
R61 VDD.n4 VDD.t100 17.0005
R62 VDD.n133 VDD.t315 15.5856
R63 VDD.n0 VDD.t314 15.5856
R64 VDD.n205 VDD.t320 15.5856
R65 VDD.n6 VDD.t323 15.5856
R66 VDD.n28 VDD.t321 15.5856
R67 VDD.n10 VDD.t322 15.5856
R68 VDD.n218 VDD.t312 15.5852
R69 VDD.n142 VDD.t319 15.5852
R70 VDD.n127 VDD.t318 15.5852
R71 VDD.n223 VDD.t317 15.5852
R72 VDD.n200 VDD.t324 15.5852
R73 VDD.n99 VDD.t325 15.5852
R74 VDD.n5 VDD.t329 15.5852
R75 VDD.n26 VDD.t326 15.5852
R76 VDD.n122 VDD.t327 15.5852
R77 VDD.n69 VDD.t313 15.5852
R78 VDD.n175 VDD.n68 14.7571
R79 VDD.n255 VDD.n254 14.7571
R80 VDD.n254 VDD.n72 14.7571
R81 VDD.n176 VDD.n175 14.7571
R82 VDD.n7 VDD.n20 14.7571
R83 VDD.n19 VDD.n20 13.5005
R84 VDD.n266 VDD.n265 13.5005
R85 VDD.n175 VDD.n174 13.5005
R86 VDD.n254 VDD.n3 13.5005
R87 VDD.n11 VDD.t129 9.32299
R88 VDD.t10 VDD.t219 9.85496
R89 VDD.n264 VDD.t120 9.12992
R90 VDD.n67 VDD.t119 9.12992
R91 VDD.n183 VDD.t14 9.12992
R92 VDD.n181 VDD.t209 9.12626
R93 VDD.n19 VDD.t44 9.12526
R94 VDD.n19 VDD.t136 9.12526
R95 VDD.n19 VDD.t57 9.12526
R96 VDD.n150 VDD.t42 9.12526
R97 VDD.n152 VDD.t55 9.12526
R98 VDD.n156 VDD.t72 9.12526
R99 VDD.n160 VDD.t76 9.12526
R100 VDD.n162 VDD.t78 9.12526
R101 VDD.n164 VDD.t80 9.12526
R102 VDD.n166 VDD.t82 9.12526
R103 VDD.n168 VDD.t84 9.12526
R104 VDD.n170 VDD.t86 9.12526
R105 VDD.n172 VDD.t250 9.12526
R106 VDD.n140 VDD.t252 9.12526
R107 VDD.n84 VDD.t242 9.12526
R108 VDD.n81 VDD.t244 9.12526
R109 VDD.n86 VDD.t246 9.12526
R110 VDD.n87 VDD.t269 9.12526
R111 VDD.n78 VDD.t271 9.12526
R112 VDD.n89 VDD.t273 9.12526
R113 VDD.n91 VDD.t275 9.12526
R114 VDD.n92 VDD.t277 9.12526
R115 VDD.n94 VDD.t281 9.12526
R116 VDD.n225 VDD.t256 9.12526
R117 VDD.n229 VDD.t258 9.12526
R118 VDD.n231 VDD.t169 9.12526
R119 VDD.n233 VDD.t170 9.12526
R120 VDD.n235 VDD.t172 9.12526
R121 VDD.n237 VDD.t174 9.12526
R122 VDD.n239 VDD.t176 9.12526
R123 VDD.n241 VDD.t178 9.12526
R124 VDD.n245 VDD.t182 9.12526
R125 VDD.n111 VDD.t132 9.12526
R126 VDD.n1 VDD.t206 9.05434
R127 VDD.n104 VDD.t48 9.05434
R128 VDD.n106 VDD.t284 9.05434
R129 VDD.n11 VDD.t294 9.05434
R130 VDD.n11 VDD.t130 9.05434
R131 VDD.n145 VDD.t223 9.05334
R132 VDD.n132 VDD.t205 9.02472
R133 VDD.n197 VDD.t165 9.02472
R134 VDD.n14 VDD.t52 9.02372
R135 VDD.n3 VDD.t237 9.02372
R136 VDD.n113 VDD.t22 8.86674
R137 VDD.n19 VDD.t53 8.86574
R138 VDD.t0 VDD.n51 0.586373
R139 VDD.n40 VDD.t0 1.41291
R140 VDD.n256 VDD.n54 0.200016
R141 VDD.n62 VDD.n253 0.127063
R142 VDD.n128 VDD.n61 0.0541834
R143 VDD.n134 VDD.n60 0.0897963
R144 VDD.n59 VDD.t10 5.65357
R145 VDD.n57 VDD.t3 5.65453
R146 VDD.n63 VDD.t3 2.03249
R147 VDD.n201 VDD.n64 0.164964
R148 VDD.n123 VDD.n65 0.0210328
R149 VDD.n261 VDD.t0 8.48597
R150 VDD.n52 VDD.t0 2.75427
R151 VDD.n16 VDD.t0 0.324186
R152 VDD.t0 VDD.n32 1.1463
R153 VDD.n264 VDD.n49 0.615108
R154 VDD.n265 VDD.n51 0.733677
R155 VDD.n50 VDD.t0 1.56975
R156 VDD.n259 VDD.n21 0.592564
R157 VDD.t0 VDD.n58 4.19911
R158 VDD.t0 VDD.n220 8.4801
R159 VDD.t0 VDD.n55 3.335
R160 VDD.t0 VDD.n54 2.03229
R161 VDD.n256 VDD.n14 0.466435
R162 VDD.n14 VDD.n15 0.304443
R163 VDD.n250 VDD.t10 8.4801
R164 VDD.n246 VDD.t10 8.4801
R165 VDD.n226 VDD.t10 8.4801
R166 VDD.t10 VDD.n61 4.21946
R167 VDD.n37 VDD.t10 1.40942
R168 VDD.n141 VDD.t10 8.4801
R169 VDD.t3 VDD.n103 8.4801
R170 VDD.n207 VDD.t3 8.4801
R171 VDD.n8 VDD.t3 0.333331
R172 VDD.n46 VDD.t311 7.78563
R173 VDD.n19 VDD.t316 7.78563
R174 VDD.n9 VDD.t328 7.7853
R175 VDD.n11 VDD.t248 6.43726
R176 VDD.t10 VDD.t54 6.78203
R177 VDD.n191 VDD.t90 6.43544
R178 VDD.n33 VDD.t114 6.65971
R179 VDD.n8 VDD.t168 6.55373
R180 VDD.n177 VDD.t4 6.43544
R181 VDD.n15 VDD.t126 6.76503
R182 VDD.t0 VDD.t9 6.88157
R183 VDD.n16 VDD.t149 6.73843
R184 VDD.n19 VDD.t292 6.43346
R185 VDD.n19 VDD.t116 6.43346
R186 VDD.n95 VDD.t207 6.43346
R187 VDD.n34 VDD.t287 6.43346
R188 VDD.n38 VDD.t16 6.43303
R189 VDD.n36 VDD.t288 6.43303
R190 VDD.n138 VDD.t254 6.39604
R191 VDD.n83 VDD.t241 6.39604
R192 VDD.n3 VDD.t255 6.39604
R193 VDD.n154 VDD.t71 6.39559
R194 VDD.n158 VDD.t74 6.39559
R195 VDD.n75 VDD.t279 6.39559
R196 VDD.n34 VDD.t283 6.39559
R197 VDD.n243 VDD.t180 6.39559
R198 VDD.n249 VDD.t184 6.39559
R199 VDD.n42 VDD.t93 6.3899
R200 VDD.n48 VDD.t2 6.52581
R201 VDD.n19 VDD.t96 6.3899
R202 VDD.n19 VDD.t99 6.3899
R203 VDD.n11 VDD.t302 6.38947
R204 VDD.n13 VDD.t146 6.38001
R205 VDD.n257 VDD.t121 6.38001
R206 VDD.n115 VDD.t25 6.38001
R207 VDD.n217 VDD.t160 6.37958
R208 VDD.n41 VDD.t43 6.42677
R209 VDD.n38 VDD.t289 6.37958
R210 VDD.n213 VDD.t143 6.37958
R211 VDD.n7 VDD.t301 6.45142
R212 VDD.n190 VDD.t138 6.37958
R213 VDD.n221 VDD.t110 6.37958
R214 VDD.n136 VDD.t239 6.36921
R215 VDD.n3 VDD.t213 6.36921
R216 VDD.n203 VDD.t108 6.36921
R217 VDD.n7 VDD.t29 6.36921
R218 VDD.n11 VDD.t23 6.36921
R219 VDD.n29 VDD.t101 6.36921
R220 VDD.n39 VDD.t158 6.36878
R221 VDD.n147 VDD.t303 6.36878
R222 VDD.n130 VDD.t103 6.36878
R223 VDD.n251 VDD.t140 6.36878
R224 VDD.n43 VDD.t144 6.37374
R225 VDD.n101 VDD.t95 6.36878
R226 VDD.n7 VDD.t106 6.36878
R227 VDD.n29 VDD.t91 6.36878
R228 VDD.n121 VDD.t202 6.36878
R229 VDD.n262 VDD.t148 6.36878
R230 VDD.n96 VDD.t50 6.3241
R231 VDD.n194 VDD.t235 6.3241
R232 VDD.n11 VDD.t118 6.3241
R233 VDD.n143 VDD.t117 6.32367
R234 VDD.n38 VDD.t307 6.29448
R235 VDD.n195 VDD.t15 6.29448
R236 VDD.n14 VDD.t17 6.29406
R237 VDD.n3 VDD.t13 6.29406
R238 VDD.t3 VDD.n56 4.2441
R239 VDD.n262 VDD.n52 0.213283
R240 VDD.n263 VDD.n53 0.155617
R241 VDD.t0 VDD.n49 0.948771
R242 VDD.n21 VDD.t0 0.53496
R243 VDD.n23 VDD.t0 0.563437
R244 VDD.n242 VDD.t10 5.63073
R245 VDD.n238 VDD.t10 5.63073
R246 VDD.n234 VDD.t10 5.63073
R247 VDD.n232 VDD.t10 5.63073
R248 VDD.t10 VDD.n97 5.63073
R249 VDD.n34 VDD.n95 0.17181
R250 VDD.t10 VDD.n35 2.33625
R251 VDD.t10 VDD.n76 5.63073
R252 VDD.t10 VDD.n90 5.63073
R253 VDD.t10 VDD.n79 5.63073
R254 VDD.t10 VDD.n88 5.63073
R255 VDD.t10 VDD.n82 5.63073
R256 VDD.n131 VDD.t10 5.63073
R257 VDD.n38 VDD.n37 0.340621
R258 VDD.n60 VDD.t10 3.35255
R259 VDD.n169 VDD.t10 5.63073
R260 VDD.n167 VDD.t10 5.63073
R261 VDD.n163 VDD.t10 5.63073
R262 VDD.n159 VDD.t10 5.63073
R263 VDD.n155 VDD.t10 5.63073
R264 VDD.n151 VDD.t10 5.63073
R265 VDD.n144 VDD.t10 5.63073
R266 VDD.t3 VDD.n108 5.63073
R267 VDD.t3 VDD.n189 5.63073
R268 VDD.n209 VDD.t3 5.63073
R269 VDD.n66 VDD.t3 1.50423
R270 VDD.n46 VDD.t1 5.62529
R271 VDD.n19 VDD.t97 5.62529
R272 VDD.n9 VDD.t247 5.62529
R273 VDD.n218 VDD.t159 5.61325
R274 VDD.n142 VDD.t304 5.61325
R275 VDD.n133 VDD.t240 5.61325
R276 VDD.n127 VDD.t104 5.61325
R277 VDD.n0 VDD.t214 5.61325
R278 VDD.n223 VDD.t141 5.61325
R279 VDD.n200 VDD.t145 5.61325
R280 VDD.n205 VDD.t109 5.61325
R281 VDD.n99 VDD.t94 5.61325
R282 VDD.n5 VDD.t107 5.61325
R283 VDD.n6 VDD.t30 5.61325
R284 VDD.n28 VDD.t102 5.61325
R285 VDD.n26 VDD.t92 5.61325
R286 VDD.n122 VDD.t201 5.61325
R287 VDD.n10 VDD.t24 5.61325
R288 VDD.n69 VDD.t147 5.61325
R289 VDD.n198 VDD.t56 4.49972
R290 VDD.n256 VDD.t51 4.49891
R291 VDD.n22 VDD.t127 4.49891
R292 VDD.n3 VDD.t40 4.46206
R293 VDD.t10 VDD.n62 2.76986
R294 VDD.n244 VDD.t10 4.1993
R295 VDD.n240 VDD.t10 4.1993
R296 VDD.n236 VDD.t10 4.1993
R297 VDD.n230 VDD.t10 4.1993
R298 VDD.n3 VDD.n2 0.154933
R299 VDD.t10 VDD.n74 4.1993
R300 VDD.t10 VDD.n93 4.1993
R301 VDD.t10 VDD.n77 4.1993
R302 VDD.t10 VDD.n80 4.1993
R303 VDD.t10 VDD.n85 4.1993
R304 VDD.n139 VDD.t10 4.1993
R305 VDD.n171 VDD.t10 4.1993
R306 VDD.n165 VDD.t10 4.1993
R307 VDD.n161 VDD.t10 4.1993
R308 VDD.n157 VDD.t10 4.1993
R309 VDD.n146 VDD.t10 4.1993
R310 VDD.t3 VDD.n196 4.1993
R311 VDD.t3 VDD.n105 4.1993
R312 VDD.n186 VDD.t3 4.1993
R313 VDD.n184 VDD.t3 4.1993
R314 VDD.n180 VDD.t3 4.1993
R315 VDD.n116 VDD.t3 4.1993
R316 VDD.n114 VDD.t3 4.1993
R317 VDD.t10 VDD.n73 3.33518
R318 VDD.n41 VDD.t10 0.729965
R319 VDD.t3 VDD.n102 3.33518
R320 VDD.t3 VDD.n64 2.3499
R321 VDD.n30 VDD.t3 0.897961
R322 VDD.n178 VDD.t3 3.33518
R323 VDD.n126 VDD.t3 3.33518
R324 VDD.n124 VDD.t3 3.33518
R325 VDD.n214 VDD.n44 0.42066
R326 VDD.n63 VDD.n100 0.281061
R327 VDD.n182 VDD.t3 2.75487
R328 VDD.n110 VDD.t3 2.75487
R329 VDD.n19 VDD.t10 0.832033
R330 VDD.t3 VDD.n199 2.33687
R331 VDD.n211 VDD.t3 2.33687
R332 VDD.t3 VDD.n204 2.02046
R333 VDD.n120 VDD.t3 2.02046
R334 VDD.n112 VDD.t3 2.02046
R335 VDD.n118 VDD.t3 1.57101
R336 VDD.n137 VDD.t10 1.40489
R337 VDD.n153 VDD.t10 1.26498
R338 VDD.n266 VDD.n20 1.25714
R339 VDD.t3 VDD.n107 1.0418
R340 VDD.n44 VDD.t3 0.752266
R341 VDD.n43 VDD.t3 0.95663
R342 VDD.n221 VDD.t10 0.963716
R343 VDD.n18 VDD.n190 0.909738
R344 VDD.n18 VDD.n191 0.766354
R345 VDD.n17 VDD.n100 0.743425
R346 VDD.t3 VDD.n17 0.679106
R347 VDD.n17 VDD.n101 0.662566
R348 VDD VDD.n266 0.64818
R349 VDD.n214 VDD.n33 0.813465
R350 VDD.n191 VDD.n107 0.572628
R351 VDD.n107 VDD.n106 0.566528
R352 VDD.n153 VDD.n152 0.463373
R353 VDD.n154 VDD.n153 0.462812
R354 VDD.n138 VDD.n137 0.459187
R355 VDD.n2 VDD.n1 0.679292
R356 VDD.n118 VDD.n117 0.433111
R357 VDD.n137 VDD.n136 0.405067
R358 VDD.n213 VDD.t3 0.956087
R359 VDD.n119 VDD.n118 0.370815
R360 VDD.n204 VDD.n202 0.37052
R361 VDD.n120 VDD.n119 0.367028
R362 VDD.n13 VDD.n12 0.366462
R363 VDD.n259 VDD.n70 0.366462
R364 VDD.n216 VDD.n215 0.366462
R365 VDD.n247 VDD.n224 0.366462
R366 VDD.n208 VDD.n98 0.366462
R367 VDD.n29 VDD.n27 0.366462
R368 VDD.n117 VDD.n109 0.366462
R369 VDD.n7 VDD.n4 0.366462
R370 VDD.n219 VDD.n218 0.36567
R371 VDD.n149 VDD.n142 0.36567
R372 VDD.n128 VDD.n127 0.36567
R373 VDD.n253 VDD.n223 0.36567
R374 VDD.n201 VDD.n200 0.36567
R375 VDD.n206 VDD.n99 0.36567
R376 VDD.n7 VDD.n5 0.36567
R377 VDD.n29 VDD.n26 0.36567
R378 VDD.n123 VDD.n122 0.36567
R379 VDD.n260 VDD.n69 0.36567
R380 VDD.n134 VDD.n133 0.36533
R381 VDD.n3 VDD.n0 0.36533
R382 VDD.n56 VDD.n205 0.380865
R383 VDD.n7 VDD.n6 0.36533
R384 VDD.n11 VDD.n10 0.36533
R385 VDD.t10 VDD.n24 13.959
R386 VDD.t3 VDD.n18 0.342352
R387 VDD.n29 VDD.n28 0.317537
R388 VDD.n199 VDD.n197 0.314935
R389 VDD.n112 VDD.n111 0.293695
R390 VDD.n204 VDD.n203 0.291836
R391 VDD.n113 VDD.n112 0.291836
R392 VDD.n121 VDD.n120 0.291836
R393 VDD.n111 VDD.n110 0.288399
R394 VDD.n11 VDD.n9 0.282499
R395 VDD.n183 VDD.n182 0.282288
R396 VDD.n47 VDD.n46 0.28216
R397 VDD.n199 VDD.n198 0.277799
R398 VDD.n198 VDD.n63 0.200438
R399 VDD.n110 VDD.n11 0.256937
R400 VDD.n212 VDD.n211 0.255101
R401 VDD.n211 VDD.n210 0.253824
R402 VDD.n125 VDD.n124 0.247764
R403 VDD.n30 VDD.n187 0.652059
R404 VDD.n24 VDD.n44 14.8111
R405 VDD.n179 VDD.n178 0.234669
R406 VDD.n29 VDD.n25 0.370465
R407 VDD.n202 VDD.n64 0.235761
R408 VDD.n124 VDD.n123 0.233276
R409 VDD.n178 VDD.n177 0.229784
R410 VDD.n182 VDD.n181 0.216778
R411 VDD.n143 VDD.n41 0.354468
R412 VDD.n50 VDD.n258 0.372538
R413 VDD.n257 VDD.t0 0.953483
R414 VDD.n66 VDD.n176 0.344464
R415 VDD.n176 VDD.n126 0.209352
R416 VDD.n114 VDD.n113 0.206507
R417 VDD.n95 VDD.n73 0.20534
R418 VDD.n181 VDD.n180 0.203125
R419 VDD.n96 VDD.n73 0.197129
R420 VDD.n102 VDD.n72 0.19661
R421 VDD.n62 VDD.n222 0.196052
R422 VDD.n132 VDD.n37 0.401957
R423 VDD.n197 VDD.n102 0.186653
R424 VDD.n186 VDD.n185 0.182063
R425 VDD.n116 VDD.n115 0.17246
R426 VDD.n126 VDD.n125 0.172165
R427 VDD.n216 VDD.n58 0.145014
R428 VDD.n264 VDD.n53 0.136153
R429 VDD.n88 VDD.n86 0.167128
R430 VDD.n232 VDD.n231 0.167128
R431 VDD.n170 VDD.n169 0.166791
R432 VDD.n210 VDD.n209 0.165045
R433 VDD.n115 VDD.n114 0.164713
R434 VDD.n81 VDD.n80 0.16373
R435 VDD.n230 VDD.n229 0.16373
R436 VDD.n167 VDD.n166 0.163636
R437 VDD.n79 VDD.n78 0.163298
R438 VDD.n235 VDD.n234 0.163298
R439 VDD.n172 VDD.n171 0.162967
R440 VDD.n188 VDD.n108 0.16189
R441 VDD.n165 VDD.n164 0.160237
R442 VDD.n84 VDD.n82 0.160144
R443 VDD.n38 VDD.n36 0.159806
R444 VDD.n89 VDD.n77 0.159475
R445 VDD.n237 VDD.n236 0.159475
R446 VDD.n85 VDD.n83 0.156745
R447 VDD.n196 VDD.n194 0.156745
R448 VDD.n163 VDD.n162 0.156652
R449 VDD.n91 VDD.n90 0.156314
R450 VDD.n239 VDD.n238 0.156314
R451 VDD.n139 VDD.n138 0.155983
R452 VDD.n177 VDD.n66 0.2984
R453 VDD.n185 VDD.n184 0.15511
R454 VDD.n161 VDD.n160 0.153253
R455 VDD.n145 VDD.n144 0.152822
R456 VDD.n97 VDD.n1 0.152822
R457 VDD.n93 VDD.n92 0.15249
R458 VDD.n241 VDD.n240 0.15249
R459 VDD.n259 VDD.n50 0.431184
R460 VDD.n23 VDD.n216 0.624545
R461 VDD.n209 VDD.n208 0.150541
R462 VDD.n106 VDD.n105 0.149761
R463 VDD.n159 VDD.n158 0.149668
R464 VDD.n60 VDD.n132 0.208644
R465 VDD.n35 VDD.n94 0.31493
R466 VDD.n156 VDD.n155 0.14933
R467 VDD.n76 VDD.n75 0.14933
R468 VDD.n243 VDD.n242 0.14933
R469 VDD.n152 VDD.n151 0.146711
R470 VDD.n157 VDD.n156 0.146269
R471 VDD.n75 VDD.n74 0.146269
R472 VDD.n244 VDD.n243 0.146269
R473 VDD.n158 VDD.n157 0.145506
R474 VDD.n94 VDD.n74 0.145506
R475 VDD.n245 VDD.n244 0.145506
R476 VDD.n151 VDD.n150 0.145303
R477 VDD.n117 VDD.n116 0.144633
R478 VDD.n180 VDD.n179 0.14365
R479 VDD.n146 VDD.n145 0.142777
R480 VDD.n155 VDD.n154 0.142684
R481 VDD.n92 VDD.n76 0.142684
R482 VDD.n242 VDD.n241 0.142684
R483 VDD.n160 VDD.n159 0.142346
R484 VDD.n105 VDD.n104 0.142014
R485 VDD.n265 VDD.n49 0.597254
R486 VDD.n93 VDD.n91 0.139285
R487 VDD.n240 VDD.n239 0.139285
R488 VDD.n144 VDD.n143 0.139192
R489 VDD.n97 VDD.n96 0.139192
R490 VDD.n162 VDD.n161 0.138522
R491 VDD.n184 VDD.n183 0.136666
R492 VDD.n140 VDD.n139 0.135793
R493 VDD.n90 VDD.n89 0.1357
R494 VDD.n238 VDD.n237 0.1357
R495 VDD.n164 VDD.n163 0.135362
R496 VDD.n85 VDD.n84 0.13503
R497 VDD.n187 VDD.n186 0.134157
R498 VDD.n78 VDD.n77 0.132301
R499 VDD.n236 VDD.n235 0.132301
R500 VDD.n82 VDD.n81 0.13187
R501 VDD.n166 VDD.n165 0.131538
R502 VDD.n147 VDD.n146 0.130665
R503 VDD.n190 VDD.n108 0.130124
R504 VDD.n196 VDD.n195 0.129792
R505 VDD.n171 VDD.n170 0.128809
R506 VDD.n87 VDD.n79 0.128716
R507 VDD.n234 VDD.n233 0.128716
R508 VDD.n168 VDD.n167 0.128378
R509 VDD.n86 VDD.n80 0.128046
R510 VDD.n231 VDD.n230 0.128046
R511 VDD.n68 VDD.n52 0.250823
R512 VDD.t0 VDD.n15 0.235833
R513 VDD.n71 VDD.n54 0.281502
R514 VDD.n255 VDD.n55 0.224236
R515 VDD.t0 VDD.n24 15.2458
R516 VDD.n7 VDD.t3 1.30866
R517 VDD.n169 VDD.n168 0.125224
R518 VDD.n88 VDD.n87 0.124886
R519 VDD.n233 VDD.n232 0.124886
R520 VDD.n141 VDD.n140 0.117881
R521 VDD.n226 VDD.n225 0.117881
R522 VDD.n255 VDD.n39 0.317066
R523 VDD.n104 VDD.n103 0.110897
R524 VDD.n262 VDD.n261 0.11051
R525 VDD.n220 VDD.n219 0.107405
R526 VDD.n61 VDD.n83 0.150481
R527 VDD.n246 VDD.n245 0.107405
R528 VDD.n207 VDD.n206 0.107405
R529 VDD.n263 VDD.n45 0.140065
R530 VDD.n36 VDD.n131 0.0937949
R531 VDD.n189 VDD.n188 0.0917112
R532 VDD.n131 VDD.n130 0.0890922
R533 VDD.n189 VDD.n25 0.0885568
R534 VDD.n58 VDD.n217 0.172077
R535 VDD.n174 VDD.n141 0.0847065
R536 VDD.n42 VDD.n47 0.113516
R537 VDD.t0 VDD.n13 0.535862
R538 VDD.n220 VDD.n217 0.0812144
R539 VDD.n193 VDD.n192 0.0808175
R540 VDD.n148 VDD.n147 0.0799444
R541 VDD.n136 VDD.n135 0.0799444
R542 VDD.n130 VDD.n129 0.0799444
R543 VDD.n252 VDD.n251 0.0799444
R544 VDD.n203 VDD.n56 0.125488
R545 VDD.n101 VDD.n57 0.120508
R546 VDD.n55 VDD.n71 0.2437
R547 VDD.n228 VDD.n227 0.0764524
R548 VDD.n45 VDD.n67 0.158933
R549 VDD.n22 VDD.n21 0.135345
R550 VDD.n250 VDD.n249 0.0689922
R551 VDD.n248 VDD.n247 0.0659762
R552 VDD.n59 VDD.n149 0.0224808
R553 VDD.n247 VDD.n246 0.0611351
R554 VDD.n208 VDD.n207 0.0611351
R555 VDD.n219 VDD.n40 0.309877
R556 VDD.n149 VDD.n148 0.0607381
R557 VDD.n135 VDD.n134 0.0607381
R558 VDD.n129 VDD.n128 0.0607381
R559 VDD.n253 VDD.n252 0.0607381
R560 VDD.n201 VDD.n43 0.135868
R561 VDD.n206 VDD.n57 0.0210328
R562 VDD.n65 VDD.n121 0.120508
R563 VDD.n249 VDD.n248 0.0581191
R564 VDD.n194 VDD.n193 0.054627
R565 VDD.n195 VDD.n72 0.0528809
R566 VDD.n32 VDD.n67 0.519769
R567 VDD.n227 VDD.n226 0.0506589
R568 VDD.n173 VDD.n172 0.0476429
R569 VDD.n229 VDD.n228 0.0476429
R570 VDD.n251 VDD.n250 0.0471668
R571 VDD.n192 VDD.n103 0.0462938
R572 VDD.n16 VDD.n68 1.28604
R573 VDD.n13 VDD.n31 1.13238
R574 VDD.n225 VDD.n3 1.13118
R575 VDD.n174 VDD.n173 0.0424048
R576 VDD.n258 VDD.n257 0.0389127
R577 VDD.n222 VDD.n221 0.0389127
R578 VDD.n213 VDD.n212 0.0389127
R579 VDD.n261 VDD.n260 0.0310658
R580 VDD.n150 VDD.n59 0.0675305
R581 VDD.t0 VDD.n42 1.11783
R582 VDD.n11 VDD.n8 1.07962
R583 VDD.n33 VDD.t3 1.03431
R584 VDD.n260 VDD.n22 1.01461
R585 VSS.n231 VSS.n176 6076.65
R586 VSS.n231 VSS.n230 5334.63
R587 VSS.t47 VSS.n231 2018.03
R588 VSS.n230 VSS.n229 2017.11
R589 VSS.n20 VSS.t228 290.348
R590 VSS.n9 VSS.t235 290.348
R591 VSS.n15 VSS.t225 290.348
R592 VSS.n18 VSS.t281 290.348
R593 VSS.n91 VSS.t50 15.7614
R594 VSS.n220 VSS.t405 289.481
R595 VSS.n121 VSS.t47 0.274357
R596 VSS.n89 VSS.t383 287.43
R597 VSS.n32 VSS.t18 24.4502
R598 VSS.t175 VSS.n24 24.4502
R599 VSS.n22 VSS.t391 284.51
R600 VSS.t274 VSS.n119 25.22
R601 VSS.t276 VSS.n115 25.22
R602 VSS.n116 VSS.t226 50.0905
R603 VSS.t48 VSS.n118 25.2185
R604 VSS.n130 VSS.t275 25.22
R605 VSS.n82 VSS.t317 50.0913
R606 VSS.t47 VSS.t205 29.9645
R607 VSS.t47 VSS.n108 0.530007
R608 VSS.t96 VSS.t47 29.9645
R609 VSS.t47 VSS.n107 0.530007
R610 VSS.t314 VSS.t50 29.9645
R611 VSS.t321 VSS.n49 29.157
R612 VSS.t50 VSS.t402 29.9645
R613 VSS.t371 VSS.n262 277.238
R614 VSS.t254 VSS.n277 277.238
R615 VSS.t336 VSS.n252 271.401
R616 VSS.n154 VSS.t47 14.6529
R617 VSS.n4 VSS.t17 35.8095
R618 VSS.n148 VSS.t50 0.796629
R619 VSS.t54 VSS.n120 280.204
R620 VSS.t36 VSS.n217 268.483
R621 VSS.t178 VSS.n216 268.483
R622 VSS.t35 VSS.n187 268.483
R623 VSS.t404 VSS.n129 280.204
R624 VSS.n287 VSS.t315 268.483
R625 VSS.t234 VSS.n181 268.483
R626 VSS.n222 VSS.t39 268.483
R627 VSS.t277 VSS.n205 268.483
R628 VSS.n249 VSS.t320 268.483
R629 VSS.t157 VSS.n253 268.483
R630 VSS.t263 VSS.n273 268.483
R631 VSS.n90 VSS.t42 154.653
R632 VSS.t289 VSS.n186 265.565
R633 VSS.t207 VSS.n210 265.565
R634 VSS.n147 VSS.t69 277.443
R635 VSS.n30 VSS.t233 31.4537
R636 VSS.n288 VSS.t4 259.728
R637 VSS.n245 VSS.t152 259.728
R638 VSS.n261 VSS.t367 259.728
R639 VSS.n276 VSS.t250 259.728
R640 VSS.n158 VSS.t47 0.317806
R641 VSS.t50 VSS.n165 14.0194
R642 VSS.n156 VSS.t47 0.317803
R643 VSS.n104 VSS.t50 0.762202
R644 VSS.t304 VSS.t47 29.9645
R645 VSS.t47 VSS.t237 46.5456
R646 VSS.t297 VSS.t47 29.9645
R647 VSS.n161 VSS.t354 267.671
R648 VSS.n161 VSS.t400 34.3229
R649 VSS.n242 VSS.t144 253.892
R650 VSS.t258 VSS.n278 253.892
R651 VSS.n281 VSS.t261 253.892
R652 VSS.t30 VSS.n14 156.148
R653 VSS.n29 VSS.t238 48.322
R654 VSS.n21 VSS.t136 252.411
R655 VSS.n88 VSS.t266 252.41
R656 VSS.t162 VSS.n224 251.542
R657 VSS.n119 VSS.t47 0.066743
R658 VSS.n115 VSS.t47 0.0667429
R659 VSS.n116 VSS.t47 0.0667429
R660 VSS.n130 VSS.t406 50.0905
R661 VSS.n11 VSS.t11 248.625
R662 VSS.n69 VSS.t15 248.625
R663 VSS.t156 VSS.n202 248.054
R664 VSS.t364 VSS.n255 248.054
R665 VSS.n162 VSS.t214 258.125
R666 VSS.t158 VSS.n208 245.137
R667 VSS.n162 VSS.t57 43.4964
R668 VSS.n275 VSS.t353 236.381
R669 VSS.n189 VSS.t287 233.464
R670 VSS.n191 VSS.t25 233.464
R671 VSS.t140 VSS.t2 233.464
R672 VSS.n244 VSS.t218 233.464
R673 VSS.t360 VSS.n259 233.464
R674 VSS.t50 VSS.n103 12.5932
R675 VSS.t8 VSS.t137 230.546
R676 VSS.t306 VSS.n223 230.546
R677 VSS.t359 VSS.t339 230.546
R678 VSS.n265 VSS.t374 230.546
R679 VSS.t379 VSS.n268 230.546
R680 VSS.n278 VSS.t257 230.546
R681 VSS.t262 VSS.n281 230.546
R682 VSS.t392 VSS.n24 225.357
R683 VSS.n25 VSS.t172 225.278
R684 VSS.n32 VSS.t398 225.357
R685 VSS.n245 VSS.t151 224.708
R686 VSS.t368 VSS.n261 224.708
R687 VSS.t251 VSS.n276 224.708
R688 VSS.t399 VSS.n7 219.441
R689 VSS.t333 VSS.n2 219.441
R690 VSS.t66 VSS.n186 218.873
R691 VSS.t174 VSS.n210 218.873
R692 VSS.n240 VSS.t173 218.873
R693 VSS.t342 VSS.t166 218.873
R694 VSS.t329 VSS.n147 54.0585
R695 VSS.t255 VSS.n77 216.524
R696 VSS.t86 VSS.n120 55.3479
R697 VSS.t63 VSS.n157 204.328
R698 VSS.t302 VSS.n216 215.953
R699 VSS.t94 VSS.n155 204.328
R700 VSS.n287 VSS.t90 215.953
R701 VSS.n152 VSS.t210 204.328
R702 VSS.n221 VSS.t83 215.953
R703 VSS.n160 VSS.t245 55.3497
R704 VSS.n249 VSS.t267 215.953
R705 VSS.t159 VSS.n266 215.953
R706 VSS.t44 VSS.n153 204.328
R707 VSS.t228 VSS.n28 21.6277
R708 VSS.t235 VSS.n5 21.6277
R709 VSS.n117 VSS.t303 66.883
R710 VSS.n138 VSS.t204 66.8826
R711 VSS.n248 VSS.t346 213.036
R712 VSS.n252 VSS.t335 213.036
R713 VSS.n271 VSS.t349 213.036
R714 VSS.t351 VSS.n70 210.686
R715 VSS.t81 VSS.n225 210.118
R716 VSS.t325 VSS.n122 68.9379
R717 VSS.t222 VSS.n167 68.9391
R718 VSS.t403 VSS.n125 68.9379
R719 VSS.t208 VSS.n40 207.768
R720 VSS.t149 VSS.n204 207.198
R721 VSS.t395 VSS.t345 207.198
R722 VSS.n262 VSS.t370 207.198
R723 VSS.n277 VSS.t253 207.198
R724 VSS.t139 VSS.n112 48.3395
R725 VSS.n13 VSS.t179 204.85
R726 VSS.n43 VSS.t309 204.85
R727 VSS.n42 VSS.t389 204.85
R728 VSS.t382 VSS.n51 204.85
R729 VSS.n63 VSS.t285 204.85
R730 VSS.t71 VSS.n185 204.28
R731 VSS.n270 VSS.t244 204.28
R732 VSS.n128 VSS.t47 11.0101
R733 VSS.t201 VSS.n6 201.931
R734 VSS.n12 VSS.t55 201.931
R735 VSS.t290 VSS.n49 202.029
R736 VSS.n37 VSS.t153 199.013
R737 VSS.n74 VSS.t249 199.013
R738 VSS.n131 VSS.t313 61.9538
R739 VSS.t76 VSS.n256 198.445
R740 VSS.n139 VSS.t184 101.239
R741 VSS.t147 VSS.t217 195.525
R742 VSS.t148 VSS.t165 195.525
R743 VSS.n247 VSS.t344 195.525
R744 VSS.n250 VSS.t13 195.525
R745 VSS.t286 VSS.n8 193.177
R746 VSS.n4 VSS.t298 193.299
R747 VSS.n46 VSS.t142 193.177
R748 VSS.n62 VSS.t377 193.177
R749 VSS.t216 VSS.n66 193.177
R750 VSS.t259 VSS.n80 193.177
R751 VSS.n289 VSS.t31 192.607
R752 VSS.n219 VSS.t310 192.607
R753 VSS.t356 VSS.n160 204.328
R754 VSS.t279 VSS.n200 192.607
R755 VSS.n250 VSS.t73 192.607
R756 VSS.t32 VSS.n275 192.607
R757 VSS.t385 VSS.n185 189.69
R758 VSS.t60 VSS.t209 189.69
R759 VSS.t184 VSS.n91 190.006
R760 VSS.t155 VSS.n35 187.34
R761 VSS.t248 VSS.n72 187.34
R762 VSS.t72 VSS.n227 186.77
R763 VSS.t291 VSS.n50 74.807
R764 VSS.t78 VSS.n44 184.422
R765 VSS.n259 VSS.t366 183.852
R766 VSS.t372 VSS.t77 183.852
R767 VSS.n166 VSS.t50 0.538613
R768 VSS.t85 VSS.n151 75.5534
R769 VSS.n84 VSS.t319 44.359
R770 VSS.t171 VSS.n87 75.8051
R771 VSS.n190 VSS.t20 178.017
R772 VSS.t141 VSS.n206 178.017
R773 VSS.t376 VSS.n267 178.017
R774 VSS.t350 VSS.t80 178.017
R775 VSS.n279 VSS.t260 178.017
R776 VSS.t343 VSS.n48 175.667
R777 VSS.n55 VSS.t338 175.667
R778 VSS.t299 VSS.n127 76.6887
R779 VSS.n124 VSS.t215 76.6913
R780 VSS.n68 VSS.t38 172.749
R781 VSS.n123 VSS.t65 186.276
R782 VSS.n288 VSS.t28 172.179
R783 VSS.n289 VSS.t213 172.179
R784 VSS.n227 VSS.t357 172.179
R785 VSS.n241 VSS.t278 172.179
R786 VSS.t327 VSS.n102 186.279
R787 VSS.t365 VSS.n257 172.179
R788 VSS.t40 VSS.n279 172.179
R789 VSS.n79 VSS.t256 169.831
R790 VSS.n140 VSS.t363 68.6122
R791 VSS.n290 VSS.t6 166.343
R792 VSS.t375 VSS.t328 166.343
R793 VSS.n268 VSS.t160 166.343
R794 VSS.t369 VSS.n57 163.994
R795 VSS.t252 VSS.n75 163.994
R796 VSS.n246 VSS.t264 163.424
R797 VSS.t269 VSS.n263 163.424
R798 VSS.t56 VSS.n26 77.4928
R799 VSS.n22 VSS.t300 161.944
R800 VSS.n51 VSS.t138 161.076
R801 VSS.n273 VSS.t352 160.506
R802 VSS.t347 VSS.n33 158.157
R803 VSS.t348 VSS.n69 158.157
R804 VSS.n190 VSS.t22 157.589
R805 VSS.t116 VSS.t50 78.0788
R806 VSS.t50 VSS.t118 78.0859
R807 VSS.t128 VSS.t47 78.0739
R808 VSS.n124 VSS.t47 0.409617
R809 VSS.t50 VSS.n101 8.47464
R810 VSS.n89 VSS.t117 156.107
R811 VSS.n88 VSS.t42 156.107
R812 VSS.n21 VSS.t61 156.107
R813 VSS.n6 VSS.t127 155.238
R814 VSS.t131 VSS.n11 155.238
R815 VSS.n40 VSS.t121 155.238
R816 VSS.t326 VSS.n54 155.238
R817 VSS.n243 VSS.t146 154.669
R818 VSS.n263 VSS.t373 154.669
R819 VSS.n34 VSS.t347 152.321
R820 VSS.n53 VSS.t334 152.321
R821 VSS.t388 VSS.t312 151.751
R822 VSS.t24 VSS.t243 151.751
R823 VSS.t300 VSS.n23 149.403
R824 VSS.t172 VSS.n26 85.6409
R825 VSS.t138 VSS.n31 149.403
R826 VSS.n244 VSS.t150 148.833
R827 VSS.t150 VSS.n47 146.484
R828 VSS.n58 VSS.t369 146.484
R829 VSS.n76 VSS.t252 146.484
R830 VSS.t334 VSS.n251 142.996
R831 VSS.t146 VSS.n39 140.648
R832 VSS.t373 VSS.n60 140.648
R833 VSS.t256 VSS.n78 140.648
R834 VSS.t61 VSS.n217 140.078
R835 VSS.t47 VSS.t129 78.0791
R836 VSS.t127 VSS.n144 155.238
R837 VSS.t91 VSS.n187 140.078
R838 VSS.n286 VSS.t131 140.078
R839 VSS.t30 VSS.n181 140.078
R840 VSS.n290 VSS.t212 140.078
R841 VSS.t212 VSS.n179 140.078
R842 VSS.n228 VSS.t114 140.078
R843 VSS.t114 VSS.n140 149.266
R844 VSS.n223 VSS.t358 140.078
R845 VSS.t358 VSS.n222 140.078
R846 VSS.t393 VSS.n141 44.3584
R847 VSS.t121 VSS.n103 143.564
R848 VSS.n242 VSS.t280 140.078
R849 VSS.t117 VSS.n101 147.683
R850 VSS.t122 VSS.n101 69.8227
R851 VSS.t47 VSS.n127 0.409602
R852 VSS.n269 VSS.t348 137.161
R853 VSS.t47 VSS.t124 76.7282
R854 VSS.n107 VSS.t97 75.8049
R855 VSS.n109 VSS.t88 75.8049
R856 VSS.n108 VSS.t26 75.8049
R857 VSS.t196 VSS.n111 75.8049
R858 VSS.t44 VSS.n87 103.099
R859 VSS.n84 VSS.t170 75.5541
R860 VSS.t240 VSS.n158 75.5535
R861 VSS.t199 VSS.n156 75.5535
R862 VSS.t47 VSS.n151 0.317808
R863 VSS.t6 VSS.n17 129.716
R864 VSS.n33 VSS.t396 128.975
R865 VSS.n166 VSS.t381 75.3335
R866 VSS.n140 VSS.t50 6.89209
R867 VSS.t290 VSS.n50 108.918
R868 VSS.t93 VSS.n30 73.9746
R869 VSS.t65 VSS.n27 124.007
R870 VSS.t357 VSS.n226 123.138
R871 VSS.n56 VSS.t365 123.138
R872 VSS.n73 VSS.t248 123.138
R873 VSS.t22 VSS.n154 123.995
R874 VSS.n246 VSS.t343 119.65
R875 VSS.t338 VSS.n254 119.65
R876 VSS.n3 VSS.t70 117.302
R877 VSS.n45 VSS.t141 117.302
R878 VSS.n61 VSS.t376 117.302
R879 VSS.t377 VSS.n61 117.302
R880 VSS.n65 VSS.t37 117.302
R881 VSS.t243 VSS.n65 117.302
R882 VSS.n67 VSS.t216 117.302
R883 VSS.t332 VSS.n67 117.302
R884 VSS.n81 VSS.t259 117.302
R885 VSS.t264 VSS.n201 116.733
R886 VSS.n264 VSS.t269 116.733
R887 VSS.n240 VSS.t388 113.814
R888 VSS.t153 VSS.n36 111.465
R889 VSS.t366 VSS.n56 111.465
R890 VSS.t249 VSS.n73 111.465
R891 VSS.t50 VSS.t34 71.0808
R892 VSS.n7 VSS.t201 108.546
R893 VSS.t55 VSS.n2 108.546
R894 VSS.t278 VSS.n206 107.978
R895 VSS.n251 VSS.t327 107.978
R896 VSS.n280 VSS.t40 107.978
R897 VSS.t185 VSS.t50 70.1815
R898 VSS.t58 VSS.n159 64.5226
R899 VSS.t179 VSS.n12 105.629
R900 VSS.t389 VSS.n41 105.629
R901 VSS.n52 VSS.t382 105.629
R902 VSS.t285 VSS.n166 106.008
R903 VSS.t47 VSS.n167 0.306401
R904 VSS.t47 VSS.n122 0.306396
R905 VSS.t47 VSS.n125 0.306396
R906 VSS.t341 VSS.t47 103.579
R907 VSS.t63 VSS.n107 103.099
R908 VSS.t94 VSS.n109 103.099
R909 VSS.n0 VSS.t210 103.099
R910 VSS.n111 VSS.t356 103.099
R911 VSS.n41 VSS.t208 102.71
R912 VSS.n189 VSS.t286 102.141
R913 VSS.t20 VSS.n188 102.141
R914 VSS.n121 VSS.t177 67.9608
R915 VSS.t288 VSS.t47 100.707
R916 VSS.n71 VSS.t351 99.7915
R917 VSS.n117 VSS.t47 0.289196
R918 VSS.t95 VSS.n5 66.883
R919 VSS.n131 VSS.t50 5.30829
R920 VSS.t296 VSS.n28 66.8826
R921 VSS.n138 VSS.t47 0.289194
R922 VSS.n139 VSS.t401 61.9533
R923 VSS.n39 VSS.t147 93.9549
R924 VSS.n60 VSS.t372 93.9549
R925 VSS.n78 VSS.t255 93.9549
R926 VSS.t298 VSS.t384 93.3857
R927 VSS.t70 VSS.t288 93.3857
R928 VSS.n128 VSS.t231 60.4766
R929 VSS.t80 VSS.n271 93.3857
R930 VSS.n168 VSS.t292 104.228
R931 VSS.n8 VSS.t399 91.0366
R932 VSS.n128 VSS.t385 95.5362
R933 VSS.t309 VSS.n209 90.4674
R934 VSS.t280 VSS.t145 90.4674
R935 VSS.n47 VSS.t149 88.1183
R936 VSS.t253 VSS.n76 88.1183
R937 VSS.t310 VSS.n131 98.3197
R938 VSS.n247 VSS.t279 87.5491
R939 VSS.t73 VSS.n196 87.5491
R940 VSS.t328 VSS.n265 87.5491
R941 VSS.t160 VSS.t378 87.5491
R942 VSS.t50 VSS.t272 86.1016
R943 VSS.n23 VSS.t392 85.2001
R944 VSS.n226 VSS.t81 85.2001
R945 VSS.t398 VSS.n31 85.2001
R946 VSS.t344 VSS.n201 84.6308
R947 VSS.t13 VSS.n197 84.6308
R948 VSS.n253 VSS.t337 84.6308
R949 VSS.n135 VSS.t192 30.477
R950 VSS.t346 VSS.n34 82.2818
R951 VSS.t165 VSS.n204 81.7126
R952 VSS.n257 VSS.t76 81.7126
R953 VSS.t260 VSS.t268 81.7126
R954 VSS.n152 VSS.t84 55.3497
R955 VSS.t198 VSS.n155 55.3497
R956 VSS.t239 VSS.n157 55.3497
R957 VSS.n160 VSS.t50 4.35809
R958 VSS.t169 VSS.n153 55.3487
R959 VSS.t47 VSS.n120 4.35795
R960 VSS.n129 VSS.t9 55.3479
R961 VSS.t5 VSS.t47 80.2317
R962 VSS.t90 VSS.n13 79.3635
R963 VSS.t83 VSS.n220 79.3635
R964 VSS.t267 VSS.n52 79.3635
R965 VSS.t394 VSS.n71 79.3635
R966 VSS.t50 VSS.n147 4.19971
R967 VSS.n192 VSS.t71 75.876
R968 VSS.n286 VSS.t333 75.876
R969 VSS.t244 VSS.n269 75.876
R970 VSS.t3 VSS.t72 72.9577
R971 VSS.n150 VSS.t135 32.6476
R972 VSS.n75 VSS.t251 70.6086
R973 VSS.t31 VSS.t301 67.1211
R974 VSS.t219 VSS.t155 67.1211
R975 VSS.t349 VSS.n270 67.1211
R976 VSS.n224 VSS.t306 64.772
R977 VSS.t257 VSS.n79 64.772
R978 VSS.n144 VSS.t302 79.3635
R979 VSS.t271 VSS.n103 47.557
R980 VSS.n248 VSS.t395 64.2028
R981 VSS.n267 VSS.t159 64.2028
R982 VSS.t25 VSS.n127 62.3634
R983 VSS.t11 VSS.n124 62.3634
R984 VSS.t282 VSS.n118 50.0913
R985 VSS.t15 VSS.n68 61.8538
R986 VSS.n191 VSS.t66 61.2845
R987 VSS.n159 VSS.t174 71.58
R988 VSS.t173 VSS.n209 61.2845
R989 VSS.t136 VSS.n27 59.8027
R990 VSS.n29 VSS.t47 0.0337558
R991 VSS.t232 VSS.n14 48.3407
R992 VSS.t221 VSS.n17 48.1742
R993 VSS.n230 VSS.n98 5677.98
R994 VSS.t52 VSS.n45 58.9355
R995 VSS.n48 VSS.t342 58.9355
R996 VSS.t167 VSS.n53 58.9355
R997 VSS.t339 VSS.n55 58.9355
R998 VSS.t142 VSS.t52 58.3663
R999 VSS.n150 VSS.t132 32.4358
R1000 VSS.n162 VSS.t50 3.09094
R1001 VSS.t318 VSS.t50 46.5463
R1002 VSS.t230 VSS.t47 46.5456
R1003 VSS.t227 VSS.t47 46.5456
R1004 VSS.t50 VSS.t407 46.5456
R1005 VSS.t47 VSS.t283 46.5456
R1006 VSS.t50 VSS.t60 56.8845
R1007 VSS.n36 VSS.t219 56.0172
R1008 VSS.t361 VSS.n58 56.0172
R1009 VSS.t151 VSS.n203 55.448
R1010 VSS.t337 VSS.t326 55.448
R1011 VSS.t352 VSS.t394 55.448
R1012 VSS.t247 VSS.t32 55.448
R1013 VSS.n158 VSS.t223 44.3594
R1014 VSS.n156 VSS.t220 44.3589
R1015 VSS.t246 VSS.n141 75.5541
R1016 VSS.n104 VSS.t0 43.9139
R1017 VSS.t202 VSS.n114 2.75229
R1018 VSS.n44 VSS.t158 50.1806
R1019 VSS.t209 VSS.n208 49.6114
R1020 VSS.t145 VSS.n205 49.6114
R1021 VSS.t374 VSS.n264 49.6114
R1022 VSS.n165 VSS.t379 51.6708
R1023 VSS.n282 VSS.t262 49.6114
R1024 VSS.n135 VSS.n150 0.082529
R1025 VSS.n135 VSS.t194 30.5009
R1026 VSS.n35 VSS.t156 47.2623
R1027 VSS.n72 VSS.t247 47.2623
R1028 VSS.t287 VSS.n188 46.6931
R1029 VSS.t218 VSS.n203 46.6931
R1030 VSS.n260 VSS.t360 46.6931
R1031 VSS.n98 VSS.n126 0.944345
R1032 VSS.n146 VSS.t188 17.1697
R1033 VSS.t213 VSS.t5 43.7748
R1034 VSS.n225 VSS.t162 43.7748
R1035 VSS.t51 VSS.t368 43.7748
R1036 VSS.t353 VSS.n274 43.7748
R1037 VSS.t266 VSS.n282 43.7748
R1038 VSS.n161 VSS.t50 2.29912
R1039 VSS.t387 VSS.n126 12.368
R1040 VSS.t307 VSS.n106 12.3693
R1041 VSS.t206 VSS.n143 12.3678
R1042 VSS.t380 VSS.n142 51.1816
R1043 VSS.t284 VSS.n145 12.3905
R1044 VSS.n110 VSS.t168 12.371
R1045 VSS.n110 VSS.t67 12.3591
R1046 VSS.t294 VSS.n163 12.3663
R1047 VSS.n229 VSS.t354 41.4257
R1048 VSS.t144 VSS.n46 41.4257
R1049 VSS.t378 VSS.n62 41.4257
R1050 VSS.n148 VSS.t23 35.8095
R1051 VSS.n66 VSS.t24 41.4257
R1052 VSS.n80 VSS.t258 41.4257
R1053 VSS.t272 VSS.t78 40.8565
R1054 VSS.n98 VSS.n105 0.234334
R1055 VSS.t137 VSS.n179 37.9382
R1056 VSS.t362 VSS.n165 31.285
R1057 VSS.n30 VSS.t47 0.787998
R1058 VSS.t305 VSS.n123 30.2698
R1059 VSS.t50 VSS.t3 36.5047
R1060 VSS.t293 VSS.n102 30.2344
R1061 VSS.t106 VSS.n98 18.1667
R1062 VSS.t100 VSS.n98 18.157
R1063 VSS.n98 VSS.t108 18.1666
R1064 VSS.n98 VSS.t110 18.1694
R1065 VSS.t242 VSS.n114 12.3672
R1066 VSS.t301 VSS.n108 35.9784
R1067 VSS.t250 VSS.n74 35.5892
R1068 VSS.t268 VSS.n81 35.5892
R1069 VSS.t214 VSS.n228 35.02
R1070 VSS.t104 VSS.n105 17.8389
R1071 VSS.t77 VSS.n59 32.6709
R1072 VSS.n105 VSS.t102 17.7768
R1073 VSS.n256 VSS.t364 32.1017
R1074 VSS.t370 VSS.t361 32.1017
R1075 VSS.n43 VSS.t207 29.7526
R1076 VSS.t312 VSS.n42 29.7526
R1077 VSS.t69 VSS.n63 29.7526
R1078 VSS.n98 VSS.t190 17.2379
R1079 VSS.n146 VSS.n98 0.0701578
R1080 VSS.n98 VSS.t181 17.2233
R1081 VSS.n116 VSS.t46 25.22
R1082 VSS.t47 VSS.n118 0.0663857
R1083 VSS.n82 VSS.t49 25.2185
R1084 VSS.n18 VSS.t8 27.7026
R1085 VSS.n15 VSS.t234 27.7026
R1086 VSS.n9 VSS.t35 27.7026
R1087 VSS.n20 VSS.t36 27.7026
R1088 VSS.n90 VSS.t386 23.749
R1089 VSS.t391 VSS.n25 26.8343
R1090 VSS.n167 VSS.t178 27.4471
R1091 VSS.t273 VSS.n37 26.8343
R1092 VSS.n57 VSS.t51 26.8343
R1093 VSS.n154 VSS.t397 22.6379
R1094 VSS.n241 VSS.t140 26.2651
R1095 VSS.n266 VSS.t375 26.2651
R1096 VSS.t261 VSS.n280 26.2651
R1097 VSS.n168 VSS.t98 16.8786
R1098 VSS.n121 VSS.t390 22.5873
R1099 VSS.t384 VSS.n3 23.916
R1100 VSS.n54 VSS.t336 23.916
R1101 VSS.n70 VSS.t350 23.916
R1102 VSS.t335 VSS.t167 23.3468
R1103 VSS.n98 VSS.t112 18.1558
R1104 VSS.n176 VSS.t292 22.3204
R1105 VSS.t217 VSS.n38 20.9977
R1106 VSS.t4 VSS.n183 20.4285
R1107 VSS.t28 VSS.t341 20.4285
R1108 VSS.t2 VSS.n112 32.9419
R1109 VSS.t367 VSS.n260 20.4285
R1110 VSS.t38 VSS.t332 20.4285
R1111 VSS.n38 VSS.t148 18.0794
R1112 VSS.n59 VSS.t371 18.0794
R1113 VSS.n77 VSS.t254 18.0794
R1114 VSS.n98 VSS.n145 0.946193
R1115 VSS.t331 VSS.n163 12.3899
R1116 VSS.t322 VSS.n143 12.3685
R1117 VSS.n98 VSS.n106 0.94291
R1118 VSS.n98 VSS.n143 0.944517
R1119 VSS.t163 VSS.n145 12.3662
R1120 VSS.n98 VSS.n163 0.946153
R1121 VSS.t324 VSS.n126 12.3661
R1122 VSS.t323 VSS.n106 12.3474
R1123 VSS.n110 VSS.n98 0.944009
R1124 VSS.t166 VSS.n202 17.5102
R1125 VSS.n135 VSS.n168 3.10325
R1126 VSS.t47 VSS.n152 4.35809
R1127 VSS.t47 VSS.n179 17.0005
R1128 VSS.t47 VSS.n290 17.0005
R1129 VSS.t47 VSS.n289 17.0005
R1130 VSS.t47 VSS.n181 17.0005
R1131 VSS.t47 VSS.n288 17.0005
R1132 VSS.t47 VSS.n183 17.0005
R1133 VSS.t47 VSS.n287 17.0005
R1134 VSS.t47 VSS.n286 17.0005
R1135 VSS.t47 VSS.n129 4.35795
R1136 VSS.t47 VSS.n185 17.0005
R1137 VSS.t47 VSS.n192 17.0005
R1138 VSS.t47 VSS.n186 17.0005
R1139 VSS.t47 VSS.n191 17.0005
R1140 VSS.t47 VSS.n155 4.35809
R1141 VSS.t47 VSS.n187 17.0005
R1142 VSS.t47 VSS.n190 17.0005
R1143 VSS.t47 VSS.n188 17.0005
R1144 VSS.t47 VSS.n189 17.0005
R1145 VSS.t47 VSS.n144 0.920926
R1146 VSS.t47 VSS.n216 17.0005
R1147 VSS.t47 VSS.n157 4.35809
R1148 VSS.t47 VSS.n217 17.0005
R1149 VSS.t47 VSS.n123 1.98219
R1150 VSS.t50 VSS.n196 17.0005
R1151 VSS.t50 VSS.n250 17.0005
R1152 VSS.t50 VSS.n197 17.0005
R1153 VSS.t50 VSS.n249 17.0005
R1154 VSS.t50 VSS.n248 17.0005
R1155 VSS.t50 VSS.n200 17.0005
R1156 VSS.t50 VSS.n247 17.0005
R1157 VSS.t50 VSS.n201 17.0005
R1158 VSS.t50 VSS.n246 17.0005
R1159 VSS.t50 VSS.n202 17.0005
R1160 VSS.t50 VSS.n245 17.0005
R1161 VSS.t50 VSS.n203 17.0005
R1162 VSS.t50 VSS.n244 17.0005
R1163 VSS.t50 VSS.n204 17.0005
R1164 VSS.t50 VSS.n243 17.0005
R1165 VSS.t50 VSS.n205 17.0005
R1166 VSS.t50 VSS.n242 17.0005
R1167 VSS.t50 VSS.n206 17.0005
R1168 VSS.t50 VSS.n241 17.0005
R1169 VSS.t50 VSS.n112 3.5654
R1170 VSS.t50 VSS.n282 17.0005
R1171 VSS.t50 VSS.n281 17.0005
R1172 VSS.t50 VSS.n280 17.0005
R1173 VSS.t50 VSS.n279 17.0005
R1174 VSS.t50 VSS.n278 17.0005
R1175 VSS.t50 VSS.n277 17.0005
R1176 VSS.t50 VSS.n276 17.0005
R1177 VSS.t50 VSS.n275 17.0005
R1178 VSS.t50 VSS.n274 17.0005
R1179 VSS.t50 VSS.n273 17.0005
R1180 VSS.t50 VSS.n271 17.0005
R1181 VSS.t50 VSS.n270 17.0005
R1182 VSS.t50 VSS.n269 17.0005
R1183 VSS.t50 VSS.n268 17.0005
R1184 VSS.t50 VSS.n267 17.0005
R1185 VSS.t50 VSS.n266 17.0005
R1186 VSS.t50 VSS.n265 17.0005
R1187 VSS.t50 VSS.n264 17.0005
R1188 VSS.t50 VSS.n263 17.0005
R1189 VSS.t50 VSS.n262 17.0005
R1190 VSS.t50 VSS.n261 17.0005
R1191 VSS.t50 VSS.n260 17.0005
R1192 VSS.t50 VSS.n259 17.0005
R1193 VSS.t50 VSS.n257 17.0005
R1194 VSS.t50 VSS.n256 17.0005
R1195 VSS.t50 VSS.n255 17.0005
R1196 VSS.t50 VSS.n254 17.0005
R1197 VSS.t50 VSS.n253 17.0005
R1198 VSS.t50 VSS.n252 17.0005
R1199 VSS.t50 VSS.n251 17.0005
R1200 VSS.t50 VSS.n102 1.97987
R1201 VSS.t50 VSS.n139 5.30825
R1202 VSS.t50 VSS.n90 1.5047
R1203 VSS.t50 VSS.n153 4.35801
R1204 VSS.n98 VSS.n142 3.90597
R1205 VSS.t50 VSS.n208 17.0005
R1206 VSS.t50 VSS.n240 17.0005
R1207 VSS.t50 VSS.n209 17.0005
R1208 VSS.t50 VSS.n210 17.0005
R1209 VSS.t50 VSS.n159 5.78346
R1210 VSS.n239 VSS.t50 17.0005
R1211 VSS.n219 VSS.t50 17.0005
R1212 VSS.n221 VSS.t50 17.0005
R1213 VSS.n222 VSS.t50 17.0005
R1214 VSS.n223 VSS.t50 17.0005
R1215 VSS.n225 VSS.t50 17.0005
R1216 VSS.n227 VSS.t50 17.0005
R1217 VSS.n228 VSS.t50 17.0005
R1218 VSS.n235 VSS.n215 14.7571
R1219 VSS.n284 VSS.n193 14.7571
R1220 VSS.n238 VSS.t189 14.7571
R1221 VSS.n237 VSS.n236 14.7571
R1222 VSS.n170 VSS.n177 14.7571
R1223 VSS.n192 VSS.t289 14.5919
R1224 VSS.n292 VSS.n291 14.0371
R1225 VSS.t82 VSS.n238 13.5005
R1226 VSS.n232 VSS.n175 13.5005
R1227 VSS.n294 VSS.n293 13.5005
R1228 VSS.n235 VSS.t130 13.5005
R1229 VSS.n236 VSS.t265 13.5005
R1230 VSS.n284 VSS.t16 13.5005
R1231 VSS.n283 VSS.n177 13.5005
R1232 VSS.t12 VSS.n285 13.5005
R1233 VSS.t315 VSS.n183 11.6737
R1234 VSS.t39 VSS.n221 11.6737
R1235 VSS.n243 VSS.t277 11.6737
R1236 VSS.t320 VSS.n197 11.6737
R1237 VSS.n254 VSS.t157 11.6737
R1238 VSS.n274 VSS.t263 11.6737
R1239 VSS.t152 VSS.t273 8.75536
R1240 VSS.t345 VSS.n200 8.75536
R1241 VSS.t383 VSS.n196 8.75536
R1242 VSS.n169 VSS.t120 0.102289
R1243 VSS.n135 VSS.n149 2.33253
R1244 VSS.t21 VSS.n174 0.910506
R1245 VSS.t130 VSS.n173 0.432025
R1246 VSS.t113 VSS.n97 1.09427
R1247 VSS.n172 VSS.t59 0.785272
R1248 VSS.t50 VSS.n171 0.628027
R1249 VSS.t50 VSS.n198 8.47111
R1250 VSS.t405 VSS.n219 5.83708
R1251 VSS.n255 VSS.t359 5.83708
R1252 VSS.n91 VSS.t316 5.41199
R1253 VSS.t50 VSS.n169 3.36039
R1254 VSS.n98 VSS.n114 0.944401
R1255 VSS.n135 VSS.n176 2.12514
R1256 VSS.t50 VSS.t355 2.01988
R1257 VSS.n98 VSS.t105 2.0108
R1258 VSS.t47 VSS.n178 1.97699
R1259 VSS.t47 VSS.n233 1.97699
R1260 VSS.t47 VSS.n180 1.97612
R1261 VSS.t47 VSS.n113 0.410373
R1262 VSS.n164 VSS.n98 0.393599
R1263 VSS.t50 VSS.n195 1.72296
R1264 VSS.t47 VSS.n173 1.36051
R1265 VSS.n194 VSS.t50 1.51792
R1266 VSS.n136 VSS.n135 0.0135733
R1267 VSS.n285 VSS.n136 15.4865
R1268 VSS.n136 VSS.t193 1.48207
R1269 VSS.n134 VSS.t191 1.4652
R1270 VSS.n137 VSS.n292 15.4472
R1271 VSS.n215 VSS.n134 1.44847
R1272 VSS.n86 VSS.n283 1.43241
R1273 VSS.t119 VSS.n86 1.41793
R1274 VSS.n137 VSS.n135 0.0345359
R1275 VSS.n98 VSS.n100 0.467139
R1276 VSS.t68 VSS.n96 1.36247
R1277 VSS.n98 VSS.n99 0.539758
R1278 VSS.t164 VSS.n99 0.27148
R1279 VSS.n293 VSS.n133 1.34409
R1280 VSS.n96 VSS.t295 1.34216
R1281 VSS.t191 VSS.n133 1.33256
R1282 VSS.n234 VSS.t224 1.32689
R1283 VSS.t130 VSS.n234 1.32451
R1284 VSS.t193 VSS.n132 1.31447
R1285 VSS.n93 VSS.t308 1.31381
R1286 VSS.n215 VSS.n132 1.30416
R1287 VSS.n95 VSS.t111 1.30276
R1288 VSS.n97 VSS.n170 1.31367
R1289 VSS.n291 VSS.t75 1.27169
R1290 VSS.n294 VSS.n175 1.25714
R1291 VSS.n238 VSS.n175 1.25714
R1292 VSS.n236 VSS.n235 1.25714
R1293 VSS.n292 VSS.n177 1.25714
R1294 VSS.n285 VSS.n284 1.25714
R1295 VSS.t189 VSS.n94 1.25613
R1296 VSS.n92 VSS.n237 1.24936
R1297 VSS.t59 VSS.t197 1.21968
R1298 VSS.t45 VSS.n85 1.21591
R1299 VSS.n98 VSS.n212 1.20586
R1300 VSS.n95 VSS.n193 1.20008
R1301 VSS.t176 VSS.t87 1.19986
R1302 VSS.t107 VSS.n93 1.197
R1303 VSS.t197 VSS.t311 1.18776
R1304 VSS.t270 VSS.t340 1.16934
R1305 VSS.n293 VSS.t99 1.16785
R1306 VSS.n16 VSS.t29 1.15841
R1307 VSS.n10 VSS.t92 1.15841
R1308 VSS.n19 VSS.t62 1.15792
R1309 VSS.n283 VSS.n85 1.13959
R1310 VSS.t14 VSS.t19 1.13902
R1311 VSS.n83 VSS.t183 1.12087
R1312 VSS.t7 VSS.n1 1.11012
R1313 VSS.t200 VSS.t89 1.10972
R1314 VSS.t109 VSS.n92 1.10161
R1315 VSS.t143 VSS.t154 1.10032
R1316 VSS.t103 VSS.n94 1.09755
R1317 VSS.n83 VSS.t45 1.09717
R1318 VSS.t64 VSS.n19 1.09072
R1319 VSS.n16 VSS.t27 1.09058
R1320 VSS.t89 VSS.n10 1.09058
R1321 VSS.n100 VSS.t109 0.988984
R1322 VSS.n258 VSS.t270 1.07661
R1323 VSS.t200 VSS.t10 1.07605
R1324 VSS.n174 VSS.t92 1.04866
R1325 VSS.n1 VSS.t211 1.06521
R1326 VSS.t161 VSS.n258 1.04986
R1327 VSS.t340 VSS.t14 1.04865
R1328 VSS.t10 VSS.n184 1.04744
R1329 VSS.t53 VSS.n207 1.04713
R1330 VSS.n64 VSS.t161 1.0465
R1331 VSS.t19 VSS.t1 1.04615
R1332 VSS.t330 VSS.n64 1.03564
R1333 VSS.n272 VSS.t33 1.03403
R1334 VSS.t41 VSS.n272 1.03145
R1335 VSS.n172 VSS.t79 1.08369
R1336 VSS.n184 VSS.t12 1.01733
R1337 VSS.t43 VSS.t183 1.00958
R1338 VSS.t43 VSS.t41 1.00732
R1339 VSS.n98 VSS.n213 0.969653
R1340 VSS.n237 VSS.n214 0.950935
R1341 VSS.n214 VSS.t107 0.94533
R1342 VSS.t62 VSS.n218 0.937955
R1343 VSS.t47 VSS.n0 0.530007
R1344 VSS.n138 VSS.t281 21.6277
R1345 VSS.t47 VSS.n17 0.177272
R1346 VSS.n117 VSS.t225 21.6277
R1347 VSS.t47 VSS.n13 0.920926
R1348 VSS.t47 VSS.n12 0.920926
R1349 VSS.t47 VSS.n2 0.920926
R1350 VSS.t47 VSS.n11 0.920926
R1351 VSS.n125 VSS.t404 27.4471
R1352 VSS.t47 VSS.n3 0.920926
R1353 VSS.t47 VSS.n4 0.796629
R1354 VSS.n115 VSS.t236 50.0905
R1355 VSS.t47 VSS.n5 0.289196
R1356 VSS.t47 VSS.n8 0.920926
R1357 VSS.t47 VSS.n7 0.920926
R1358 VSS.t47 VSS.n6 0.920926
R1359 VSS.n119 VSS.t229 50.0906
R1360 VSS.t47 VSS.n28 0.289194
R1361 VSS.n122 VSS.t54 27.4471
R1362 VSS.t47 VSS.n26 0.478407
R1363 VSS.t47 VSS.n25 0.920926
R1364 VSS.t47 VSS.n23 0.920926
R1365 VSS.t47 VSS.n24 0.839631
R1366 VSS.t50 VSS.n52 0.920926
R1367 VSS.t50 VSS.n51 0.920926
R1368 VSS.t50 VSS.n31 0.920926
R1369 VSS.t50 VSS.n32 0.839632
R1370 VSS.t50 VSS.n50 0.547215
R1371 VSS.t50 VSS.n49 0.822414
R1372 VSS.n104 VSS.t396 181.661
R1373 VSS.t50 VSS.n33 0.920926
R1374 VSS.t50 VSS.n34 0.920926
R1375 VSS.t50 VSS.n48 0.920926
R1376 VSS.t50 VSS.n35 0.920926
R1377 VSS.t50 VSS.n36 0.920926
R1378 VSS.t50 VSS.n37 0.920926
R1379 VSS.t50 VSS.n47 0.920926
R1380 VSS.t50 VSS.n38 0.920926
R1381 VSS.t50 VSS.n39 0.920926
R1382 VSS.t50 VSS.n46 0.920926
R1383 VSS.t50 VSS.n45 0.920926
R1384 VSS.t50 VSS.n44 0.920926
R1385 VSS.t50 VSS.n81 0.920926
R1386 VSS.t50 VSS.n80 0.920926
R1387 VSS.t50 VSS.n79 0.920926
R1388 VSS.t50 VSS.n78 0.920926
R1389 VSS.t50 VSS.n77 0.920926
R1390 VSS.t50 VSS.n76 0.920926
R1391 VSS.t50 VSS.n75 0.920926
R1392 VSS.t50 VSS.n74 0.920926
R1393 VSS.t50 VSS.n73 0.920926
R1394 VSS.t50 VSS.n72 0.920926
R1395 VSS.t50 VSS.n71 0.920926
R1396 VSS.t50 VSS.n70 0.920926
R1397 VSS.t50 VSS.n69 0.920926
R1398 VSS.t50 VSS.n68 0.920926
R1399 VSS.t50 VSS.n67 0.920926
R1400 VSS.t50 VSS.n66 0.920926
R1401 VSS.t50 VSS.n65 0.920926
R1402 VSS.n148 VSS.t37 193.299
R1403 VSS.t50 VSS.n63 0.920926
R1404 VSS.t50 VSS.n62 0.920926
R1405 VSS.t50 VSS.n61 0.920926
R1406 VSS.t50 VSS.n60 0.920926
R1407 VSS.t50 VSS.n59 0.920926
R1408 VSS.t50 VSS.n58 0.920926
R1409 VSS.t50 VSS.n57 0.920926
R1410 VSS.t50 VSS.n56 0.920926
R1411 VSS.t50 VSS.n55 0.920926
R1412 VSS.t50 VSS.n54 0.920926
R1413 VSS.t50 VSS.n53 0.920926
R1414 VSS.t50 VSS.n82 0.0663857
R1415 VSS.t50 VSS.n87 0.530008
R1416 VSS.t50 VSS.n84 0.317806
R1417 VSS.t50 VSS.n40 0.920926
R1418 VSS.t50 VSS.n41 0.920926
R1419 VSS.t50 VSS.n42 0.920926
R1420 VSS.t50 VSS.n43 0.920926
R1421 VSS.n141 VSS.t50 0.318008
R1422 VSS.n130 VSS.t50 0.0667429
R1423 VSS.n220 VSS.t50 0.920926
R1424 VSS.n224 VSS.t50 0.920926
R1425 VSS.n226 VSS.t50 0.920926
R1426 VSS.n229 VSS.t50 0.920926
R1427 VSS.n199 VSS.t265 0.912413
R1428 VSS.n164 VSS.t101 0.491477
R1429 VSS.t115 VSS.n171 0.736448
R1430 VSS.t143 VSS.t53 0.859966
R1431 VSS.t29 VSS.n182 0.858871
R1432 VSS.n211 VSS.t68 0.842234
R1433 VSS.t176 VSS.n232 0.835198
R1434 VSS.t125 VSS.n113 0.457751
R1435 VSS.n98 VSS.n211 0.808242
R1436 VSS.t47 VSS.t176 0.800206
R1437 VSS.n151 VSS.t74 0.444075
R1438 VSS.n207 VSS.t79 0.748314
R1439 VSS.t82 VSS.n171 0.911978
R1440 VSS.n113 VSS.n232 1.04787
R1441 VSS.n182 VSS.t12 0.731314
R1442 VSS.t189 VSS.n164 1.07973
R1443 VSS.t50 VSS.n199 0.727742
R1444 VSS.t295 VSS.n212 0.725625
R1445 VSS.t187 VSS.n100 0.312425
R1446 VSS.n199 VSS.t154 0.703662
R1447 VSS.t47 VSS.n182 0.674975
R1448 VSS.t50 VSS.n172 0.567904
R1449 VSS.n99 VSS.n193 0.945704
R1450 VSS.n98 VSS.n214 0.663037
R1451 VSS.t50 VSS.t143 0.66264
R1452 VSS.t111 VSS.n211 0.653586
R1453 VSS.n218 VSS.t87 0.632603
R1454 VSS.n212 VSS.n170 0.623184
R1455 VSS.t16 VSS.n194 0.621455
R1456 VSS.n213 VSS.t113 0.613952
R1457 VSS.n194 VSS.t330 0.555034
R1458 VSS.t50 VSS.n272 0.552523
R1459 VSS.t47 VSS.n218 0.552278
R1460 VSS.t50 VSS.n207 0.552232
R1461 VSS.n173 VSS.t21 0.640377
R1462 VSS.t50 VSS.n64 0.505849
R1463 VSS.t50 VSS.t19 0.504952
R1464 VSS.t47 VSS.n184 0.480425
R1465 VSS.n233 VSS.t64 0.474506
R1466 VSS.t211 VSS.n178 0.474506
R1467 VSS.t27 VSS.n180 0.473336
R1468 VSS.t33 VSS.n195 0.472915
R1469 VSS.t16 VSS.n195 0.470023
R1470 VSS.t47 VSS.n174 0.392272
R1471 VSS.t115 VSS.t355 0.454918
R1472 VSS.t105 VSS.t308 0.454257
R1473 VSS.t50 VSS.t43 0.441683
R1474 VSS.n180 VSS.t7 0.439002
R1475 VSS.n233 VSS.t224 0.43798
R1476 VSS.n178 VSS.t75 0.43798
R1477 VSS.t105 VSS.t103 0.434625
R1478 VSS.t47 VSS.n1 0.426096
R1479 VSS.t50 VSS.n258 0.423639
R1480 VSS.t47 VSS.n16 0.391165
R1481 VSS.t47 VSS.n10 0.391165
R1482 VSS.t47 VSS.n19 0.391023
R1483 VSS.t47 VSS.t200 0.388167
R1484 VSS.t50 VSS.n83 0.355502
R1485 VSS.t134 VSS.n149 0.219251
R1486 VSS.t99 VSS.n135 0.309673
R1487 VSS.t50 VSS.t340 0.299882
R1488 VSS.t197 VSS.t50 0.275574
R1489 VSS.t50 VSS.n85 0.275182
R1490 VSS.n98 VSS.n97 0.185106
R1491 VSS.n98 VSS.n95 0.199973
R1492 VSS.n291 VSS.t47 0.199648
R1493 VSS.n98 VSS.n94 0.182187
R1494 VSS.n146 VSS.t380 17.4821
R1495 VSS.n169 VSS.t119 0.0971505
R1496 VSS.n98 VSS.n92 0.167239
R1497 VSS.n234 VSS.t47 0.153214
R1498 VSS.n135 VSS.n132 0.133127
R1499 VSS.n149 VSS.t133 0.216499
R1500 VSS.n135 VSS.n133 0.113437
R1501 VSS.t1 VSS.n198 0.093289
R1502 VSS.t265 VSS.n198 0.090789
R1503 VSS.n137 VSS.t133 1.44695
R1504 VSS.n98 VSS.n96 0.070981
R1505 VSS.t311 VSS.n239 0.06675
R1506 VSS.t50 VSS.n86 0.0562993
R1507 VSS.n0 VSS.t241 75.8049
R1508 VSS.t47 VSS.n18 0.0509534
R1509 VSS.t47 VSS.n15 0.0509534
R1510 VSS.t47 VSS.n109 0.530007
R1511 VSS.t47 VSS.n9 0.0509534
R1512 VSS.t47 VSS.n20 0.0509534
R1513 VSS.t47 VSS.n21 0.0509534
R1514 VSS.t47 VSS.n27 0.0509534
R1515 VSS.t47 VSS.n22 0.0509534
R1516 VSS.t47 VSS.t126 77.3813
R1517 VSS.n111 VSS.t50 0.530007
R1518 VSS.n239 VSS.t82 0.0505
R1519 VSS.n213 VSS.t203 0.0339057
R1520 VSS VSS.n294 0.01986
R1521 VSS.n135 VSS.n134 0.0185773
R1522 VSS.n142 VSS.t195 9.61805
R1523 VSS.n98 VSS.n93 0.214249
R1524 VSS.t50 VSS.n89 0.205163
R1525 VSS.t50 VSS.n88 0.191602
R1526 VSS.t47 VSS.n14 0.173005
R1527 VSS.n29 VSS.t91 156.245
R1528 sg13g2_hv_a21oi_1_1.B1.n0 sg13g2_hv_a21oi_1_1.B1 33.6548
R1529 sg13g2_hv_a21oi_1_1.B1.n3 sg13g2_hv_a21oi_1_1.B1.n2 30.4227
R1530 sg13g2_hv_a21oi_1_1.B1.n2 sg13g2_hv_a21oi_1_1.B1.n1 28.0085
R1531 sg13g2_hv_a21oi_1_1.B1.n4 sg13g2_hv_a21oi_1_1.B1.n3 24.4181
R1532 sg13g2_hv_a21oi_1_1.B1 sg13g2_hv_a21oi_1_1.B1.n4 22.7075
R1533 sg13g2_hv_a21oi_1_1.B1.n4 sg13g2_hv_a21oi_1_1.B1 20.3225
R1534 sg13g2_hv_a21oi_1_1.B1.n1 sg13g2_hv_a21oi_1_1.B1 18.9743
R1535 sg13g2_hv_a21oi_1_1.B1 sg13g2_hv_a21oi_1_1.B1.t4 15.2105
R1536 sg13g2_hv_a21oi_1_1.B1 sg13g2_hv_a21oi_1_1.B1.t2 15.2105
R1537 sg13g2_hv_a21oi_1_1.B1 sg13g2_hv_a21oi_1_1.B1.t3 15.2105
R1538 sg13g2_hv_a21oi_1_1.B1 sg13g2_hv_a21oi_1_1.B1.t1 15.0005
R1539 sg13g2_hv_a21oi_1_1.B1.n1 sg13g2_hv_a21oi_1_1.B1.n0 14.8935
R1540 sg13g2_hv_a21oi_1_1.B1.n2 sg13g2_hv_a21oi_1_1.B1 9.71906
R1541 sg13g2_hv_a21oi_1_1.B1.n3 sg13g2_hv_a21oi_1_1.B1 9.2105
R1542 sg13g2_hv_a21oi_1_1.B1.n0 sg13g2_hv_a21oi_1_1.B1 9.0005
R1543 sg13g2_hv_a21oi_1_1.B1 sg13g2_hv_a21oi_1_1.B1.t0 5.9142
C0 a_9352_8900# sg13g2_hv_dfrbpq_1_1.CLK 0.01569f
C1 a_28513_11551# a_28679_11694# 0.59728f
C2 VDD a_27496_8900# 0.26059f
C3 sg13g2_hv_a21oi_1_0.Y sg13g2_hv_tiehi_0.L_HI 0.22302f
C4 a_10120_8900# a_10888_8900# 0.11571f
C5 sg13g2_hv_nand2b_1_0.Y sg13g2_hv_nand2b_1_1.Y 0.24749f
C6 VDD a_37192_13304# 0.32404f
C7 sg13g2_hv_a21oi_1_1.B1 a_12136_7592# 0.02272f
C8 a_34216_10448# a_34984_10448# 0.11571f
C9 a_29063_8838# sg13g2_hv_dfrbpq_1_7.RESET_B 0.21007f
C10 sg13g2_hv_tiehi_1.L_HI a_6376_6044# 0.03935f
C11 sg13g2_hv_dfrbpq_1_0.CLK a_28208_9261# 0.08901f
C12 a_7847_7412# a_6470_8336# 0.28559f
C13 a_27686_8716# sg13g2_hv_a21oi_1_5.Y 0.24805f
C14 a_21385_7443# sg13g2_hv_o21ai_1_0.A2 0.27239f
C15 a_6902_7309# sg13g2_hv_tiehi_1.L_HI 0.44203f
C16 sg13g2_hv_nand3_1_1.A a_22230_11632# 0.01819f
C17 sg13g2_hv_tiehi_3.L_HI a_11329_11551# 0.11985f
C18 sg13g2_hv_or3_1_1.B sg13g2_hv_or3_1_1.A 0.28198f
C19 sg13g2_hv_tiehi_1.L_HI a_8843_8259# 0.16389f
C20 sg13g2_hv_or3_1_3.A VDD 2.89435f
C21 a_3815_11694# a_2438_11572# 0.28559f
C22 a_10550_11795# sg13g2_hv_nand4_1_0.Y 0.03007f
C23 sg13g2_hv_or3_1_1.B a_22216_13304# 0.07816f
C24 sg13g2_hv_o21ai_1_0.B1 sg13g2_hv_tiehi_0.L_HI 0.18426f
C25 a_2522_10879# a_3976_10448# 0.01996f
C26 sg13g2_hv_nand2b_1_0.B sg13g2_hv_nand3_1_0.Y 0.51276f
C27 a_9337_7966# sg13g2_hv_tiehi_1.L_HI 0.2166f
C28 sg13g2_hv_nand2_1_2.Y a_3041_10242# 0.02246f
C29 VDD a_26248_11756# 0.94923f
C30 a_15629_7443# a_15043_8026# 0.03807f
C31 VDD a_27400_6044# 0.94145f
C32 VDD a_23821_9213# 0.01255f
C33 a_31240_6044# a_31144_7592# 0.01675f
C34 sg13g2_hv_a21oi_1_2.A1 sg13g2_hv_a21oi_1_2.A2 0.23549f
C35 a_28208_9261# a_30059_8793# 0.01632f
C36 sg13g2_hv_or3_1_1.B a_15514_8764# 0.05837f
C37 sg13g2_hv_nand2b_1_0.B sg13g2_hv_tiehi_5.L_HI 0.17837f
C38 a_18376_13304# a_19144_13304# 0.11571f
C39 a_18311_11694# a_17456_12117# 0.26366f
C40 sg13g2_hv_a21oi_1_2.A1 sg13g2_hv_a21oi_1_1.B1 0.14004f
C41 sg13g2_hv_and2_1_0.B sg13g2_hv_nand3_1_0.Y 0.17671f
C42 VDD a_8589_11050# 0.60131f
C43 a_27083_8259# sg13g2_hv_tiehi_0.L_HI 0.16389f
C44 sg13g2_hv_nand2b_1_2.Y sg13g2_hv_nand2_1_1.Y 0.20551f
C45 sg13g2_hv_or3_1_3.A a_33352_8900# 0.01319f
C46 VDD a_32776_6044# 1.01974f
C47 a_2438_11572# a_2960_12117# 0.25017f
C48 a_30059_8793# a_31269_9212# 0.25683f
C49 sg13g2_hv_or3_1_1.B a_20584_8900# 0.01238f
C50 a_15976_7592# sg13g2_hv_a21oi_1_2.Y 0.02096f
C51 sg13g2_hv_tiehi_3.L_HI sg13g2_hv_nand4_1_0.Y 0.5902f
C52 a_14632_10448# sg13g2_hv_buf_16_0.A 0.06604f
C53 sg13g2_hv_o21ai_1_0.Y sg13g2_hv_o21ai_1_0.A2 0.17104f
C54 a_35272_11756# a_35272_13304# 0.01947f
C55 a_27302_11572# a_28679_11694# 0.28559f
C56 sg13g2_hv_tiehi_4.L_HI sg13g2_hv_dfrbpq_1_0.CLK 0.04541f
C57 VDD a_17473_7412# 0.93278f
C58 VDD a_10118_11572# 0.78074f
C59 sg13g2_hv_o21ai_1_0.B1 sg13g2_hv_a21oi_1_0.Y 1.12978f
C60 sg13g2_hv_a21oi_1_4.Y sg13g2_hv_a21oi_1_1.B1 0.22958f
C61 sg13g2_hv_nand2b_1_0.B sg13g2_hv_nand4_1_0.Y 0.24248f
C62 VDD a_4456_13304# 0.94453f
C63 a_37192_8900# a_37288_7592# 0.0222f
C64 a_4811_11649# sg13g2_hv_tiehi_5.L_HI 0.16507f
C65 a_29224_13304# a_29992_13304# 0.11571f
C66 a_24520_13304# a_25288_13304# 0.11571f
C67 sg13g2_hv_o21ai_1_0.B1 a_21536_8900# 0.04958f
C68 a_21448_13304# counter_value_o[4] 0.0159f
C69 sg13g2_hv_nand3_1_1.A a_22312_8900# 0.0745f
C70 VDD sg13g2_hv_buf_1_9.X 1.47962f
C71 a_10312_13304# a_11080_13304# 0.11571f
C72 a_8776_13304# sg13g2_hv_nand4_1_0.C 0.01224f
C73 VDD a_12985_11792# 0.36332f
C74 sg13g2_hv_nand3_1_1.A a_18145_11551# 0.05535f
C75 a_21256_6044# a_22024_6044# 0.11571f
C76 sg13g2_hv_and2_1_0.B sg13g2_hv_nand4_1_0.Y 0.04621f
C77 VDD a_24334_10242# 5.06682f
C78 a_21064_11756# sg13g2_hv_dfrbpq_1_0.CLK 0.03933f
C79 a_16784_7395# sg13g2_hv_or3_1_1.C 0.06009f
C80 a_16744_8900# a_17512_8900# 0.11571f
C81 sg13g2_hv_tiehi_0.L_HI a_25232_7395# 0.55757f
C82 sg13g2_hv_a21oi_1_0.A2 sg13g2_hv_a21oi_1_0.Y 0.02189f
C83 sg13g2_hv_nand2b_1_0.B a_7646_11632# 0.01723f
C84 VDD a_34504_11756# 0.94102f
C85 a_17326_10242# clock_i 1.06453f
C86 a_28513_11551# VDD 0.93625f
C87 a_26728_8900# a_27496_8900# 0.11571f
C88 sg13g2_hv_a21oi_1_1.B1 sg13g2_hv_dfrbpq_1_0.CLK 0.69258f
C89 sg13g2_hv_o21ai_1_0.B1 a_27083_8259# 0.12715f
C90 a_2604_13011# a_2336_13304# 0.02644f
C91 VDD sg13g2_hv_and2_1_0.X 0.44567f
C92 sg13g2_hv_o21ai_1_0.B1 sg13g2_hv_a21oi_1_0.A2 0.10174f
C93 a_25921_7412# sg13g2_hv_dfrbpq_1_0.CLK 0.39569f
C94 VDD a_29063_8838# 0.71828f
C95 sg13g2_hv_or3_1_1.A sg13g2_hv_buf_16_0.A 0.01968f
C96 a_2621_11072# sg13g2_hv_buf_1_9.X 0.01593f
C97 sg13g2_hv_or3_1_3.A a_26728_8900# 0.03695f
C98 a_13000_6044# a_13768_6044# 0.11571f
C99 a_35272_13304# a_36040_13304# 0.11571f
C100 sg13g2_hv_o21ai_1_0.B1 a_29608_7592# 0.01018f
C101 sg13g2_hv_a21oi_1_2.A1 a_15680_9260# 0.01897f
C102 VDD sg13g2_hv_nand2b_1_0.Y 0.4738f
C103 a_10600_7592# a_11368_7592# 0.11571f
C104 a_17945_11585# a_17456_12117# 0.35847f
C105 a_4744_10448# sg13g2_hv_xnor2_1_1.A 0.06737f
C106 a_27577_7966# a_28293_7386# 0.11973f
C107 a_26087_7412# a_26925_8259# 0.01699f
C108 a_28697_8729# a_28208_9261# 0.35847f
C109 VDD sg13g2_hv_a21oi_1_5.A1 0.76643f
C110 sg13g2_hv_a21oi_1_5.Y a_25192_8900# 0.10923f
C111 a_32392_13098# sg13g2_hv_or3_1_3.A 0.40419f
C112 a_24520_13304# VDD 0.94156f
C113 a_29224_13304# VDD 0.94423f
C114 VDD a_22312_8900# 1.07154f
C115 VDD a_17224_13304# 0.34134f
C116 VDD a_21256_6044# 0.95211f
C117 a_28293_7386# a_28840_7592# 0.02946f
C118 a_29901_8793# a_30059_8793# 0.30349f
C119 VDD a_18145_11551# 0.93434f
C120 VDD a_37384_6044# 1.01146f
C121 a_17326_10242# a_20968_10448# 0.03513f
C122 a_34504_11756# a_34216_10448# 0.015f
C123 sg13g2_hv_nand2b_1_0.B a_7681_7412# 0.07471f
C124 a_2438_11572# sg13g2_hv_buf_1_9.X 0.01173f
C125 sg13g2_hv_or3_1_1.C a_16262_8336# 0.01858f
C126 a_25480_11756# a_26248_11756# 0.11571f
C127 a_24821_12068# sg13g2_hv_o21ai_1_1.B1 0.01433f
C128 a_10053_7386# a_10600_7592# 0.02946f
C129 sg13g2_hv_nand2b_1_0.B counter_value_o[0] 0.03412f
C130 sg13g2_hv_o21ai_1_0.B1 a_25232_7395# 0.0785f
C131 a_27302_11572# VDD 0.78067f
C132 VDD a_13000_6044# 1.01723f
C133 sg13g2_hv_or3_1_1.C a_23272_10448# 0.10807f
C134 VDD a_35272_13304# 0.94432f
C135 a_26632_6044# a_27400_6044# 0.11571f
C136 VDD a_10600_7592# 0.97325f
C137 sg13g2_hv_nand2b_1_0.B sg13g2_hv_buf_1_0.X 0.82366f
C138 a_8008_13304# sg13g2_hv_xnor2_1_1.A 0.10477f
C139 a_37576_11756# a_37288_10448# 0.015f
C140 a_21385_7443# a_21709_7443# 0.02494f
C141 a_6376_6044# a_7136_6044# 0.12205f
C142 sg13g2_hv_or3_1_1.B a_21736_10448# 0.09877f
C143 a_6902_7309# a_6992_7395# 0.47124f
C144 a_22408_13098# a_22984_13304# 0.02578f
C145 sg13g2_hv_or3_1_1.B a_21536_8900# 0.01021f
C146 a_27083_8259# a_25232_7395# 0.01632f
C147 a_3649_11551# a_3449_11585# 0.02842f
C148 a_6992_7395# a_8843_8259# 0.01632f
C149 sg13g2_hv_a21oi_1_1.B1 a_14056_7592# 0.05668f
C150 VDD a_6376_6044# 0.93943f
C151 sg13g2_hv_a21oi_1_1.B1 a_15893_12068# 0.02797f
C152 a_6902_7309# VDD 0.41487f
C153 a_8843_8259# a_10053_7386# 0.25683f
C154 sg13g2_hv_dfrbpq_1_1.CLK sg13g2_hv_tiehi_2.L_HI 0.08172f
C155 a_32008_6044# a_32776_6044# 0.11571f
C156 a_24334_10242# a_26728_8900# 0.02136f
C157 sg13g2_hv_or3_1_1.B sg13g2_hv_o21ai_1_0.B1 1.57645f
C158 a_7681_7412# a_7847_7412# 0.60436f
C159 a_18635_8259# sg13g2_hv_tiehi_2.L_HI 0.16389f
C160 a_36520_10448# a_36808_11756# 0.015f
C161 a_36040_11756# sg13g2_hv_o21ai_1_1.B1 0.05003f
C162 sg13g2_hv_tiehi_5.L_HI a_2870_11795# 0.436f
C163 VDD a_8843_8259# 0.58896f
C164 a_7847_7412# a_8685_8259# 0.01699f
C165 a_9337_7966# a_10053_7386# 0.11973f
C166 sg13g2_hv_and2_1_1.X sg13g2_hv_buf_1_9.X 0.07021f
C167 VDD a_1773_11050# 0.55583f
C168 a_5813_7386# sg13g2_hv_a21oi_1_1.B1 0.02797f
C169 VDD a_5305_11792# 0.3181f
C170 a_24109_12069# a_23785_11628# 0.02494f
C171 a_5305_11792# a_6021_12068# 0.11973f
C172 a_27208_13304# counter_value_o[5] 0.05896f
C173 a_9337_7966# VDD 0.31823f
C174 sg13g2_hv_nand2b_1_0.B a_4744_8900# 0.03683f
C175 VDD a_34216_7592# 0.9415f
C176 VDD a_23080_7592# 1.10168f
C177 a_34216_7592# a_34984_7592# 0.11571f
C178 sg13g2_hv_dfrbpq_1_1.CLK a_15043_8026# 0.02468f
C179 a_15400_10448# VDD 0.21628f
C180 a_25480_11756# a_24334_10242# 0.02897f
C181 sg13g2_hv_o21ai_1_0.Y sg13g2_hv_a21oi_1_1.B1 0.07375f
C182 a_17326_10242# sg13g2_hv_a21oi_1_1.B1 0.06318f
C183 a_32584_8900# VDD 1.01986f
C184 a_15400_10448# a_15584_10448# 0.12205f
C185 sg13g2_hv_or3_1_1.B sg13g2_hv_a21oi_1_2.Y 0.01187f
C186 a_25142_7309# a_25921_7412# 0.12012f
C187 a_16784_7395# a_17473_7412# 0.51508f
C188 sg13g2_hv_nand2_1_1.Y a_15893_12068# 0.0896f
C189 a_30760_13304# sg13g2_hv_o21ai_1_1.B1 0.01158f
C190 sg13g2_hv_or3_1_3.A a_28897_8695# 0.05266f
C191 sg13g2_hv_nand2b_1_0.B a_2960_12117# 0.09159f
C192 a_11080_13304# sg13g2_hv_tiehi_3.L_HI 0.0283f
C193 sg13g2_hv_nand4_1_0.C a_8654_11628# 0.02951f
C194 a_14632_10448# sg13g2_hv_or3_1_1.C 0.10619f
C195 sg13g2_hv_o21ai_1_0.B1 a_28118_8939# 0.0231f
C196 VDD a_3208_8900# 1.03709f
C197 VDD sg13g2_hv_xnor2_1_1.Y 0.69749f
C198 a_36424_8900# a_36520_7592# 0.0222f
C199 a_16784_7395# a_17273_8323# 0.35847f
C200 a_3815_11694# a_4811_11649# 0.39137f
C201 a_3688_13304# a_4456_13304# 0.11571f
C202 a_24710_8336# sg13g2_hv_a21oi_1_1.B1 0.01995f
C203 sg13g2_hv_tiehi_5.L_HI a_3200_13304# 0.02062f
C204 VDD a_9352_8900# 0.94199f
C205 a_32584_8900# a_33352_8900# 0.11571f
C206 VDD a_33448_10448# 0.95312f
C207 VDD a_23604_10194# 0.02569f
C208 VDD a_6280_10448# 1.00804f
C209 sg13g2_hv_buf_1_0.X a_5512_10448# 0.01573f
C210 sg13g2_hv_dfrbpq_1_1.CLK sg13g2_hv_a21oi_1_2.A2 0.04668f
C211 sg13g2_hv_a21oi_1_1.B1 sg13g2_hv_dfrbpq_1_1.CLK 3.42092f
C212 a_24710_8336# a_25921_7412# 0.09592f
C213 sg13g2_hv_o21ai_1_0.Y a_20820_7338# 0.01897f
C214 a_1192_10242# sg13g2_hv_buf_1_9.X 0.34845f
C215 VDD a_13701_12068# 0.58739f
C216 sg13g2_hv_a21oi_1_1.B1 a_11656_8900# 0.02062f
C217 a_8654_11628# a_8327_12110# 0.36475f
C218 a_12491_11649# a_12985_11792# 0.44368f
C219 VDD a_15112_8900# 0.33846f
C220 sg13g2_hv_a21oi_1_4.Y sg13g2_hv_dfrbpq_1_0.CLK 0.02993f
C221 sg13g2_hv_nand4_1_1.Y a_21832_11756# 0.03216f
C222 a_4811_11649# a_2960_12117# 0.01632f
C223 sg13g2_hv_nand2b_1_2.Y a_15893_12068# 0.18357f
C224 sg13g2_hv_buf_16_0.A a_21736_10448# 0.07082f
C225 a_37960_13304# counter_value_o[7] 0.08153f
C226 a_33352_8900# a_33448_10448# 0.01675f
C227 a_3208_8900# a_3976_8900# 0.11571f
C228 a_10550_11795# a_10118_11572# 0.47309f
C229 a_27824_12117# a_28313_11585# 0.35847f
C230 sg13g2_hv_dfrbpq_1_4.RESET_B a_24334_10242# 0.02204f
C231 a_2621_11072# sg13g2_hv_xnor2_1_1.Y 0.01505f
C232 sg13g2_hv_o21ai_1_0.B1 sg13g2_hv_a21oi_1_5.Y 0.1639f
C233 VDD sg13g2_hv_nand2_1_2.Y 1.49585f
C234 sg13g2_hv_nand3_1_1.A sg13g2_hv_o21ai_1_0.A2 0.3163f
C235 a_9544_13304# VDD 0.94315f
C236 a_17473_7412# a_16262_8336# 0.09592f
C237 a_33736_11756# a_34504_11756# 0.11571f
C238 sg13g2_hv_dfrbpq_1_4.RESET_B a_28513_11551# 0.12789f
C239 sg13g2_hv_o21ai_1_0.B1 sg13g2_hv_buf_16_0.A 0.02915f
C240 VDD a_15976_8900# 0.9914f
C241 sg13g2_hv_or3_1_3.A a_27686_8716# 0.03878f
C242 a_29675_11649# a_29517_11649# 0.30349f
C243 a_27824_12117# a_28513_11551# 0.51401f
C244 sg13g2_hv_or3_1_1.A sg13g2_hv_or3_1_1.C 0.9804f
C245 VDD a_25960_8900# 0.942f
C246 a_31528_13304# counter_value_o[6] 0.01979f
C247 sg13g2_hv_or3_1_1.B a_19845_7386# 0.18553f
C248 a_9352_8900# a_10120_8900# 0.11571f
C249 a_28208_9261# sg13g2_hv_dfrbpq_1_7.RESET_B 0.53287f
C250 a_17273_8323# a_16262_8336# 0.2572f
C251 a_33448_10448# a_34216_10448# 0.11571f
C252 sg13g2_hv_buf_1_0.X enable_i 0.01466f
C253 a_8654_11628# sg13g2_hv_nand3_1_0.Y 0.02109f
C254 a_18635_8259# a_18477_8259# 0.30349f
C255 sg13g2_hv_tiehi_3.L_HI a_10118_11572# 0.29569f
C256 a_28679_11694# a_30169_11792# 0.08792f
C257 sg13g2_hv_tiehi_4.L_HI a_19307_11649# 0.165f
C258 a_6470_8336# a_7621_7498# 0.01695f
C259 sg13g2_hv_and2_1_1.X a_1773_11050# 0.16223f
C260 a_27968_13304# VDD 0.16358f
C261 VDD a_2336_11756# 0.21685f
C262 sg13g2_hv_and2_1_0.B a_8589_11050# 0.28229f
C263 a_2604_13011# a_3016_13304# 0.02109f
C264 a_15514_8764# sg13g2_hv_or3_1_1.C 0.11296f
C265 a_17639_7412# sg13g2_hv_tiehi_2.L_HI 0.21254f
C266 a_22408_13098# a_21448_13304# 0.01605f
C267 a_5115_7520# sg13g2_hv_buf_1_0.X 0.39596f
C268 sg13g2_hv_nand3_1_1.A clock_i 0.18885f
C269 a_17326_10242# a_19816_8900# 0.02098f
C270 sg13g2_hv_or3_1_1.C sg13g2_hv_o21ai_1_1.B1 0.58834f
C271 a_2522_10879# a_3527_11050# 0.03534f
C272 sg13g2_hv_nand2_1_2.Y a_2621_11072# 0.02025f
C273 sg13g2_hv_tiehi_3.L_HI a_12985_11792# 0.22463f
C274 VDD a_25864_6044# 0.93591f
C275 sg13g2_hv_tiehi_1.L_HI sg13g2_hv_a21oi_1_1.B1 0.09193f
C276 a_28897_8695# a_29063_8838# 0.59728f
C277 a_30472_6044# a_30376_7592# 0.01675f
C278 a_36040_11756# a_36808_11756# 0.11571f
C279 a_29608_10448# sg13g2_hv_o21ai_1_1.B1 0.01652f
C280 a_18311_11694# a_17366_11795# 0.06127f
C281 enable_i a_1192_5950# 0.38635f
C282 VDD a_23785_11628# 0.55664f
C283 sg13g2_hv_nand2b_1_0.B sg13g2_hv_buf_1_9.X 0.10268f
C284 a_26087_7412# sg13g2_hv_tiehi_0.L_HI 0.20596f
C285 sg13g2_hv_a21oi_1_1.B1 a_24533_9212# 0.03853f
C286 sg13g2_hv_or3_1_3.A a_31816_8900# 0.26772f
C287 sg13g2_hv_buf_1_0.X a_7424_10448# 0.0561f
C288 VDD a_31240_6044# 0.95077f
C289 a_22408_13098# counter_value_o[4] 0.37295f
C290 VDD sg13g2_hv_o21ai_1_0.A2 0.79915f
C291 sg13g2_hv_or3_1_1.B a_19048_8900# 0.07669f
C292 a_34312_6044# a_33544_6044# 0.11571f
C293 a_23062_11620# sg13g2_hv_or3_1_1.C 0.13877f
C294 sg13g2_hv_dfrbpq_1_4.RESET_B a_27302_11572# 0.35506f
C295 sg13g2_hv_dfrbpq_1_1.CLK a_12136_7592# 0.05848f
C296 sg13g2_hv_and2_1_0.B sg13g2_hv_buf_1_9.X 0.17189f
C297 a_34504_11756# a_34504_13304# 0.01947f
C298 sg13g2_hv_a21oi_1_1.B1 a_19307_11649# 0.02587f
C299 sg13g2_hv_tiehi_3.L_HI sg13g2_hv_and2_1_0.X 0.36876f
C300 a_27302_11572# a_27824_12117# 0.25017f
C301 sg13g2_hv_and2_1_1.X sg13g2_hv_xnor2_1_1.Y 0.38729f
C302 a_3815_11694# a_2870_11795# 0.06127f
C303 VDD a_37960_8900# 0.93832f
C304 sg13g2_hv_tiehi_2.L_HI a_16694_7309# 0.44203f
C305 sg13g2_hv_nand4_1_1.Y sg13g2_hv_o21ai_1_1.B1 0.42511f
C306 sg13g2_hv_or3_1_3.A a_32680_10448# 0.05139f
C307 VDD a_7596_13011# 0.43914f
C308 a_14427_7386# sg13g2_hv_a21oi_1_2.A2 0.19869f
C309 a_28456_13304# a_29224_13304# 0.11571f
C310 a_23752_13304# a_24520_13304# 0.11571f
C311 a_20968_10448# sg13g2_hv_nand3_1_1.A 0.0843f
C312 a_14427_7386# sg13g2_hv_a21oi_1_1.B1 0.02797f
C313 sg13g2_hv_tiehi_1.L_HI a_7048_8900# 0.01874f
C314 sg13g2_hv_dfrbpq_1_1.D sg13g2_hv_a21oi_1_1.B1 0.33671f
C315 VDD a_16160_7592# 0.14534f
C316 a_4811_11649# sg13g2_hv_buf_1_9.X 0.01197f
C317 a_12588_13011# sg13g2_hv_nand4_1_0.C 0.4145f
C318 a_9544_13304# a_10312_13304# 0.11571f
C319 VDD clock_i 1.97356f
C320 sg13g2_hv_nand3_1_1.A a_16934_11572# 0.09799f
C321 a_20488_6044# a_21256_6044# 0.11571f
C322 VDD sg13g2_hv_o21ai_1_1.Y 0.48716f
C323 sg13g2_hv_nand2b_1_0.B sg13g2_hv_nand2b_1_0.Y 0.32617f
C324 sg13g2_hv_a21oi_1_2.A1 sg13g2_hv_dfrbpq_1_1.CLK 0.02471f
C325 a_17456_12117# a_18145_11551# 0.51401f
C326 a_19149_11649# a_18311_11694# 0.01699f
C327 sg13g2_hv_and2_1_0.B sg13g2_hv_and2_1_0.X 0.13657f
C328 a_15976_8900# a_16744_8900# 0.11571f
C329 a_2870_11795# a_2960_12117# 0.47124f
C330 a_36616_6044# a_37384_6044# 0.11571f
C331 VDD a_32968_11756# 1.01312f
C332 a_27686_8716# a_29063_8838# 0.28559f
C333 sg13g2_hv_or3_1_1.B sg13g2_hv_buf_16_0.A 0.06024f
C334 sg13g2_hv_nand4_1_1.Y a_23062_11620# 0.09506f
C335 a_37384_13098# a_37960_13304# 0.02578f
C336 sg13g2_hv_o21ai_1_1.B1 a_37192_13304# 0.07927f
C337 a_25960_8900# a_26728_8900# 0.11571f
C338 a_15976_7592# sg13g2_hv_or3_1_1.C 0.05856f
C339 sg13g2_hv_nand3_1_1.A sg13g2_hv_tiehi_4.L_HI 0.63386f
C340 a_4811_11649# a_4653_11649# 0.30349f
C341 a_12424_8900# sg13g2_hv_buf_16_0.A 0.01123f
C342 sg13g2_hv_o21ai_1_0.B1 a_26087_7412# 0.06807f
C343 a_30169_11792# VDD 0.3181f
C344 a_20662_8224# sg13g2_hv_o21ai_1_0.A2 0.12495f
C345 a_15195_11666# a_15104_11756# 0.01572f
C346 sg13g2_hv_or3_1_3.A sg13g2_hv_o21ai_1_1.B1 0.06367f
C347 VDD a_28208_9261# 0.38588f
C348 sg13g2_hv_or3_1_3.A a_25192_8900# 0.03915f
C349 a_12232_6044# a_13000_6044# 0.11571f
C350 a_30059_8793# a_31144_7592# 0.01216f
C351 a_34504_13304# a_35272_13304# 0.11571f
C352 sg13g2_hv_nand4_1_0.C a_8327_12110# 0.31348f
C353 a_26248_11756# sg13g2_hv_o21ai_1_1.B1 0.02838f
C354 a_11464_6044# a_11368_7592# 0.01675f
C355 VDD a_4264_7592# 0.23624f
C356 a_3496_7592# sg13g2_hv_buf_1_0.X 0.05723f
C357 sg13g2_hv_nand2b_1_0.B a_10600_7592# 0.09921f
C358 VDD reset_n_i 0.50528f
C359 sg13g2_hv_dfrbpq_1_1.CLK a_11495_11694# 0.06364f
C360 a_26087_7412# a_27083_8259# 0.39137f
C361 VDD a_31269_9212# 0.59181f
C362 VDD a_22504_10448# 1.01068f
C363 sg13g2_hv_dfrbpq_1_1.CLK sg13g2_hv_xnor2_1_1.A 0.25074f
C364 a_20968_10448# VDD 1.00326f
C365 a_21064_11756# sg13g2_hv_nand3_1_1.A 0.20452f
C366 a_22984_13304# VDD 1.05158f
C367 a_2336_11756# sg13g2_hv_and2_1_1.X 0.07423f
C368 VDD a_15304_13304# 0.94567f
C369 a_23785_11628# a_23943_12069# 0.03803f
C370 VDD a_19720_6044# 0.94277f
C371 VDD sg13g2_hv_tiehi_2.L_HI 2.53611f
C372 a_27083_8259# a_27522_7681# 0.01321f
C373 a_13701_12068# a_12491_11649# 0.25683f
C374 a_12333_11649# a_11329_11551# 0.02728f
C375 VDD a_16934_11572# 0.791f
C376 a_17639_7412# a_18477_8259# 0.01699f
C377 sg13g2_hv_or3_1_3.A a_23062_11620# 0.01249f
C378 VDD a_9544_11756# 0.30445f
C379 VDD a_35848_6044# 0.94079f
C380 a_30376_10448# sg13g2_hv_dfrbpq_1_0.CLK 0.01084f
C381 a_33736_11756# a_33448_10448# 0.015f
C382 sg13g2_hv_a21oi_1_1.B1 a_23497_8772# 0.01033f
C383 sg13g2_hv_nand3_1_1.A sg13g2_hv_a21oi_1_1.B1 0.70756f
C384 a_1192_7592# a_1192_8900# 0.0258f
C385 sg13g2_hv_nand2b_1_0.B a_6902_7309# 0.0551f
C386 VDD a_25096_6044# 0.9377f
C387 sg13g2_hv_nand2b_1_0.B a_8843_8259# 0.04837f
C388 a_8843_8259# a_9282_7681# 0.01321f
C389 sg13g2_hv_a21oi_1_0.Y sg13g2_hv_or3_1_1.C 0.37674f
C390 a_1192_13304# counter_value_o[0] 0.0139f
C391 VDD a_11464_6044# 0.95722f
C392 VDD a_33736_13304# 0.94031f
C393 sg13g2_hv_xnor2_1_1.A a_3649_11551# 0.01436f
C394 a_25864_6044# a_26632_6044# 0.11571f
C395 sg13g2_hv_nand4_1_1.Y a_23220_12116# 0.01252f
C396 a_2336_13304# VDD 0.22141f
C397 VDD a_15043_8026# 0.56661f
C398 a_23446_11080# sg13g2_hv_or3_1_1.C 0.11732f
C399 a_2522_10879# sg13g2_hv_buf_1_9.X 0.03816f
C400 sg13g2_hv_nand2b_1_0.B a_9337_7966# 0.04174f
C401 a_15195_11666# sg13g2_hv_or3_1_1.C 0.2373f
C402 sg13g2_hv_nand3_1_1.Y a_23497_8772# 0.29758f
C403 sg13g2_hv_nand3_1_1.Y sg13g2_hv_nand3_1_1.A 0.29345f
C404 VDD sg13g2_hv_tiehi_4.L_HI 2.47248f
C405 sg13g2_hv_nand4_1_0.C sg13g2_hv_nand3_1_0.Y 0.56765f
C406 a_5608_6044# a_6376_6044# 0.11571f
C407 VDD a_28293_7386# 0.58947f
C408 sg13g2_hv_nand4_1_0.C a_11329_11551# 0.05513f
C409 VDD counter_value_o[7] 0.17348f
C410 sg13g2_hv_a21oi_1_1.B1 a_11368_7592# 0.02218f
C411 VDD a_16840_6044# 0.2501f
C412 a_29608_7592# a_30376_7592# 0.11571f
C413 sg13g2_hv_o21ai_1_0.B1 sg13g2_hv_or3_1_1.C 0.94176f
C414 a_26087_7412# a_25232_7395# 0.26354f
C415 a_31432_11756# a_31528_13304# 0.01675f
C416 a_2438_11572# a_3449_11585# 0.2572f
C417 sg13g2_hv_o21ai_1_0.Y a_21385_7443# 0.08726f
C418 a_23785_11628# sg13g2_hv_a21oi_1_4.A2 0.25638f
C419 VDD a_4840_6044# 0.94163f
C420 a_31240_6044# a_32008_6044# 0.11571f
C421 a_24334_10242# a_25192_8900# 0.02016f
C422 a_17413_7498# a_16262_8336# 0.01695f
C423 a_6992_7395# a_7481_8323# 0.35847f
C424 a_6902_7309# a_7847_7412# 0.06127f
C425 a_34504_11756# sg13g2_hv_o21ai_1_1.B1 0.05003f
C426 sg13g2_hv_nand3_1_1.A sg13g2_hv_nand2_1_1.Y 0.597f
C427 sg13g2_hv_nand3_1_0.Y a_8327_12110# 0.46925f
C428 a_7847_7412# a_8843_8259# 0.39137f
C429 a_12588_13011# counter_value_o[2] 0.30213f
C430 VDD a_21064_11756# 0.98054f
C431 a_28513_11551# sg13g2_hv_o21ai_1_1.B1 0.06157f
C432 sg13g2_hv_a21oi_1_4.Y a_27016_11756# 0.01948f
C433 a_6992_7395# sg13g2_hv_a21oi_1_1.B1 0.10241f
C434 a_4811_11649# a_5305_11792# 0.44368f
C435 a_5115_7520# a_5445_8216# 0.01045f
C436 sg13g2_hv_a21oi_1_0.A2 sg13g2_hv_or3_1_1.C 0.03079f
C437 sg13g2_hv_nand2b_1_0.B a_3208_8900# 0.16494f
C438 VDD a_32680_7592# 1.02079f
C439 sg13g2_hv_or3_1_3.A sg13g2_hv_tiehi_0.L_HI 0.01031f
C440 sg13g2_hv_a21oi_1_1.B1 a_10053_7386# 0.01797f
C441 a_7847_7412# a_9337_7966# 0.08899f
C442 sg13g2_hv_nand2b_1_0.B sg13g2_hv_xnor2_1_1.Y 0.07407f
C443 VDD a_34312_6044# 0.94079f
C444 VDD a_21709_7443# 0.01328f
C445 a_14427_7386# sg13g2_hv_a21oi_1_2.A1 0.0883f
C446 VDD sg13g2_hv_a21oi_1_2.A2 0.49002f
C447 a_33448_7592# a_34216_7592# 0.11571f
C448 VDD sg13g2_hv_a21oi_1_1.B1 3.47802f
C449 sg13g2_hv_nand4_1_0.C counter_value_o[2] 0.03966f
C450 sg13g2_hv_dfrbpq_1_4.RESET_B a_27968_13304# 0.0193f
C451 sg13g2_hv_nand4_1_0.C sg13g2_hv_nand4_1_0.Y 1.61607f
C452 sg13g2_hv_or3_1_1.C sg13g2_hv_a21oi_1_2.Y 0.04378f
C453 sg13g2_hv_or3_1_3.A a_32200_11756# 0.12772f
C454 a_12588_13011# a_13000_13304# 0.04179f
C455 VDD counter_value_o[6] 0.1958f
C456 VDD a_38056_7592# 0.96578f
C457 VDD a_25921_7412# 0.93278f
C458 a_7424_10448# sg13g2_hv_buf_1_9.X 0.0322f
C459 a_14632_10448# a_15400_10448# 0.11571f
C460 sg13g2_hv_o21ai_1_0.B1 sg13g2_hv_nand4_1_1.Y 0.11457f
C461 sg13g2_hv_nand3_1_1.Y VDD 1.41522f
C462 a_28679_11694# a_27734_11795# 0.06127f
C463 sg13g2_hv_o21ai_1_1.Y sg13g2_hv_a21oi_1_4.A2 0.20955f
C464 sg13g2_hv_nand4_1_0.C a_13000_13304# 0.11898f
C465 a_27016_11756# sg13g2_hv_dfrbpq_1_0.CLK 0.01735f
C466 a_18376_13304# sg13g2_hv_tiehi_4.L_HI 0.01703f
C467 a_37960_8900# a_38720_8900# 0.12205f
C468 a_16744_8900# sg13g2_hv_tiehi_2.L_HI 0.02437f
C469 a_36424_8900# VDD 0.9415f
C470 sg13g2_hv_nand3_1_1.A sg13g2_hv_nand2b_1_2.Y 0.06025f
C471 VDD a_1192_8900# 1.04443f
C472 sg13g2_hv_nand4_1_0.Y a_8327_12110# 0.07568f
C473 a_35656_8900# a_35752_7592# 0.0222f
C474 a_5115_7520# sg13g2_hv_nand2b_1_0.Y 0.13318f
C475 sg13g2_hv_nand2b_1_0.B sg13g2_hv_nand2_1_2.Y 0.57432f
C476 sg13g2_hv_nand3_1_1.A a_19816_8900# 0.03356f
C477 VDD a_20820_7338# 0.025f
C478 a_10118_11572# a_11269_12292# 0.01695f
C479 sg13g2_hv_or3_1_3.A a_30553_8936# 0.05223f
C480 a_14233_11648# a_14920_11756# 0.07569f
C481 a_10640_12117# a_11495_11694# 0.26366f
C482 VDD a_7816_8900# 0.94204f
C483 a_31816_8900# a_32584_8900# 0.11571f
C484 VDD a_31912_10448# 0.96558f
C485 sg13g2_hv_o21ai_1_0.B1 a_27496_8900# 0.01022f
C486 sg13g2_hv_dfrbpq_1_0.CLK a_19307_11649# 0.04626f
C487 a_18311_11694# a_19801_11792# 0.08792f
C488 VDD a_4744_10448# 0.9433f
C489 VDD a_7048_8900# 0.94349f
C490 sg13g2_hv_or3_1_3.A a_23446_11080# 0.04758f
C491 sg13g2_hv_buf_1_0.X a_6280_8900# 0.11422f
C492 VDD sg13g2_hv_nand2_1_1.Y 0.52251f
C493 a_24710_8336# a_25142_7309# 0.47309f
C494 a_27302_11572# sg13g2_hv_o21ai_1_1.B1 0.04764f
C495 sg13g2_hv_o21ai_1_1.B1 a_35272_13304# 0.02076f
C496 sg13g2_hv_a21oi_1_1.B1 a_10120_8900# 0.02071f
C497 VDD counter_value_o[5] 0.25111f
C498 VDD a_13192_8900# 0.99237f
C499 VDD a_13864_10448# 1.00033f
C500 sg13g2_hv_buf_16_0.A sg13g2_hv_nand4_1_0.Y 0.04315f
C501 sg13g2_hv_or3_1_3.A sg13g2_hv_o21ai_1_0.B1 0.31752f
C502 a_12136_7592# a_11368_7592# 0.11571f
C503 a_20517_12068# a_21064_11756# 0.02946f
C504 VDD a_14233_11648# 0.86768f
C505 a_32584_8900# a_32680_10448# 0.01675f
C506 sg13g2_hv_or3_1_1.B sg13g2_hv_or3_1_1.C 1.1826f
C507 a_21448_13304# VDD 0.95847f
C508 a_2522_10879# a_1773_11050# 0.02616f
C509 a_20517_12068# sg13g2_hv_a21oi_1_1.B1 0.01419f
C510 sg13g2_hv_or3_1_3.X sg13g2_hv_a21oi_1_5.Y 0.01497f
C511 sg13g2_hv_nand4_1_0.Y sg13g2_hv_nand3_1_0.Y 0.04844f
C512 a_15400_10448# sg13g2_hv_or3_1_1.A 0.02137f
C513 sg13g2_hv_or3_1_3.A a_27083_8259# 0.01211f
C514 a_8008_13304# VDD 0.96014f
C515 sg13g2_hv_or3_1_1.C a_19845_7386# 0.03409f
C516 a_11329_11551# sg13g2_hv_nand4_1_0.Y 0.03822f
C517 a_32968_11756# a_33736_11756# 0.11571f
C518 sg13g2_hv_xnor2_1_1.A a_6952_11756# 0.01307f
C519 VDD a_15680_9260# 0.025f
C520 VDD a_37384_13098# 0.46807f
C521 sg13g2_hv_dfrbpq_1_0.CLK sg13g2_hv_dfrbpq_1_7.RESET_B 0.13647f
C522 sg13g2_hv_or3_1_3.X sg13g2_hv_buf_16_0.A 0.01003f
C523 VDD a_37288_10448# 0.9415f
C524 VDD sg13g2_hv_nand2b_1_2.Y 0.51073f
C525 a_8584_8900# a_9352_8900# 0.11571f
C526 sg13g2_hv_or3_1_3.A a_29608_7592# 0.02075f
C527 sg13g2_hv_or3_1_1.B a_19129_7966# 0.01111f
C528 sg13g2_hv_or3_1_1.C a_20576_7592# 0.06687f
C529 sg13g2_hv_nand4_1_0.C sg13g2_hv_buf_1_0.X 0.15784f
C530 a_32680_10448# a_33448_10448# 0.11571f
C531 VDD a_12136_7592# 0.97332f
C532 a_28679_11694# sg13g2_hv_dfrbpq_1_0.CLK 0.06043f
C533 reset_n_i a_1192_10242# 0.41473f
C534 a_16784_7395# sg13g2_hv_tiehi_2.L_HI 0.54187f
C535 sg13g2_hv_dfrbpq_1_4.RESET_B a_30169_11792# 0.22463f
C536 VDD counter_value_o[4] 0.1944f
C537 a_5512_10448# a_6280_10448# 0.11571f
C538 VDD a_19816_8900# 0.95381f
C539 a_7681_7412# a_6470_8336# 0.09592f
C540 a_11656_8900# sg13g2_hv_dfrbpq_1_1.CLK 0.01636f
C541 a_19129_7966# a_19845_7386# 0.11973f
C542 a_27968_13304# a_27564_13011# 0.01073f
C543 VDD a_1192_11756# 1.04712f
C544 a_7480_11632# sg13g2_hv_xnor2_1_1.A 0.01509f
C545 a_30059_8793# sg13g2_hv_dfrbpq_1_7.RESET_B 0.165f
C546 VDD a_4443_7520# 0.4333f
C547 sg13g2_hv_or3_1_3.A a_31912_7592# 0.01799f
C548 a_17326_10242# a_18280_8900# 0.02148f
C549 a_16072_13304# clock_i 0.02207f
C550 sg13g2_hv_nand2_1_2.Y a_2810_8772# 0.01425f
C551 VDD a_27734_11795# 0.41466f
C552 sg13g2_hv_or3_1_1.B sg13g2_hv_nand4_1_1.Y 0.25973f
C553 a_17456_12117# clock_i 0.11693f
C554 a_30169_11792# a_30885_12068# 0.11973f
C555 a_29675_11649# a_30114_12109# 0.01321f
C556 a_2522_10879# sg13g2_hv_xnor2_1_1.Y 0.2742f
C557 a_17580_13011# counter_value_o[3] 0.31425f
C558 VDD a_8812_12068# 0.01183f
C559 sg13g2_hv_dfrbpq_1_1.CLK a_3649_11551# 0.39567f
C560 a_28208_9261# a_28897_8695# 0.51401f
C561 a_32392_13098# counter_value_o[6] 0.37295f
C562 a_25480_11756# sg13g2_hv_a21oi_1_1.B1 0.07017f
C563 sg13g2_hv_or3_1_3.A a_25232_7395# 0.01587f
C564 VDD sg13g2_hv_a21oi_1_2.A1 0.54514f
C565 sg13g2_hv_o21ai_1_0.B1 a_24334_10242# 0.09036f
C566 VDD a_29704_6044# 0.94079f
C567 counter_value_o[2] a_13000_13304# 0.01475f
C568 sg13g2_hv_nand3_1_1.A sg13g2_hv_dfrbpq_1_0.CLK 0.46628f
C569 a_29063_8838# a_30553_8936# 0.08792f
C570 sg13g2_hv_or3_1_1.B a_17512_8900# 0.06818f
C571 a_33736_11756# a_33736_13304# 0.01947f
C572 a_8654_11628# sg13g2_hv_and2_1_0.X 0.0246f
C573 a_22504_10448# a_23272_10448# 0.11571f
C574 sg13g2_hv_tiehi_2.L_HI a_16262_8336# 0.36077f
C575 a_23446_11080# sg13g2_hv_a21oi_1_5.A1 0.02948f
C576 a_5813_7386# sg13g2_hv_dfrbpq_1_1.D 0.10475f
C577 a_2522_10879# sg13g2_hv_nand2_1_2.Y 0.43848f
C578 sg13g2_hv_or3_1_1.A a_15976_8900# 0.14959f
C579 VDD sg13g2_hv_a21oi_1_4.Y 0.51926f
C580 sg13g2_hv_or3_1_3.A a_31144_10448# 0.02601f
C581 sg13g2_hv_or3_1_3.A sg13g2_hv_or3_1_1.B 0.02633f
C582 VDD a_3016_13304# 0.25565f
C583 a_17326_10242# a_19307_11649# 0.02715f
C584 a_22984_13304# a_23752_13304# 0.11571f
C585 sg13g2_hv_buf_1_0.X sg13g2_hv_nand3_1_0.Y 0.05287f
C586 sg13g2_hv_nand3_1_1.A a_21352_8900# 0.01093f
C587 a_15304_13304# a_16072_13304# 0.11571f
C588 VDD a_37576_11756# 1.01449f
C589 a_8776_13304# a_9544_13304# 0.11571f
C590 a_5813_7386# sg13g2_hv_nand2b_1_1.Y 0.18357f
C591 VDD a_11495_11694# 0.73561f
C592 sg13g2_hv_or3_1_1.C sg13g2_hv_buf_16_0.A 0.39384f
C593 sg13g2_hv_tiehi_1.L_HI sg13g2_hv_dfrbpq_1_1.CLK 0.04141f
C594 a_19720_6044# a_20488_6044# 0.11571f
C595 VDD sg13g2_hv_xnor2_1_1.A 2.55902f
C596 VDD a_22888_11756# 0.2957f
C597 a_6021_12068# sg13g2_hv_xnor2_1_1.A 0.18337f
C598 a_17366_11795# a_18145_11551# 0.12012f
C599 a_16934_11572# a_17456_12117# 0.25017f
C600 sg13g2_hv_o21ai_1_0.B1 a_22312_8900# 0.15039f
C601 a_17945_11585# a_18311_11694# 0.07572f
C602 a_35848_6044# a_36616_6044# 0.11571f
C603 sg13g2_hv_o21ai_1_0.B1 a_21256_6044# 0.01204f
C604 a_11080_13304# sg13g2_hv_nand4_1_0.C 0.01316f
C605 a_27686_8716# a_28208_9261# 0.25017f
C606 VDD a_31432_11756# 0.98883f
C607 sg13g2_hv_nand2_1_1.Y a_16051_11650# 0.01378f
C608 a_25192_8900# a_25960_8900# 0.11571f
C609 sg13g2_hv_dfrbpq_1_1.CLK a_10100_10155# 3.07881f
C610 VDD sg13g2_hv_dfrbpq_1_0.CLK 3.42142f
C611 a_11656_8900# a_10100_10155# 0.02148f
C612 a_8589_11050# a_9256_10448# 0.0301f
C613 sg13g2_hv_tiehi_4.L_HI a_17456_12117# 0.52552f
C614 sg13g2_hv_o21ai_1_0.B1 a_27302_11572# 0.05475f
C615 sg13g2_hv_a21oi_1_0.A2 a_22312_8900# 0.01022f
C616 sg13g2_hv_or3_1_3.A a_32288_13304# 0.06743f
C617 sg13g2_hv_or3_1_3.A a_28118_8939# 0.04354f
C618 a_11464_6044# a_12232_6044# 0.11571f
C619 a_33736_13304# a_34504_13304# 0.11571f
C620 sg13g2_hv_buf_1_0.X sg13g2_hv_nand4_1_0.Y 0.04347f
C621 sg13g2_hv_and2_1_0.B a_9544_11756# 0.03176f
C622 VDD a_2728_7592# 1.02368f
C623 a_10696_6044# a_10600_7592# 0.01675f
C624 a_1960_7592# sg13g2_hv_buf_1_0.X 0.08355f
C625 a_2621_11072# sg13g2_hv_xnor2_1_1.A 0.02831f
C626 sg13g2_hv_nand3_1_1.A a_15893_12068# 0.01264f
C627 sg13g2_hv_dfrbpq_1_1.CLK a_10640_12117# 0.15273f
C628 a_16784_7395# a_18477_8259# 0.39112f
C629 VDD a_30059_8793# 0.58741f
C630 sg13g2_hv_nand2b_1_1.Y a_5512_8900# 0.01338f
C631 a_3815_11694# sg13g2_hv_tiehi_5.L_HI 0.21456f
C632 sg13g2_hv_a21oi_1_0.Y a_23080_7592# 0.09974f
C633 VDD a_21352_8900# 0.2701f
C634 VDD a_13768_13304# 0.94149f
C635 sg13g2_hv_o21ai_1_1.B1 a_23785_11628# 0.37471f
C636 a_17639_7412# sg13g2_hv_dfrbpq_1_1.CLK 0.0742f
C637 VDD a_18184_6044# 0.94395f
C638 a_19149_11649# a_18145_11551# 0.02728f
C639 a_11129_11585# a_11329_11551# 0.02842f
C640 a_17639_7412# a_18635_8259# 0.39137f
C641 a_29901_8793# a_28897_8695# 0.02728f
C642 sg13g2_hv_a21oi_1_5.Y a_27496_8900# 0.09184f
C643 sg13g2_hv_or3_1_1.C sg13g2_hv_nand4_1_0.Y 0.01604f
C644 a_32968_11756# a_32680_10448# 0.015f
C645 a_27208_13304# VDD 0.3418f
C646 sg13g2_hv_a21oi_1_1.B1 a_17456_12117# 0.06746f
C647 VDD a_23560_6044# 0.94662f
C648 a_31816_8900# a_31269_9212# 0.02946f
C649 sg13g2_hv_o21ai_1_0.B1 a_23080_7592# 0.05223f
C650 sg13g2_hv_o21ai_1_0.Y sg13g2_hv_nand3_1_1.A 0.04405f
C651 VDD a_9928_6044# 0.94277f
C652 a_2604_13011# VDD 0.45975f
C653 sg13g2_hv_tiehi_5.L_HI a_2960_12117# 0.53621f
C654 a_3496_7592# a_3208_8900# 0.015f
C655 sg13g2_hv_nand2b_1_0.B a_7481_8323# 0.02742f
C656 sg13g2_hv_or3_1_3.A sg13g2_hv_a21oi_1_5.Y 0.41874f
C657 a_37384_6044# a_37288_7592# 0.01675f
C658 sg13g2_hv_nand3_1_1.Y a_21976_8776# 0.01247f
C659 a_17326_10242# sg13g2_hv_nand3_1_1.A 0.082f
C660 sg13g2_hv_dfrbpq_1_1.CLK a_6952_11756# 0.01001f
C661 VDD a_27577_7966# 0.31949f
C662 a_4840_6044# a_5608_6044# 0.11571f
C663 sg13g2_hv_nand4_1_0.C a_10118_11572# 0.04912f
C664 sg13g2_hv_nand2b_1_0.B sg13g2_hv_a21oi_1_1.B1 0.99424f
C665 VDD a_15304_6044# 0.9416f
C666 VDD a_21385_7443# 0.56496f
C667 sg13g2_hv_or3_1_3.A sg13g2_hv_buf_16_0.A 0.11985f
C668 sg13g2_hv_and2_1_0.X a_9256_10448# 0.15685f
C669 a_20517_12068# sg13g2_hv_dfrbpq_1_0.CLK 0.02316f
C670 sg13g2_hv_nand4_1_0.C sg13g2_hv_buf_1_9.X 0.02182f
C671 sg13g2_hv_o21ai_1_1.B1 sg13g2_hv_o21ai_1_1.Y 0.25805f
C672 VDD a_3304_6044# 0.96156f
C673 VDD a_28840_7592# 0.97303f
C674 sg13g2_hv_nand4_1_0.C a_12985_11792# 0.0461f
C675 VDD a_14056_7592# 0.32906f
C676 sg13g2_hv_dfrbpq_1_1.CLK a_16694_7309# 0.0417f
C677 VDD a_15893_12068# 0.19582f
C678 a_30472_6044# a_31240_6044# 0.11571f
C679 sg13g2_hv_or3_1_1.B a_22312_8900# 0.04217f
C680 a_26925_8259# a_25921_7412# 0.02728f
C681 a_32968_11756# sg13g2_hv_o21ai_1_1.B1 0.05003f
C682 a_21064_11756# a_21832_11756# 0.11571f
C683 a_7681_7412# a_8685_8259# 0.02728f
C684 sg13g2_hv_a21oi_1_4.Y a_25480_11756# 0.10987f
C685 VDD a_8392_6044# 0.94395f
C686 a_5813_7386# VDD 0.19581f
C687 VDD a_31144_7592# 0.95089f
C688 a_7481_8323# a_7847_7412# 0.07572f
C689 sg13g2_hv_dfrbpq_1_1.D sg13g2_hv_tiehi_1.L_HI 0.12718f
C690 a_13000_6044# a_12904_7592# 0.01675f
C691 sg13g2_hv_dfrbpq_1_0.CLK a_26728_8900# 0.10876f
C692 a_32680_7592# a_33448_7592# 0.11571f
C693 a_11080_13304# counter_value_o[2] 0.01171f
C694 a_30169_11792# sg13g2_hv_o21ai_1_1.B1 0.05394f
C695 a_7847_7412# sg13g2_hv_a21oi_1_1.B1 0.02669f
C696 sg13g2_hv_nand2b_1_0.B a_7816_8900# 0.12134f
C697 sg13g2_hv_a21oi_1_4.Y sg13g2_hv_a21oi_1_4.A2 0.0313f
C698 a_23062_11620# sg13g2_hv_o21ai_1_1.Y 0.03187f
C699 sg13g2_hv_or3_1_1.C a_15104_11756# 0.0539f
C700 sg13g2_hv_tiehi_0.L_HI a_25864_6044# 0.02029f
C701 sg13g2_hv_nand2b_1_0.B a_7048_8900# 0.04083f
C702 VDD a_36520_7592# 0.9415f
C703 sg13g2_hv_a21oi_1_1.B1 a_22421_7386# 0.02797f
C704 a_29063_8838# a_28118_8939# 0.06127f
C705 VDD a_25142_7309# 0.41494f
C706 VDD sg13g2_hv_o21ai_1_0.Y 0.48709f
C707 sg13g2_hv_dfrbpq_1_4.RESET_B a_27734_11795# 0.43154f
C708 a_8589_11050# sg13g2_hv_nand3_1_0.Y 0.01266f
C709 a_25861_7498# a_24710_8336# 0.01695f
C710 a_19912_13304# sg13g2_hv_nand3_1_1.A 0.01073f
C711 sg13g2_hv_dfrbpq_1_1.CLK a_11368_7592# 0.06541f
C712 a_14632_10448# sg13g2_hv_a21oi_1_1.B1 0.02772f
C713 a_10640_12117# a_10100_10155# 0.01292f
C714 a_17326_10242# VDD 5.0673f
C715 a_27824_12117# a_27734_11795# 0.47124f
C716 a_11656_8900# a_11368_7592# 0.015f
C717 a_25480_11756# sg13g2_hv_dfrbpq_1_0.CLK 0.03388f
C718 a_24334_10242# sg13g2_hv_a21oi_1_5.Y 0.03851f
C719 a_37192_8900# a_37960_8900# 0.11571f
C720 sg13g2_hv_or3_1_1.A a_15043_8026# 0.38707f
C721 a_34888_8900# VDD 0.9415f
C722 a_25232_7395# a_25721_8323# 0.35847f
C723 a_34888_8900# a_34984_7592# 0.0222f
C724 sg13g2_hv_and2_1_0.X a_8327_12110# 0.03503f
C725 sg13g2_hv_buf_1_0.X a_1192_5950# 0.27448f
C726 a_4443_7520# a_4773_8216# 0.01045f
C727 sg13g2_hv_buf_16_0.A a_24334_10242# 1.03174f
C728 a_23752_13304# counter_value_o[4] 0.0106f
C729 a_6992_7395# sg13g2_hv_dfrbpq_1_1.CLK 0.08901f
C730 sg13g2_hv_dfrbpq_1_0.CLK sg13g2_hv_a21oi_1_4.A2 0.01869f
C731 VDD a_24710_8336# 0.77866f
C732 a_10118_11572# a_11329_11551# 0.09667f
C733 a_22408_13098# VDD 0.45332f
C734 VDD a_30376_10448# 0.94271f
C735 VDD a_3041_10242# 0.01691f
C736 VDD a_5512_8900# 0.94266f
C737 sg13g2_hv_dfrbpq_1_1.CLK a_10053_7386# 0.01466f
C738 sg13g2_hv_buf_1_0.X a_4744_8900# 0.04101f
C739 sg13g2_hv_nand3_1_0.Y sg13g2_hv_buf_1_9.X 0.06353f
C740 sg13g2_hv_o21ai_1_1.B1 a_33736_13304# 0.01999f
C741 a_15976_7592# a_16160_7592# 0.12205f
C742 VDD sg13g2_hv_dfrbpq_1_1.CLK 3.69776f
C743 sg13g2_hv_dfrbpq_1_1.CLK a_6021_12068# 0.03416f
C744 sg13g2_hv_dfrbpq_1_1.D sg13g2_hv_nand2b_1_1.Y 0.01783f
C745 sg13g2_hv_a21oi_1_1.B1 a_8584_8900# 0.02073f
C746 a_27564_13011# counter_value_o[5] 0.28052f
C747 VDD a_18635_8259# 0.58896f
C748 a_11495_11694# a_12491_11649# 0.39137f
C749 VDD a_11656_8900# 0.96042f
C750 sg13g2_hv_dfrbpq_1_4.RESET_B sg13g2_hv_a21oi_1_4.Y 0.11798f
C751 VDD a_35752_10448# 0.9415f
C752 sg13g2_hv_tiehi_5.L_HI sg13g2_hv_buf_1_9.X 0.02183f
C753 a_12232_6044# a_12136_7592# 0.01675f
C754 a_27968_13304# sg13g2_hv_o21ai_1_0.B1 0.06743f
C755 sg13g2_hv_o21ai_1_1.B1 counter_value_o[7] 0.10145f
C756 sg13g2_hv_or3_1_3.A sg13g2_hv_or3_1_3.X 0.06518f
C757 a_23220_12116# sg13g2_hv_o21ai_1_1.Y 0.01897f
C758 sg13g2_hv_a21oi_1_1.B1 a_13960_8900# 0.15867f
C759 VDD a_20392_7592# 0.25652f
C760 a_26056_13304# a_26248_11756# 0.01403f
C761 a_31816_8900# a_31912_10448# 0.01675f
C762 a_14632_10448# a_13864_10448# 0.11571f
C763 sg13g2_hv_a21oi_1_5.A1 sg13g2_hv_a21oi_1_5.Y 0.13023f
C764 a_19912_13304# VDD 0.94315f
C765 sg13g2_hv_or3_1_1.A sg13g2_hv_a21oi_1_2.A2 0.01198f
C766 sg13g2_hv_nand2b_1_0.B a_4443_7520# 0.46221f
C767 sg13g2_hv_o21ai_1_0.Y a_20662_8224# 0.03343f
C768 sg13g2_hv_or3_1_1.A sg13g2_hv_a21oi_1_1.B1 0.05505f
C769 a_15195_11666# a_15525_11628# 0.01045f
C770 VDD a_3649_11551# 0.93643f
C771 sg13g2_hv_or3_1_1.C a_19129_7966# 0.04664f
C772 a_10118_11572# sg13g2_hv_nand4_1_0.Y 0.01677f
C773 sg13g2_hv_and2_1_0.X sg13g2_hv_nand3_1_0.Y 0.01488f
C774 a_18085_12292# a_16934_11572# 0.01695f
C775 sg13g2_hv_buf_16_0.A sg13g2_hv_a21oi_1_5.A1 0.30983f
C776 a_32200_11756# a_32968_11756# 0.11571f
C777 a_10550_11795# a_11495_11694# 0.06127f
C778 VDD a_31528_13304# 0.95514f
C779 a_28513_11551# a_29517_11649# 0.02728f
C780 sg13g2_hv_nand3_1_1.A a_19307_11649# 0.07045f
C781 sg13g2_hv_dfrbpq_1_4.RESET_B sg13g2_hv_dfrbpq_1_0.CLK 0.07184f
C782 sg13g2_hv_o21ai_1_0.B1 sg13g2_hv_o21ai_1_0.A2 0.33121f
C783 a_7816_8900# a_8584_8900# 0.11571f
C784 a_12232_13304# VDD 0.34596f
C785 a_12985_11792# sg13g2_hv_nand4_1_0.Y 0.04193f
C786 a_31912_10448# a_32680_10448# 0.11571f
C787 a_29608_10448# a_28840_10448# 0.11571f
C788 a_27824_12117# sg13g2_hv_dfrbpq_1_0.CLK 0.14915f
C789 sg13g2_hv_a21oi_1_1.B1 sg13g2_hv_o21ai_1_1.B1 0.01761f
C790 a_4744_10448# a_5512_10448# 0.11571f
C791 a_6280_10448# a_6280_8900# 0.01947f
C792 VDD a_18280_8900# 0.94115f
C793 sg13g2_hv_and2_1_0.B a_8812_12068# 0.01255f
C794 a_6902_7309# a_6470_8336# 0.47309f
C795 a_30885_12068# a_31432_11756# 0.02946f
C796 a_10120_8900# sg13g2_hv_dfrbpq_1_1.CLK 0.08155f
C797 sg13g2_hv_a21oi_1_1.B1 a_25192_8900# 0.13765f
C798 sg13g2_hv_nand4_1_1.Y sg13g2_hv_or3_1_1.C 0.55996f
C799 counter_value_o[3] a_17224_13304# 0.02885f
C800 VDD a_37960_13304# 0.972f
C801 a_9352_8900# a_9256_10448# 0.01675f
C802 sg13g2_hv_or3_1_1.B a_15112_8900# 0.0394f
C803 a_17639_7412# a_16694_7309# 0.06127f
C804 sg13g2_hv_tiehi_1.L_HI a_7136_6044# 0.0193f
C805 sg13g2_hv_or3_1_3.A a_30376_7592# 0.02068f
C806 sg13g2_hv_dfrbpq_1_0.CLK a_28897_8695# 0.46845f
C807 a_6992_7395# sg13g2_hv_tiehi_1.L_HI 0.54144f
C808 a_17366_11795# clock_i 0.07849f
C809 sg13g2_hv_tiehi_3.L_HI a_11495_11694# 0.2061f
C810 a_29675_11649# a_30169_11792# 0.44368f
C811 a_13192_8900# a_13960_8900# 0.11571f
C812 a_13960_8900# a_13864_10448# 0.01675f
C813 a_3815_11694# a_2960_12117# 0.26366f
C814 sg13g2_hv_nand2b_1_0.B a_3016_13304# 0.07959f
C815 sg13g2_hv_and2_1_0.X sg13g2_hv_nand4_1_0.Y 0.20581f
C816 VDD sg13g2_hv_tiehi_1.L_HI 2.53276f
C817 sg13g2_hv_nand2_1_2.Y a_3976_10448# 0.01717f
C818 VDD a_27016_11756# 0.22522f
C819 sg13g2_hv_tiehi_0.L_HI a_25096_6044# 0.01876f
C820 a_15976_7592# a_15043_8026# 0.02211f
C821 VDD a_28168_6044# 0.94277f
C822 a_19746_12109# a_19307_11649# 0.01321f
C823 VDD a_24533_9212# 0.17871f
C824 a_3496_7592# a_4264_7592# 0.11571f
C825 sg13g2_hv_nand2b_1_0.B sg13g2_hv_xnor2_1_1.A 0.86598f
C826 sg13g2_hv_or3_1_1.B a_15976_8900# 0.06819f
C827 sg13g2_hv_dfrbpq_1_0.CLK a_17456_12117# 0.10202f
C828 a_18311_11694# a_18145_11551# 0.59728f
C829 sg13g2_hv_a21oi_1_1.B1 a_7424_10448# 0.01926f
C830 VDD a_10100_10155# 5.17332f
C831 a_32968_11756# a_32968_13304# 0.01947f
C832 VDD a_33544_6044# 0.94676f
C833 sg13g2_hv_or3_1_3.A sg13g2_hv_or3_1_1.C 0.34415f
C834 VDD a_19307_11649# 0.58715f
C835 a_2438_11572# a_3649_11551# 0.09667f
C836 a_30553_8936# a_31269_9212# 0.11973f
C837 a_30059_8793# a_30498_9253# 0.01321f
C838 sg13g2_hv_nand4_1_0.C a_13701_12068# 0.18245f
C839 a_21448_13304# a_22216_13304# 0.11571f
C840 a_16160_7592# sg13g2_hv_a21oi_1_2.Y 0.07415f
C841 a_21736_10448# a_22504_10448# 0.11571f
C842 sg13g2_hv_o21ai_1_0.B1 a_28208_9261# 0.0267f
C843 sg13g2_hv_or3_1_1.A a_15680_9260# 0.01197f
C844 a_20968_10448# a_21736_10448# 0.11571f
C845 VDD a_24109_12069# 0.01246f
C846 sg13g2_hv_a21oi_1_3.Y clock_i 0.03462f
C847 a_27302_11572# a_28453_12292# 0.01695f
C848 sg13g2_hv_or3_1_1.A sg13g2_hv_nand2b_1_2.Y 0.1497f
C849 a_14536_13304# a_15304_13304# 0.11571f
C850 VDD a_14427_7386# 0.1789f
C851 a_8008_13304# a_8776_13304# 0.11571f
C852 VDD a_10640_12117# 0.39498f
C853 VDD sg13g2_hv_dfrbpq_1_1.D 0.44237f
C854 a_18952_6044# a_19720_6044# 0.11571f
C855 sg13g2_hv_dfrbpq_1_0.CLK a_27686_8716# 0.02652f
C856 sg13g2_hv_o21ai_1_0.B1 a_22504_10448# 0.1063f
C857 VDD a_5224_13304# 0.94621f
C858 sg13g2_hv_or3_1_3.X sg13g2_hv_a21oi_1_5.A1 0.33748f
C859 a_4811_11649# sg13g2_hv_xnor2_1_1.A 0.02675f
C860 a_5305_11792# sg13g2_hv_tiehi_5.L_HI 0.22463f
C861 a_17366_11795# a_16934_11572# 0.47309f
C862 VDD sg13g2_hv_nand2b_1_1.Y 0.51015f
C863 VDD a_17639_7412# 0.71795f
C864 sg13g2_hv_buf_1_0.X sg13g2_hv_buf_1_9.X 0.29334f
C865 a_35080_6044# a_35848_6044# 0.11571f
C866 a_37384_13098# sg13g2_hv_o21ai_1_1.B1 0.41218f
C867 a_9544_13304# sg13g2_hv_nand4_1_0.C 0.01075f
C868 sg13g2_hv_tiehi_0.L_HI sg13g2_hv_a21oi_1_1.B1 0.06096f
C869 sg13g2_hv_or3_1_1.B sg13g2_hv_o21ai_1_0.A2 0.34051f
C870 VDD sg13g2_hv_dfrbpq_1_7.RESET_B 2.54591f
C871 a_28840_7592# a_28897_8695# 0.03276f
C872 a_17473_7412# sg13g2_hv_or3_1_1.C 0.03594f
C873 sg13g2_hv_or3_1_3.A sg13g2_hv_nand4_1_1.Y 0.08878f
C874 sg13g2_hv_tiehi_0.L_HI a_25921_7412# 0.12071f
C875 a_17580_13011# a_17224_13304# 0.02578f
C876 a_36424_8900# a_37192_8900# 0.11571f
C877 a_37960_8900# a_38056_10448# 0.01675f
C878 a_10120_8900# a_10100_10155# 0.02148f
C879 VDD a_35272_11756# 0.94102f
C880 a_17024_10448# clock_i 0.03493f
C881 a_24328_6044# a_25096_6044# 0.11571f
C882 sg13g2_hv_tiehi_4.L_HI a_17366_11795# 0.42372f
C883 a_28679_11694# VDD 0.71729f
C884 a_32392_13098# a_31528_13304# 0.02351f
C885 sg13g2_hv_or3_1_1.A sg13g2_hv_a21oi_1_2.A1 0.05357f
C886 a_16072_6044# sg13g2_hv_tiehi_2.L_HI 0.02735f
C887 a_19816_8900# a_20584_8900# 0.11571f
C888 a_10696_6044# a_11464_6044# 0.11571f
C889 VDD a_6952_11756# 0.3462f
C890 a_32968_13304# a_33736_13304# 0.11571f
C891 sg13g2_hv_o21ai_1_0.B1 a_28293_7386# 0.19773f
C892 VDD a_1192_7592# 0.97242f
C893 a_27734_11795# sg13g2_hv_o21ai_1_1.B1 0.04556f
C894 a_2604_13011# sg13g2_hv_nand2b_1_0.B 0.39826f
C895 a_16784_7395# sg13g2_hv_dfrbpq_1_1.CLK 0.1075f
C896 a_16784_7395# a_18635_8259# 0.01632f
C897 sg13g2_hv_a21oi_1_2.Y sg13g2_hv_tiehi_2.L_HI 0.12862f
C898 sg13g2_hv_a21oi_1_3.Y a_16934_11572# 0.25171f
C899 a_20517_12068# a_19307_11649# 0.25683f
C900 sg13g2_hv_a21oi_1_2.A1 a_15514_8764# 0.02911f
C901 sg13g2_hv_nand2b_1_0.Y sg13g2_hv_buf_1_0.X 0.29299f
C902 a_3815_11694# sg13g2_hv_buf_1_9.X 0.0121f
C903 VDD a_16694_7309# 0.41666f
C904 a_5512_10448# sg13g2_hv_xnor2_1_1.A 0.07468f
C905 a_17945_11585# a_18145_11551# 0.02842f
C906 sg13g2_hv_a21oi_1_0.Y sg13g2_hv_a21oi_1_1.B1 0.51028f
C907 a_11129_11585# a_10118_11572# 0.2572f
C908 a_27083_8259# a_28293_7386# 0.25683f
C909 a_28697_8729# a_28897_8695# 0.02842f
C910 a_17416_6044# sg13g2_hv_tiehi_2.L_HI 0.02901f
C911 sg13g2_hv_a21oi_1_1.B1 a_21736_10448# 0.0101f
C912 sg13g2_hv_a21oi_1_5.Y a_25960_8900# 0.06595f
C913 a_32200_11756# a_31912_10448# 0.015f
C914 a_16072_6044# a_16840_6044# 0.11571f
C915 a_27564_13011# a_27208_13304# 0.02578f
C916 sg13g2_hv_a21oi_1_2.Y a_15043_8026# 0.05525f
C917 a_29992_13304# VDD 0.94211f
C918 a_25288_13304# VDD 0.94511f
C919 VDD a_23497_8772# 0.62702f
C920 VDD sg13g2_hv_nand3_1_1.A 3.40613f
C921 a_34312_6044# a_35080_6044# 0.11571f
C922 sg13g2_hv_a21oi_1_1.B1 a_17366_11795# 0.01768f
C923 VDD a_22024_6044# 0.97038f
C924 sg13g2_hv_dfrbpq_1_7.RESET_B a_28352_10448# 0.0193f
C925 sg13g2_hv_tiehi_4.L_HI sg13g2_hv_a21oi_1_3.Y 0.11708f
C926 a_23080_7592# a_22792_6044# 0.01132f
C927 sg13g2_hv_o21ai_1_0.B1 sg13g2_hv_a21oi_1_1.B1 0.12272f
C928 sg13g2_hv_nand3_1_1.Y a_23446_11080# 0.09717f
C929 sg13g2_hv_or3_1_3.A a_23821_9213# 0.01037f
C930 sg13g2_hv_nand2b_1_0.B a_5813_7386# 0.01287f
C931 a_36616_6044# a_36520_7592# 0.01675f
C932 a_15584_10448# sg13g2_hv_nand3_1_1.A 0.03144f
C933 a_2960_12117# sg13g2_hv_buf_1_9.X 0.02399f
C934 a_28513_11551# a_28840_10448# 0.01654f
C935 a_37192_8900# a_37288_10448# 0.01675f
C936 sg13g2_hv_a21oi_1_4.Y sg13g2_hv_o21ai_1_1.B1 1.25911f
C937 a_3815_11694# a_4653_11649# 0.01699f
C938 a_4072_6044# a_4840_6044# 0.11571f
C939 a_2522_10879# sg13g2_hv_xnor2_1_1.A 0.30729f
C940 sg13g2_hv_o21ai_1_0.B1 a_25921_7412# 0.06619f
C941 sg13g2_hv_nand2_1_2.Y sg13g2_hv_tiehi_5.L_HI 0.01677f
C942 VDD a_13768_6044# 0.94105f
C943 sg13g2_hv_or3_1_1.C sg13g2_hv_a21oi_1_5.A1 0.02174f
C944 VDD a_36040_13304# 1.01252f
C945 a_17473_7412# a_17512_8900# 0.03216f
C946 VDD a_11368_7592# 0.95341f
C947 sg13g2_hv_or3_1_1.C a_22312_8900# 0.02699f
C948 sg13g2_hv_o21ai_1_0.B1 sg13g2_hv_nand3_1_1.Y 0.09353f
C949 a_32968_13304# counter_value_o[6] 0.08153f
C950 a_13701_12068# sg13g2_hv_nand4_1_0.Y 0.05675f
C951 VDD a_1768_6044# 0.99738f
C952 sg13g2_hv_dfrbpq_1_1.CLK a_16262_8336# 0.03428f
C953 VDD a_14920_11756# 0.2517f
C954 a_29704_6044# a_30472_6044# 0.11571f
C955 sg13g2_hv_or3_1_1.B a_20968_10448# 0.02976f
C956 a_6902_7309# a_7681_7412# 0.12012f
C957 a_26087_7412# a_25721_8323# 0.07572f
C958 a_31432_11756# sg13g2_hv_o21ai_1_1.B1 0.16785f
C959 sg13g2_hv_a21oi_1_2.Y sg13g2_hv_a21oi_1_2.A2 0.07823f
C960 sg13g2_hv_or3_1_1.B sg13g2_hv_tiehi_2.L_HI 0.01092f
C961 a_2960_12117# a_4653_11649# 0.39112f
C962 sg13g2_hv_a21oi_1_1.B1 sg13g2_hv_a21oi_1_2.Y 0.22645f
C963 VDD a_7136_6044# 0.14529f
C964 sg13g2_hv_a21oi_1_1.B1 sg13g2_hv_a21oi_1_3.Y 0.23993f
C965 a_6992_7395# VDD 0.38408f
C966 a_8843_8259# a_8685_8259# 0.30349f
C967 a_28697_8729# a_27686_8716# 0.2572f
C968 sg13g2_hv_o21ai_1_1.B1 sg13g2_hv_dfrbpq_1_0.CLK 0.88769f
C969 sg13g2_hv_tiehi_3.L_HI sg13g2_hv_dfrbpq_1_1.CLK 0.24025f
C970 VDD a_10053_7386# 0.58879f
C971 sg13g2_hv_dfrbpq_1_0.CLK a_25192_8900# 0.014f
C972 a_19149_11649# sg13g2_hv_a21oi_1_1.B1 0.01343f
C973 a_31912_7592# a_32680_7592# 0.11571f
C974 VDD a_6021_12068# 0.59542f
C975 a_14233_11648# a_15195_11666# 0.01549f
C976 sg13g2_hv_o21ai_1_0.B1 counter_value_o[5] 0.03322f
C977 sg13g2_hv_or3_1_1.B a_15043_8026# 0.26053f
C978 VDD a_34984_7592# 0.9415f
C979 a_28208_9261# a_28118_8939# 0.47124f
C980 VDD a_24224_7592# 0.21754f
C981 a_18376_13304# sg13g2_hv_nand3_1_1.A 0.02095f
C982 sg13g2_hv_nand2b_1_0.B sg13g2_hv_dfrbpq_1_1.CLK 1.22052f
C983 a_21385_7443# a_21543_7443# 0.03803f
C984 a_15584_10448# VDD 0.14501f
C985 a_20517_12068# sg13g2_hv_nand3_1_1.A 0.20852f
C986 sg13g2_hv_o21ai_1_0.Y a_22421_7386# 0.08793f
C987 a_10888_8900# a_10600_7592# 0.015f
C988 a_26248_11756# a_24334_10242# 0.02908f
C989 sg13g2_hv_a21oi_1_1.B1 a_25232_7395# 0.01923f
C990 a_8589_11050# sg13g2_hv_buf_1_9.X 0.20665f
C991 sg13g2_hv_and2_1_0.B sg13g2_hv_dfrbpq_1_1.CLK 0.03984f
C992 a_37288_7592# a_38056_7592# 0.11571f
C993 a_33352_8900# VDD 0.95898f
C994 a_15195_11666# sg13g2_hv_nand2b_1_2.Y 0.35473f
C995 sg13g2_hv_buf_16_0.A clock_i 0.10956f
C996 a_25232_7395# a_25921_7412# 0.51508f
C997 a_34120_8900# a_34216_7592# 0.0222f
C998 sg13g2_hv_nand2_1_1.Y sg13g2_hv_a21oi_1_3.Y 0.10899f
C999 a_3016_13304# a_3200_13304# 0.12205f
C1000 a_4443_7520# a_3496_7592# 0.0181f
C1001 sg13g2_hv_or3_1_1.C a_23080_7592# 0.04984f
C1002 sg13g2_hv_or3_1_3.A a_29063_8838# 0.05359f
C1003 a_15400_10448# sg13g2_hv_or3_1_1.C 0.03037f
C1004 VDD a_3976_8900# 0.94535f
C1005 sg13g2_hv_buf_1_0.X a_3208_8900# 0.0116f
C1006 counter_value_o[3] clock_i 0.61243f
C1007 sg13g2_hv_a21oi_1_1.B1 a_12904_7592# 0.02804f
C1008 a_17473_7412# a_17273_8323# 0.02842f
C1009 a_16784_7395# a_17639_7412# 0.26354f
C1010 a_24821_12068# sg13g2_hv_o21ai_1_1.Y 0.08793f
C1011 sg13g2_hv_dfrbpq_1_1.CLK a_4811_11649# 0.06381f
C1012 a_3815_11694# a_5305_11792# 0.08792f
C1013 a_7847_7412# sg13g2_hv_dfrbpq_1_1.CLK 0.05313f
C1014 a_10640_12117# a_12491_11649# 0.01632f
C1015 sg13g2_hv_or3_1_1.B sg13g2_hv_a21oi_1_1.B1 0.07978f
C1016 VDD a_10120_8900# 0.9423f
C1017 VDD a_34216_10448# 0.9415f
C1018 sg13g2_hv_or3_1_3.A sg13g2_hv_a21oi_1_5.A1 0.47335f
C1019 VDD a_28352_10448# 0.21527f
C1020 sg13g2_hv_buf_1_0.X a_6280_10448# 0.08781f
C1021 sg13g2_hv_and2_1_0.X a_8589_11050# 0.18142f
C1022 sg13g2_hv_a21oi_1_1.B1 a_12424_8900# 0.027f
C1023 a_25288_13304# a_25480_11756# 0.01403f
C1024 sg13g2_hv_o21ai_1_0.B1 a_27734_11795# 0.1029f
C1025 a_9544_11756# a_8327_12110# 0.02958f
C1026 a_35656_8900# a_36424_8900# 0.11571f
C1027 sg13g2_hv_or3_1_1.B sg13g2_hv_nand3_1_1.Y 0.40415f
C1028 a_1192_13304# a_1192_11756# 0.01947f
C1029 a_18376_13304# VDD 0.99366f
C1030 sg13g2_hv_a21oi_1_2.A1 a_14593_8194# 0.01335f
C1031 a_23497_8772# a_23655_9213# 0.03803f
C1032 VDD a_20517_12068# 0.58949f
C1033 VDD a_2438_11572# 0.83014f
C1034 sg13g2_hv_o21ai_1_0.A2 a_21018_8772# 0.01868f
C1035 sg13g2_hv_nand2b_1_2.Y sg13g2_hv_a21oi_1_3.Y 0.01524f
C1036 sg13g2_hv_buf_16_0.A a_22504_10448# 0.06193f
C1037 sg13g2_hv_tiehi_0.L_HI sg13g2_hv_dfrbpq_1_0.CLK 0.03803f
C1038 a_31432_11756# a_32200_11756# 0.11571f
C1039 a_20968_10448# sg13g2_hv_buf_16_0.A 0.08808f
C1040 a_10550_11795# a_10640_12117# 0.47146f
C1041 sg13g2_hv_and2_1_0.X a_10118_11572# 0.2503f
C1042 a_28513_11551# a_28313_11585# 0.02842f
C1043 sg13g2_hv_nand2b_1_0.B sg13g2_hv_tiehi_1.L_HI 0.08575f
C1044 sg13g2_hv_buf_1_0.X sg13g2_hv_nand2_1_2.Y 0.15303f
C1045 counter_value_o[2] clock_i 0.03543f
C1046 a_10312_13304# VDD 0.94401f
C1047 sg13g2_hv_tiehi_3.L_HI a_10100_10155# 0.04859f
C1048 a_19307_11649# a_17456_12117# 0.01632f
C1049 a_16784_7395# a_16694_7309# 0.47124f
C1050 a_31144_10448# a_31912_10448# 0.11571f
C1051 a_36424_8900# a_36520_10448# 0.01675f
C1052 sg13g2_hv_dfrbpq_1_4.RESET_B a_28679_11694# 0.21244f
C1053 a_3976_10448# a_4744_10448# 0.11571f
C1054 a_5512_10448# a_5512_8900# 0.01947f
C1055 a_6280_8900# a_7048_8900# 0.11571f
C1056 VDD a_16744_8900# 0.94449f
C1057 a_13192_8900# a_12904_7592# 0.015f
C1058 a_27824_12117# a_28679_11694# 0.26366f
C1059 VDD a_26728_8900# 0.95291f
C1060 a_36808_11756# a_37576_11756# 0.11571f
C1061 a_17639_7412# a_16262_8336# 0.28559f
C1062 a_28897_8695# sg13g2_hv_dfrbpq_1_7.RESET_B 0.12385f
C1063 sg13g2_hv_o21ai_1_0.B1 sg13g2_hv_a21oi_1_4.Y 0.02638f
C1064 a_7481_8323# a_6470_8336# 0.2572f
C1065 sg13g2_hv_tiehi_3.L_HI a_10640_12117# 0.52313f
C1066 sg13g2_hv_a21oi_1_2.A1 sg13g2_hv_a21oi_1_2.Y 0.12022f
C1067 sg13g2_hv_tiehi_4.L_HI a_19801_11792# 0.22463f
C1068 a_29608_7592# a_29704_6044# 0.01675f
C1069 a_12424_8900# a_13192_8900# 0.11571f
C1070 a_32392_13098# VDD 0.45553f
C1071 VDD sg13g2_hv_and2_1_1.X 0.52373f
C1072 a_6470_8336# sg13g2_hv_a21oi_1_1.B1 0.02223f
C1073 sg13g2_hv_or3_1_1.A sg13g2_hv_dfrbpq_1_1.CLK 0.08693f
C1074 sg13g2_hv_or3_1_1.B a_21448_13304# 0.02831f
C1075 a_22408_13098# a_22216_13304# 0.02109f
C1076 a_15976_8900# sg13g2_hv_or3_1_1.C 0.01204f
C1077 sg13g2_hv_a21oi_1_5.A1 a_24334_10242# 0.15362f
C1078 counter_value_o[1] a_7596_13011# 0.30213f
C1079 a_7847_7412# sg13g2_hv_tiehi_1.L_HI 0.21242f
C1080 VDD a_25480_11756# 0.96412f
C1081 a_37288_10448# a_38056_10448# 0.11571f
C1082 a_15476_7443# a_15043_8026# 0.02494f
C1083 VDD a_26632_6044# 0.9415f
C1084 sg13g2_hv_nand2b_1_0.B sg13g2_hv_dfrbpq_1_1.D 0.05503f
C1085 a_2728_7592# a_3496_7592# 0.11571f
C1086 counter_value_o[1] clock_i 0.03543f
C1087 a_30376_10448# sg13g2_hv_o21ai_1_1.B1 0.01649f
C1088 a_18311_11694# a_16934_11572# 0.28559f
C1089 a_12136_7592# a_12904_7592# 0.11571f
C1090 VDD sg13g2_hv_a21oi_1_4.A2 0.48527f
C1091 sg13g2_hv_nand2b_1_0.B sg13g2_hv_nand2b_1_1.Y 0.049f
C1092 a_27302_11572# a_28313_11585# 0.2572f
C1093 a_27577_7966# sg13g2_hv_tiehi_0.L_HI 0.2166f
C1094 sg13g2_hv_a21oi_1_1.B1 sg13g2_hv_a21oi_1_5.Y 0.36253f
C1095 sg13g2_hv_or3_1_3.A a_32584_8900# 0.06744f
C1096 VDD a_32008_6044# 0.96914f
C1097 sg13g2_hv_o21ai_1_0.B1 sg13g2_hv_dfrbpq_1_0.CLK 0.28493f
C1098 sg13g2_hv_or3_1_1.B counter_value_o[4] 0.11406f
C1099 a_33544_6044# a_33448_7592# 0.01675f
C1100 a_30059_8793# a_30553_8936# 0.44368f
C1101 sg13g2_hv_or3_1_1.B a_19816_8900# 0.1089f
C1102 a_20680_13304# a_21448_13304# 0.11571f
C1103 a_16262_8336# a_16694_7309# 0.47309f
C1104 a_36520_10448# a_37288_10448# 0.11571f
C1105 sg13g2_hv_a21oi_1_1.B1 sg13g2_hv_buf_16_0.A 0.57711f
C1106 sg13g2_hv_a21oi_1_1.B1 a_19801_11792# 0.01289f
C1107 a_12424_8900# a_12136_7592# 0.015f
C1108 a_27302_11572# a_28513_11551# 0.09667f
C1109 sg13g2_hv_tiehi_4.L_HI a_18311_11694# 0.21244f
C1110 a_21352_8900# a_21536_8900# 0.12205f
C1111 a_13768_13304# a_14536_13304# 0.11571f
C1112 sg13g2_hv_nand4_1_0.C a_14233_11648# 0.13318f
C1113 VDD a_16784_7395# 0.38408f
C1114 a_27686_8716# sg13g2_hv_dfrbpq_1_7.RESET_B 0.36122f
C1115 VDD a_38720_8900# 0.13838f
C1116 sg13g2_hv_or3_1_1.C a_23785_11628# 0.23886f
C1117 a_24821_12068# sg13g2_hv_a21oi_1_1.B1 0.02921f
C1118 a_18184_6044# a_18952_6044# 0.11571f
C1119 sg13g2_hv_nand3_1_1.Y sg13g2_hv_buf_16_0.A 0.07017f
C1120 sg13g2_hv_or3_1_3.A a_33448_10448# 0.01084f
C1121 VDD a_3688_13304# 0.99159f
C1122 sg13g2_hv_a21oi_1_1.B1 sg13g2_hv_nand3_1_0.Y 0.01066f
C1123 sg13g2_hv_or3_1_1.C sg13g2_hv_o21ai_1_0.A2 0.53029f
C1124 sg13g2_hv_buf_1_9.X a_1773_11050# 0.29386f
C1125 VDD a_1192_10242# 0.42295f
C1126 a_31528_13304# sg13g2_hv_o21ai_1_1.B1 0.01999f
C1127 counter_value_o[0] clock_i 0.03543f
C1128 sg13g2_hv_or3_1_1.B sg13g2_hv_a21oi_1_2.A1 0.3145f
C1129 VDD a_12491_11649# 0.61905f
C1130 sg13g2_hv_nand3_1_1.A a_17456_12117# 0.06566f
C1131 a_2870_11795# a_3649_11551# 0.12012f
C1132 sg13g2_hv_and2_1_1.X a_2438_11572# 0.25287f
C1133 sg13g2_hv_dfrbpq_1_4.RESET_B VDD 2.46973f
C1134 sg13g2_hv_tiehi_0.L_HI a_25142_7309# 0.4594f
C1135 a_3496_7592# a_3304_6044# 0.01403f
C1136 a_27686_8716# a_28837_9436# 0.01695f
C1137 VDD a_33736_11756# 0.94102f
C1138 a_23560_6044# a_24328_6044# 0.11571f
C1139 a_27824_12117# VDD 0.38718f
C1140 sg13g2_hv_nand2_1_1.Y sg13g2_hv_buf_16_0.A 0.02336f
C1141 sg13g2_hv_a21oi_1_1.B1 a_18311_11694# 0.01955f
C1142 a_19048_8900# a_19816_8900# 0.11571f
C1143 a_9928_6044# a_10696_6044# 0.11571f
C1144 a_13192_8900# sg13g2_hv_buf_16_0.A 0.01741f
C1145 sg13g2_hv_o21ai_1_0.B1 a_27577_7966# 0.14008f
C1146 sg13g2_hv_buf_16_0.A a_13864_10448# 0.12228f
C1147 VDD a_10550_11795# 0.41578f
C1148 sg13g2_hv_or3_1_1.C sg13g2_hv_o21ai_1_1.Y 0.04062f
C1149 sg13g2_hv_o21ai_1_0.B1 a_21385_7443# 0.43315f
C1150 a_30885_12068# VDD 0.58933f
C1151 a_25232_7395# sg13g2_hv_dfrbpq_1_0.CLK 0.11218f
C1152 sg13g2_hv_nand4_1_1.Y a_23785_11628# 0.30207f
C1153 VDD a_28897_8695# 0.93341f
C1154 sg13g2_hv_or3_1_3.A a_25960_8900# 0.03921f
C1155 sg13g2_hv_tiehi_0.L_HI a_24710_8336# 0.32602f
C1156 sg13g2_hv_buf_1_9.X sg13g2_hv_xnor2_1_1.Y 0.20079f
C1157 sg13g2_hv_o21ai_1_0.B1 a_28840_7592# 0.09833f
C1158 a_17580_13011# sg13g2_hv_tiehi_4.L_HI 0.11756f
C1159 a_4264_7592# sg13g2_hv_buf_1_0.X 0.06447f
C1160 sg13g2_hv_nand2b_1_0.B a_11368_7592# 0.0119f
C1161 VDD a_16262_8336# 0.78218f
C1162 a_3976_10448# sg13g2_hv_xnor2_1_1.A 0.10152f
C1163 a_17945_11585# a_16934_11572# 0.2572f
C1164 a_27577_7966# a_27083_8259# 0.44368f
C1165 a_17416_6044# a_18184_6044# 0.11571f
C1166 a_6280_10448# sg13g2_hv_buf_1_9.X 0.09884f
C1167 VDD a_23272_10448# 0.25884f
C1168 a_15304_6044# a_16072_6044# 0.11571f
C1169 a_31432_11756# a_31144_10448# 0.015f
C1170 a_21832_11756# sg13g2_hv_nand3_1_1.A 0.05615f
C1171 a_28456_13304# VDD 0.99035f
C1172 a_23752_13304# VDD 0.94252f
C1173 sg13g2_hv_o21ai_1_0.Y sg13g2_hv_a21oi_1_0.Y 0.10389f
C1174 a_21385_7443# sg13g2_hv_a21oi_1_0.A2 0.26585f
C1175 VDD a_16072_13304# 1.01268f
C1176 VDD a_20488_6044# 0.94013f
C1177 a_13701_12068# a_12985_11792# 0.11973f
C1178 a_12333_11649# a_11495_11694# 0.01699f
C1179 a_12930_12109# a_12491_11649# 0.01321f
C1180 VDD a_17456_12117# 0.38408f
C1181 VDD sg13g2_hv_tiehi_3.L_HI 2.35631f
C1182 VDD a_36616_6044# 0.94466f
C1183 sg13g2_hv_or3_1_1.B sg13g2_hv_dfrbpq_1_0.CLK 0.03514f
C1184 sg13g2_hv_a21oi_1_1.B1 sg13g2_hv_or3_1_3.X 0.01149f
C1185 sg13g2_hv_nand2b_1_0.B a_6992_7395# 0.07464f
C1186 a_35848_6044# a_35752_7592# 0.01675f
C1187 a_29675_11649# a_30376_10448# 0.02326f
C1188 a_3815_11694# a_3449_11585# 0.07572f
C1189 sg13g2_hv_nand2b_1_0.B a_10053_7386# 0.18208f
C1190 a_3304_6044# a_4072_6044# 0.11571f
C1191 a_28840_7592# a_29608_7592# 0.11571f
C1192 sg13g2_hv_o21ai_1_0.B1 a_25142_7309# 0.05018f
C1193 sg13g2_hv_o21ai_1_0.B1 sg13g2_hv_o21ai_1_0.Y 0.4012f
C1194 a_2336_13304# counter_value_o[0] 0.01877f
C1195 VDD a_12232_6044# 0.97504f
C1196 sg13g2_hv_or3_1_1.C a_22504_10448# 0.0907f
C1197 VDD a_34504_13304# 0.94031f
C1198 sg13g2_hv_or3_1_3.A a_23785_11628# 0.04331f
C1199 a_14056_7592# sg13g2_hv_a21oi_1_2.Y 0.03064f
C1200 sg13g2_hv_nand4_1_1.Y sg13g2_hv_o21ai_1_1.Y 0.12845f
C1201 sg13g2_hv_nand2b_1_0.B VDD 3.80506f
C1202 a_15893_12068# sg13g2_hv_a21oi_1_3.Y 0.10321f
C1203 sg13g2_hv_nand2_1_2.Y sg13g2_hv_buf_1_9.X 0.02437f
C1204 sg13g2_hv_a21oi_1_0.Y a_24710_8336# 0.24703f
C1205 sg13g2_hv_or3_1_1.C sg13g2_hv_tiehi_2.L_HI 0.04727f
C1206 sg13g2_hv_nand4_1_0.C a_11495_11694# 0.07997f
C1207 a_28936_6044# a_29704_6044# 0.11571f
C1208 a_13864_10448# sg13g2_hv_nand4_1_0.Y 0.01077f
C1209 VDD sg13g2_hv_and2_1_0.B 0.57778f
C1210 VDD a_27686_8716# 0.77911f
C1211 sg13g2_hv_nand4_1_0.C sg13g2_hv_xnor2_1_1.A 0.34418f
C1212 sg13g2_hv_or3_1_1.B a_21352_8900# 0.08366f
C1213 a_26087_7412# a_25921_7412# 0.60436f
C1214 a_17512_8900# clock_i 0.02012f
C1215 a_2960_12117# a_3449_11585# 0.35847f
C1216 a_14233_11648# sg13g2_hv_nand4_1_0.Y 0.4304f
C1217 sg13g2_hv_o21ai_1_0.Y sg13g2_hv_a21oi_1_0.A2 0.20794f
C1218 VDD a_5608_6044# 0.94124f
C1219 sg13g2_hv_a21oi_1_5.A1 a_23604_10194# 0.01897f
C1220 sg13g2_hv_o21ai_1_0.B1 a_24710_8336# 0.04535f
C1221 sg13g2_hv_or3_1_1.C a_15043_8026# 0.28808f
C1222 a_24334_10242# a_25960_8900# 0.02148f
C1223 a_7681_7412# a_7481_8323# 0.02842f
C1224 a_6992_7395# a_7847_7412# 0.26354f
C1225 a_19129_7966# sg13g2_hv_tiehi_2.L_HI 0.2166f
C1226 a_8654_11628# sg13g2_hv_dfrbpq_1_1.CLK 0.01424f
C1227 a_35272_11756# sg13g2_hv_o21ai_1_1.B1 0.05003f
C1228 a_17945_11585# sg13g2_hv_a21oi_1_1.B1 0.01154f
C1229 a_31144_7592# a_31912_7592# 0.11571f
C1230 sg13g2_hv_nand3_1_0.Y a_8812_12068# 0.01541f
C1231 a_9337_7966# a_8843_8259# 0.44368f
C1232 VDD a_21832_11756# 0.2541f
C1233 a_28679_11694# sg13g2_hv_o21ai_1_1.B1 0.0628f
C1234 a_27564_13011# VDD 0.42628f
C1235 sg13g2_hv_a21oi_1_4.Y a_27200_11756# 0.07375f
C1236 a_7681_7412# sg13g2_hv_a21oi_1_1.B1 0.03014f
C1237 VDD a_4811_11649# 0.58634f
C1238 a_4811_11649# a_6021_12068# 0.25683f
C1239 a_26056_13304# counter_value_o[5] 0.01736f
C1240 a_5115_7520# sg13g2_hv_nand2b_1_1.Y 0.36399f
C1241 a_7847_7412# VDD 0.71737f
C1242 sg13g2_hv_nand2b_1_0.B a_2621_11072# 0.02227f
C1243 sg13g2_hv_nand2b_1_0.B a_3976_8900# 0.10495f
C1244 VDD a_33448_7592# 0.95312f
C1245 sg13g2_hv_xnor2_1_1.A a_8327_12110# 0.01149f
C1246 sg13g2_hv_or3_1_3.A sg13g2_hv_o21ai_1_1.Y 0.24747f
C1247 VDD a_22421_7386# 0.18765f
C1248 sg13g2_hv_a21oi_1_1.B1 sg13g2_hv_buf_1_0.X 0.34322f
C1249 a_22984_13304# sg13g2_hv_nand4_1_1.Y 0.01379f
C1250 a_14632_10448# VDD 0.94687f
C1251 sg13g2_hv_or3_1_1.A sg13g2_hv_nand3_1_1.A 0.22137f
C1252 sg13g2_hv_or3_1_3.A a_32968_11756# 0.02677f
C1253 a_36520_7592# a_37288_7592# 0.11571f
C1254 a_31816_8900# VDD 0.99386f
C1255 a_25142_7309# a_25232_7395# 0.47124f
C1256 sg13g2_hv_nand4_1_0.C a_13768_13304# 0.01537f
C1257 a_24821_12068# sg13g2_hv_a21oi_1_4.Y 0.10402f
C1258 a_33352_8900# a_33448_7592# 0.0222f
C1259 sg13g2_hv_dfrbpq_1_1.CLK sg13g2_hv_a21oi_1_2.Y 0.50543f
C1260 sg13g2_hv_or3_1_3.A a_28208_9261# 0.07573f
C1261 sg13g2_hv_nand2b_1_0.B a_2438_11572# 0.06116f
C1262 a_10312_13304# sg13g2_hv_tiehi_3.L_HI 0.01116f
C1263 sg13g2_hv_a21oi_1_1.B1 sg13g2_hv_or3_1_1.C 0.69463f
C1264 sg13g2_hv_dfrbpq_1_0.CLK sg13g2_hv_a21oi_1_5.Y 0.05476f
C1265 a_7681_7412# a_7816_8900# 0.02726f
C1266 sg13g2_hv_buf_1_0.X a_1192_8900# 0.01891f
C1267 a_8008_13304# counter_value_o[1] 0.01475f
C1268 sg13g2_hv_xnor2_1_1.Y a_1773_11050# 0.36767f
C1269 a_9352_8900# a_8843_8259# 0.01541f
C1270 sg13g2_hv_tiehi_5.L_HI a_3016_13304# 0.01495f
C1271 sg13g2_hv_nand3_1_1.A a_20584_8900# 0.05123f
C1272 sg13g2_hv_or3_1_3.A a_31269_9212# 0.20207f
C1273 a_11329_11551# a_11495_11694# 0.59728f
C1274 sg13g2_hv_xnor2_1_1.A sg13g2_hv_nand3_1_0.Y 0.31151f
C1275 VDD a_8584_8900# 0.94262f
C1276 VDD a_32680_10448# 1.02079f
C1277 sg13g2_hv_nand3_1_1.Y sg13g2_hv_or3_1_1.C 1.4072f
C1278 VDD a_5512_10448# 0.94335f
C1279 sg13g2_hv_dfrbpq_1_0.CLK a_19801_11792# 0.03864f
C1280 sg13g2_hv_buf_1_0.X a_7048_8900# 0.05103f
C1281 a_24710_8336# a_25232_7395# 0.25017f
C1282 sg13g2_hv_o21ai_1_0.Y a_22579_8194# 0.01431f
C1283 sg13g2_hv_o21ai_1_1.B1 a_36040_13304# 0.02832f
C1284 sg13g2_hv_or3_1_1.B sg13g2_hv_o21ai_1_0.Y 0.02293f
C1285 sg13g2_hv_tiehi_5.L_HI sg13g2_hv_xnor2_1_1.A 0.02938f
C1286 sg13g2_hv_a21oi_1_1.B1 a_10888_8900# 0.02062f
C1287 a_8187_11670# a_8327_12110# 0.03534f
C1288 VDD a_13960_8900# 1.01573f
C1289 a_34888_8900# a_35656_8900# 0.11571f
C1290 sg13g2_hv_or3_1_1.B a_17326_10242# 0.0242f
C1291 a_16250_11072# sg13g2_hv_nand2_1_1.Y 0.01798f
C1292 sg13g2_hv_nand4_1_1.Y a_21064_11756# 0.02736f
C1293 VDD sg13g2_hv_or3_1_1.A 1.4029f
C1294 enable_i a_1768_6044# 0.01185f
C1295 sg13g2_hv_nand2b_1_0.B sg13g2_hv_and2_1_1.X 0.06924f
C1296 sg13g2_hv_nand2_1_1.Y sg13g2_hv_or3_1_1.C 0.17273f
C1297 a_22216_13304# VDD 0.24141f
C1298 VDD a_2522_10879# 0.56568f
C1299 a_15584_10448# sg13g2_hv_or3_1_1.A 0.02008f
C1300 a_8776_13304# VDD 0.942f
C1301 a_11495_11694# sg13g2_hv_nand4_1_0.Y 0.03356f
C1302 a_16784_7395# a_16262_8336# 0.25017f
C1303 a_30376_10448# a_31144_10448# 0.11571f
C1304 a_22408_13098# sg13g2_hv_or3_1_1.B 0.40423f
C1305 sg13g2_hv_or3_1_1.C a_13864_10448# 0.01551f
C1306 a_35656_8900# a_35752_10448# 0.01675f
C1307 sg13g2_hv_dfrbpq_1_4.RESET_B a_27824_12117# 0.52709f
C1308 sg13g2_hv_dfrbpq_1_1.CLK a_12904_7592# 0.05711f
C1309 a_5512_8900# a_6280_8900# 0.11571f
C1310 a_4744_10448# a_4744_8900# 0.01947f
C1311 sg13g2_hv_xnor2_1_1.A sg13g2_hv_nand4_1_0.Y 0.52782f
C1312 VDD sg13g2_hv_o21ai_1_1.B1 2.81391f
C1313 sg13g2_hv_or3_1_1.B sg13g2_hv_dfrbpq_1_1.CLK 0.01839f
C1314 a_18311_11694# sg13g2_hv_dfrbpq_1_0.CLK 0.06505f
C1315 VDD a_25192_8900# 0.96306f
C1316 a_3815_11694# a_4744_10448# 0.01084f
C1317 a_14233_11648# sg13g2_hv_or3_1_1.C 0.52717f
C1318 sg13g2_hv_or3_1_1.B a_18635_8259# 0.03377f
C1319 reset_n_i sg13g2_hv_buf_1_9.X 0.0449f
C1320 VDD enable_i 0.34224f
C1321 a_17473_7412# sg13g2_hv_tiehi_2.L_HI 0.12885f
C1322 VDD a_20584_8900# 0.26736f
C1323 sg13g2_hv_dfrbpq_1_1.CLK a_9256_10448# 0.05954f
C1324 a_18635_8259# a_19845_7386# 0.25683f
C1325 a_28679_11694# a_29675_11649# 0.39137f
C1326 a_28840_7592# a_28936_6044# 0.01675f
C1327 a_11656_8900# a_12424_8900# 0.11571f
C1328 sg13g2_hv_or3_1_1.B a_20392_7592# 0.05375f
C1329 VDD a_2870_11795# 0.45503f
C1330 a_30553_8936# sg13g2_hv_dfrbpq_1_7.RESET_B 0.22463f
C1331 a_35752_10448# a_36520_10448# 0.11571f
C1332 VDD a_5115_7520# 0.41932f
C1333 a_15680_9260# sg13g2_hv_or3_1_1.C 0.01644f
C1334 a_17224_13304# clock_i 0.02345f
C1335 a_4443_7520# sg13g2_hv_buf_1_0.X 0.2478f
C1336 a_17326_10242# a_19048_8900# 0.02119f
C1337 sg13g2_hv_nand2_1_2.Y a_3208_8900# 0.01891f
C1338 a_2522_10879# a_2621_11072# 0.36475f
C1339 VDD a_23062_11620# 0.01456f
C1340 a_19845_7386# a_20392_7592# 0.02946f
C1341 a_3976_10448# a_3649_11551# 0.01654f
C1342 sg13g2_hv_tiehi_3.L_HI a_12491_11649# 0.165f
C1343 sg13g2_hv_nand2_1_2.Y sg13g2_hv_xnor2_1_1.Y 0.07856f
C1344 sg13g2_hv_or3_1_3.A sg13g2_hv_a21oi_1_1.B1 0.34981f
C1345 sg13g2_hv_dfrbpq_1_4.RESET_B a_28456_13304# 0.02901f
C1346 a_1960_7592# a_2728_7592# 0.11571f
C1347 a_28208_9261# a_29063_8838# 0.26366f
C1348 a_2604_13011# sg13g2_hv_tiehi_5.L_HI 0.03497f
C1349 sg13g2_hv_or3_1_3.A counter_value_o[6] 0.11406f
C1350 counter_value_o[1] sg13g2_hv_xnor2_1_1.A 0.05093f
C1351 sg13g2_hv_o21ai_1_0.B1 sg13g2_hv_dfrbpq_1_7.RESET_B 0.09839f
C1352 a_20392_7592# a_20576_7592# 0.12205f
C1353 VDD a_7424_10448# 0.17654f
C1354 VDD a_30472_6044# 0.94079f
C1355 a_19149_11649# a_19307_11649# 0.30349f
C1356 sg13g2_hv_or3_1_3.A sg13g2_hv_nand3_1_1.Y 0.58084f
C1357 a_32776_6044# a_32680_7592# 0.01675f
C1358 sg13g2_hv_or3_1_1.B a_18280_8900# 0.06962f
C1359 sg13g2_hv_nand4_1_0.C sg13g2_hv_dfrbpq_1_1.CLK 0.36201f
C1360 a_19912_13304# a_20680_13304# 0.11571f
C1361 a_14427_7386# sg13g2_hv_a21oi_1_2.Y 0.12657f
C1362 sg13g2_hv_tiehi_3.L_HI a_10550_11795# 0.39449f
C1363 a_19048_8900# a_18635_8259# 0.01191f
C1364 a_27083_8259# sg13g2_hv_dfrbpq_1_7.RESET_B 0.04036f
C1365 a_13000_13304# a_13768_13304# 0.11571f
C1366 a_26087_7412# sg13g2_hv_dfrbpq_1_0.CLK 0.05226f
C1367 sg13g2_hv_a21oi_1_2.A1 sg13g2_hv_or3_1_1.C 0.09355f
C1368 VDD a_37192_8900# 0.9415f
C1369 a_17326_10242# sg13g2_hv_buf_16_0.A 3.11091f
C1370 sg13g2_hv_or3_1_1.A a_16744_8900# 0.01593f
C1371 sg13g2_hv_or3_1_3.A a_31912_10448# 0.11787f
C1372 VDD a_3200_13304# 0.15328f
C1373 a_22312_8900# a_22504_10448# 0.01403f
C1374 sg13g2_hv_nand3_1_1.A a_21736_10448# 0.03118f
C1375 sg13g2_hv_tiehi_1.L_HI a_6280_8900# 0.01626f
C1376 sg13g2_hv_dfrbpq_1_1.CLK a_8327_12110# 0.02281f
C1377 VDD a_38720_11756# 0.20829f
C1378 VDD a_15976_7592# 0.25031f
C1379 a_31528_13304# a_32288_13304# 0.12205f
C1380 a_12588_13011# a_12232_13304# 0.02578f
C1381 sg13g2_hv_nand3_1_1.A a_17366_11795# 0.09382f
C1382 VDD sg13g2_hv_tiehi_0.L_HI 2.43785f
C1383 VDD a_23220_12116# 0.03128f
C1384 sg13g2_hv_buf_1_0.X sg13g2_hv_xnor2_1_1.A 0.28076f
C1385 a_16934_11572# a_18145_11551# 0.09667f
C1386 sg13g2_hv_a21oi_1_1.B1 sg13g2_hv_buf_1_9.X 0.14709f
C1387 sg13g2_hv_o21ai_1_0.B1 sg13g2_hv_nand3_1_1.A 0.05777f
C1388 sg13g2_hv_dfrbpq_1_4.RESET_B a_27564_13011# 0.06201f
C1389 a_2870_11795# a_2438_11572# 0.47309f
C1390 a_2728_7592# a_2536_6044# 0.01403f
C1391 VDD a_32200_11756# 0.97418f
C1392 a_27686_8716# a_28897_8695# 0.09667f
C1393 a_22792_6044# a_23560_6044# 0.11571f
C1394 sg13g2_hv_a21oi_1_1.B1 a_24334_10242# 0.24145f
C1395 a_37384_13098# a_37192_13304# 0.02109f
C1396 a_2522_10879# sg13g2_hv_and2_1_1.X 0.02566f
C1397 a_18280_8900# a_19048_8900# 0.11571f
C1398 a_9160_6044# a_9928_6044# 0.11571f
C1399 a_10100_10155# a_9256_10448# 0.03513f
C1400 sg13g2_hv_tiehi_4.L_HI a_18145_11551# 0.12789f
C1401 a_5971_8194# sg13g2_hv_nand2b_1_0.Y 0.01431f
C1402 sg13g2_hv_or3_1_1.C a_22888_11756# 0.07658f
C1403 a_29675_11649# VDD 0.58666f
C1404 a_15195_11666# a_14920_11756# 0.01174f
C1405 a_17326_10242# a_18311_11694# 0.01208f
C1406 sg13g2_hv_dfrbpq_1_1.D a_6280_8900# 0.01018f
C1407 a_37960_13304# a_38720_13304# 0.12205f
C1408 sg13g2_hv_and2_1_0.B sg13g2_hv_tiehi_3.L_HI 0.01208f
C1409 a_25480_11756# sg13g2_hv_o21ai_1_1.B1 0.02846f
C1410 VDD a_3496_7592# 0.95026f
C1411 sg13g2_hv_dfrbpq_1_1.CLK sg13g2_hv_nand3_1_0.Y 0.04109f
C1412 a_2728_7592# sg13g2_hv_buf_1_0.X 0.05748f
C1413 sg13g2_hv_or3_1_1.B a_22396_11632# 0.01418f
C1414 sg13g2_hv_dfrbpq_1_1.CLK a_11329_11551# 0.41974f
C1415 sg13g2_hv_nand3_1_1.A sg13g2_hv_a21oi_1_3.Y 0.16884f
C1416 a_26087_7412# a_27577_7966# 0.08899f
C1417 a_17473_7412# a_18477_8259# 0.02728f
C1418 VDD sg13g2_hv_a21oi_1_0.Y 0.44832f
C1419 VDD a_30553_8936# 0.3181f
C1420 sg13g2_hv_or3_1_1.C sg13g2_hv_dfrbpq_1_0.CLK 0.58394f
C1421 VDD a_21736_10448# 0.96739f
C1422 sg13g2_hv_dfrbpq_1_1.CLK sg13g2_hv_tiehi_5.L_HI 0.057f
C1423 sg13g2_hv_nand2b_1_0.Y sg13g2_hv_a21oi_1_1.B1 0.08973f
C1424 a_14536_6044# a_15304_6044# 0.11571f
C1425 VDD a_21536_8900# 0.14768f
C1426 VDD a_36808_11756# 0.94616f
C1427 VDD a_15195_11666# 0.44303f
C1428 VDD a_14536_13304# 0.94236f
C1429 sg13g2_hv_o21ai_1_1.B1 sg13g2_hv_a21oi_1_4.A2 0.06918f
C1430 VDD a_18952_6044# 0.94145f
C1431 a_11129_11585# a_11495_11694# 0.07572f
C1432 a_12333_11649# a_10640_12117# 0.39112f
C1433 a_29901_8793# a_29063_8838# 0.01699f
C1434 VDD a_17366_11795# 0.41607f
C1435 sg13g2_hv_a21oi_1_1.B1 sg13g2_hv_a21oi_1_5.A1 0.29381f
C1436 sg13g2_hv_tiehi_1.L_HI a_6470_8336# 0.36071f
C1437 VDD a_35080_6044# 0.94079f
C1438 a_9160_6044# a_8392_6044# 0.11571f
C1439 a_29608_10448# sg13g2_hv_dfrbpq_1_0.CLK 0.0543f
C1440 sg13g2_hv_a21oi_1_1.B1 a_22312_8900# 0.0106f
C1441 sg13g2_hv_o21ai_1_0.B1 VDD 3.43442f
C1442 a_35080_6044# a_34984_7592# 0.01675f
C1443 VDD a_24328_6044# 0.94333f
C1444 sg13g2_hv_a21oi_1_1.B1 a_18145_11551# 0.02917f
C1445 a_2536_6044# a_3304_6044# 0.11571f
C1446 a_2604_13011# counter_value_o[0] 0.3022f
C1447 VDD a_10696_6044# 0.94079f
C1448 sg13g2_hv_xnor2_1_1.A a_2960_12117# 0.01594f
C1449 sg13g2_hv_nand3_1_1.Y sg13g2_hv_a21oi_1_5.A1 0.0571f
C1450 sg13g2_hv_nand4_1_1.Y a_22888_11756# 0.0149f
C1451 sg13g2_hv_dfrbpq_1_0.CLK a_28840_10448# 0.14995f
C1452 VDD a_32968_13304# 1.05246f
C1453 a_1192_13304# VDD 1.04429f
C1454 sg13g2_hv_tiehi_5.L_HI a_3649_11551# 0.1307f
C1455 a_36040_11756# a_35752_10448# 0.015f
C1456 sg13g2_hv_nand2b_1_0.B a_7847_7412# 0.07765f
C1457 sg13g2_hv_nand3_1_1.Y a_22312_8900# 0.0716f
C1458 a_27016_11756# a_27200_11756# 0.12205f
C1459 sg13g2_hv_dfrbpq_1_1.CLK sg13g2_hv_nand4_1_0.Y 0.25337f
C1460 VDD a_27083_8259# 0.58823f
C1461 sg13g2_hv_nand4_1_0.C a_10640_12117# 0.04803f
C1462 sg13g2_hv_a21oi_1_1.B1 a_10600_7592# 0.02103f
C1463 VDD a_16072_6044# 0.94272f
C1464 VDD sg13g2_hv_a21oi_1_0.A2 0.49642f
C1465 a_28168_6044# a_28936_6044# 0.11571f
C1466 a_26087_7412# a_25142_7309# 0.06127f
C1467 a_24533_9212# sg13g2_hv_a21oi_1_5.Y 0.10398f
C1468 sg13g2_hv_nand4_1_1.Y sg13g2_hv_dfrbpq_1_0.CLK 0.11617f
C1469 a_7624_6044# a_8392_6044# 0.11571f
C1470 VDD a_29608_7592# 0.94271f
C1471 VDD a_4072_6044# 0.94154f
C1472 VDD sg13g2_hv_a21oi_1_2.Y 0.5671f
C1473 VDD sg13g2_hv_a21oi_1_3.Y 0.63925f
C1474 sg13g2_hv_dfrbpq_1_7.RESET_B a_28118_8939# 0.44203f
C1475 sg13g2_hv_dfrbpq_1_4.RESET_B sg13g2_hv_o21ai_1_1.B1 0.09497f
C1476 sg13g2_hv_dfrbpq_1_1.D a_6470_8336# 0.25945f
C1477 sg13g2_hv_or3_1_1.B sg13g2_hv_nand3_1_1.A 0.78265f
C1478 a_33736_11756# sg13g2_hv_o21ai_1_1.B1 0.05003f
C1479 a_30376_7592# a_31144_7592# 0.11571f
C1480 a_27824_12117# sg13g2_hv_o21ai_1_1.B1 0.07173f
C1481 a_1192_11756# sg13g2_hv_buf_1_9.X 0.02329f
C1482 a_6902_7309# sg13g2_hv_a21oi_1_1.B1 0.02693f
C1483 sg13g2_hv_a21oi_1_4.Y a_26248_11756# 0.06929f
C1484 a_10100_10155# sg13g2_hv_buf_16_0.A 1.03345f
C1485 VDD a_17416_6044# 0.99035f
C1486 a_21385_7443# sg13g2_hv_or3_1_1.C 0.26401f
C1487 VDD a_31912_7592# 0.96737f
C1488 sg13g2_hv_a21oi_1_1.B1 a_8843_8259# 0.03434f
C1489 sg13g2_hv_or3_1_3.A a_22888_11756# 0.05996f
C1490 a_26087_7412# a_24710_8336# 0.28559f
C1491 a_19307_11649# a_19801_11792# 0.44368f
C1492 a_12232_13304# counter_value_o[2] 0.03999f
C1493 a_30885_12068# sg13g2_hv_o21ai_1_1.B1 0.2068f
C1494 a_34312_6044# a_34216_7592# 0.01675f
C1495 a_9337_7966# sg13g2_hv_a21oi_1_1.B1 0.02063f
C1496 sg13g2_hv_nand2b_1_0.B a_8584_8900# 0.02213f
C1497 a_24979_11650# sg13g2_hv_o21ai_1_1.Y 0.01431f
C1498 sg13g2_hv_or3_1_3.A a_31432_11756# 0.04099f
C1499 sg13g2_hv_o21ai_1_0.B1 a_20662_8224# 0.03264f
C1500 sg13g2_hv_a21oi_1_1.B1 a_23080_7592# 0.08131f
C1501 VDD a_37288_7592# 0.9415f
C1502 VDD a_25232_7395# 0.38408f
C1503 a_20680_13304# sg13g2_hv_nand3_1_1.A 0.01043f
C1504 a_35752_7592# a_36520_7592# 0.11571f
C1505 sg13g2_hv_or3_1_3.A sg13g2_hv_dfrbpq_1_0.CLK 0.8046f
C1506 a_11329_11551# a_10100_10155# 0.05173f
C1507 a_17024_10448# VDD 0.22088f
C1508 a_28513_11551# a_27734_11795# 0.12012f
C1509 sg13g2_hv_o21ai_1_1.Y a_23785_11628# 0.09035f
C1510 a_32584_8900# a_32680_7592# 0.0222f
C1511 a_26248_11756# sg13g2_hv_dfrbpq_1_0.CLK 0.04742f
C1512 a_23752_13304# sg13g2_hv_o21ai_1_1.B1 0.01219f
C1513 a_30760_13304# a_31528_13304# 0.11571f
C1514 sg13g2_hv_dfrbpq_1_7.RESET_B sg13g2_hv_a21oi_1_5.Y 0.11139f
C1515 sg13g2_hv_a21oi_1_5.A1 a_24691_8794# 0.01005f
C1516 a_15976_8900# sg13g2_hv_tiehi_2.L_HI 0.01072f
C1517 a_35656_8900# VDD 0.9415f
C1518 VDD a_38056_10448# 0.97586f
C1519 a_25921_7412# a_25721_8323# 0.02842f
C1520 a_4443_7520# sg13g2_hv_nand2b_1_0.Y 0.31926f
C1521 VDD a_12904_7592# 1.08455f
C1522 sg13g2_hv_o21ai_1_0.Y sg13g2_hv_or3_1_1.C 0.37743f
C1523 sg13g2_hv_nand2b_1_0.B a_2522_10879# 0.04916f
C1524 a_7681_7412# sg13g2_hv_dfrbpq_1_1.CLK 0.38075f
C1525 a_10640_12117# a_11329_11551# 0.51401f
C1526 sg13g2_hv_or3_1_3.A a_30059_8793# 0.08083f
C1527 a_10118_11572# a_11495_11694# 0.28559f
C1528 VDD a_31144_10448# 0.95246f
C1529 sg13g2_hv_or3_1_1.B VDD 3.14557f
C1530 sg13g2_hv_o21ai_1_0.B1 a_26728_8900# 0.02257f
C1531 VDD a_3976_10448# 1.00094f
C1532 a_18311_11694# a_19307_11649# 0.39137f
C1533 VDD a_6280_8900# 0.9418f
C1534 a_7847_7412# a_8584_8900# 0.01051f
C1535 sg13g2_hv_buf_1_0.X a_5512_8900# 0.04932f
C1536 a_4811_11649# a_5512_10448# 0.02326f
C1537 sg13g2_hv_o21ai_1_1.B1 a_34504_13304# 0.01999f
C1538 a_5224_13304# a_5992_13304# 0.11571f
C1539 sg13g2_hv_dfrbpq_1_1.CLK sg13g2_hv_buf_1_0.X 0.05766f
C1540 sg13g2_hv_a21oi_1_1.B1 a_9352_8900# 0.02065f
C1541 VDD a_19845_7386# 0.58791f
C1542 a_11495_11694# a_12985_11792# 0.08792f
C1543 VDD a_12424_8900# 0.98974f
C1544 sg13g2_hv_a21oi_1_1.B1 a_6280_10448# 0.01147f
C1545 a_34120_8900# a_34888_8900# 0.11571f
C1546 sg13g2_hv_xnor2_1_1.A sg13g2_hv_buf_1_9.X 0.94755f
C1547 a_10100_10155# sg13g2_hv_nand4_1_0.Y 0.02336f
C1548 VDD a_9256_10448# 1.02547f
C1549 VDD a_36520_10448# 0.9415f
C1550 a_3589_12292# a_2438_11572# 0.01695f
C1551 VDD a_20576_7592# 0.13729f
C1552 a_32392_13098# a_32968_13304# 0.02578f
C1553 sg13g2_hv_nand3_1_1.Y a_23604_10194# 0.02645f
C1554 sg13g2_hv_nand2b_1_0.B a_2870_11795# 0.10025f
C1555 a_20680_13304# VDD 0.94184f
C1556 sg13g2_hv_nand2b_1_0.B a_5115_7520# 0.25104f
C1557 sg13g2_hv_or3_1_3.X a_24533_9212# 0.21621f
C1558 sg13g2_hv_or3_1_1.C sg13g2_hv_dfrbpq_1_1.CLK 1.47633f
C1559 a_25864_6044# a_25096_6044# 0.11571f
C1560 a_27302_11572# a_27734_11795# 0.47309f
C1561 a_14632_10448# sg13g2_hv_or3_1_1.A 0.01794f
C1562 sg13g2_hv_or3_1_1.C a_18635_8259# 0.06062f
C1563 a_28313_11585# sg13g2_hv_dfrbpq_1_0.CLK 0.01041f
C1564 a_12588_13011# VDD 0.45913f
C1565 a_10640_12117# sg13g2_hv_nand4_1_0.Y 0.04374f
C1566 a_29608_10448# a_30376_10448# 0.11571f
C1567 a_34888_8900# a_34984_10448# 0.01675f
C1568 a_3976_10448# a_3976_8900# 0.01947f
C1569 a_4744_8900# a_5512_8900# 0.11571f
C1570 sg13g2_hv_dfrbpq_1_0.CLK a_24334_10242# 3.12108f
C1571 a_28679_11694# a_29517_11649# 0.01699f
C1572 VDD a_32288_13304# 0.13315f
C1573 sg13g2_hv_nand3_1_1.A sg13g2_hv_buf_16_0.A 0.14865f
C1574 sg13g2_hv_nand3_1_1.A a_19801_11792# 0.04693f
C1575 VDD a_28118_8939# 0.41521f
C1576 sg13g2_hv_or3_1_1.C a_20392_7592# 0.02205f
C1577 sg13g2_hv_nand4_1_0.C VDD 2.36442f
C1578 sg13g2_hv_or3_1_3.A a_28840_7592# 0.02061f
C1579 a_35272_11756# a_36040_11756# 0.11571f
C1580 a_3815_11694# sg13g2_hv_dfrbpq_1_1.CLK 0.07329f
C1581 a_15976_8900# sg13g2_hv_a21oi_1_1.B1 0.02066f
C1582 a_28513_11551# sg13g2_hv_dfrbpq_1_0.CLK 0.41381f
C1583 sg13g2_hv_dfrbpq_1_4.RESET_B a_29675_11649# 0.165f
C1584 VDD a_19048_8900# 0.94314f
C1585 a_6992_7395# a_6470_8336# 0.25017f
C1586 a_10888_8900# sg13g2_hv_dfrbpq_1_1.CLK 0.08168f
C1587 sg13g2_hv_a21oi_1_1.B1 a_25960_8900# 0.01735f
C1588 a_19129_7966# a_18635_8259# 0.44368f
C1589 counter_value_o[3] sg13g2_hv_nand3_1_1.A 0.10332f
C1590 a_27824_12117# a_29675_11649# 0.01632f
C1591 a_10888_8900# a_11656_8900# 0.11571f
C1592 sg13g2_hv_or3_1_1.B a_20662_8224# 0.0132f
C1593 VDD a_38720_13304# 0.13826f
C1594 a_34984_10448# a_35752_10448# 0.11571f
C1595 a_11129_11585# sg13g2_hv_dfrbpq_1_1.CLK 0.01876f
C1596 VDD a_6470_8336# 0.77883f
C1597 sg13g2_hv_tiehi_1.L_HI a_7624_6044# 0.02901f
C1598 a_25921_7412# a_25960_8900# 0.03216f
C1599 sg13g2_hv_or3_1_3.A a_31144_7592# 0.02267f
C1600 sg13g2_hv_dfrbpq_1_0.CLK a_29063_8838# 0.15978f
C1601 a_7681_7412# sg13g2_hv_tiehi_1.L_HI 0.12858f
C1602 a_18635_8259# a_19074_7681# 0.01321f
C1603 a_16934_11572# clock_i 0.05693f
C1604 a_29675_11649# a_30885_12068# 0.25683f
C1605 VDD a_8327_12110# 0.53192f
C1606 a_27302_11572# sg13g2_hv_a21oi_1_4.Y 0.25301f
C1607 a_3815_11694# a_3649_11551# 0.59728f
C1608 sg13g2_hv_dfrbpq_1_1.CLK a_2960_12117# 0.11266f
C1609 a_1192_7592# a_1960_7592# 0.11571f
C1610 sg13g2_hv_tiehi_1.L_HI sg13g2_hv_buf_1_0.X 0.01648f
C1611 VDD a_27200_11756# 0.14539f
C1612 VDD a_28936_6044# 0.94079f
C1613 sg13g2_hv_dfrbpq_1_4.RESET_B sg13g2_hv_o21ai_1_0.B1 0.22402f
C1614 sg13g2_hv_nand3_1_1.A a_18311_11694# 0.06171f
C1615 VDD sg13g2_hv_a21oi_1_5.Y 0.53011f
C1616 a_29063_8838# a_30059_8793# 0.39137f
C1617 sg13g2_hv_or3_1_1.B a_16744_8900# 0.06818f
C1618 a_32008_6044# a_31912_7592# 0.01675f
C1619 a_19144_13304# a_19912_13304# 0.11571f
C1620 sg13g2_hv_dfrbpq_1_0.CLK a_18145_11551# 0.38939f
C1621 sg13g2_hv_tiehi_4.L_HI clock_i 0.10997f
C1622 sg13g2_hv_o21ai_1_0.B1 a_27824_12117# 0.09108f
C1623 VDD sg13g2_hv_buf_16_0.A 5.75337f
C1624 VDD a_19801_11792# 0.31857f
C1625 a_2960_12117# a_3649_11551# 0.51401f
C1626 a_27302_11572# sg13g2_hv_dfrbpq_1_0.CLK 0.01917f
C1627 sg13g2_hv_or3_1_1.A a_15514_8764# 0.13571f
C1628 VDD a_24821_12068# 0.17884f
C1629 a_36040_11756# a_36040_13304# 0.01947f
C1630 counter_value_o[3] VDD 0.18289f
C1631 VDD sg13g2_hv_nand3_1_0.Y 1.22463f
C1632 VDD a_15476_7443# 0.01244f
C1633 VDD a_11329_11551# 0.94321f
C1634 sg13g2_hv_dfrbpq_1_1.D sg13g2_hv_buf_1_0.X 0.01037f
C1635 VDD a_5992_13304# 1.01271f
C1636 a_37960_8900# a_38056_7592# 0.0222f
C1637 VDD sg13g2_hv_tiehi_5.L_HI 2.63472f
C1638 a_17366_11795# a_17456_12117# 0.47124f
C1639 a_28456_13304# sg13g2_hv_o21ai_1_0.B1 0.01141f
C1640 a_29992_13304# a_30760_13304# 0.11571f
C1641 a_25288_13304# a_26056_13304# 0.11571f
C1642 a_23497_8772# sg13g2_hv_or3_1_3.X 0.25524f
C1643 sg13g2_hv_nand2b_1_1.Y sg13g2_hv_buf_1_0.X 0.06676f
C1644 sg13g2_hv_a21oi_1_1.B1 clock_i 0.10229f
C1645 a_10312_13304# sg13g2_hv_nand4_1_0.C 0.0107f
C1646 a_1960_7592# a_1768_6044# 0.01403f
C1647 a_22024_6044# a_22792_6044# 0.11571f
C1648 sg13g2_hv_a21oi_1_1.B1 sg13g2_hv_o21ai_1_1.Y 0.96044f
C1649 VDD a_18311_11694# 0.7172f
C1650 a_17512_8900# a_18280_8900# 0.11571f
C1651 sg13g2_hv_a21oi_1_2.A1 a_15112_8900# 0.04053f
C1652 a_17580_13011# sg13g2_hv_nand3_1_1.A 0.43264f
C1653 a_10888_8900# a_10100_10155# 0.02098f
C1654 a_4811_11649# a_5250_12109# 0.01321f
C1655 VDD a_36040_11756# 0.94102f
C1656 sg13g2_hv_tiehi_4.L_HI a_16934_11572# 0.34855f
C1657 sg13g2_hv_a21oi_1_2.Y a_16262_8336# 0.25235f
C1658 sg13g2_hv_or3_1_3.A a_31528_13304# 0.03754f
C1659 a_32392_13098# a_32288_13304# 0.01073f
C1660 a_16840_6044# sg13g2_hv_tiehi_2.L_HI 0.03576f
C1661 sg13g2_hv_or3_1_1.B a_16784_7395# 0.01185f
C1662 a_17639_7412# sg13g2_hv_or3_1_1.C 0.03594f
C1663 counter_value_o[2] VDD 0.22383f
C1664 VDD sg13g2_hv_nand4_1_0.Y 1.00858f
C1665 sg13g2_hv_buf_1_0.X a_6952_11756# 0.07167f
C1666 VDD a_1960_7592# 0.99167f
C1667 a_23062_11620# sg13g2_hv_o21ai_1_1.B1 0.03392f
C1668 sg13g2_hv_and2_1_0.B a_8654_11628# 0.03132f
C1669 a_1192_7592# sg13g2_hv_buf_1_0.X 0.1439f
C1670 a_17473_7412# sg13g2_hv_dfrbpq_1_1.CLK 0.40766f
C1671 a_5813_7386# sg13g2_hv_nand2b_1_0.Y 0.08793f
C1672 sg13g2_hv_dfrbpq_1_1.CLK a_10118_11572# 0.02101f
C1673 sg13g2_hv_o21ai_1_0.B1 a_27686_8716# 0.10481f
C1674 a_20968_10448# a_21064_11756# 0.0222f
C1675 a_20517_12068# a_19801_11792# 0.11973f
C1676 a_13768_6044# a_14536_6044# 0.11571f
C1677 sg13g2_hv_a21oi_1_0.Y a_22421_7386# 0.10475f
C1678 VDD a_13000_13304# 1.03608f
C1679 sg13g2_hv_dfrbpq_1_1.CLK sg13g2_hv_buf_1_9.X 0.17962f
C1680 a_6280_10448# sg13g2_hv_xnor2_1_1.A 0.0469f
C1681 a_19149_11649# a_17456_12117# 0.39112f
C1682 a_27083_8259# a_26925_8259# 0.30349f
C1683 a_11129_11585# a_10640_12117# 0.35847f
C1684 a_28697_8729# a_29063_8838# 0.07572f
C1685 a_17639_7412# a_19129_7966# 0.08899f
C1686 a_29901_8793# a_28208_9261# 0.39112f
C1687 a_20968_10448# sg13g2_hv_a21oi_1_1.B1 0.01016f
C1688 sg13g2_hv_a21oi_1_5.Y a_26728_8900# 0.08096f
C1689 a_27564_13011# sg13g2_hv_o21ai_1_0.B1 0.4095f
C1690 a_30760_13304# VDD 0.94306f
C1691 a_26056_13304# VDD 1.013f
C1692 VDD sg13g2_hv_or3_1_3.X 0.47605f
C1693 a_28679_11694# a_29608_10448# 0.01084f
C1694 sg13g2_hv_a21oi_1_1.B1 a_16934_11572# 0.02026f
C1695 VDD a_22792_6044# 1.01978f
C1696 a_1768_6044# a_2536_6044# 0.11571f
C1697 sg13g2_hv_dfrbpq_1_7.RESET_B a_28840_10448# 0.02901f
C1698 a_12333_11649# a_12491_11649# 0.30349f
C1699 sg13g2_hv_o21ai_1_0.B1 a_22421_7386# 0.02071f
C1700 VDD a_9160_6044# 0.94145f
C1701 sg13g2_hv_o21ai_1_0.Y a_22312_8900# 0.01636f
C1702 sg13g2_hv_nand3_1_1.Y a_22504_10448# 0.01381f
C1703 sg13g2_hv_tiehi_5.L_HI a_2438_11572# 0.35686f
C1704 a_8008_13304# a_7596_13011# 0.04179f
C1705 a_35272_11756# a_34984_10448# 0.015f
C1706 sg13g2_hv_or3_1_3.A a_24533_9212# 0.01099f
C1707 counter_value_o[1] VDD 0.22959f
C1708 a_14920_11756# a_15104_11756# 0.12205f
C1709 a_3649_11551# sg13g2_hv_buf_1_9.X 0.01327f
C1710 sg13g2_hv_or3_1_1.C a_16694_7309# 0.01642f
C1711 a_26248_11756# a_27016_11756# 0.11571f
C1712 a_17580_13011# VDD 0.41679f
C1713 reset_n_i a_1192_8900# 0.01055f
C1714 a_17326_10242# a_18145_11551# 0.04759f
C1715 sg13g2_hv_a21oi_1_2.A2 a_15043_8026# 0.26585f
C1716 VDD a_26087_7412# 0.71795f
C1717 sg13g2_hv_nand2_1_2.Y sg13g2_hv_xnor2_1_1.A 0.49551f
C1718 sg13g2_hv_dfrbpq_1_1.CLK sg13g2_hv_and2_1_0.X 0.70904f
C1719 VDD a_14536_6044# 0.94161f
C1720 a_27400_6044# a_28168_6044# 0.11571f
C1721 sg13g2_hv_or3_1_1.C a_23497_8772# 0.33925f
C1722 sg13g2_hv_tiehi_4.L_HI sg13g2_hv_a21oi_1_1.B1 0.03669f
C1723 sg13g2_hv_nand3_1_1.A sg13g2_hv_or3_1_1.C 0.21068f
C1724 a_33736_13304# counter_value_o[6] 0.0106f
C1725 sg13g2_hv_a21oi_1_0.A2 a_22421_7386# 0.19869f
C1726 VDD a_2536_6044# 1.01467f
C1727 sg13g2_hv_buf_1_0.X a_1768_6044# 0.05629f
C1728 sg13g2_hv_nand4_1_0.C a_12491_11649# 0.09945f
C1729 sg13g2_hv_tiehi_0.L_HI a_25192_8900# 0.02817f
C1730 VDD a_15104_11756# 0.13165f
C1731 a_6992_7395# a_7681_7412# 0.51508f
C1732 a_26925_8259# a_25232_7395# 0.39112f
C1733 a_32200_11756# sg13g2_hv_o21ai_1_1.B1 0.05818f
C1734 a_6992_7395# a_8685_8259# 0.39112f
C1735 a_3649_11551# a_4653_11649# 0.02728f
C1736 VDD a_7624_6044# 0.99035f
C1737 sg13g2_hv_buf_16_0.A sg13g2_hv_a21oi_1_4.A2 0.01051f
C1738 a_7681_7412# VDD 0.93341f
C1739 a_32776_6044# a_33544_6044# 0.11571f
C1740 VDD a_30376_7592# 0.94235f
C1741 sg13g2_hv_tiehi_5.L_HI sg13g2_hv_and2_1_1.X 0.11609f
C1742 sg13g2_hv_dfrbpq_1_0.CLK a_25960_8900# 0.06494f
C1743 counter_value_o[0] VDD 0.24615f
C1744 a_29675_11649# sg13g2_hv_o21ai_1_1.B1 0.08059f
C1745 VDD sg13g2_hv_buf_1_0.X 2.74507f
C1746 a_7481_8323# sg13g2_hv_a21oi_1_1.B1 0.01171f
C1747 a_24821_12068# sg13g2_hv_a21oi_1_4.A2 0.21728f
C1748 sg13g2_hv_or3_1_1.A a_15195_11666# 0.42999f
C1749 sg13g2_hv_or3_1_1.C a_14920_11756# 0.0189f
C1750 a_1192_5950# a_1768_6044# 0.02578f
C1751 sg13g2_hv_nand4_1_0.C a_10550_11795# 0.04995f
C1752 VDD a_35752_7592# 0.9415f
C1753 a_28897_8695# a_28118_8939# 0.12012f
C1754 a_19144_13304# sg13g2_hv_nand3_1_1.A 0.01189f
C1755 a_7864_11068# sg13g2_hv_nand3_1_0.Y 0.01415f
C1756 sg13g2_hv_or3_1_3.A sg13g2_hv_dfrbpq_1_7.RESET_B 0.07316f
C1757 a_34984_7592# a_35752_7592# 0.11571f
C1758 sg13g2_hv_dfrbpq_1_1.CLK a_10600_7592# 0.10028f
C1759 sg13g2_hv_nand4_1_1.Y sg13g2_hv_nand3_1_1.A 0.30961f
C1760 a_31816_8900# a_31912_7592# 0.0222f
C1761 sg13g2_hv_o21ai_1_1.B1 a_36808_11756# 0.05449f
C1762 sg13g2_hv_nand3_1_1.Y sg13g2_hv_a21oi_1_1.B1 0.02028f
C1763 VDD sg13g2_hv_or3_1_1.C 4.06117f
C1764 a_34120_8900# VDD 0.9415f
C1765 a_12491_11649# sg13g2_hv_buf_16_0.A 0.01879f
C1766 VDD a_1192_5950# 0.42179f
C1767 a_4443_7520# a_4264_7592# 0.02934f
C1768 a_22984_13304# counter_value_o[4] 0.08153f
C1769 sg13g2_hv_o21ai_1_0.B1 sg13g2_hv_o21ai_1_1.B1 0.03228f
C1770 sg13g2_hv_dfrbpq_1_0.CLK a_23785_11628# 0.02276f
C1771 a_10118_11572# a_10640_12117# 0.25017f
C1772 sg13g2_hv_nand4_1_0.C sg13g2_hv_tiehi_3.L_HI 0.11979f
C1773 a_15584_10448# sg13g2_hv_or3_1_1.C 0.011f
C1774 VDD a_29608_10448# 0.94538f
C1775 VDD a_4744_8900# 0.94288f
C1776 sg13g2_hv_dfrbpq_1_1.CLK a_8843_8259# 0.02033f
C1777 sg13g2_hv_buf_1_0.X a_3976_8900# 0.01953f
C1778 sg13g2_hv_o21ai_1_1.B1 a_32968_13304# 0.01588f
C1779 sg13g2_hv_a21oi_1_4.Y sg13g2_hv_o21ai_1_1.Y 0.11014f
C1780 a_17473_7412# a_17639_7412# 0.60436f
C1781 VDD a_3815_11694# 0.7176f
C1782 a_7596_13011# sg13g2_hv_xnor2_1_1.A 0.42563f
C1783 a_4456_13304# a_5224_13304# 0.11571f
C1784 sg13g2_hv_dfrbpq_1_1.CLK a_5305_11792# 0.04739f
C1785 sg13g2_hv_tiehi_5.L_HI a_3688_13304# 0.02502f
C1786 sg13g2_hv_or3_1_1.A sg13g2_hv_a21oi_1_2.Y 0.01201f
C1787 sg13g2_hv_a21oi_1_1.B1 a_7816_8900# 0.0279f
C1788 a_9337_7966# sg13g2_hv_dfrbpq_1_1.CLK 0.02003f
C1789 VDD a_19129_7966# 0.3181f
C1790 VDD a_10888_8900# 0.94295f
C1791 sg13g2_hv_a21oi_1_1.B1 a_7048_8900# 0.14407f
C1792 a_33352_8900# a_34120_8900# 0.11571f
C1793 sg13g2_hv_nand2b_1_0.B sg13g2_hv_nand4_1_0.C 0.0375f
C1794 VDD a_28840_10448# 0.9921f
C1795 sg13g2_hv_nand2_1_1.Y sg13g2_hv_a21oi_1_1.B1 0.10804f
C1796 VDD a_34984_10448# 0.9415f
C1797 sg13g2_hv_and2_1_0.X a_10100_10155# 0.01744f
C1798 sg13g2_hv_or3_1_3.A a_23497_8772# 0.45516f
C1799 a_37384_13098# counter_value_o[7] 0.37295f
C1800 a_24710_8336# a_25721_8323# 0.2572f
C1801 a_17273_8323# a_17639_7412# 0.07572f
C1802 sg13g2_hv_a21oi_1_1.B1 a_13192_8900# 0.04927f
C1803 sg13g2_hv_a21oi_1_1.B1 a_13864_10448# 0.01438f
C1804 a_27686_8716# a_28118_8939# 0.47309f
C1805 sg13g2_hv_a21oi_1_5.A1 a_24533_9212# 0.15658f
C1806 sg13g2_hv_nand4_1_0.C sg13g2_hv_and2_1_0.B 0.26935f
C1807 a_19144_13304# VDD 0.94491f
C1808 sg13g2_hv_nand2b_1_0.B a_6470_8336# 0.0735f
C1809 a_23497_8772# a_23821_9213# 0.02494f
C1810 VDD sg13g2_hv_nand4_1_1.Y 1.28394f
C1811 VDD a_2960_12117# 0.41387f
C1812 sg13g2_hv_buf_16_0.A a_23272_10448# 0.01061f
C1813 a_34120_8900# a_34216_10448# 0.01675f
C1814 sg13g2_hv_dfrbpq_1_0.CLK sg13g2_hv_o21ai_1_1.Y 0.27418f
C1815 a_10550_11795# a_11329_11551# 0.12016f
C1816 a_3976_8900# a_4744_8900# 0.11571f
C1817 a_27824_12117# a_29517_11649# 0.39112f
C1818 a_28679_11694# a_28313_11585# 0.07572f
C1819 sg13g2_hv_or3_1_1.C a_20662_8224# 0.11996f
C1820 a_11080_13304# VDD 1.01225f
C1821 sg13g2_hv_a21oi_1_2.A1 a_15043_8026# 0.02473f
C1822 a_12491_11649# sg13g2_hv_nand4_1_0.Y 0.04801f
C1823 a_7816_8900# a_7048_8900# 0.11571f
C1824 sg13g2_hv_dfrbpq_1_1.D sg13g2_hv_nand2b_1_0.Y 0.11296f
C1825 a_17473_7412# a_16694_7309# 0.12012f
C1826 a_34504_11756# a_35272_11756# 0.11571f
C1827 VDD a_17512_8900# 0.94094f
C1828 sg13g2_hv_and2_1_0.B a_8327_12110# 0.28056f
C1829 counter_value_o[7] VSS 3.25731f
C1830 counter_value_o[6] VSS 2.6767f
C1831 counter_value_o[5] VSS 2.62907f
C1832 counter_value_o[4] VSS 2.67707f
C1833 counter_value_o[3] VSS 2.21418f
C1834 counter_value_o[2] VSS 2.60294f
C1835 counter_value_o[1] VSS 2.65043f
C1836 counter_value_o[0] VSS 2.60582f
C1837 VDD VSS 26.80876f
C1838 a_37384_6044# VSS 0.56383f ; **FLOATING
C1839 a_36616_6044# VSS 0.49608f ; **FLOATING
C1840 a_35848_6044# VSS 0.49417f ; **FLOATING
C1841 a_35080_6044# VSS 0.50156f ; **FLOATING
C1842 a_34312_6044# VSS 0.51984f ; **FLOATING
C1843 a_33544_6044# VSS 0.57568f ; **FLOATING
C1844 a_32776_6044# VSS 0.50627f ; **FLOATING
C1845 a_32008_6044# VSS 0.49417f ; **FLOATING
C1846 a_31240_6044# VSS 0.49417f ; **FLOATING
C1847 a_30472_6044# VSS 0.49417f ; **FLOATING
C1848 a_29704_6044# VSS 0.49417f ; **FLOATING
C1849 a_28936_6044# VSS 0.49417f ; **FLOATING
C1850 a_28168_6044# VSS 0.49662f ; **FLOATING
C1851 a_27400_6044# VSS 0.49499f ; **FLOATING
C1852 a_26632_6044# VSS 0.49537f ; **FLOATING
C1853 a_25864_6044# VSS 0.49458f ; **FLOATING
C1854 a_25096_6044# VSS 0.50217f ; **FLOATING
C1855 a_24328_6044# VSS 0.52701f ; **FLOATING
C1856 a_23560_6044# VSS 0.58592f ; **FLOATING
C1857 a_22792_6044# VSS 0.50783f ; **FLOATING
C1858 a_22024_6044# VSS 0.49655f ; **FLOATING
C1859 a_21256_6044# VSS 0.49623f ; **FLOATING
C1860 a_20488_6044# VSS 0.49622f ; **FLOATING
C1861 a_19720_6044# VSS 0.49662f ; **FLOATING
C1862 a_18952_6044# VSS 0.49499f ; **FLOATING
C1863 a_18184_6044# VSS 0.4975f ; **FLOATING
C1864 a_17416_6044# VSS 0.56576f ; **FLOATING
C1865 a_16840_6044# VSS 0.14929f ; **FLOATING
C1866 a_16072_6044# VSS 0.49652f ; **FLOATING
C1867 a_15304_6044# VSS 0.49867f ; **FLOATING
C1868 a_14536_6044# VSS 0.51703f ; **FLOATING
C1869 a_13768_6044# VSS 0.55825f ; **FLOATING
C1870 a_13000_6044# VSS 0.52597f ; **FLOATING
C1871 a_12232_6044# VSS 0.49417f ; **FLOATING
C1872 a_11464_6044# VSS 0.49417f ; **FLOATING
C1873 a_10696_6044# VSS 0.49417f ; **FLOATING
C1874 a_9928_6044# VSS 0.49662f ; **FLOATING
C1875 a_9160_6044# VSS 0.49499f ; **FLOATING
C1876 a_8392_6044# VSS 0.4975f ; **FLOATING
C1877 a_7624_6044# VSS 0.56576f ; **FLOATING
C1878 a_7136_6044# VSS 0.09399f ; **FLOATING
C1879 a_6376_6044# VSS 0.49473f ; **FLOATING
C1880 a_5608_6044# VSS 0.49635f ; **FLOATING
C1881 a_4840_6044# VSS 0.51046f ; **FLOATING
C1882 a_4072_6044# VSS 0.52804f ; **FLOATING
C1883 a_3304_6044# VSS 0.5759f ; **FLOATING
C1884 a_2536_6044# VSS 0.49417f ; **FLOATING
C1885 a_1768_6044# VSS 0.50764f ; **FLOATING
C1886 a_38056_7592# VSS 0.56086f ; **FLOATING
C1887 a_37288_7592# VSS 0.47875f ; **FLOATING
C1888 a_36520_7592# VSS 0.47875f ; **FLOATING
C1889 a_35752_7592# VSS 0.47875f ; **FLOATING
C1890 a_34984_7592# VSS 0.48853f ; **FLOATING
C1891 a_34216_7592# VSS 0.50689f ; **FLOATING
C1892 a_33448_7592# VSS 0.56152f ; **FLOATING
C1893 a_32680_7592# VSS 0.48519f ; **FLOATING
C1894 a_31912_7592# VSS 0.47875f ; **FLOATING
C1895 a_31144_7592# VSS 0.4801f ; **FLOATING
C1896 a_30376_7592# VSS 0.47713f ; **FLOATING
C1897 a_29608_7592# VSS 0.47974f ; **FLOATING
C1898 a_28840_7592# VSS 0.4835f ; **FLOATING
C1899 a_27522_7681# VSS 0.16148f
C1900 a_25861_7498# VSS 1.33614f
C1901 a_26925_8259# VSS 0.06642f
C1902 a_25721_8323# VSS 0.5024f
C1903 a_25581_8323# VSS 0.24415f
C1904 a_25232_7395# VSS 0.10494f
C1905 a_24868_8336# VSS 0.22337f
C1906 a_24224_7592# VSS 0.13091f ; **FLOATING
C1907 a_23080_7592# VSS 0.60289f ; **FLOATING
C1908 a_22421_7386# VSS 0.39723f
C1909 a_21709_7443# VSS 1.48471f
C1910 a_21543_7443# VSS 0.38938f
C1911 a_22579_8194# VSS 0.18011f
C1912 a_24710_8336# VSS 1.3063f
C1913 a_20576_7592# VSS 0.05642f ; **FLOATING
C1914 a_20392_7592# VSS 0.11591f ; **FLOATING
C1915 a_19074_7681# VSS 0.32518f
C1916 a_20662_8224# VSS 0.13401f
C1917 a_19419_8336# VSS 0.33273f
C1918 a_18477_8259# VSS 0.06642f
C1919 a_17273_8323# VSS 0.8638f
C1920 a_17133_8323# VSS 0.81544f
C1921 a_16160_7592# VSS 0.05581f ; **FLOATING
C1922 a_15976_7592# VSS 0.11267f ; **FLOATING
C1923 a_14427_7386# VSS 1.52655f
C1924 a_16420_8336# VSS 0.25189f
C1925 a_16262_8336# VSS 1.24123f
C1926 a_14593_8194# VSS 0.17851f
C1927 a_14056_7592# VSS 0.14422f ; **FLOATING
C1928 a_12904_7592# VSS 0.5668f ; **FLOATING
C1929 a_12136_7592# VSS 0.48064f ; **FLOATING
C1930 a_11368_7592# VSS 0.47875f ; **FLOATING
C1931 a_10600_7592# VSS 0.49102f ; **FLOATING
C1932 a_9282_7681# VSS 0.32529f
C1933 a_7621_7498# VSS 0.15172f
C1934 a_9627_8336# VSS 0.33273f
C1935 a_8685_8259# VSS 0.06642f
C1936 a_7481_8323# VSS 0.60899f
C1937 a_7341_8323# VSS 0.56064f
C1938 a_5813_7386# VSS 0.15332f
C1939 a_6628_8336# VSS 2.98087f
C1940 a_5971_8194# VSS 0.3773f
C1941 sg13g2_hv_nand2b_1_1.Y VSS 0.30433f
C1942 a_4773_8216# VSS 0.16573f
C1943 a_4264_7592# VSS 0.11372f ; **FLOATING
C1944 a_3496_7592# VSS 0.55341f ; **FLOATING
C1945 a_2728_7592# VSS 0.48956f ; **FLOATING
C1946 a_1960_7592# VSS 0.48053f ; **FLOATING
C1947 a_1192_7592# VSS 0.54513f ; **FLOATING
C1948 a_6470_8336# VSS 2.89051f
C1949 sg13g2_hv_dfrbpq_1_1.D VSS 0.12071f
C1950 a_30843_8716# VSS 0.33232f
C1951 a_38720_8900# VSS 0.11738f ; **FLOATING
C1952 a_37960_8900# VSS 0.4775f ; **FLOATING
C1953 a_37192_8900# VSS 0.47875f ; **FLOATING
C1954 a_36424_8900# VSS 0.47875f ; **FLOATING
C1955 a_35656_8900# VSS 0.47875f ; **FLOATING
C1956 a_34888_8900# VSS 0.49117f ; **FLOATING
C1957 a_34120_8900# VSS 0.50944f ; **FLOATING
C1958 a_33352_8900# VSS 0.56147f ; **FLOATING
C1959 a_32584_8900# VSS 0.47982f ; **FLOATING
C1960 a_31816_8900# VSS 0.49102f ; **FLOATING
C1961 a_29901_8793# VSS 0.39216f
C1962 a_28557_8729# VSS 0.66723f
C1963 a_28697_8729# VSS 0.71559f
C1964 a_30498_9253# VSS 0.30462f
C1965 a_31269_9212# VSS 0.25733f
C1966 a_27844_8716# VSS 0.59377f
C1967 a_28208_9261# VSS 0.1021f
C1968 a_27686_8716# VSS 0.59924f
C1969 a_27496_8900# VSS 0.11057f ; **FLOATING
C1970 a_26728_8900# VSS 0.47792f ; **FLOATING
C1971 a_25960_8900# VSS 0.47133f ; **FLOATING
C1972 a_25192_8900# VSS 0.48445f ; **FLOATING
C1973 a_24691_8794# VSS 1.45653f
C1974 sg13g2_hv_a21oi_1_5.Y VSS 1.14608f
C1975 a_22312_8900# VSS 0.55983f ; **FLOATING
C1976 a_21810_8776# VSS 0.08869f
C1977 a_21536_8900# VSS 0.05851f ; **FLOATING
C1978 a_21352_8900# VSS 0.10927f ; **FLOATING
C1979 a_21018_8772# VSS 0.05794f
C1980 a_20584_8900# VSS 0.11584f ; **FLOATING
C1981 a_19816_8900# VSS 0.47895f ; **FLOATING
C1982 a_19048_8900# VSS 0.47601f ; **FLOATING
C1983 a_18280_8900# VSS 0.47792f ; **FLOATING
C1984 a_17512_8900# VSS 0.47185f ; **FLOATING
C1985 a_16744_8900# VSS 0.48068f ; **FLOATING
C1986 a_15976_8900# VSS 0.48708f ; **FLOATING
C1987 a_15514_8764# VSS 0.77366f
C1988 a_15680_9260# VSS 2.09916f
C1989 a_15112_8900# VSS 0.14425f ; **FLOATING
C1990 a_13960_8900# VSS 0.58493f ; **FLOATING
C1991 a_13192_8900# VSS 0.56096f ; **FLOATING
C1992 a_12424_8900# VSS 0.4787f ; **FLOATING
C1993 a_11656_8900# VSS 0.4778f ; **FLOATING
C1994 a_10888_8900# VSS 0.4778f ; **FLOATING
C1995 a_10120_8900# VSS 0.47897f ; **FLOATING
C1996 a_9352_8900# VSS 0.47623f ; **FLOATING
C1997 a_8584_8900# VSS 0.48223f ; **FLOATING
C1998 a_7816_8900# VSS 0.48404f ; **FLOATING
C1999 a_7048_8900# VSS 0.47618f ; **FLOATING
C2000 a_6280_8900# VSS 0.47475f ; **FLOATING
C2001 a_5512_8900# VSS 0.47984f ; **FLOATING
C2002 a_4744_8900# VSS 0.4961f ; **FLOATING
C2003 a_3976_8900# VSS 0.51255f ; **FLOATING
C2004 a_3208_8900# VSS 0.56123f ; **FLOATING
C2005 a_1192_8900# VSS 0.61565f ; **FLOATING
C2006 a_38056_10448# VSS 0.54616f ; **FLOATING
C2007 a_37288_10448# VSS 0.47875f ; **FLOATING
C2008 a_36520_10448# VSS 0.47875f ; **FLOATING
C2009 a_35752_10448# VSS 0.47875f ; **FLOATING
C2010 a_34984_10448# VSS 0.48853f ; **FLOATING
C2011 a_34216_10448# VSS 0.50689f ; **FLOATING
C2012 a_33448_10448# VSS 0.56207f ; **FLOATING
C2013 a_32680_10448# VSS 0.48519f ; **FLOATING
C2014 a_31912_10448# VSS 0.47875f ; **FLOATING
C2015 a_31144_10448# VSS 0.48251f ; **FLOATING
C2016 a_30376_10448# VSS 0.47575f ; **FLOATING
C2017 a_29608_10448# VSS 0.48111f ; **FLOATING
C2018 a_28840_10448# VSS 0.54822f ; **FLOATING
C2019 a_28352_10448# VSS 0.1196f ; **FLOATING
C2020 a_23604_10194# VSS 0.32035f
C2021 a_23272_10448# VSS 0.11816f ; **FLOATING
C2022 a_22504_10448# VSS 0.48344f ; **FLOATING
C2023 a_21736_10448# VSS 0.48304f ; **FLOATING
C2024 a_20968_10448# VSS 0.49056f ; **FLOATING
C2025 a_23446_11080# VSS 0.24338f
C2026 a_17024_10448# VSS 0.0866f ; **FLOATING
C2027 a_15584_10448# VSS 0.06231f ; **FLOATING
C2028 a_15400_10448# VSS 0.10362f ; **FLOATING
C2029 a_14632_10448# VSS 0.50964f ; **FLOATING
C2030 a_13864_10448# VSS 0.52835f ; **FLOATING
C2031 a_9256_10448# VSS 0.50657f ; **FLOATING
C2032 a_8747_11050# VSS 0.32024f
C2033 a_8589_11050# VSS 0.17992f
C2034 a_7864_11068# VSS 1.49367f
C2035 a_7424_10448# VSS 0.07018f ; **FLOATING
C2036 a_6280_10448# VSS 0.48699f ; **FLOATING
C2037 a_5512_10448# VSS 0.47399f ; **FLOATING
C2038 a_4744_10448# VSS 0.49275f ; **FLOATING
C2039 a_3976_10448# VSS 0.52332f ; **FLOATING
C2040 a_3041_10242# VSS 1.18684f
C2041 a_3527_11050# VSS 0.28315f
C2042 a_2621_11072# VSS 0.49427f
C2043 a_1931_11050# VSS 0.33241f
C2044 a_2522_10879# VSS 0.08943f
C2045 a_30459_11572# VSS 0.61819f
C2046 a_38720_11756# VSS 0.1435f ; **FLOATING
C2047 a_37576_11756# VSS 0.55094f ; **FLOATING
C2048 a_36808_11756# VSS 0.49129f ; **FLOATING
C2049 a_36040_11756# VSS 0.4778f ; **FLOATING
C2050 a_35272_11756# VSS 0.48105f ; **FLOATING
C2051 a_34504_11756# VSS 0.49896f ; **FLOATING
C2052 a_33736_11756# VSS 0.54221f ; **FLOATING
C2053 a_32968_11756# VSS 0.50316f ; **FLOATING
C2054 a_32200_11756# VSS 0.48244f ; **FLOATING
C2055 a_31432_11756# VSS 0.49102f ; **FLOATING
C2056 a_29517_11649# VSS 0.47569f
C2057 a_28173_11585# VSS 0.56291f
C2058 a_28313_11585# VSS 0.8206f
C2059 a_30114_12109# VSS 0.16137f
C2060 a_27460_11572# VSS 0.53662f
C2061 a_28453_12292# VSS 0.10166f
C2062 a_27302_11572# VSS 0.67921f
C2063 a_27200_11756# VSS 0.05617f ; **FLOATING
C2064 a_27016_11756# VSS 0.10536f ; **FLOATING
C2065 a_26248_11756# VSS 0.47923f ; **FLOATING
C2066 a_25480_11756# VSS 0.48486f ; **FLOATING
C2067 a_24979_11650# VSS 0.47783f
C2068 a_23062_11620# VSS 0.14289f
C2069 a_24821_12068# VSS 0.45335f
C2070 sg13g2_hv_a21oi_1_4.A2 VSS 0.1076f
C2071 sg13g2_hv_o21ai_1_1.Y VSS 0.92272f
C2072 a_23220_12116# VSS 0.92448f
C2073 a_22888_11756# VSS 0.11703f ; **FLOATING
C2074 a_22396_11632# VSS 1.21862f
C2075 a_22230_11632# VSS 2.46801f
C2076 a_20091_11572# VSS 0.08693f
C2077 a_21832_11756# VSS 0.1151f ; **FLOATING
C2078 a_21064_11756# VSS 0.49102f ; **FLOATING
C2079 a_19149_11649# VSS 0.06642f
C2080 a_17805_11585# VSS 0.61083f
C2081 a_17945_11585# VSS 0.65919f
C2082 a_19746_12109# VSS 0.37158f
C2083 a_17092_11572# VSS 0.44397f
C2084 a_16051_11650# VSS 0.08306f
C2085 a_15525_11628# VSS 0.15662f
C2086 a_18085_12292# VSS 0.448f
C2087 a_16934_11572# VSS 1.76245f
C2088 a_15893_12068# VSS 0.37708f
C2089 a_15104_11756# VSS 0.0549f ; **FLOATING
C2090 a_14920_11756# VSS 0.11023f ; **FLOATING
C2091 a_12333_11649# VSS 2.14224f
C2092 a_10989_11585# VSS 1.21538f
C2093 a_11129_11585# VSS 0.65889f
C2094 a_12930_12109# VSS 0.91633f
C2095 a_10276_11572# VSS 0.29991f
C2096 a_10118_11572# VSS 0.48564f
C2097 a_9544_11756# VSS 0.17173f ; **FLOATING
C2098 a_8654_11628# VSS 2.34514f
C2099 a_8187_11670# VSS 0.09922f
C2100 a_5595_11572# VSS 0.64979f
C2101 a_8812_12068# VSS 0.85547f
C2102 a_6952_11756# VSS 0.13974f ; **FLOATING
C2103 a_4653_11649# VSS 0.06775f
C2104 a_3309_11585# VSS 0.16654f
C2105 a_3449_11585# VSS 0.22509f
C2106 a_5250_12109# VSS 0.38756f
C2107 a_2596_11572# VSS 0.05223f
C2108 a_3589_12292# VSS 1.00222f
C2109 a_2438_11572# VSS 0.52016f
C2110 a_2336_11756# VSS 0.08252f ; **FLOATING
C2111 a_1192_11756# VSS 0.61448f ; **FLOATING
C2112 a_38720_13304# VSS 0.11794f ; **FLOATING
C2113 a_37960_13304# VSS 0.5157f ; **FLOATING
C2114 a_37192_13304# VSS 0.14021f ; **FLOATING
C2115 a_36040_13304# VSS 0.56328f ; **FLOATING
C2116 a_35272_13304# VSS 0.49835f ; **FLOATING
C2117 a_34504_13304# VSS 0.51438f ; **FLOATING
C2118 a_33736_13304# VSS 0.55722f ; **FLOATING
C2119 a_32968_13304# VSS 0.53204f ; **FLOATING
C2120 a_32288_13304# VSS 0.05883f ; **FLOATING
C2121 a_31528_13304# VSS 0.49292f ; **FLOATING
C2122 a_30760_13304# VSS 0.49662f ; **FLOATING
C2123 a_29992_13304# VSS 0.49499f ; **FLOATING
C2124 a_29224_13304# VSS 0.4975f ; **FLOATING
C2125 a_28456_13304# VSS 0.56576f ; **FLOATING
C2126 a_27968_13304# VSS 0.10235f ; **FLOATING
C2127 a_27208_13304# VSS 0.14682f ; **FLOATING
C2128 a_26056_13304# VSS 0.56423f ; **FLOATING
C2129 a_25288_13304# VSS 0.49924f ; **FLOATING
C2130 a_24520_13304# VSS 0.51784f ; **FLOATING
C2131 a_23752_13304# VSS 0.55553f ; **FLOATING
C2132 a_22984_13304# VSS 0.53842f ; **FLOATING
C2133 a_22216_13304# VSS 0.11496f ; **FLOATING
C2134 a_21448_13304# VSS 0.49645f ; **FLOATING
C2135 a_20680_13304# VSS 0.49634f ; **FLOATING
C2136 a_19912_13304# VSS 0.49457f ; **FLOATING
C2137 a_19144_13304# VSS 0.49669f ; **FLOATING
C2138 a_18376_13304# VSS 0.56745f ; **FLOATING
C2139 a_17224_13304# VSS 0.14628f ; **FLOATING
C2140 a_16072_13304# VSS 0.57254f ; **FLOATING
C2141 a_15304_13304# VSS 0.50094f ; **FLOATING
C2142 a_14536_13304# VSS 0.51656f ; **FLOATING
C2143 a_13768_13304# VSS 0.55294f ; **FLOATING
C2144 a_13000_13304# VSS 0.53406f ; **FLOATING
C2145 a_17580_13011# VSS 0.18975f
C2146 a_12232_13304# VSS 0.1466f ; **FLOATING
C2147 a_11080_13304# VSS 0.56358f ; **FLOATING
C2148 a_10312_13304# VSS 0.49752f ; **FLOATING
C2149 a_9544_13304# VSS 0.502f ; **FLOATING
C2150 a_8776_13304# VSS 0.49517f ; **FLOATING
C2151 a_8008_13304# VSS 0.50326f ; **FLOATING
C2152 a_5992_13304# VSS 0.5692f ; **FLOATING
C2153 a_5224_13304# VSS 0.50112f ; **FLOATING
C2154 a_4456_13304# VSS 0.51913f ; **FLOATING
C2155 a_3688_13304# VSS 0.64156f ; **FLOATING
C2156 a_3200_13304# VSS 0.09362f ; **FLOATING
C2157 a_3016_13304# VSS 0.11439f ; **FLOATING
C2158 a_2336_13304# VSS 0.09107f ; **FLOATING
C2159 a_1192_13304# VSS 0.62795f ; **FLOATING
C2160 sg13g2_hv_a21oi_1_1.B1.n0 VSS 1.52163f
C2161 sg13g2_hv_a21oi_1_1.B1.n1 VSS 2.32342f
C2162 sg13g2_hv_a21oi_1_1.B1.n2 VSS 2.13314f
C2163 sg13g2_hv_a21oi_1_1.B1.n3 VSS 1.87797f
C2164 sg13g2_hv_a21oi_1_1.B1.n4 VSS 2.41568f
C2165 sg13g2_hv_a21oi_1_1.B1.t0 VSS 0.32041f
C2166 VSS.t47 VSS 0.80533f
C2167 VSS.t50 VSS 3.00531f
C2168 VSS.t134 VSS 0.13314f
C2169 VSS.t75 VSS 0.26867f
C2170 VSS.t211 VSS 0.32574f
C2171 VSS.t27 VSS 0.59353f
C2172 VSS.t7 VSS 0.48319f
C2173 VSS.t29 VSS 0.93467f
C2174 VSS.t10 VSS 0.81448f
C2175 VSS.t200 VSS 0.10278f
C2176 VSS.t21 VSS 0.06397f
C2177 VSS.t265 VSS 0.1683f
C2178 VSS.t143 VSS 3.00217f
C2179 VSS.t59 VSS 1.29195f
C2180 VSS.t197 VSS 0.6462f
C2181 VSS.t82 VSS 0.11073f
C2182 VSS.t101 VSS 0.21085f
C2183 VSS.t164 VSS 0.15281f
C2184 VSS.t68 VSS 0.14519f
C2185 VSS.t111 VSS 0.06397f
C2186 VSS.t113 VSS 0.06397f
C2187 VSS.t203 VSS 1.8747f
C2188 VSS.t295 VSS 0.15279f
C2189 VSS.t103 VSS 0.06657f
C2190 VSS.t105 VSS 0.06657f
C2191 VSS.t308 VSS 0.16554f
C2192 VSS.t107 VSS 0.21912f
C2193 VSS.t130 VSS 0.06397f
C2194 VSS.t62 VSS 5.29329f
C2195 VSS.t87 VSS 0.24897f
C2196 VSS.t355 VSS 0.71731f
C2197 VSS.t115 VSS 0.39202f
C2198 VSS.t109 VSS 0.06397f
C2199 VSS.t1 VSS 0.76182f
C2200 VSS.t14 VSS 1.03542f
C2201 VSS.t270 VSS 1.53813f
C2202 VSS.t161 VSS 0.43274f
C2203 VSS.t33 VSS 1.47009f
C2204 VSS.t41 VSS 0.82829f
C2205 VSS.t43 VSS 0.06397f
C2206 VSS.t119 VSS 0.03198f
C2207 VSS.t120 VSS 0.03198f
C2208 VSS.t45 VSS 0.81923f
C2209 VDD.n0 VSS 0.11649f
C2210 VDD.n1 VSS 0.1281f
C2211 VDD.n2 VSS 0.03971f
C2212 VDD.n3 VSS 0.60594f
C2213 VDD.n4 VSS 0.03718f
C2214 VDD.n5 VSS 0.11648f
C2215 VDD.n6 VSS 0.11649f
C2216 VDD.t3 VSS 0.10126p
C2217 VDD.n7 VSS 0.87214f
C2218 VDD.n8 VSS 0.2258f
C2219 VDD.n9 VSS 0.19392f
C2220 VDD.n10 VSS 0.11649f
C2221 VDD.n11 VSS 0.68223f
C2222 VDD.n12 VSS 0.03718f
C2223 VDD.n13 VSS 0.4315f
C2224 VDD.t10 VSS 98.87379f
C2225 VDD.n14 VSS 0.28394f
C2226 VDD.n15 VSS 0.23195f
C2227 VDD.t0 VSS 0.1p
C2228 VDD.n16 VSS 0.50248f
C2229 VDD.n17 VSS 0.11277f
C2230 VDD.n18 VSS 0.17707f
C2231 VDD.n19 VSS 0.98723f
C2232 VDD.n20 VSS 1.48786f
C2233 VDD.n21 VSS 0.03304f
C2234 VDD.n22 VSS 0.38174f
C2235 VDD.n23 VSS 0.28892f
C2236 VDD.n24 VSS 2.2321f
C2237 VDD.n25 VSS 0.07651f
C2238 VDD.n26 VSS 0.11648f
C2239 VDD.n27 VSS 0.03718f
C2240 VDD.n28 VSS 0.10985f
C2241 VDD.n29 VSS 0.34932f
C2242 VDD.n31 VSS 0.17152f
C2243 VDD.n33 VSS 0.34334f
C2244 VDD.n34 VSS 0.14378f
C2245 VDD.n35 VSS 0.01026f
C2246 VDD.n36 VSS 0.07671f
C2247 VDD.n37 VSS 0.01367f
C2248 VDD.n38 VSS 0.23016f
C2249 VDD.n39 VSS 0.13234f
C2250 VDD.n41 VSS 0.23476f
C2251 VDD.n42 VSS 0.25075f
C2252 VDD.n43 VSS 0.22357f
C2253 VDD.n44 VSS 0.29265f
C2254 VDD.n45 VSS 0.02244f
C2255 VDD.n46 VSS 0.19393f
C2256 VDD.n47 VSS 0.11103f
C2257 VDD.n48 VSS 0.06749f
C2258 VDD.n49 VSS 0.09272f
C2259 VDD.n50 VSS 0.05408f
C2260 VDD.n51 VSS 0.25111f
C2261 VDD.n52 VSS 0.02798f
C2262 VDD.n53 VSS 0.01615f
C2263 VDD.n54 VSS 0.02386f
C2264 VDD.n55 VSS 0.03346f
C2265 VDD.n56 VSS 0.09359f
C2266 VDD.n58 VSS 0.01959f
C2267 VDD.n60 VSS 0.01606f
C2268 VDD.n61 VSS 0.01036f
C2269 VDD.n62 VSS 0.01376f
C2270 VDD.n63 VSS 0.02367f
C2271 VDD.n64 VSS 0.01823f
C2272 VDD.n66 VSS 0.07186f
C2273 VDD.t67 VSS 1.52011f
C2274 VDD.t120 VSS 0.13993f
C2275 VDD.t215 VSS 0.04928f
C2276 VDD.t119 VSS 0.36243f
C2277 VDD.n67 VSS 0.08176f
C2278 VDD.t41 VSS 0.1941f
C2279 VDD.t39 VSS 0.20481f
C2280 VDD.t218 VSS 0.01921f
C2281 VDD.t46 VSS 0.13558f
C2282 VDD.t27 VSS 0.2347f
C2283 VDD.t146 VSS 0.05273f
C2284 VDD.t149 VSS 0.23943f
C2285 VDD.n68 VSS 0.30302f
C2286 VDD.t148 VSS 0.04757f
C2287 VDD.t147 VSS 0.04361f
C2288 VDD.n69 VSS 0.11648f
C2289 VDD.t122 VSS 1.57237f
C2290 VDD.t127 VSS 0.14641f
C2291 VDD.t154 VSS 0.22999f
C2292 VDD.t63 VSS 0.87698f
C2293 VDD.n70 VSS 0.03718f
C2294 VDD.t26 VSS 0.08298f
C2295 VDD.t121 VSS 0.05273f
C2296 VDD.t126 VSS 0.43946f
C2297 VDD.t17 VSS 0.0522f
C2298 VDD.t52 VSS 0.05017f
C2299 VDD.t51 VSS 2.04292f
C2300 VDD.t12 VSS 0.44872f
C2301 VDD.n71 VSS 0.08769f
C2302 VDD.n72 VSS 0.10631f
C2303 VDD.t213 VSS 0.04757f
C2304 VDD.t206 VSS 0.05602f
C2305 VDD.n73 VSS 0.02528f
C2306 VDD.n74 VSS 0.01625f
C2307 VDD.t279 VSS 0.05858f
C2308 VDD.n75 VSS 0.0779f
C2309 VDD.n76 VSS 0.02164f
C2310 VDD.n77 VSS 0.01616f
C2311 VDD.t271 VSS 0.05631f
C2312 VDD.n78 VSS 0.06988f
C2313 VDD.n79 VSS 0.02155f
C2314 VDD.n80 VSS 0.01606f
C2315 VDD.t244 VSS 0.05631f
C2316 VDD.n81 VSS 0.06932f
C2317 VDD.n82 VSS 0.02158f
C2318 VDD.t241 VSS 3.76958f
C2319 VDD.n83 VSS 0.07811f
C2320 VDD.t242 VSS 0.0563f
C2321 VDD.n84 VSS 0.06966f
C2322 VDD.n85 VSS 0.01618f
C2323 VDD.t246 VSS 0.05631f
C2324 VDD.n86 VSS 0.07008f
C2325 VDD.t269 VSS 0.05631f
C2326 VDD.n87 VSS 0.06384f
C2327 VDD.n88 VSS 0.0215f
C2328 VDD.t273 VSS 0.05631f
C2329 VDD.n89 VSS 0.06938f
C2330 VDD.n90 VSS 0.02161f
C2331 VDD.t275 VSS 1.91468f
C2332 VDD.n91 VSS 0.06968f
C2333 VDD.t277 VSS 0.05631f
C2334 VDD.n92 VSS 0.06947f
C2335 VDD.n93 VSS 0.01623f
C2336 VDD.t281 VSS 0.05631f
C2337 VDD.n94 VSS 0.08096f
C2338 VDD.t283 VSS 0.05498f
C2339 VDD.t287 VSS 0.05356f
C2340 VDD.t207 VSS 0.05356f
C2341 VDD.n95 VSS 0.09211f
C2342 VDD.t50 VSS 0.05238f
C2343 VDD.n96 VSS 0.08137f
C2344 VDD.n97 VSS 0.02163f
C2345 VDD.t212 VSS 0.05466f
C2346 VDD.t114 VSS 0.82746f
C2347 VDD.t143 VSS 0.05273f
C2348 VDD.t33 VSS 0.18464f
C2349 VDD.t49 VSS 0.05466f
C2350 VDD.t189 VSS 0.01921f
C2351 VDD.t31 VSS 0.3389f
C2352 VDD.n98 VSS 0.03718f
C2353 VDD.t94 VSS 0.04361f
C2354 VDD.n99 VSS 0.11648f
C2355 VDD.t185 VSS 0.05503f
C2356 VDD.n100 VSS 0.15741f
C2357 VDD.t95 VSS 0.04757f
C2358 VDD.n101 VSS 0.14961f
C2359 VDD.n102 VSS 0.02275f
C2360 VDD.t48 VSS 0.05602f
C2361 VDD.n104 VSS 0.06149f
C2362 VDD.n105 VSS 0.01624f
C2363 VDD.t284 VSS 0.05027f
C2364 VDD.n106 VSS 0.12406f
C2365 VDD.n107 VSS 0.08505f
C2366 VDD.n108 VSS 0.02156f
C2367 VDD.t92 VSS 0.04361f
C2368 VDD.t211 VSS 0.01921f
C2369 VDD.t111 VSS 0.23613f
C2370 VDD.t91 VSS 0.04757f
C2371 VDD.t102 VSS 0.26679f
C2372 VDD.t101 VSS 0.27076f
C2373 VDD.t188 VSS 0.42857f
C2374 VDD.t70 VSS 0.04928f
C2375 VDD.t14 VSS 0.05811f
C2376 VDD.t209 VSS 0.09579f
C2377 VDD.t208 VSS 0.05396f
C2378 VDD.t4 VSS 0.25121f
C2379 VDD.t131 VSS 0.05466f
C2380 VDD.t202 VSS 0.04757f
C2381 VDD.t196 VSS 0.08298f
C2382 VDD.t5 VSS 0.07058f
C2383 VDD.t38 VSS 0.2348f
C2384 VDD.n109 VSS 0.03718f
C2385 VDD.t25 VSS 0.05273f
C2386 VDD.t22 VSS 0.13178f
C2387 VDD.t132 VSS 0.93128f
C2388 VDD.t129 VSS 0.11598f
C2389 VDD.t294 VSS 0.05027f
C2390 VDD.t222 VSS 0.05466f
C2391 VDD.t130 VSS 0.05602f
C2392 VDD.t302 VSS 0.04759f
C2393 VDD.t118 VSS 0.05238f
C2394 VDD.t248 VSS 0.04797f
C2395 VDD.t23 VSS 0.04757f
C2396 VDD.t168 VSS 0.68515f
C2397 VDD.t301 VSS 0.05485f
C2398 VDD.t28 VSS 0.65738f
C2399 VDD.t231 VSS 0.05466f
C2400 VDD.t6 VSS 0.30462f
C2401 VDD.t100 VSS 0.46844f
C2402 VDD.t107 VSS 0.04361f
C2403 VDD.t30 VSS 0.04361f
C2404 VDD.t106 VSS 0.04757f
C2405 VDD.t29 VSS 0.04757f
C2406 VDD.t24 VSS 0.04361f
C2407 VDD.t247 VSS 0.04874f
C2408 VDD.n110 VSS 0.0384f
C2409 VDD.n111 VSS 0.10658f
C2410 VDD.n112 VSS 0.034f
C2411 VDD.n113 VSS 0.11975f
C2412 VDD.n114 VSS 0.02627f
C2413 VDD.n115 VSS 0.08278f
C2414 VDD.n116 VSS 0.01953f
C2415 VDD.n117 VSS 0.08024f
C2416 VDD.n118 VSS 0.05395f
C2417 VDD.n119 VSS 0.13674f
C2418 VDD.n120 VSS 0.04346f
C2419 VDD.n121 VSS 0.09508f
C2420 VDD.t201 VSS 0.04361f
C2421 VDD.n122 VSS 0.11648f
C2422 VDD.n123 VSS 0.09635f
C2423 VDD.n124 VSS 0.03506f
C2424 VDD.n125 VSS 0.07563f
C2425 VDD.n126 VSS 0.02241f
C2426 VDD.t252 VSS 0.0563f
C2427 VDD.t254 VSS 0.05285f
C2428 VDD.t239 VSS 0.77105f
C2429 VDD.t205 VSS 0.05017f
C2430 VDD.t307 VSS 0.0522f
C2431 VDD.t289 VSS 0.05273f
C2432 VDD.t16 VSS 0.05356f
C2433 VDD.t288 VSS 0.05356f
C2434 VDD.t103 VSS 0.07956f
C2435 VDD.t104 VSS 0.07559f
C2436 VDD.n127 VSS 0.11648f
C2437 VDD.n128 VSS 0.08007f
C2438 VDD.n129 VSS 0.01347f
C2439 VDD.n130 VSS 0.06374f
C2440 VDD.n132 VSS 0.09331f
C2441 VDD.t240 VSS 0.76708f
C2442 VDD.n133 VSS 0.11649f
C2443 VDD.n134 VSS 0.08555f
C2444 VDD.n135 VSS 0.01347f
C2445 VDD.n136 VSS 0.10613f
C2446 VDD.n137 VSS 0.05806f
C2447 VDD.n138 VSS 0.12014f
C2448 VDD.n139 VSS 0.0162f
C2449 VDD.n140 VSS 0.06414f
C2450 VDD.n141 VSS 0.01583f
C2451 VDD.t250 VSS 1.93981f
C2452 VDD.t86 VSS 0.05631f
C2453 VDD.t84 VSS 0.05631f
C2454 VDD.t82 VSS 0.05631f
C2455 VDD.t80 VSS 0.05631f
C2456 VDD.t78 VSS 0.05631f
C2457 VDD.t76 VSS 0.05631f
C2458 VDD.t74 VSS 0.05858f
C2459 VDD.t72 VSS 0.05631f
C2460 VDD.t71 VSS 0.05498f
C2461 VDD.t55 VSS 0.15359f
C2462 VDD.t42 VSS 0.21816f
C2463 VDD.t304 VSS 1.27182f
C2464 VDD.n142 VSS 0.11648f
C2465 VDD.t303 VSS 1.27579f
C2466 VDD.t223 VSS 0.05602f
C2467 VDD.t117 VSS 1.79613f
C2468 VDD.t43 VSS 0.05436f
C2469 VDD.t219 VSS 0.2189f
C2470 VDD.t57 VSS 1.26265f
C2471 VDD.t292 VSS 0.05356f
C2472 VDD.t116 VSS 0.05356f
C2473 VDD.t53 VSS 0.27097f
C2474 VDD.t99 VSS 0.04759f
C2475 VDD.t97 VSS 0.11531f
C2476 VDD.t136 VSS 0.15449f
C2477 VDD.t96 VSS 0.11419f
C2478 VDD.t44 VSS 0.03825f
C2479 VDD.t261 VSS 0.05524f
C2480 VDD.n143 VSS 0.0931f
C2481 VDD.n144 VSS 0.02163f
C2482 VDD.n145 VSS 0.06691f
C2483 VDD.n146 VSS 0.01367f
C2484 VDD.n147 VSS 0.06917f
C2485 VDD.n148 VSS 0.01347f
C2486 VDD.n149 VSS 0.07441f
C2487 VDD.n150 VSS 0.05655f
C2488 VDD.n151 VSS 0.02164f
C2489 VDD.n152 VSS 0.11074f
C2490 VDD.n153 VSS 0.06282f
C2491 VDD.n154 VSS 0.11994f
C2492 VDD.n155 VSS 0.02164f
C2493 VDD.n156 VSS 0.06953f
C2494 VDD.n157 VSS 0.01625f
C2495 VDD.n158 VSS 0.07796f
C2496 VDD.n159 VSS 0.02163f
C2497 VDD.n160 VSS 0.06942f
C2498 VDD.n161 VSS 0.01622f
C2499 VDD.n162 VSS 0.06975f
C2500 VDD.n163 VSS 0.0216f
C2501 VDD.n164 VSS 0.06934f
C2502 VDD.n165 VSS 0.01613f
C2503 VDD.n166 VSS 0.06996f
C2504 VDD.n167 VSS 0.02154f
C2505 VDD.n168 VSS 0.06384f
C2506 VDD.n169 VSS 0.02152f
C2507 VDD.n170 VSS 0.06999f
C2508 VDD.n171 VSS 0.0161f
C2509 VDD.n172 VSS 0.0578f
C2510 VDD.n174 VSS 0.02304f
C2511 VDD.n175 VSS 2.20432f
C2512 VDD.n176 VSS 0.14831f
C2513 VDD.n177 VSS 0.12112f
C2514 VDD.n178 VSS 0.03306f
C2515 VDD.n179 VSS 0.06978f
C2516 VDD.n180 VSS 0.02312f
C2517 VDD.n181 VSS 0.08527f
C2518 VDD.n182 VSS 0.03239f
C2519 VDD.n183 VSS 0.08585f
C2520 VDD.n184 VSS 0.01621f
C2521 VDD.n185 VSS 0.06414f
C2522 VDD.n186 VSS 0.01924f
C2523 VDD.n187 VSS 0.08653f
C2524 VDD.t123 VSS 0.05466f
C2525 VDD.t87 VSS 1.15204f
C2526 VDD.n188 VSS 0.07293f
C2527 VDD.t138 VSS 0.21942f
C2528 VDD.n190 VSS 0.18721f
C2529 VDD.t90 VSS 0.43872f
C2530 VDD.n191 VSS 0.26758f
C2531 VDD.t105 VSS 0.05466f
C2532 VDD.n192 VSS 0.03781f
C2533 VDD.n193 VSS 0.01296f
C2534 VDD.t235 VSS 0.05238f
C2535 VDD.n194 VSS 0.0645f
C2536 VDD.t15 VSS 0.0522f
C2537 VDD.n195 VSS 0.06212f
C2538 VDD.n196 VSS 0.01542f
C2539 VDD.t165 VSS 0.05017f
C2540 VDD.n197 VSS 0.09277f
C2541 VDD.t56 VSS 0.25401f
C2542 VDD.n198 VSS 0.22371f
C2543 VDD.n199 VSS 0.03975f
C2544 VDD.t145 VSS 0.04361f
C2545 VDD.n200 VSS 0.11648f
C2546 VDD.t144 VSS 0.04774f
C2547 VDD.n201 VSS 0.10382f
C2548 VDD.t128 VSS 0.05466f
C2549 VDD.n202 VSS 0.09844f
C2550 VDD.t108 VSS 0.04757f
C2551 VDD.n203 VSS 0.09544f
C2552 VDD.n204 VSS 0.04388f
C2553 VDD.t109 VSS 0.04361f
C2554 VDD.n205 VSS 0.12011f
C2555 VDD.n206 VSS 0.08007f
C2556 VDD.n207 VSS 0.01162f
C2557 VDD.n208 VSS 0.0321f
C2558 VDD.n209 VSS 0.02436f
C2559 VDD.n210 VSS 0.0755f
C2560 VDD.n211 VSS 0.02875f
C2561 VDD.n212 VSS 0.07984f
C2562 VDD.n213 VSS 0.18617f
C2563 VDD.n214 VSS 0.17304f
C2564 VDD.t9 VSS 0.25101f
C2565 VDD.t7 VSS 0.25437f
C2566 VDD.t21 VSS 0.94988f
C2567 VDD.n215 VSS 0.03718f
C2568 VDD.n216 VSS 0.09699f
C2569 VDD.t160 VSS 0.05273f
C2570 VDD.n217 VSS 0.07165f
C2571 VDD.t159 VSS 0.20258f
C2572 VDD.n218 VSS 0.11648f
C2573 VDD.t158 VSS 0.20655f
C2574 VDD.n219 VSS 0.0884f
C2575 VDD.n220 VSS 0.01425f
C2576 VDD.t20 VSS 0.64693f
C2577 VDD.t93 VSS 0.04762f
C2578 VDD.t1 VSS 0.04874f
C2579 VDD.t2 VSS 0.04896f
C2580 VDD.t54 VSS 0.22779f
C2581 VDD.t11 VSS 0.08298f
C2582 VDD.t110 VSS 0.05273f
C2583 VDD.n221 VSS 0.18626f
C2584 VDD.n222 VSS 0.07026f
C2585 VDD.t141 VSS 0.04361f
C2586 VDD.n223 VSS 0.11648f
C2587 VDD.t140 VSS 0.04757f
C2588 VDD.t184 VSS 0.05498f
C2589 VDD.t216 VSS 0.47491f
C2590 VDD.t133 VSS 0.23768f
C2591 VDD.n224 VSS 0.03718f
C2592 VDD.t182 VSS 0.05631f
C2593 VDD.t180 VSS 0.05858f
C2594 VDD.t178 VSS 0.05631f
C2595 VDD.t176 VSS 0.05631f
C2596 VDD.t174 VSS 0.05631f
C2597 VDD.t172 VSS 1.54299f
C2598 VDD.t170 VSS 0.05631f
C2599 VDD.t169 VSS 0.05631f
C2600 VDD.t258 VSS 0.05631f
C2601 VDD.t62 VSS 0.05503f
C2602 VDD.t256 VSS 0.98548f
C2603 VDD.t255 VSS 0.05285f
C2604 VDD.t40 VSS 0.14531f
C2605 VDD.t237 VSS 1.54938f
C2606 VDD.t13 VSS 0.0522f
C2607 VDD.t214 VSS 0.04361f
C2608 VDD.n225 VSS 0.06422f
C2609 VDD.n226 VSS 0.01118f
C2610 VDD.n227 VSS 0.03715f
C2611 VDD.n228 VSS 0.01187f
C2612 VDD.n229 VSS 0.05775f
C2613 VDD.n230 VSS 0.01606f
C2614 VDD.n231 VSS 0.07008f
C2615 VDD.n232 VSS 0.0215f
C2616 VDD.n233 VSS 0.06384f
C2617 VDD.n234 VSS 0.02155f
C2618 VDD.n235 VSS 0.06988f
C2619 VDD.n236 VSS 0.01616f
C2620 VDD.n237 VSS 0.06938f
C2621 VDD.n238 VSS 0.02161f
C2622 VDD.n239 VSS 0.06968f
C2623 VDD.n240 VSS 0.01623f
C2624 VDD.n241 VSS 0.06947f
C2625 VDD.n242 VSS 0.02164f
C2626 VDD.n243 VSS 0.0779f
C2627 VDD.n244 VSS 0.01625f
C2628 VDD.n245 VSS 0.0641f
C2629 VDD.n246 VSS 0.01162f
C2630 VDD.n247 VSS 0.02096f
C2631 VDD.n248 VSS 0.01187f
C2632 VDD.n249 VSS 0.05535f
C2633 VDD.n251 VSS 0.05821f
C2634 VDD.n252 VSS 0.01347f
C2635 VDD.n253 VSS 0.09098f
C2636 VDD.n254 VSS 2.20432f
C2637 VDD.n255 VSS 0.14477f
C2638 VDD.n256 VSS 0.23961f
C2639 VDD.n257 VSS 0.18608f
C2640 VDD.n258 VSS 0.09541f
C2641 VDD.n259 VSS 0.12995f
C2642 VDD.n260 VSS 0.11609f
C2643 VDD.n262 VSS 0.08358f
C2644 VDD.n263 VSS 0.05868f
C2645 VDD.n264 VSS 0.13157f
C2646 VDD.n265 VSS 0.18985f
C2647 VDD.n266 VSS 0.58649f
.ends
