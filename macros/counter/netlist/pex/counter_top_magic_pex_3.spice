* PEX produced on Tue Aug 25 09:14:04 AM CEST 2026 using /foss/tools/sak/sak-pex.sh with m=3 and s=1 (extresist threshold=10000 mOhm, minres=1000 mOhm, mindelay=1 ps)
* NGSPICE file created from counter_top_pex.ext - technology: ihp-sg13cmos5l

.subckt counter_top_pex VDD VSS clock_i reset_n_i enable_i counter_value_o[0]
+ counter_value_o[1] counter_value_o[2] counter_value_o[3] counter_value_o[4]
+ counter_value_o[5] counter_value_o[6] counter_value_o[7]
X0 VDD VSS.t876 VDD VDD sg13_lv_pmos ad=0.19p pd=1.38u as=3.19196n ps=0.01242 w=1u l=1u
X1 VDD enable_i a_1192_3900# VDD sg13_lv_pmos ad=0.2114p pd=1.54u as=0.2856p ps=2.36u w=0.84u l=0.13u
X2 VDD VSS.t2614 VDD VDD sg13_lv_pmos ad=0.19p pd=1.38u as=0 ps=0 w=1u l=1u
X3 VSS.t41 a_4432_15454# a_4081_15311# VSS.t42 sg13_lv_nmos ad=79.8f pd=0.8u as=0.1428p ps=1.52u w=0.42u l=0.13u
X4 VDD VSS.t1707 VDD VDD sg13_lv_pmos ad=0.34p pd=2.68u as=0 ps=0 w=1u l=1u
X5 VSS.t1995 VDD VSS.t1997 VSS.t1996 sg13_lv_nmos ad=79.8f pd=0.8u as=0 ps=0 w=0.42u l=1u
X6 VDD sg13cmos5l_and2_1_2.B a_8685_14832# VDD sg13_lv_pmos ad=0.1918p pd=1.5u as=0.1596p ps=1.22u w=0.84u l=0.13u
X7 VDD VSS.t583 VDD VDD sg13_lv_pmos ad=0.34p pd=2.68u as=0 ps=0 w=1u l=1u
X8 VSS.t1558 VDD VSS.t1560 VSS.t1559 sg13_lv_nmos ad=79.8f pd=0.8u as=0 ps=0 w=0.42u l=1u
X9 VSS.t3079 VDD VSS.t3081 VSS.t3080 sg13_lv_nmos ad=79.8f pd=0.8u as=0 ps=0 w=0.42u l=1u
X10 VDD VSS.t1161 VDD VDD sg13_lv_pmos ad=0.34p pd=2.68u as=0 ps=0 w=1u l=1u
X11 VSS.t1950 VDD VSS.t1949 VSS.t1948 sg13_lv_nmos ad=0.1428p pd=1.52u as=0 ps=0 w=0.42u l=1u
X12 VDD VSS.t813 VDD VDD sg13_lv_pmos ad=0.34p pd=2.68u as=0 ps=0 w=1u l=1u
X13 VSS.t2624 VDD VSS.t2625 VSS.t206 sg13_lv_nmos ad=79.8f pd=0.8u as=0 ps=0 w=0.42u l=1u
X14 VSS.t1306 VDD VSS.t1305 VSS.t1154 sg13_lv_nmos ad=0.1428p pd=1.52u as=0 ps=0 w=0.42u l=1u
X15 VDD VSS.t2396 VDD VDD sg13_lv_pmos ad=0.34p pd=2.68u as=0 ps=0 w=1u l=1u
X16 VDD VSS.t2054 VDD VDD sg13_lv_pmos ad=0.34p pd=2.68u as=0 ps=0 w=1u l=1u
X17 VDD VSS.t1829 VDD VDD sg13_lv_pmos ad=0.34p pd=2.68u as=0 ps=0 w=1u l=1u
X18 VDD VSS.t2625 VDD VDD sg13_lv_pmos ad=0.34p pd=2.68u as=0 ps=0 w=1u l=1u
X19 VSS.t934 VDD VSS.t933 VSS.t932 sg13_lv_nmos ad=0.1428p pd=1.52u as=0 ps=0 w=0.42u l=1u
X20 VDD VSS.t550 VDD VDD sg13_lv_pmos ad=0.34p pd=2.68u as=0 ps=0 w=1u l=1u
X21 VSS.t979 VDD VSS.t978 VSS.t977 sg13_lv_nmos ad=0.1428p pd=1.52u as=0 ps=0 w=0.42u l=1u
X22 VDD VSS.t1170 VDD VDD sg13_lv_pmos ad=0.34p pd=2.68u as=0 ps=0 w=1u l=1u
X23 a_27500_15960# sg13cmos5l_dfrbpq_1_6.Q VSS.t349 VSS.t3218 sg13_lv_nmos ad=0.187p pd=1.78u as=0.14875p ps=1.16u w=0.55u l=0.13u
X24 VDD VSS.t1031 VDD VDD sg13_lv_pmos ad=0.19p pd=1.38u as=0 ps=0 w=1u l=1u
X25 VDD VSS.t1282 VDD VDD sg13_lv_pmos ad=0.19p pd=1.38u as=0 ps=0 w=1u l=1u
X26 VDD a_27407_13799# a_27664_13942# VDD sg13_lv_pmos ad=2.42015p pd=15.68u as=79.8f ps=0.8u w=0.42u l=0.13u
X27 VDD VSS.t843 VDD VDD sg13_lv_pmos ad=0.34p pd=2.68u as=0 ps=0 w=1u l=1u
X28 VSS.t2679 VDD VSS.t2678 VSS.t206 sg13_lv_nmos ad=0.1428p pd=1.52u as=0 ps=0 w=0.42u l=1u
X29 VDD sg13cmos5l_xnor2_1_2.A sg13cmos5l_nand4_1_0.Y VDD sg13_lv_pmos ad=0.2128p pd=1.5u as=0.2128p ps=1.5u w=1.12u l=0.13u
X30 VSS.t2482 VDD VSS.t2484 VSS.t2483 sg13_lv_nmos ad=79.8f pd=0.8u as=0 ps=0 w=0.42u l=1u
X31 a_19450_15202# sg13cmos5l_dfrbpq_1_3.Q VSS.t47 VSS.t107 sg13_lv_nmos ad=0.1428p pd=1.52u as=79.8f ps=0.8u w=0.42u l=0.13u
X32 VDD VSS.t632 VDD VDD sg13_lv_pmos ad=0.19p pd=1.38u as=0 ps=0 w=1u l=1u
X33 VDD VSS.t1550 VDD VDD sg13_lv_pmos ad=0.19p pd=1.38u as=0 ps=0 w=1u l=1u
X34 VDD VSS.t3013 VDD VDD sg13_lv_pmos ad=0.34p pd=2.68u as=0 ps=0 w=1u l=1u
X35 VSS.t2748 VDD VSS.t2747 VSS.t206 sg13_lv_nmos ad=0.1428p pd=1.52u as=0 ps=0 w=0.42u l=1u
X36 VDD VSS.t1884 VDD VDD sg13_lv_pmos ad=0.34p pd=2.68u as=0 ps=0 w=1u l=1u
X37 a_26436_13735# a_26148_14040# a_26374_13735# VSS.t177 sg13_lv_nmos ad=0.1428p pd=1.52u as=37.8f ps=0.6u w=0.42u l=0.13u
X38 VSS.t899 VDD VSS.t901 VSS.t900 sg13_lv_nmos ad=79.8f pd=0.8u as=0 ps=0 w=0.42u l=1u
X39 VSS.t1980 VDD VSS.t1982 VSS.t1981 sg13_lv_nmos ad=79.8f pd=0.8u as=0 ps=0 w=0.42u l=1u
X40 VDD VSS.t1555 VDD VDD sg13_lv_pmos ad=0.19p pd=1.38u as=0 ps=0 w=1u l=1u
X41 VSS.t1320 VDD VSS.t1319 VSS.t1154 sg13_lv_nmos ad=0.1428p pd=1.52u as=0 ps=0 w=0.42u l=1u
X42 VSS.t2616 VDD VSS.t2617 VSS.t206 sg13_lv_nmos ad=79.8f pd=0.8u as=0 ps=0 w=0.42u l=1u
X43 VDD VSS.t906 VDD VDD sg13_lv_pmos ad=0.19p pd=1.38u as=0 ps=0 w=1u l=1u
X44 VSS.t949 VDD VSS.t948 VSS.t947 sg13_lv_nmos ad=0.1428p pd=1.52u as=0 ps=0 w=0.42u l=1u
X45 VSS.t2352 VDD VSS.t2354 VSS.t2353 sg13_lv_nmos ad=79.8f pd=0.8u as=0 ps=0 w=0.42u l=1u
X46 VSS.t1900 VDD VSS.t1899 VSS.t1898 sg13_lv_nmos ad=0.1428p pd=1.52u as=0 ps=0 w=0.42u l=1u
X47 VDD VSS.t1897 VDD VDD sg13_lv_pmos ad=0.19p pd=1.38u as=0 ps=0 w=1u l=1u
X48 VSS.t774 VDD VSS.t776 VSS.t775 sg13_lv_nmos ad=79.8f pd=0.8u as=0 ps=0 w=0.42u l=1u
X49 VDD VSS.t430 VDD VDD sg13_lv_pmos ad=0.34p pd=2.68u as=0 ps=0 w=1u l=1u
X50 VDD VSS.t833 VDD VDD sg13_lv_pmos ad=0.34p pd=2.68u as=0 ps=0 w=1u l=1u
X51 VDD VSS.t2022 VDD VDD sg13_lv_pmos ad=0.19p pd=1.38u as=0 ps=0 w=1u l=1u
X52 a_17412_14922# sg13cmos5l_dfrbpq_1_3.D a_17318_14922# VSS.t52 sg13_lv_nmos ad=60.89999f pd=0.71u as=0.1428p ps=1.52u w=0.42u l=0.13u
X53 VSS.t1443 VDD VSS.t1442 VSS.t1441 sg13_lv_nmos ad=0.1428p pd=1.52u as=0 ps=0 w=0.42u l=1u
X54 VDD VSS.t1263 VDD VDD sg13_lv_pmos ad=0.34p pd=2.68u as=0 ps=0 w=1u l=1u
X55 VDD VSS.t3128 VDD VDD sg13_lv_pmos ad=0.34p pd=2.68u as=0 ps=0 w=1u l=1u
X56 VSS.t2633 VDD VSS.t2632 VSS.t206 sg13_lv_nmos ad=0.1428p pd=1.52u as=0 ps=0 w=0.42u l=1u
X57 VDD a_25774_15423# sg13cmos5l_dfrbpq_1_7.D VDD sg13_lv_pmos ad=0.2254p pd=1.53u as=0.4256p ps=3u w=1.12u l=0.13u
X58 VDD VSS.t687 VDD VDD sg13_lv_pmos ad=0.19p pd=1.38u as=0 ps=0 w=1u l=1u
X59 VSS.t1009 VDD VSS.t1011 VSS.t1010 sg13_lv_nmos ad=79.8f pd=0.8u as=0 ps=0 w=0.42u l=1u
X60 VSS.t2694 VDD VSS.t2695 VSS.t206 sg13_lv_nmos ad=79.8f pd=0.8u as=0 ps=0 w=0.42u l=1u
X61 VDD VSS.t1705 VDD VDD sg13_lv_pmos ad=0.19p pd=1.38u as=0 ps=0 w=1u l=1u
X62 VDD a_18021_14495# a_18123_14495# VDD sg13_lv_pmos ad=2.42015p pd=15.68u as=0.3864p ps=2.93u w=1.12u l=0.13u
X63 VDD a_22319_14845# a_22986_14484# VDD sg13_lv_pmos ad=0.2128p pd=1.5u as=0.3864p ps=2.93u w=1.12u l=0.13u
X64 VSS.t869 VDD VSS.t868 VSS.t867 sg13_lv_nmos ad=0.1428p pd=1.52u as=0 ps=0 w=0.42u l=1u
X65 VDD VSS.t1535 VDD VDD sg13_lv_pmos ad=0.19p pd=1.38u as=0 ps=0 w=1u l=1u
X66 VSS.t387 VDD VSS.t386 VSS.t385 sg13_lv_nmos ad=0.1428p pd=1.52u as=0 ps=0 w=0.42u l=1u
X67 VDD VSS.t588 VDD VDD sg13_lv_pmos ad=0.34p pd=2.68u as=0 ps=0 w=1u l=1u
X68 VSS.t1206 VDD VSS.t1207 VSS.t1154 sg13_lv_nmos ad=79.8f pd=0.8u as=0 ps=0 w=0.42u l=1u
X69 VDD VSS.t1301 VDD VDD sg13_lv_pmos ad=0.19p pd=1.38u as=0 ps=0 w=1u l=1u
X70 VDD VSS.t294 VDD VDD sg13_lv_pmos ad=0.34p pd=2.68u as=0 ps=0 w=1u l=1u
X71 VSS.t2646 VDD VSS.t2646 VSS.t206 sg13_lv_nmos ad=0.1428p pd=1.52u as=0 ps=0 w=0.42u l=1u
X72 VDD VSS.t2449 VDD VDD sg13_lv_pmos ad=0.19p pd=1.38u as=0 ps=0 w=1u l=1u
X73 VDD sg13cmos5l_dlygate4sd3_1_4.X a_17165_16020# VDD sg13_lv_pmos ad=0.3822p pd=1.84u as=0.1575p ps=1.315u w=1u l=0.13u
X74 VSS.t1935 VDD VSS.t1934 VSS.t1933 sg13_lv_nmos ad=0.1428p pd=1.52u as=0 ps=0 w=0.42u l=1u
X75 VSS.t3019 VDD VSS.t3018 VSS.t3017 sg13_lv_nmos ad=0.1428p pd=1.52u as=0 ps=0 w=0.42u l=1u
X76 VSS.t283 VDD VSS.t283 VSS.t285 sg13_lv_nmos ad=0.1428p pd=1.52u as=0 ps=0 w=0.42u l=1u
X77 VDD VSS.t2236 VDD VDD sg13_lv_pmos ad=0.34p pd=2.68u as=0 ps=0 w=1u l=1u
X78 VDD VSS.t796 VDD VDD sg13_lv_pmos ad=0.19p pd=1.38u as=0 ps=0 w=1u l=1u
X79 VDD VSS.t1500 VDD VDD sg13_lv_pmos ad=0.19p pd=1.38u as=0 ps=0 w=1u l=1u
X80 VDD VSS.t2409 VDD VDD sg13_lv_pmos ad=0.19p pd=1.38u as=0 ps=0 w=1u l=1u
X81 VSS.t2467 VDD VSS.t2469 VSS.t2468 sg13_lv_nmos ad=79.8f pd=0.8u as=0 ps=0 w=0.42u l=1u
X82 VSS.t407 VDD VSS.t408 VSS.t4 sg13_lv_nmos ad=79.8f pd=0.8u as=0 ps=0 w=0.42u l=1u
X83 VDD VSS.t246 VDD VDD sg13_lv_pmos ad=0.34p pd=2.68u as=0 ps=0 w=1u l=1u
X84 VDD VSS.t506 VDD VDD sg13_lv_pmos ad=0.34p pd=2.68u as=0 ps=0 w=1u l=1u
X85 VSS.t979 VDD VSS.t978 VSS.t977 sg13_lv_nmos ad=0.1428p pd=1.52u as=0 ps=0 w=0.42u l=1u
X86 VSS.t1845 VDD VSS.t1844 VSS.t1843 sg13_lv_nmos ad=0.1428p pd=1.52u as=0 ps=0 w=0.42u l=1u
X87 VDD VSS.t550 VDD VDD sg13_lv_pmos ad=0.34p pd=2.68u as=0 ps=0 w=1u l=1u
X88 VSS.t1633 VDD VSS.t1635 VSS.t1634 sg13_lv_nmos ad=79.8f pd=0.8u as=0 ps=0 w=0.42u l=1u
X89 VSS.t2015 VDD VSS.t2017 VSS.t2016 sg13_lv_nmos ad=79.8f pd=0.8u as=0 ps=0 w=0.42u l=1u
X90 VSS.t1189 VDD VSS.t1190 VSS.t1154 sg13_lv_nmos ad=79.8f pd=0.8u as=0 ps=0 w=0.42u l=1u
X91 VDD VSS.t1944 VDD VDD sg13_lv_pmos ad=0.34p pd=2.68u as=0 ps=0 w=1u l=1u
X92 VSS.t7 a_26633_16334# a_26554_16237# VSS.t223 sg13_lv_nmos ad=7.70437p pd=50.66u as=0.27427p ps=2.28u w=0.795u l=0.13u
X93 VDD VSS.t1309 VDD VDD sg13_lv_pmos ad=0.19p pd=1.38u as=0 ps=0 w=1u l=1u
X94 sg13cmos5l_dfrbpq_1_2.D sg13cmos5l_a21oi_1_3.B1 VSS.t110 VSS.t109 sg13_lv_nmos ad=0.1406p pd=1.12u as=0.2516p ps=2.16u w=0.74u l=0.13u
X95 a_2516_14484# a_2490_14447# sg13cmos5l_xor2_1_0.X VDD sg13_lv_pmos ad=0.2128p pd=1.5u as=0.3808p ps=2.92u w=1.12u l=0.13u
X96 VSS.t2670 VDD VSS.t2670 VSS.t206 sg13_lv_nmos ad=0.1428p pd=1.52u as=0 ps=0 w=0.42u l=1u
X97 VDD VSS.t438 VDD VDD sg13_lv_pmos ad=0.19p pd=1.38u as=0 ps=0 w=1u l=1u
X98 VSS.t899 VDD VSS.t901 VSS.t900 sg13_lv_nmos ad=79.8f pd=0.8u as=0 ps=0 w=0.42u l=1u
X99 VDD VSS.t888 VDD VDD sg13_lv_pmos ad=0.34p pd=2.68u as=0 ps=0 w=1u l=1u
X100 VDD VSS.t1712 VDD VDD sg13_lv_pmos ad=0.34p pd=2.68u as=0 ps=0 w=1u l=1u
X101 VDD VSS.t325 VDD VDD sg13_lv_pmos ad=0.19p pd=1.38u as=0 ps=0 w=1u l=1u
X102 VSS.t1563 VDD VSS.t1565 VSS.t1564 sg13_lv_nmos ad=79.8f pd=0.8u as=0 ps=0 w=0.42u l=1u
X103 VSS.t3084 VDD VSS.t3086 VSS.t3085 sg13_lv_nmos ad=79.8f pd=0.8u as=0 ps=0 w=0.42u l=1u
X104 VDD VSS.t573 VDD VDD sg13_lv_pmos ad=0.34p pd=2.68u as=0 ps=0 w=1u l=1u
X105 VSS.t608 VDD VSS.t605 VSS.t607 sg13_lv_nmos ad=0.1428p pd=1.52u as=0 ps=0 w=0.42u l=1u
X106 VDD VSS.t1013 VDD VDD sg13_lv_pmos ad=0.34p pd=2.68u as=0 ps=0 w=1u l=1u
X107 VDD a_3130_16237# sg13cmos5l_dfrbpq_1_0.RESET_B VDD sg13_lv_pmos ad=2.8961p pd=18.25u as=0.3927p ps=2.99u w=1.155u l=0.13u
X108 VSS.t620 VDD VSS.t620 VSS.t750 sg13_lv_nmos ad=0.1428p pd=1.52u as=0 ps=0 w=0.42u l=1u
X109 VSS.t2337 VDD VSS.t2339 VSS.t2338 sg13_lv_nmos ad=79.8f pd=0.8u as=0 ps=0 w=0.42u l=1u
X110 VDD VSS.t2401 VDD VDD sg13_lv_pmos ad=0.34p pd=2.68u as=0 ps=0 w=1u l=1u
X111 VSS.t774 VDD VSS.t776 VSS.t775 sg13_lv_nmos ad=79.8f pd=0.8u as=0 ps=0 w=0.42u l=1u
X112 VDD VSS.t763 VDD VDD sg13_lv_pmos ad=0.34p pd=2.68u as=0 ps=0 w=1u l=1u
X113 VDD VSS.t951 VDD VDD sg13_lv_pmos ad=0.19p pd=1.38u as=0 ps=0 w=1u l=1u
X114 VDD VSS.t2059 VDD VDD sg13_lv_pmos ad=0.34p pd=2.68u as=0 ps=0 w=1u l=1u
X115 VSS.t531 VDD VSS.t533 VSS.t532 sg13_lv_nmos ad=79.8f pd=0.8u as=0 ps=0 w=0.42u l=1u
X116 VDD VSS.t369 VDD VDD sg13_lv_pmos ad=0.34p pd=2.68u as=0 ps=0 w=1u l=1u
X117 VDD sg13cmos5l_dlygate4sd3_1_0.X a_5613_14832# VDD sg13_lv_pmos ad=0.1918p pd=1.5u as=0.1596p ps=1.22u w=0.84u l=0.13u
X118 VDD VSS.t216 VDD VDD sg13_lv_pmos ad=0.19p pd=1.38u as=0 ps=0 w=1u l=1u
X119 VDD VSS.t1231 VDD VDD sg13_lv_pmos ad=0.19p pd=1.38u as=0 ps=0 w=1u l=1u
X120 VDD VSS.t2724 VDD VDD sg13_lv_pmos ad=0.19p pd=1.38u as=0 ps=0 w=1u l=1u
X121 VSS.t2422 VDD VSS.t2421 VSS.t2420 sg13_lv_nmos ad=0.1428p pd=1.52u as=0 ps=0 w=0.42u l=1u
X122 VSS.t2035 VDD VSS.t2037 VSS.t2036 sg13_lv_nmos ad=79.8f pd=0.8u as=0 ps=0 w=0.42u l=1u
X123 sg13cmos5l_a21oi_1_0.A2 a_16969_16020# VSS.t11 VSS.t3262 sg13_lv_nmos ad=0.2516p pd=2.16u as=0.13395p ps=1.12u w=0.74u l=0.13u
X124 VSS.t869 VDD VSS.t868 VSS.t867 sg13_lv_nmos ad=0.1428p pd=1.52u as=0 ps=0 w=0.42u l=1u
X125 VSS.t1164 VDD VSS.t1165 VSS.t1154 sg13_lv_nmos ad=79.8f pd=0.8u as=0 ps=0 w=0.42u l=1u
X126 VDD VSS.t2102 VDD VDD sg13_lv_pmos ad=0.19p pd=1.38u as=0 ps=0 w=1u l=1u
X127 VSS.t425 VDD VSS.t426 VSS.t4 sg13_lv_nmos ad=79.8f pd=0.8u as=0 ps=0 w=0.42u l=1u
X128 VDD VSS.t418 VDD VDD sg13_lv_pmos ad=0.34p pd=2.68u as=0 ps=0 w=1u l=1u
X129 VSS.t2662 VDD VSS.t2661 VSS.t206 sg13_lv_nmos ad=0.1428p pd=1.52u as=0 ps=0 w=0.42u l=1u
X130 VDD VSS.t361 VDD VDD sg13_lv_pmos ad=0.19p pd=1.38u as=0 ps=0 w=1u l=1u
X131 VSS.t914 VDD VSS.t913 VSS.t912 sg13_lv_nmos ad=0.1428p pd=1.52u as=0 ps=0 w=0.42u l=1u
X132 VSS.t2487 VDD VSS.t2489 VSS.t2488 sg13_lv_nmos ad=79.8f pd=0.8u as=0 ps=0 w=0.42u l=1u
X133 a_27407_13799# a_26565_13701# a_26148_14040# VDD sg13_lv_pmos ad=0.2048p pd=1.63u as=0.34p ps=2.68u w=1u l=0.13u
X134 VDD VSS.t2983 VDD VDD sg13_lv_pmos ad=0.34p pd=2.68u as=0 ps=0 w=1u l=1u
X135 VDD VSS.t1889 VDD VDD sg13_lv_pmos ad=0.34p pd=2.68u as=0 ps=0 w=1u l=1u
X136 VSS.t138 a_22319_14845# a_22986_14484# VSS.t8 sg13_lv_nmos ad=0.1406p pd=1.12u as=0.2516p ps=2.16u w=0.74u l=0.13u
X137 VDD VSS.t1520 VDD VDD sg13_lv_pmos ad=0.19p pd=1.38u as=0 ps=0 w=1u l=1u
X138 VDD VSS.t1697 VDD VDD sg13_lv_pmos ad=0.34p pd=2.68u as=0 ps=0 w=1u l=1u
X139 VSS.t1985 VDD VSS.t1987 VSS.t1986 sg13_lv_nmos ad=79.8f pd=0.8u as=0 ps=0 w=0.42u l=1u
X140 VDD VSS.t273 VDD VDD sg13_lv_pmos ad=0.19p pd=1.38u as=0 ps=0 w=1u l=1u
X141 VDD VSS.t1560 VDD VDD sg13_lv_pmos ad=0.19p pd=1.38u as=0 ps=0 w=1u l=1u
X142 VSS.t2637 VDD VSS.t2637 VSS.t206 sg13_lv_nmos ad=0.1428p pd=1.52u as=0 ps=0 w=0.42u l=1u
X143 VSS.t521 VDD VSS.t520 VSS.t519 sg13_lv_nmos ad=0.1428p pd=1.52u as=0 ps=0 w=0.42u l=1u
X144 VDD VSS.t1215 VDD VDD sg13_lv_pmos ad=0.34p pd=2.68u as=0 ps=0 w=1u l=1u
X145 VDD VSS.t2688 VDD VDD sg13_lv_pmos ad=0.19p pd=1.38u as=0 ps=0 w=1u l=1u
X146 VDD VSS.t918 VDD VDD sg13_lv_pmos ad=0.34p pd=2.68u as=0 ps=0 w=1u l=1u
X147 a_17892_14909# a_17604_14488# a_17830_14909# VSS.t74 sg13_lv_nmos ad=0.1428p pd=1.52u as=37.8f ps=0.6u w=0.42u l=0.13u
X148 VDD VSS.t506 VDD VDD sg13_lv_pmos ad=0.34p pd=2.68u as=0 ps=0 w=1u l=1u
X149 VSS.t1252 VDD VSS.t1252 VSS.t1154 sg13_lv_nmos ad=79.8f pd=0.8u as=0 ps=0 w=0.42u l=1u
X150 VDD VSS.t2221 VDD VDD sg13_lv_pmos ad=0.34p pd=2.68u as=0 ps=0 w=1u l=1u
X151 VSS.t2282 VDD VSS.t2284 VSS.t2283 sg13_lv_nmos ad=79.8f pd=0.8u as=0 ps=0 w=0.42u l=1u
X152 VSS.t1830 VDD VSS.t1829 VSS.t1828 sg13_lv_nmos ad=0.1428p pd=1.52u as=0 ps=0 w=0.42u l=1u
X153 a_16425_14113# a_16068_14040# VDD VDD sg13_lv_pmos ad=63f pd=0.72u as=0.1563p ps=1.22u w=0.42u l=0.13u
X154 VSS.t2636 VDD VSS.t2634 VSS.t206 sg13_lv_nmos ad=0.1428p pd=1.52u as=0 ps=0 w=0.42u l=1u
X155 VSS.t1257 VDD VSS.t1258 VSS.t1154 sg13_lv_nmos ad=79.8f pd=0.8u as=0 ps=0 w=0.42u l=1u
X156 VSS.t2730 VDD VSS.t2731 VSS.t206 sg13_lv_nmos ad=79.8f pd=0.8u as=0 ps=0 w=0.42u l=1u
X157 VDD a_17584_13942# a_17529_14037# VDD sg13_lv_pmos ad=2.42015p pd=15.68u as=93.45f ps=0.865u w=0.42u l=0.13u
X158 VSS.t1573 VDD VSS.t1572 VSS.t1571 sg13_lv_nmos ad=0.1428p pd=1.52u as=0 ps=0 w=0.42u l=1u
X159 VDD VSS.t3051 VDD VDD sg13_lv_pmos ad=0.19p pd=1.38u as=0 ps=0 w=1u l=1u
X160 VSS.t2322 VDD VSS.t2324 VSS.t2323 sg13_lv_nmos ad=79.8f pd=0.8u as=0 ps=0 w=0.42u l=1u
X161 VDD VSS.t2264 VDD VDD sg13_lv_pmos ad=0.19p pd=1.38u as=0 ps=0 w=1u l=1u
X162 VDD VSS.t933 VDD VDD sg13_lv_pmos ad=0.34p pd=2.68u as=0 ps=0 w=1u l=1u
X163 VDD VSS.t1238 VDD VDD sg13_lv_pmos ad=0.34p pd=2.68u as=0 ps=0 w=1u l=1u
X164 VDD VSS.t2731 VDD VDD sg13_lv_pmos ad=0.34p pd=2.68u as=0 ps=0 w=1u l=1u
X165 VSS.t1548 VDD VSS.t1550 VSS.t1549 sg13_lv_nmos ad=79.8f pd=0.8u as=0 ps=0 w=0.42u l=1u
X166 VDD VSS.t1193 VDD VDD sg13_lv_pmos ad=0.19p pd=1.38u as=0 ps=0 w=1u l=1u
X167 a_9252_15234# sg13cmos5l_and2_1_2.X a_9158_15234# VSS.t128 sg13_lv_nmos ad=60.89999f pd=0.71u as=0.1428p ps=1.52u w=0.42u l=0.13u
X168 a_17806_15423# a_17921_15424# VDD VDD sg13_lv_pmos ad=0.34p pd=2.68u as=0.2254p ps=1.53u w=1u l=0.5u
X169 VSS.t1940 VDD VSS.t1939 VSS.t1938 sg13_lv_nmos ad=0.1428p pd=1.52u as=0 ps=0 w=0.42u l=1u
X170 VSS.t446 VDD VSS.t445 VSS.t4 sg13_lv_nmos ad=0.1428p pd=1.52u as=0 ps=0 w=0.42u l=1u
X171 VSS.t576 VDD VSS.t576 VSS.t702 sg13_lv_nmos ad=79.8f pd=0.8u as=0 ps=0 w=0.42u l=1u
X172 VDD VSS.t996 VDD VDD sg13_lv_pmos ad=0.19p pd=1.38u as=0 ps=0 w=1u l=1u
X173 VSS.t1266 VDD VSS.t1267 VSS.t1154 sg13_lv_nmos ad=79.8f pd=0.8u as=0 ps=0 w=0.42u l=1u
X174 VDD VSS.t1567 VDD VDD sg13_lv_pmos ad=0.34p pd=2.68u as=0 ps=0 w=1u l=1u
X175 VDD VSS.t2414 VDD VDD sg13_lv_pmos ad=0.19p pd=1.38u as=0 ps=0 w=1u l=1u
X176 VSS.t2472 VDD VSS.t2474 VSS.t2473 sg13_lv_nmos ad=79.8f pd=0.8u as=0 ps=0 w=0.42u l=1u
X177 VDD VSS.t611 VDD VDD sg13_lv_pmos ad=0.19p pd=1.38u as=0 ps=0 w=1u l=1u
X178 VSS.t1638 VDD VSS.t1640 VSS.t1639 sg13_lv_nmos ad=79.8f pd=0.8u as=0 ps=0 w=0.42u l=1u
X179 VSS.t2020 VDD VSS.t2022 VSS.t2021 sg13_lv_nmos ad=79.8f pd=0.8u as=0 ps=0 w=0.42u l=1u
X180 VSS.t1029 VDD VSS.t1031 VSS.t1030 sg13_lv_nmos ad=79.8f pd=0.8u as=0 ps=0 w=0.42u l=1u
X181 VDD VSS.t294 VDD VDD sg13_lv_pmos ad=0.19p pd=1.38u as=0 ps=0 w=1u l=1u
X182 VSS.t914 VDD VSS.t913 VSS.t912 sg13_lv_nmos ad=0.1428p pd=1.52u as=0 ps=0 w=0.42u l=1u
X183 VDD VSS.t1914 VDD VDD sg13_lv_pmos ad=0.34p pd=2.68u as=0 ps=0 w=1u l=1u
X184 VDD VSS.t896 VDD VDD sg13_lv_pmos ad=0.19p pd=1.38u as=0 ps=0 w=1u l=1u
X185 VDD VSS.t3036 VDD VDD sg13_lv_pmos ad=0.19p pd=1.38u as=0 ps=0 w=1u l=1u
X186 VDD VSS.t2249 VDD VDD sg13_lv_pmos ad=0.19p pd=1.38u as=0 ps=0 w=1u l=1u
X187 VDD VSS.t2087 VDD VDD sg13_lv_pmos ad=0.19p pd=1.38u as=0 ps=0 w=1u l=1u
X188 VSS.t32 a_4078_14751# sg13cmos5l_xor2_1_0.B VSS.t31 sg13_lv_nmos ad=0.1426p pd=1.16u as=0.2516p ps=2.16u w=0.74u l=0.13u
X189 VSS.t2652 VDD VSS.t2652 VSS.t206 sg13_lv_nmos ad=0.1428p pd=1.52u as=0 ps=0 w=0.42u l=1u
X190 a_12010_15202# sg13cmos5l_buf_8_2.A VDD VDD sg13_lv_pmos ad=0.2128p pd=1.5u as=0.2128p ps=1.5u w=1.12u l=0.13u
X191 VDD sg13cmos5l_buf_8_2.A a_19323_13726# VDD sg13_lv_pmos ad=0.2128p pd=1.5u as=0.3808p ps=2.92u w=1.12u l=0.13u
X192 VDD VSS.t2039 VDD VDD sg13_lv_pmos ad=0.34p pd=2.68u as=0 ps=0 w=1u l=1u
X193 VDD VSS.t1173 VDD VDD sg13_lv_pmos ad=0.34p pd=2.68u as=0 ps=0 w=1u l=1u
X194 VDD VSS.t1874 VDD VDD sg13_lv_pmos ad=0.34p pd=2.68u as=0 ps=0 w=1u l=1u
X195 VDD VSS.t409 VDD VDD sg13_lv_pmos ad=0.34p pd=2.68u as=0 ps=0 w=1u l=1u
X196 VDD VSS.t1682 VDD VDD sg13_lv_pmos ad=0.34p pd=2.68u as=0 ps=0 w=1u l=1u
X197 VSS.t2267 VDD VSS.t2269 VSS.t2268 sg13_lv_nmos ad=79.8f pd=0.8u as=0 ps=0 w=0.42u l=1u
X198 VSS.t1970 VDD VSS.t1972 VSS.t1971 sg13_lv_nmos ad=79.8f pd=0.8u as=0 ps=0 w=0.42u l=1u
X199 VSS.t440 VDD VSS.t439 VSS.t4 sg13_lv_nmos ad=0.1428p pd=1.52u as=0 ps=0 w=0.42u l=1u
X200 VDD VSS.t506 VDD VDD sg13_lv_pmos ad=0.19p pd=1.38u as=0 ps=0 w=1u l=1u
X201 VSS.t1533 VDD VSS.t1535 VSS.t1534 sg13_lv_nmos ad=79.8f pd=0.8u as=0 ps=0 w=0.42u l=1u
X202 VSS.t3054 VDD VSS.t3056 VSS.t3055 sg13_lv_nmos ad=79.8f pd=0.8u as=0 ps=0 w=0.42u l=1u
X203 VDD VSS.t1242 VDD VDD sg13_lv_pmos ad=0.34p pd=2.68u as=0 ps=0 w=1u l=1u
X204 VSS.t1234 VDD VSS.t1234 VSS.t1154 sg13_lv_nmos ad=79.8f pd=0.8u as=0 ps=0 w=0.42u l=1u
X205 VDD VSS.t1545 VDD VDD sg13_lv_pmos ad=0.19p pd=1.38u as=0 ps=0 w=1u l=1u
X206 a_10905_15549# a_9963_15356# a_10703_15311# VDD sg13_lv_pmos ad=93.45f pd=0.865u as=0.2048p ps=1.63u w=0.42u l=0.13u
X207 VDD sg13cmos5l_xnor2_1_2.A a_6714_12972# VDD sg13_lv_pmos ad=0.2891p pd=1.695u as=0.1428p ps=1.375u w=1.12u l=0.13u
X208 VDD VSS.t771 VDD VDD sg13_lv_pmos ad=0.19p pd=1.38u as=0 ps=0 w=1u l=1u
X209 VSS.t2342 VDD VSS.t2344 VSS.t2343 sg13_lv_nmos ad=79.8f pd=0.8u as=0 ps=0 w=0.42u l=1u
X210 VDD VSS.t2406 VDD VDD sg13_lv_pmos ad=0.34p pd=2.68u as=0 ps=0 w=1u l=1u
X211 VSS.t25 a_12010_15202# sg13cmos5l_dfrbpq_1_2.CLK VSS.t27 sg13_lv_nmos ad=0.1406p pd=1.12u as=0.1406p ps=1.12u w=0.74u l=0.13u
X212 a_22426_15202# sg13cmos5l_dfrbpq_1_6.Q VSS.t176 VSS.t57 sg13_lv_nmos ad=0.1428p pd=1.52u as=79.8f ps=0.8u w=0.42u l=0.13u
X213 sg13cmos5l_a21oi_1_0.Y sg13cmos5l_a21oi_1_3.B1 VSS.t16 VSS.t108 sg13_lv_nmos ad=0.1406p pd=1.12u as=0.2516p ps=2.16u w=0.74u l=0.13u
X214 VDD VSS.t2615 VDD VDD sg13_lv_pmos ad=0.34p pd=2.68u as=0 ps=0 w=1u l=1u
X215 VDD sg13cmos5l_o21ai_1_2.B1 sg13cmos5l_or3_1_1.C VDD sg13_lv_pmos ad=0.3808p pd=2.92u as=0.2128p ps=1.5u w=1.12u l=0.13u
X216 a_19120_14726# sg13cmos5l_dfrbpq_1_3.RESET_B VDD VDD sg13_lv_pmos ad=79.8f pd=0.8u as=2.42015p ps=15.68u w=0.42u l=0.13u
X217 a_23480_15242# sg13cmos5l_dfrbpq_1_3.Q a_23378_15242# VSS.t57 sg13_lv_nmos ad=0.1406p pd=1.12u as=0.1406p ps=1.12u w=0.74u l=0.13u
X218 VDD VSS.t1182 VDD VDD sg13_lv_pmos ad=0.34p pd=2.68u as=0 ps=0 w=1u l=1u
X219 VSS.t1284 VDD VSS.t1285 VSS.t1154 sg13_lv_nmos ad=79.8f pd=0.8u as=0 ps=0 w=0.42u l=1u
X220 VSS.t2627 VDD VSS.t2625 VSS.t206 sg13_lv_nmos ad=0.1428p pd=1.52u as=0 ps=0 w=0.42u l=1u
X221 VSS.t305 VDD VSS.t302 VSS.t304 sg13_lv_nmos ad=0.1428p pd=1.52u as=0 ps=0 w=0.42u l=1u
X222 VDD a_21562_15960# a_21281_16262# VDD sg13_lv_pmos ad=0.1523p pd=1.38u as=0.34p ps=2.68u w=1u l=0.5u
X223 VDD sg13cmos5l_o21ai_1_2.Y a_24824_15238# VDD sg13_lv_pmos ad=0.1523p pd=1.38u as=0.1428p ps=1.52u w=0.42u l=0.13u
X224 VDD a_18863_14845# a_19530_14484# VDD sg13_lv_pmos ad=0.2128p pd=1.5u as=0.3864p ps=2.93u w=1.12u l=0.13u
X225 VDD VSS.t841 VDD VDD sg13_lv_pmos ad=0.19p pd=1.38u as=0 ps=0 w=1u l=1u
X226 VDD VSS.t1270 VDD VDD sg13_lv_pmos ad=0.19p pd=1.38u as=0 ps=0 w=1u l=1u
X227 VDD VSS.t2763 VDD VDD sg13_lv_pmos ad=0.19p pd=1.38u as=0 ps=0 w=1u l=1u
X228 VDD VSS.t2072 VDD VDD sg13_lv_pmos ad=0.19p pd=1.38u as=0 ps=0 w=1u l=1u
X229 a_20603_15532# sg13cmos5l_a21oi_1_3.B1 sg13cmos5l_a21oi_1_1.Y VDD sg13_lv_pmos ad=0.2128p pd=1.5u as=0.3808p ps=2.92u w=1.12u l=0.13u
X230 VSS.t2664 VDD VSS.t2664 VSS.t206 sg13_lv_nmos ad=0.1428p pd=1.52u as=0 ps=0 w=0.42u l=1u
X231 VSS.t2487 VDD VSS.t2486 VSS.t2485 sg13_lv_nmos ad=0.1428p pd=1.52u as=0 ps=0 w=0.42u l=1u
X232 VSS.t2307 VDD VSS.t2309 VSS.t2308 sg13_lv_nmos ad=79.8f pd=0.8u as=0 ps=0 w=0.42u l=1u
X233 VDD VSS.t2988 VDD VDD sg13_lv_pmos ad=0.34p pd=2.68u as=0 ps=0 w=1u l=1u
X234 VSS.t2733 VDD VSS.t2731 VSS.t206 sg13_lv_nmos ad=0.1428p pd=1.52u as=0 ps=0 w=0.42u l=1u
X235 sg13cmos5l_dfrbpq_1_2.CLK a_12010_15202# VDD VDD sg13_lv_pmos ad=0.2128p pd=1.5u as=0.2128p ps=1.5u w=1.12u l=0.13u
X236 VDD VSS.t1859 VDD VDD sg13_lv_pmos ad=0.34p pd=2.68u as=0 ps=0 w=1u l=1u
X237 VSS.t407 VDD VSS.t406 VSS.t4 sg13_lv_nmos ad=0.1428p pd=1.52u as=0 ps=0 w=0.42u l=1u
X238 VDD VSS.t926 VDD VDD sg13_lv_pmos ad=0.19p pd=1.38u as=0 ps=0 w=1u l=1u
X239 VSS.t1713 VDD VSS.t1712 VSS.t1711 sg13_lv_nmos ad=0.1428p pd=1.52u as=0 ps=0 w=0.42u l=1u
X240 VDD VSS.t1565 VDD VDD sg13_lv_pmos ad=0.19p pd=1.38u as=0 ps=0 w=1u l=1u
X241 VDD VSS.t2439 VDD VDD sg13_lv_pmos ad=0.19p pd=1.38u as=0 ps=0 w=1u l=1u
X242 VSS.t3009 VDD VSS.t3008 VSS.t3007 sg13_lv_nmos ad=0.1428p pd=1.52u as=0 ps=0 w=0.42u l=1u
X243 VDD a_15579_14854# sg13cmos5l_buf_8_2.A VDD sg13_lv_pmos ad=0.3864p pd=2.93u as=0.2128p ps=1.5u w=1.12u l=0.13u
X244 VDD VSS.t289 VDD VDD sg13_lv_pmos ad=0.34p pd=2.68u as=0 ps=0 w=1u l=1u
X245 VSS.t123 a_22508_15960# counter_value_o[4] VSS.t189 sg13_lv_nmos ad=0.14875p pd=1.16u as=0.2886p ps=2.26u w=0.74u l=0.13u
X246 VSS.t22 a_12010_15202# sg13cmos5l_dfrbpq_1_2.CLK VSS.t21 sg13_lv_nmos ad=0.1406p pd=1.12u as=0.1406p ps=1.12u w=0.74u l=0.13u
X247 VDD VSS.t417 VDD VDD sg13_lv_pmos ad=0.19p pd=1.38u as=0 ps=0 w=1u l=1u
X248 VDD VSS.t2722 VDD VDD sg13_lv_pmos ad=0.19p pd=1.38u as=0 ps=0 w=1u l=1u
X249 VSS.t2457 VDD VSS.t2459 VSS.t2458 sg13_lv_nmos ad=79.8f pd=0.8u as=0 ps=0 w=0.42u l=1u
X250 VSS.t1029 VDD VSS.t1031 VSS.t1030 sg13_lv_nmos ad=79.8f pd=0.8u as=0 ps=0 w=0.42u l=1u
X251 VDD VSS.t1275 VDD VDD sg13_lv_pmos ad=0.34p pd=2.68u as=0 ps=0 w=1u l=1u
X252 VDD VSS.t153 VDD VDD sg13_lv_pmos ad=0.19p pd=1.38u as=0 ps=0 w=1u l=1u
X253 VSS.t2618 VDD VSS.t2618 VSS.t206 sg13_lv_nmos ad=0.1428p pd=1.52u as=0 ps=0 w=0.42u l=1u
X254 VSS.t1225 VDD VSS.t1224 VSS.t1154 sg13_lv_nmos ad=0.1428p pd=1.52u as=0 ps=0 w=0.42u l=1u
X255 VDD VSS.t2494 VDD VDD sg13_lv_pmos ad=0.19p pd=1.38u as=0 ps=0 w=1u l=1u
X256 VDD VSS.t1899 VDD VDD sg13_lv_pmos ad=0.34p pd=2.68u as=0 ps=0 w=1u l=1u
X257 VSS.t531 VDD VSS.t533 VSS.t532 sg13_lv_nmos ad=79.8f pd=0.8u as=0 ps=0 w=0.42u l=1u
X258 VSS.t889 VDD VSS.t888 VSS.t887 sg13_lv_nmos ad=0.1428p pd=1.52u as=0 ps=0 w=0.42u l=1u
X259 VSS.t2327 VDD VSS.t2329 VSS.t2328 sg13_lv_nmos ad=79.8f pd=0.8u as=0 ps=0 w=0.42u l=1u
X260 VDD VSS.t2234 VDD VDD sg13_lv_pmos ad=0.19p pd=1.38u as=0 ps=0 w=1u l=1u
X261 VDD sg13cmos5l_dlygate4sd3_1_17.A a_24824_14525# VDD sg13_lv_pmos ad=0.1523p pd=1.38u as=0.1428p ps=1.52u w=0.42u l=0.13u
X262 VSS.t1218 VDD VSS.t1219 VSS.t1154 sg13_lv_nmos ad=79.8f pd=0.8u as=0 ps=0 w=0.42u l=1u
X263 VSS.t2100 VDD VSS.t2102 VSS.t2101 sg13_lv_nmos ad=79.8f pd=0.8u as=0 ps=0 w=0.42u l=1u
X264 VDD VSS.t2024 VDD VDD sg13_lv_pmos ad=0.34p pd=2.68u as=0 ps=0 w=1u l=1u
X265 VDD VSS.t506 VDD VDD sg13_lv_pmos ad=0.19p pd=1.38u as=0 ps=0 w=1u l=1u
X266 VDD VSS.t1312 VDD VDD sg13_lv_pmos ad=0.19p pd=1.38u as=0 ps=0 w=1u l=1u
X267 VDD a_19450_15202# a_19169_15424# VDD sg13_lv_pmos ad=0.1523p pd=1.38u as=0.34p ps=2.68u w=1u l=0.5u
X268 a_26373_14495# sg13cmos5l_buf_8_2.X VSS.t4 VSS.t72 sg13_lv_nmos ad=0.2516p pd=2.16u as=3.8707p ps=25.555u w=0.74u l=0.13u
X269 VSS.t1698 VDD VSS.t1697 VSS.t1696 sg13_lv_nmos ad=0.1428p pd=1.52u as=0 ps=0 w=0.42u l=1u
X270 a_26170_15202# sg13cmos5l_a21oi_1_3.Y VSS.t3 VSS.t3273 sg13_lv_nmos ad=0.1428p pd=1.52u as=79.8f ps=0.8u w=0.42u l=0.13u
X271 VDD VSS.t1707 VDD VDD sg13_lv_pmos ad=0.34p pd=2.68u as=0 ps=0 w=1u l=1u
X272 VDD VSS.t283 VDD VDD sg13_lv_pmos ad=0.34p pd=2.68u as=0 ps=0 w=1u l=1u
X273 VSS.t764 VDD VSS.t763 VSS.t762 sg13_lv_nmos ad=0.1428p pd=1.52u as=0 ps=0 w=0.42u l=1u
X274 VSS.t949 VDD VSS.t951 VSS.t950 sg13_lv_nmos ad=79.8f pd=0.8u as=0 ps=0 w=0.42u l=1u
X275 VSS.t58 sg13cmos5l_or3_1_2.B a_24310_15230# VSS.t57 sg13_lv_nmos ad=0.1406p pd=1.12u as=0.2516p ps=2.16u w=0.74u l=0.15u
X276 VDD VSS.t2391 VDD VDD sg13_lv_pmos ad=0.34p pd=2.68u as=0 ps=0 w=1u l=1u
X277 a_16042_13945# a_16485_13701# a_15782_13722# VSS.t3191 sg13_lv_nmos ad=79.8f pd=0.8u as=0.1296p ps=1.52u w=0.42u l=0.13u
X278 VDD VSS.t1537 VDD VDD sg13_lv_pmos ad=0.34p pd=2.68u as=0 ps=0 w=1u l=1u
X279 VSS.t2442 VDD VSS.t2444 VSS.t2443 sg13_lv_nmos ad=79.8f pd=0.8u as=0 ps=0 w=0.42u l=1u
X280 VSS.t425 VDD VSS.t424 VSS.t4 sg13_lv_nmos ad=0.1428p pd=1.52u as=0 ps=0 w=0.42u l=1u
X281 VDD VSS.t571 VDD VDD sg13_lv_pmos ad=0.34p pd=2.68u as=0 ps=0 w=1u l=1u
X282 VSS.t1608 VDD VSS.t1610 VSS.t1609 sg13_lv_nmos ad=79.8f pd=0.8u as=0 ps=0 w=0.42u l=1u
X283 VSS.t328 VDD VSS.t330 VSS.t329 sg13_lv_nmos ad=79.8f pd=0.8u as=0 ps=0 w=0.42u l=1u
X284 VDD VSS.t372 VDD VDD sg13_lv_pmos ad=0.19p pd=1.38u as=0 ps=0 w=1u l=1u
X285 VDD VSS.t1157 VDD VDD sg13_lv_pmos ad=0.34p pd=2.68u as=0 ps=0 w=1u l=1u
X286 VDD VSS.t1919 VDD VDD sg13_lv_pmos ad=0.34p pd=2.68u as=0 ps=0 w=1u l=1u
X287 a_17710_16263# a_17825_16262# VDD VDD sg13_lv_pmos ad=0.34p pd=2.68u as=0.2254p ps=1.53u w=1u l=0.5u
X288 a_19120_14726# a_18863_14845# a_19282_14922# VSS.t13 sg13_lv_nmos ad=0.1428p pd=1.52u as=37.8f ps=0.6u w=0.42u l=0.13u
X289 VSS.t1200 VDD VSS.t1199 VSS.t1154 sg13_lv_nmos ad=0.1428p pd=1.52u as=0 ps=0 w=0.42u l=1u
X290 VDD VSS.t1261 VDD VDD sg13_lv_pmos ad=0.19p pd=1.38u as=0 ps=0 w=1u l=1u
X291 VDD VSS.t2754 VDD VDD sg13_lv_pmos ad=0.19p pd=1.38u as=0 ps=0 w=1u l=1u
X292 VSS.t47 a_18863_14845# a_19530_14484# VSS.t13 sg13_lv_nmos ad=0.1406p pd=1.12u as=0.2516p ps=2.16u w=0.74u l=0.13u
X293 VDD VSS.t1293 VDD VDD sg13_lv_pmos ad=0.34p pd=2.68u as=0 ps=0 w=1u l=1u
X294 VSS.t2656 VDD VSS.t2655 VSS.t206 sg13_lv_nmos ad=0.1428p pd=1.52u as=0 ps=0 w=0.42u l=1u
X295 VSS.t2472 VDD VSS.t2471 VSS.t2470 sg13_lv_nmos ad=0.1428p pd=1.52u as=0 ps=0 w=0.42u l=1u
X296 VSS.t2085 VDD VSS.t2087 VSS.t2086 sg13_lv_nmos ad=79.8f pd=0.8u as=0 ps=0 w=0.42u l=1u
X297 VDD VSS.t41 VDD VDD sg13_lv_pmos ad=0.34p pd=2.68u as=0 ps=0 w=1u l=1u
X298 VSS.t620 VDD VSS.t617 VSS.t619 sg13_lv_nmos ad=0.1428p pd=1.52u as=0 ps=0 w=0.42u l=1u
X299 VDD VSS.t1033 VDD VDD sg13_lv_pmos ad=0.34p pd=2.68u as=0 ps=0 w=1u l=1u
X300 VSS.t1243 VDD VSS.t1242 VSS.t1154 sg13_lv_nmos ad=0.1428p pd=1.52u as=0 ps=0 w=0.42u l=1u
X301 VSS.t2272 VDD VSS.t2274 VSS.t2273 sg13_lv_nmos ad=79.8f pd=0.8u as=0 ps=0 w=0.42u l=1u
X302 VSS.t1975 VDD VSS.t1977 VSS.t1976 sg13_lv_nmos ad=79.8f pd=0.8u as=0 ps=0 w=0.42u l=1u
X303 VSS.t372 VDD VSS.t372 VSS.t374 sg13_lv_nmos ad=0.1428p pd=1.52u as=0 ps=0 w=0.42u l=1u
X304 VSS.t434 VDD VSS.t433 VSS.t4 sg13_lv_nmos ad=0.1428p pd=1.52u as=0 ps=0 w=0.42u l=1u
X305 VSS.t3059 VDD VSS.t3061 VSS.t3060 sg13_lv_nmos ad=79.8f pd=0.8u as=0 ps=0 w=0.42u l=1u
X306 VSS.t919 VDD VSS.t918 VSS.t917 sg13_lv_nmos ad=0.1428p pd=1.52u as=0 ps=0 w=0.42u l=1u
X307 VDD VSS.t1550 VDD VDD sg13_lv_pmos ad=0.19p pd=1.38u as=0 ps=0 w=1u l=1u
X308 VDD VSS.t971 VDD VDD sg13_lv_pmos ad=0.19p pd=1.38u as=0 ps=0 w=1u l=1u
X309 VDD VSS.t1605 VDD VDD sg13_lv_pmos ad=0.19p pd=1.38u as=0 ps=0 w=1u l=1u
X310 VSS.t401 VDD VSS.t246 VSS.t4 sg13_lv_nmos ad=0.1428p pd=1.52u as=0 ps=0 w=0.42u l=1u
X311 VSS.t2347 VDD VSS.t2349 VSS.t2348 sg13_lv_nmos ad=79.8f pd=0.8u as=0 ps=0 w=0.42u l=1u
X312 VDD VSS.t278 VDD VDD sg13_lv_pmos ad=0.19p pd=1.38u as=0 ps=0 w=1u l=1u
X313 a_27034_15202# sg13cmos5l_dfrbpq_1_7.Q VDD VDD sg13_lv_pmos ad=0.1428p pd=1.52u as=0.1523p ps=1.38u w=0.42u l=0.13u
X314 VSS.t2654 VDD VSS.t2652 VSS.t206 sg13_lv_nmos ad=0.1428p pd=1.52u as=0 ps=0 w=0.42u l=1u
X315 VDD VSS.t2376 VDD VDD sg13_lv_pmos ad=0.34p pd=2.68u as=0 ps=0 w=1u l=1u
X316 VDD VSS.t596 VDD VDD sg13_lv_pmos ad=0.19p pd=1.38u as=0 ps=0 w=1u l=1u
X317 VDD VSS.t89 VDD VDD sg13_lv_pmos ad=0.19p pd=1.38u as=0 ps=0 w=1u l=1u
X318 VDD VSS.t1887 VDD VDD sg13_lv_pmos ad=0.19p pd=1.38u as=0 ps=0 w=1u l=1u
X319 VDD VSS.t2714 VDD VDD sg13_lv_pmos ad=0.19p pd=1.38u as=0 ps=0 w=1u l=1u
X320 VSS.t1568 VDD VSS.t1567 VSS.t1566 sg13_lv_nmos ad=0.1428p pd=1.52u as=0 ps=0 w=0.42u l=1u
X321 VSS.t3089 VDD VSS.t3088 VSS.t3087 sg13_lv_nmos ad=0.1428p pd=1.52u as=0 ps=0 w=0.42u l=1u
X322 VDD VSS.t2294 VDD VDD sg13_lv_pmos ad=0.19p pd=1.38u as=0 ps=0 w=1u l=1u
X323 VSS.t16 a_18202_15202# a_17921_15424# VSS.t132 sg13_lv_nmos ad=79.8f pd=0.8u as=0.1428p ps=1.52u w=0.42u l=0.5u
X324 VDD VSS.t2689 VDD VDD sg13_lv_pmos ad=0.34p pd=2.68u as=0 ps=0 w=1u l=1u
X325 a_25390_16263# a_25505_16262# VDD VDD sg13_lv_pmos ad=0.34p pd=2.68u as=0.2254p ps=1.53u w=1u l=0.5u
X326 VSS.t437 VDD VSS.t438 VSS.t4 sg13_lv_nmos ad=79.8f pd=0.8u as=0 ps=0 w=0.42u l=1u
X327 VDD VSS.t430 VDD VDD sg13_lv_pmos ad=0.34p pd=2.68u as=0 ps=0 w=1u l=1u
X328 VDD VSS.t846 VDD VDD sg13_lv_pmos ad=0.19p pd=1.38u as=0 ps=0 w=1u l=1u
X329 VSS.t889 VDD VSS.t888 VSS.t887 sg13_lv_nmos ad=0.1428p pd=1.52u as=0 ps=0 w=0.42u l=1u
X330 VDD VSS.t2479 VDD VDD sg13_lv_pmos ad=0.19p pd=1.38u as=0 ps=0 w=1u l=1u
X331 VDD VSS.t1273 VDD VDD sg13_lv_pmos ad=0.19p pd=1.38u as=0 ps=0 w=1u l=1u
X332 VSS.t1563 VDD VSS.t1562 VSS.t1561 sg13_lv_nmos ad=0.1428p pd=1.52u as=0 ps=0 w=0.42u l=1u
X333 VDD VSS.t2766 VDD VDD sg13_lv_pmos ad=0.19p pd=1.38u as=0 ps=0 w=1u l=1u
X334 VDD VSS.t2077 VDD VDD sg13_lv_pmos ad=0.19p pd=1.38u as=0 ps=0 w=1u l=1u
X335 VDD VSS.t2431 VDD VDD sg13_lv_pmos ad=0.34p pd=2.68u as=0 ps=0 w=1u l=1u
X336 VSS.t2492 VDD VSS.t2491 VSS.t2490 sg13_lv_nmos ad=0.1428p pd=1.52u as=0 ps=0 w=0.42u l=1u
X337 VSS.t2312 VDD VSS.t2314 VSS.t2313 sg13_lv_nmos ad=79.8f pd=0.8u as=0 ps=0 w=0.42u l=1u
X338 VDD VSS.t2993 VDD VDD sg13_lv_pmos ad=0.34p pd=2.68u as=0 ps=0 w=1u l=1u
X339 VSS.t578 VDD VSS.t580 VSS.t579 sg13_lv_nmos ad=79.8f pd=0.8u as=0 ps=0 w=0.42u l=1u
X340 VSS.t2040 VDD VSS.t2039 VSS.t2038 sg13_lv_nmos ad=0.1428p pd=1.52u as=0 ps=0 w=0.42u l=1u
X341 VDD VSS.t1227 VDD VDD sg13_lv_pmos ad=0.34p pd=2.68u as=0 ps=0 w=1u l=1u
X342 VDD VSS.t2037 VDD VDD sg13_lv_pmos ad=0.19p pd=1.38u as=0 ps=0 w=1u l=1u
X343 VSS.t764 VDD VSS.t763 VSS.t762 sg13_lv_nmos ad=0.1428p pd=1.52u as=0 ps=0 w=0.42u l=1u
X344 VSS.t949 VDD VSS.t951 VSS.t950 sg13_lv_nmos ad=79.8f pd=0.8u as=0 ps=0 w=0.42u l=1u
X345 VDD VSS.t1535 VDD VDD sg13_lv_pmos ad=0.19p pd=1.38u as=0 ps=0 w=1u l=1u
X346 VDD VSS.t1590 VDD VDD sg13_lv_pmos ad=0.19p pd=1.38u as=0 ps=0 w=1u l=1u
X347 VDD a_8218_13690# a_7937_13912# VDD sg13_lv_pmos ad=0.1523p pd=1.38u as=0.34p ps=2.68u w=1u l=0.5u
X348 sg13cmos5l_dfrbpq_1_2.Q a_17994_14020# VDD VDD sg13_lv_pmos ad=0.3808p pd=2.92u as=0.2128p ps=1.5u w=1.12u l=0.13u
X349 VDD VSS.t83 VDD VDD sg13_lv_pmos ad=0.34p pd=2.68u as=0 ps=0 w=1u l=1u
X350 VDD VSS.t878 VDD VDD sg13_lv_pmos ad=0.34p pd=2.68u as=0 ps=0 w=1u l=1u
X351 VDD VSS.t2651 VDD VDD sg13_lv_pmos ad=0.19p pd=1.38u as=0 ps=0 w=1u l=1u
X352 VDD VSS.t2725 VDD VDD sg13_lv_pmos ad=0.19p pd=1.38u as=0 ps=0 w=1u l=1u
X353 VSS.t1990 VDD VSS.t1989 VSS.t1988 sg13_lv_nmos ad=0.1428p pd=1.52u as=0 ps=0 w=0.42u l=1u
X354 VDD VSS.t41 VDD VDD sg13_lv_pmos ad=0.34p pd=2.68u as=0 ps=0 w=1u l=1u
X355 a_23960_15242# sg13cmos5l_dfrbpq_1_3.Q a_23858_15242# VSS.t57 sg13_lv_nmos ad=0.1406p pd=1.12u as=0.1406p ps=1.12u w=0.74u l=0.13u
X356 VSS.t3074 VDD VSS.t3073 VSS.t3072 sg13_lv_nmos ad=0.1428p pd=1.52u as=0 ps=0 w=0.42u l=1u
X357 VSS.t2287 VDD VSS.t2286 VSS.t2285 sg13_lv_nmos ad=0.1428p pd=1.52u as=0 ps=0 w=0.42u l=1u
X358 VDD VSS.t317 VDD VDD sg13_lv_pmos ad=0.19p pd=1.38u as=0 ps=0 w=1u l=1u
X359 a_7680_15549# sg13cmos5l_dlygate4sd3_1_8.X VDD VDD sg13_lv_pmos ad=0.1596p pd=1.22u as=0.4536p ps=2.76u w=0.84u l=0.13u
X360 VSS.t419 VDD VSS.t418 VSS.t4 sg13_lv_nmos ad=0.1428p pd=1.52u as=0 ps=0 w=0.42u l=1u
X361 VSS.t2621 VDD VSS.t2620 VSS.t206 sg13_lv_nmos ad=0.1428p pd=1.52u as=0 ps=0 w=0.42u l=1u
X362 a_24923_15996# sg13cmos5l_or3_1_1.X VDD VDD sg13_lv_pmos ad=0.3808p pd=2.92u as=0.2128p ps=1.5u w=1.12u l=0.13u
X363 VDD sg13cmos5l_xnor2_1_0.Y a_8312_15238# VDD sg13_lv_pmos ad=0.1523p pd=1.38u as=0.1428p ps=1.52u w=0.42u l=0.13u
X364 VSS.t2716 VDD VSS.t2717 VSS.t206 sg13_lv_nmos ad=79.8f pd=0.8u as=0 ps=0 w=0.42u l=1u
X365 VDD VSS.t2464 VDD VDD sg13_lv_pmos ad=0.19p pd=1.38u as=0 ps=0 w=1u l=1u
X366 VDD VSS.t614 VDD VDD sg13_lv_pmos ad=0.19p pd=1.38u as=0 ps=0 w=1u l=1u
X367 VDD VSS.t1904 VDD VDD sg13_lv_pmos ad=0.34p pd=2.68u as=0 ps=0 w=1u l=1u
X368 VDD VSS.t2239 VDD VDD sg13_lv_pmos ad=0.19p pd=1.38u as=0 ps=0 w=1u l=1u
X369 VDD VSS.t3026 VDD VDD sg13_lv_pmos ad=0.19p pd=1.38u as=0 ps=0 w=1u l=1u
X370 VSS.t2070 VDD VSS.t2072 VSS.t2071 sg13_lv_nmos ad=79.8f pd=0.8u as=0 ps=0 w=0.42u l=1u
X371 VDD VSS.t147 VDD VDD sg13_lv_pmos ad=0.19p pd=1.38u as=0 ps=0 w=1u l=1u
X372 a_20868_14922# sg13cmos5l_dfrbpq_1_6.D a_20774_14922# VSS.t13 sg13_lv_nmos ad=60.89999f pd=0.71u as=0.1428p ps=1.52u w=0.42u l=0.13u
X373 VDD VSS.t2029 VDD VDD sg13_lv_pmos ad=0.34p pd=2.68u as=0 ps=0 w=1u l=1u
X374 VSS.t1301 VDD VSS.t1419 VSS.t1154 sg13_lv_nmos ad=0.1428p pd=1.52u as=0 ps=0 w=0.42u l=1u
X375 VSS.t356 VDD VSS.t356 VSS.t359 sg13_lv_nmos ad=79.8f pd=0.8u as=0 ps=0 w=0.42u l=1u
X376 VDD VSS.t535 VDD VDD sg13_lv_pmos ad=0.34p pd=2.68u as=0 ps=0 w=1u l=1u
X377 VSS.t919 VDD VSS.t918 VSS.t917 sg13_lv_nmos ad=0.1428p pd=1.52u as=0 ps=0 w=0.42u l=1u
X378 VDD sg13cmos5l_dlygate4sd3_1_1.A sg13cmos5l_nand3_1_0.Y VDD sg13_lv_pmos ad=0.2128p pd=1.5u as=0.2128p ps=1.5u w=1.12u l=0.13u
X379 VSS.t3044 VDD VSS.t3046 VSS.t3045 sg13_lv_nmos ad=79.8f pd=0.8u as=0 ps=0 w=0.42u l=1u
X380 VSS.t2257 VDD VSS.t2259 VSS.t2258 sg13_lv_nmos ad=79.8f pd=0.8u as=0 ps=0 w=0.42u l=1u
X381 a_21562_15960# sg13cmos5l_a21oi_1_1.Y VSS.t89 VSS.t240 sg13_lv_nmos ad=0.1428p pd=1.52u as=79.8f ps=0.8u w=0.42u l=0.13u
X382 VDD VSS.t1712 VDD VDD sg13_lv_pmos ad=0.34p pd=2.68u as=0 ps=0 w=1u l=1u
X383 VDD a_21477_14495# a_21579_14495# VDD sg13_lv_pmos ad=2.42015p pd=15.68u as=0.3864p ps=2.93u w=1.12u l=0.13u
X384 VSS.t1618 VDD VSS.t1620 VSS.t1619 sg13_lv_nmos ad=79.8f pd=0.8u as=0 ps=0 w=0.42u l=1u
X385 VSS.t2332 VDD VSS.t2334 VSS.t2333 sg13_lv_nmos ad=79.8f pd=0.8u as=0 ps=0 w=0.42u l=1u
X386 a_17830_14909# sg13cmos5l_dfrbpq_1_3.RESET_B VSS.t16 VSS.t3210 sg13_lv_nmos ad=37.8f pd=0.6u as=0.1701p ps=1.65u w=0.42u l=0.13u
X387 VDD VSS.t623 VDD VDD sg13_lv_pmos ad=0.19p pd=1.38u as=0 ps=0 w=1u l=1u
X388 VDD VSS.t1542 VDD VDD sg13_lv_pmos ad=0.34p pd=2.68u as=0 ps=0 w=1u l=1u
X389 VSS.t1613 VDD VSS.t1615 VSS.t1614 sg13_lv_nmos ad=79.8f pd=0.8u as=0 ps=0 w=0.42u l=1u
X390 VDD VSS.t2682 VDD VDD sg13_lv_pmos ad=0.34p pd=2.68u as=0 ps=0 w=1u l=1u
X391 VDD VSS.t2456 VDD VDD sg13_lv_pmos ad=0.34p pd=2.68u as=0 ps=0 w=1u l=1u
X392 VSS.t839 VDD VSS.t841 VSS.t840 sg13_lv_nmos ad=79.8f pd=0.8u as=0 ps=0 w=0.42u l=1u
X393 VSS.t2727 VDD VSS.t2728 VSS.t206 sg13_lv_nmos ad=79.8f pd=0.8u as=0 ps=0 w=0.42u l=1u
X394 VDD VSS.t1160 VDD VDD sg13_lv_pmos ad=0.34p pd=2.68u as=0 ps=0 w=1u l=1u
X395 a_26565_13701# sg13cmos5l_buf_8_2.X VSS.t66 VSS.t71 sg13_lv_nmos ad=0.2516p pd=2.16u as=15.38618p ps=0.10091m w=0.74u l=0.13u
X396 VDD VSS.t1264 VDD VDD sg13_lv_pmos ad=0.19p pd=1.38u as=0 ps=0 w=1u l=1u
X397 VDD VSS.t2757 VDD VDD sg13_lv_pmos ad=0.19p pd=1.38u as=0 ps=0 w=1u l=1u
X398 VDD VSS.t2062 VDD VDD sg13_lv_pmos ad=0.19p pd=1.38u as=0 ps=0 w=1u l=1u
X399 VDD VSS.t2416 VDD VDD sg13_lv_pmos ad=0.34p pd=2.68u as=0 ps=0 w=1u l=1u
X400 VSS.t2477 VDD VSS.t2476 VSS.t2475 sg13_lv_nmos ad=0.1428p pd=1.52u as=0 ps=0 w=0.42u l=1u
X401 VDD VSS.t2728 VDD VDD sg13_lv_pmos ad=0.34p pd=2.68u as=0 ps=0 w=1u l=1u
X402 VSS.t16 a_15579_14854# sg13cmos5l_buf_8_2.A VSS.t3244 sg13_lv_nmos ad=0.1406p pd=1.12u as=0.1406p ps=1.12u w=0.74u l=0.13u
X403 VDD VSS.t516 VDD VDD sg13_lv_pmos ad=0.19p pd=1.38u as=0 ps=0 w=1u l=1u
X404 VSS.t1643 VDD VSS.t1642 VSS.t1641 sg13_lv_nmos ad=0.1428p pd=1.52u as=0 ps=0 w=0.42u l=1u
X405 VDD VSS.t2978 VDD VDD sg13_lv_pmos ad=0.34p pd=2.68u as=0 ps=0 w=1u l=1u
X406 sg13cmos5l_o21ai_1_3.Y sg13cmos5l_or3_1_1.C a_24408_15552# VDD sg13_lv_pmos ad=0.2128p pd=1.5u as=0.2128p ps=1.5u w=1.12u l=0.15u
X407 VDD sg13cmos5l_inv_1_0.Y a_16140_15424# VDD sg13_lv_pmos ad=0.4536p pd=2.76u as=0.1596p ps=1.22u w=0.84u l=0.13u
X408 a_27664_13942# a_27407_13799# a_27826_13722# VSS.t202 sg13_lv_nmos ad=0.1428p pd=1.52u as=37.8f ps=0.6u w=0.42u l=0.13u
X409 VDD VSS.t1932 VDD VDD sg13_lv_pmos ad=0.19p pd=1.38u as=0 ps=0 w=1u l=1u
X410 a_17584_13942# sg13cmos5l_dfrbpq_1_2.RESET_B VDD VDD sg13_lv_pmos ad=79.8f pd=0.8u as=2.42015p ps=15.68u w=0.42u l=0.13u
X411 VDD VSS.t1520 VDD VDD sg13_lv_pmos ad=0.19p pd=1.38u as=0 ps=0 w=1u l=1u
X412 VDD VSS.t1697 VDD VDD sg13_lv_pmos ad=0.34p pd=2.68u as=0 ps=0 w=1u l=1u
X413 VDD VSS.t602 VDD VDD sg13_lv_pmos ad=0.34p pd=2.68u as=0 ps=0 w=1u l=1u
X414 VSS.t2317 VDD VSS.t2319 VSS.t2318 sg13_lv_nmos ad=79.8f pd=0.8u as=0 ps=0 w=0.42u l=1u
X415 VDD a_25786_15960# a_25505_16262# VDD sg13_lv_pmos ad=0.1523p pd=1.38u as=0.34p ps=2.68u w=1u l=0.5u
X416 VSS.t1171 VDD VSS.t1172 VSS.t1154 sg13_lv_nmos ad=79.8f pd=0.8u as=0 ps=0 w=0.42u l=1u
X417 VDD VSS.t2642 VDD VDD sg13_lv_pmos ad=0.19p pd=1.38u as=0 ps=0 w=1u l=1u
X418 VSS.t1538 VDD VSS.t1537 VSS.t1536 sg13_lv_nmos ad=0.1428p pd=1.52u as=0 ps=0 w=0.42u l=1u
X419 VSS.t3059 VDD VSS.t3058 VSS.t3057 sg13_lv_nmos ad=0.1428p pd=1.52u as=0 ps=0 w=0.42u l=1u
X420 VSS.t2272 VDD VSS.t2271 VSS.t2270 sg13_lv_nmos ad=0.1428p pd=1.52u as=0 ps=0 w=0.42u l=1u
X421 VDD VSS.t2299 VDD VDD sg13_lv_pmos ad=0.19p pd=1.38u as=0 ps=0 w=1u l=1u
X422 VSS.t2613 VDD VSS.t207 VSS.t206 sg13_lv_nmos ad=0.1428p pd=1.52u as=0 ps=0 w=0.42u l=1u
X423 a_21466_15202# sg13cmos5l_o21ai_1_1.Y VSS.t179 VSS.t3264 sg13_lv_nmos ad=0.1428p pd=1.52u as=79.8f ps=0.8u w=0.42u l=0.13u
X424 VDD VSS.t2748 VDD VDD sg13_lv_pmos ad=0.19p pd=1.38u as=0 ps=0 w=1u l=1u
X425 VDD VSS.t2082 VDD VDD sg13_lv_pmos ad=0.19p pd=1.38u as=0 ps=0 w=1u l=1u
X426 a_3209_16334# a_3333_16033# VDD VDD sg13_lv_pmos ad=0.2442p pd=2.06u as=2.8961p ps=18.25u w=0.66u l=0.13u
X427 VDD VSS.t66 VDD VDD sg13_lv_pmos ad=0.34p pd=2.68u as=0 ps=0 w=1u l=1u
X428 VDD VSS.t798 VDD VDD sg13_lv_pmos ad=0.34p pd=2.68u as=0 ps=0 w=1u l=1u
X429 VSS.t1228 VDD VSS.t1227 VSS.t1154 sg13_lv_nmos ad=0.1428p pd=1.52u as=0 ps=0 w=0.42u l=1u
X430 VSS.t16 a_15579_14854# sg13cmos5l_buf_8_2.A VSS.t3240 sg13_lv_nmos ad=0.1406p pd=1.12u as=0.1406p ps=1.12u w=0.74u l=0.13u
X431 VSS.t566 VDD VSS.t568 VSS.t567 sg13_lv_nmos ad=79.8f pd=0.8u as=0 ps=0 w=0.42u l=1u
X432 VDD VSS.t535 VDD VDD sg13_lv_pmos ad=0.34p pd=2.68u as=0 ps=0 w=1u l=1u
X433 VSS.t1628 VDD VSS.t1627 VSS.t1626 sg13_lv_nmos ad=0.1428p pd=1.52u as=0 ps=0 w=0.42u l=1u
X434 VSS.t1180 VDD VSS.t1181 VSS.t1154 sg13_lv_nmos ad=79.8f pd=0.8u as=0 ps=0 w=0.42u l=1u
X435 VSS.t110 VDD VSS.t110 VSS.t397 sg13_lv_nmos ad=0.1428p pd=1.52u as=0 ps=0 w=0.42u l=1u
X436 VSS.t4 a_15671_15315# a_15671_15315# VSS.t56 sg13_lv_nmos ad=4.11262p pd=27.15u as=0.111p ps=1.34u w=0.3u l=0.13u
X437 VDD a_25094_14484# a_25206_14508# VDD sg13_lv_pmos ad=0.2254p pd=1.53u as=0.34p ps=2.68u w=1u l=0.5u
X438 VSS.t2497 VDD VSS.t2496 VSS.t2495 sg13_lv_nmos ad=0.1428p pd=1.52u as=0 ps=0 w=0.42u l=1u
X439 VSS.t1185 VDD VSS.t1186 VSS.t1154 sg13_lv_nmos ad=79.8f pd=0.8u as=0 ps=0 w=0.42u l=1u
X440 VSS.t1603 VDD VSS.t1605 VSS.t1604 sg13_lv_nmos ad=79.8f pd=0.8u as=0 ps=0 w=0.42u l=1u
X441 VDD VSS.t2279 VDD VDD sg13_lv_pmos ad=0.19p pd=1.38u as=0 ps=0 w=1u l=1u
X442 a_19054_15423# a_19169_15424# VDD VDD sg13_lv_pmos ad=0.34p pd=2.68u as=0.2254p ps=1.53u w=1u l=0.5u
X443 VDD VSS.t1877 VDD VDD sg13_lv_pmos ad=0.19p pd=1.38u as=0 ps=0 w=1u l=1u
X444 VDD VSS.t2709 VDD VDD sg13_lv_pmos ad=0.19p pd=1.38u as=0 ps=0 w=1u l=1u
X445 VSS.t1995 VDD VSS.t1994 VSS.t1993 sg13_lv_nmos ad=0.1428p pd=1.52u as=0 ps=0 w=0.42u l=1u
X446 VDD VSS.t399 VDD VDD sg13_lv_pmos ad=0.34p pd=2.68u as=0 ps=0 w=1u l=1u
X447 VSS.t1558 VDD VSS.t1557 VSS.t1556 sg13_lv_nmos ad=0.1428p pd=1.52u as=0 ps=0 w=0.42u l=1u
X448 VSS.t3079 VDD VSS.t3078 VSS.t3077 sg13_lv_nmos ad=0.1428p pd=1.52u as=0 ps=0 w=0.42u l=1u
X449 VSS.t839 VDD VSS.t841 VSS.t840 sg13_lv_nmos ad=79.8f pd=0.8u as=0 ps=0 w=0.42u l=1u
X450 VDD VSS.t1567 VDD VDD sg13_lv_pmos ad=0.34p pd=2.68u as=0 ps=0 w=1u l=1u
X451 VSS.t1598 VDD VSS.t1600 VSS.t1599 sg13_lv_nmos ad=79.8f pd=0.8u as=0 ps=0 w=0.42u l=1u
X452 VDD VSS.t2441 VDD VDD sg13_lv_pmos ad=0.34p pd=2.68u as=0 ps=0 w=1u l=1u
X453 VDD VSS.t403 VDD VDD sg13_lv_pmos ad=0.34p pd=2.68u as=0 ps=0 w=1u l=1u
X454 VSS.t2718 VDD VSS.t2719 VSS.t206 sg13_lv_nmos ad=79.8f pd=0.8u as=0 ps=0 w=0.42u l=1u
X455 VDD VSS.t2469 VDD VDD sg13_lv_pmos ad=0.19p pd=1.38u as=0 ps=0 w=1u l=1u
X456 VDD VSS.t1909 VDD VDD sg13_lv_pmos ad=0.34p pd=2.68u as=0 ps=0 w=1u l=1u
X457 VSS.t2302 VDD VSS.t2304 VSS.t2303 sg13_lv_nmos ad=79.8f pd=0.8u as=0 ps=0 w=0.42u l=1u
X458 VDD VSS.t2244 VDD VDD sg13_lv_pmos ad=0.19p pd=1.38u as=0 ps=0 w=1u l=1u
X459 a_9801_15625# a_9444_15552# VDD VDD sg13_lv_pmos ad=63f pd=0.72u as=0.1563p ps=1.22u w=0.42u l=0.13u
X460 VDD VSS.t953 VDD VDD sg13_lv_pmos ad=0.34p pd=2.68u as=0 ps=0 w=1u l=1u
X461 VDD VSS.t3031 VDD VDD sg13_lv_pmos ad=0.19p pd=1.38u as=0 ps=0 w=1u l=1u
X462 VSS.t2075 VDD VSS.t2077 VSS.t2076 sg13_lv_nmos ad=79.8f pd=0.8u as=0 ps=0 w=0.42u l=1u
X463 VSS.t536 VDD VSS.t535 VSS.t534 sg13_lv_nmos ad=0.1428p pd=1.52u as=0 ps=0 w=0.42u l=1u
X464 VDD VSS.t516 VDD VDD sg13_lv_pmos ad=0.19p pd=1.38u as=0 ps=0 w=1u l=1u
X465 VDD VSS.t1199 VDD VDD sg13_lv_pmos ad=0.19p pd=1.38u as=0 ps=0 w=1u l=1u
X466 VSS.t1273 VDD VSS.t1273 VSS.t1154 sg13_lv_nmos ad=79.8f pd=0.8u as=0 ps=0 w=0.42u l=1u
X467 VDD VSS.t1226 VDD VDD sg13_lv_pmos ad=0.34p pd=2.68u as=0 ps=0 w=1u l=1u
X468 VDD VSS.t2719 VDD VDD sg13_lv_pmos ad=0.34p pd=2.68u as=0 ps=0 w=1u l=1u
X469 VDD a_25094_15238# a_25206_15302# VDD sg13_lv_pmos ad=0.2254p pd=1.53u as=0.34p ps=2.68u w=1u l=0.5u
X470 VDD VSS.t2094 VDD VDD sg13_lv_pmos ad=0.34p pd=2.68u as=0 ps=0 w=1u l=1u
X471 VDD VSS.t1917 VDD VDD sg13_lv_pmos ad=0.19p pd=1.38u as=0 ps=0 w=1u l=1u
X472 VDD VSS.t409 VDD VDD sg13_lv_pmos ad=0.34p pd=2.68u as=0 ps=0 w=1u l=1u
X473 VDD VSS.t1682 VDD VDD sg13_lv_pmos ad=0.34p pd=2.68u as=0 ps=0 w=1u l=1u
X474 VSS.t2482 VDD VSS.t2481 VSS.t2480 sg13_lv_nmos ad=0.1428p pd=1.52u as=0 ps=0 w=0.42u l=1u
X475 VSS.t437 VDD VSS.t436 VSS.t4 sg13_lv_nmos ad=0.1428p pd=1.52u as=0 ps=0 w=0.42u l=1u
X476 VSS.t1588 VDD VSS.t1590 VSS.t1589 sg13_lv_nmos ad=79.8f pd=0.8u as=0 ps=0 w=0.42u l=1u
X477 VSS.t3109 VDD VSS.t3111 VSS.t3110 sg13_lv_nmos ad=79.8f pd=0.8u as=0 ps=0 w=0.42u l=1u
X478 VDD VSS.t93 VDD VDD sg13_lv_pmos ad=0.34p pd=2.68u as=0 ps=0 w=1u l=1u
X479 VDD VSS.t1547 VDD VDD sg13_lv_pmos ad=0.34p pd=2.68u as=0 ps=0 w=1u l=1u
X480 VSS.t2768 VDD VSS.t2769 VSS.t206 sg13_lv_nmos ad=79.8f pd=0.8u as=0 ps=0 w=0.42u l=1u
X481 VDD a_21946_16237# sg13cmos5l_dfrbpq_1_6.RESET_B VDD sg13_lv_pmos ad=2.8961p pd=18.25u as=0.3927p ps=2.99u w=1.155u l=0.13u
X482 VDD a_12010_15202# sg13cmos5l_dfrbpq_1_2.CLK VDD sg13_lv_pmos ad=0.2128p pd=1.5u as=0.2128p ps=1.5u w=1.12u l=0.13u
X483 VDD VSS.t968 VDD VDD sg13_lv_pmos ad=0.34p pd=2.68u as=0 ps=0 w=1u l=1u
X484 VDD VSS.t2684 VDD VDD sg13_lv_pmos ad=0.34p pd=2.68u as=0 ps=0 w=1u l=1u
X485 VDD VSS.t2461 VDD VDD sg13_lv_pmos ad=0.34p pd=2.68u as=0 ps=0 w=1u l=1u
X486 VDD VSS.t66 VDD VDD sg13_lv_pmos ad=0.34p pd=2.68u as=0 ps=0 w=1u l=1u
X487 VDD VSS.t1267 VDD VDD sg13_lv_pmos ad=0.19p pd=1.38u as=0 ps=0 w=1u l=1u
X488 VDD VSS.t2067 VDD VDD sg13_lv_pmos ad=0.19p pd=1.38u as=0 ps=0 w=1u l=1u
X489 VSS.t509 VDD VSS.t516 VSS.t515 sg13_lv_nmos ad=79.8f pd=0.8u as=0 ps=0 w=0.42u l=1u
X490 VSS.t632 VDD VSS.t629 VSS.t631 sg13_lv_nmos ad=0.1428p pd=1.52u as=0 ps=0 w=0.42u l=1u
X491 VDD VSS.t2739 VDD VDD sg13_lv_pmos ad=0.19p pd=1.38u as=0 ps=0 w=1u l=1u
X492 VDD VSS.t2421 VDD VDD sg13_lv_pmos ad=0.34p pd=2.68u as=0 ps=0 w=1u l=1u
X493 VSS.t2447 VDD VSS.t2446 VSS.t2445 sg13_lv_nmos ad=0.1428p pd=1.52u as=0 ps=0 w=0.42u l=1u
X494 VSS.t38 a_6286_13911# sg13cmos5l_dlygate4sd3_1_0.X VSS.t3274 sg13_lv_nmos ad=0.1426p pd=1.16u as=0.2516p ps=2.16u w=0.74u l=0.13u
X495 VSS.t1255 VDD VSS.t1254 VSS.t1154 sg13_lv_nmos ad=0.1428p pd=1.52u as=0 ps=0 w=0.42u l=1u
X496 VSS.t278 VDD VSS.t278 VSS.t281 sg13_lv_nmos ad=79.8f pd=0.8u as=0 ps=0 w=0.42u l=1u
X497 VSS.t2939 VDD VSS.t2941 VSS.t2940 sg13_lv_nmos ad=79.8f pd=0.8u as=0 ps=0 w=0.42u l=1u
X498 VSS.t2030 VDD VSS.t2029 VSS.t2028 sg13_lv_nmos ad=0.1428p pd=1.52u as=0 ps=0 w=0.42u l=1u
X499 VSS.t1248 VDD VSS.t1249 VSS.t1154 sg13_lv_nmos ad=79.8f pd=0.8u as=0 ps=0 w=0.42u l=1u
X500 VSS.t1613 VDD VSS.t1612 VSS.t1611 sg13_lv_nmos ad=0.1428p pd=1.52u as=0 ps=0 w=0.42u l=1u
X501 VDD VSS.t302 VDD VDD sg13_lv_pmos ad=0.34p pd=2.68u as=0 ps=0 w=1u l=1u
X502 a_26638_15423# a_26753_15424# VDD VDD sg13_lv_pmos ad=0.34p pd=2.68u as=0.2254p ps=1.53u w=1u l=0.5u
X503 VDD VSS.t791 VDD VDD sg13_lv_pmos ad=0.19p pd=1.38u as=0 ps=0 w=1u l=1u
X504 VDD VSS.t2256 VDD VDD sg13_lv_pmos ad=0.34p pd=2.68u as=0 ps=0 w=1u l=1u
X505 VDD VSS.t599 VDD VDD sg13_lv_pmos ad=0.19p pd=1.38u as=0 ps=0 w=1u l=1u
X506 VDD VSS.t1580 VDD VDD sg13_lv_pmos ad=0.19p pd=1.38u as=0 ps=0 w=1u l=1u
X507 VDD VSS.t3043 VDD VDD sg13_lv_pmos ad=0.34p pd=2.68u as=0 ps=0 w=1u l=1u
X508 VSS.t593 VDD VSS.t593 VSS.t732 sg13_lv_nmos ad=0.1428p pd=1.52u as=0 ps=0 w=0.42u l=1u
X509 VDD VSS.t1231 VDD VDD sg13_lv_pmos ad=0.19p pd=1.38u as=0 ps=0 w=1u l=1u
X510 VSS.t1291 VDD VSS.t1292 VSS.t1154 sg13_lv_nmos ad=79.8f pd=0.8u as=0 ps=0 w=0.42u l=1u
X511 VDD a_26170_15202# a_25889_15424# VDD sg13_lv_pmos ad=0.1523p pd=1.38u as=0.34p ps=2.68u w=1u l=0.5u
X512 VDD VSS.t1862 VDD VDD sg13_lv_pmos ad=0.19p pd=1.38u as=0 ps=0 w=1u l=1u
X513 VDD VSS.t2645 VDD VDD sg13_lv_pmos ad=0.19p pd=1.38u as=0 ps=0 w=1u l=1u
X514 VDD VSS.t2701 VDD VDD sg13_lv_pmos ad=0.19p pd=1.38u as=0 ps=0 w=1u l=1u
X515 VSS.t1980 VDD VSS.t1979 VSS.t1978 sg13_lv_nmos ad=0.1428p pd=1.52u as=0 ps=0 w=0.42u l=1u
X516 VDD a_12010_15202# sg13cmos5l_dfrbpq_1_2.CLK VDD sg13_lv_pmos ad=0.2128p pd=1.5u as=0.2128p ps=1.5u w=1.12u l=0.13u
X517 a_6789_14495# sg13cmos5l_dfrbpq_1_2.CLK VSS.t4 VSS.t3178 sg13_lv_nmos ad=0.2516p pd=2.16u as=3.8707p ps=25.555u w=0.74u l=0.13u
X518 VSS.t1543 VDD VSS.t1542 VSS.t1541 sg13_lv_nmos ad=0.1428p pd=1.52u as=0 ps=0 w=0.42u l=1u
X519 VSS.t3064 VDD VSS.t3063 VSS.t3062 sg13_lv_nmos ad=0.1428p pd=1.52u as=0 ps=0 w=0.42u l=1u
X520 VSS.t2277 VDD VSS.t2276 VSS.t2275 sg13_lv_nmos ad=0.1428p pd=1.52u as=0 ps=0 w=0.42u l=1u
X521 VSS.t387 VDD VSS.t389 VSS.t388 sg13_lv_nmos ad=79.8f pd=0.8u as=0 ps=0 w=0.42u l=1u
X522 VDD VSS.t1194 VDD VDD sg13_lv_pmos ad=0.34p pd=2.68u as=0 ps=0 w=1u l=1u
X523 VDD VSS.t578 VDD VDD sg13_lv_pmos ad=0.34p pd=2.68u as=0 ps=0 w=1u l=1u
X524 VSS.t2352 VDD VSS.t2351 VSS.t2350 sg13_lv_nmos ad=0.1428p pd=1.52u as=0 ps=0 w=0.42u l=1u
X525 VDD VSS.t1157 VDD VDD sg13_lv_pmos ad=0.19p pd=1.38u as=0 ps=0 w=1u l=1u
X526 VDD VSS.t2751 VDD VDD sg13_lv_pmos ad=0.19p pd=1.38u as=0 ps=0 w=1u l=1u
X527 VDD VSS.t2454 VDD VDD sg13_lv_pmos ad=0.19p pd=1.38u as=0 ps=0 w=1u l=1u
X528 VDD VSS.t2052 VDD VDD sg13_lv_pmos ad=0.19p pd=1.38u as=0 ps=0 w=1u l=1u
X529 sg13cmos5l_buf_8_2.A a_15579_14854# VDD VDD sg13_lv_pmos ad=0.2128p pd=1.5u as=0.2128p ps=1.5u w=1.12u l=0.13u
X530 VSS.t113 sg13cmos5l_dlygate4sd3_1_17.A a_24824_14525# VSS.t8 sg13_lv_nmos ad=79.8f pd=0.8u as=0.1428p ps=1.52u w=0.42u l=0.13u
X531 VDD VSS.t998 VDD VDD sg13_lv_pmos ad=0.34p pd=2.68u as=0 ps=0 w=1u l=1u
X532 VDD VSS.t1258 VDD VDD sg13_lv_pmos ad=0.19p pd=1.38u as=0 ps=0 w=1u l=1u
X533 VSS.t2467 VDD VSS.t2466 VSS.t2465 sg13_lv_nmos ad=0.1428p pd=1.52u as=0 ps=0 w=0.42u l=1u
X534 VSS.t2287 VDD VSS.t2289 VSS.t2288 sg13_lv_nmos ad=79.8f pd=0.8u as=0 ps=0 w=0.42u l=1u
X535 a_22576_14726# sg13cmos5l_dfrbpq_1_6.RESET_B VDD VDD sg13_lv_pmos ad=79.8f pd=0.8u as=2.42015p ps=15.68u w=0.42u l=0.13u
X536 VDD VSS.t806 VDD VDD sg13_lv_pmos ad=0.19p pd=1.38u as=0 ps=0 w=1u l=1u
X537 VDD VSS.t2229 VDD VDD sg13_lv_pmos ad=0.19p pd=1.38u as=0 ps=0 w=1u l=1u
X538 a_27609_14037# a_26667_13844# a_27407_13799# VDD sg13_lv_pmos ad=93.45f pd=0.865u as=0.2048p ps=1.63u w=0.42u l=0.13u
X539 VSS.t2766 VDD VSS.t2767 VSS.t206 sg13_lv_nmos ad=79.8f pd=0.8u as=0 ps=0 w=0.42u l=1u
X540 VSS.t4 a_26373_14495# a_26475_14495# VSS.t234 sg13_lv_nmos ad=4.11262p pd=27.15u as=0.2516p ps=2.16u w=0.74u l=0.13u
X541 VSS.t1633 VDD VSS.t1632 VSS.t1631 sg13_lv_nmos ad=0.1428p pd=1.52u as=0 ps=0 w=0.42u l=1u
X542 VDD VSS.t2324 VDD VDD sg13_lv_pmos ad=0.19p pd=1.38u as=0 ps=0 w=1u l=1u
X543 VSS.t320 VDD VSS.t160 VSS.t321 sg13_lv_nmos ad=79.8f pd=0.8u as=0 ps=0 w=0.42u l=1u
X544 VDD sg13cmos5l_dfrbpq_1_1.RESET_B a_6086_14922# VDD sg13_lv_pmos ad=0.36237p pd=2.605u as=79.8f ps=0.8u w=0.42u l=0.13u
X545 VDD VSS.t112 VDD VDD sg13_lv_pmos ad=0.34p pd=2.68u as=0 ps=0 w=1u l=1u
X546 VSS.t1034 VDD VSS.t1033 VSS.t1032 sg13_lv_nmos ad=0.1428p pd=1.52u as=0 ps=0 w=0.42u l=1u
X547 VDD VSS.t1273 VDD VDD sg13_lv_pmos ad=0.34p pd=2.68u as=0 ps=0 w=1u l=1u
X548 VDD VSS.t2767 VDD VDD sg13_lv_pmos ad=0.34p pd=2.68u as=0 ps=0 w=1u l=1u
X549 VDD VSS.t2079 VDD VDD sg13_lv_pmos ad=0.34p pd=2.68u as=0 ps=0 w=1u l=1u
X550 VDD a_37484_15960# counter_value_o[7] VDD sg13_lv_pmos ad=0.2114p pd=1.54u as=0.42p ps=2.99u w=1.12u l=0.13u
X551 a_20774_14922# a_21579_14495# a_21034_14452# VDD sg13_lv_pmos ad=0.1428p pd=1.52u as=79.8f ps=0.8u w=0.42u l=0.13u
X552 VSS.t1422 VDD VSS.t1306 VSS.t1154 sg13_lv_nmos ad=79.8f pd=0.8u as=0 ps=0 w=0.42u l=1u
X553 VSS.t1930 VDD VSS.t1932 VSS.t1931 sg13_lv_nmos ad=79.8f pd=0.8u as=0 ps=0 w=0.42u l=1u
X554 VDD VSS.t543 VDD VDD sg13_lv_pmos ad=0.19p pd=1.38u as=0 ps=0 w=1u l=1u
X555 VDD VSS.t588 VDD VDD sg13_lv_pmos ad=0.34p pd=2.68u as=0 ps=0 w=1u l=1u
X556 VDD VSS.t2107 VDD VDD sg13_lv_pmos ad=0.19p pd=1.38u as=0 ps=0 w=1u l=1u
X557 VDD VSS.t1532 VDD VDD sg13_lv_pmos ad=0.34p pd=2.68u as=0 ps=0 w=1u l=1u
X558 VDD VSS.t1882 VDD VDD sg13_lv_pmos ad=0.19p pd=1.38u as=0 ps=0 w=1u l=1u
X559 VSS.t2759 VDD VSS.t2760 VSS.t206 sg13_lv_nmos ad=79.8f pd=0.8u as=0 ps=0 w=0.42u l=1u
X560 VDD VSS.t2712 VDD VDD sg13_lv_pmos ad=0.19p pd=1.38u as=0 ps=0 w=1u l=1u
X561 VSS.t431 VDD VSS.t430 VSS.t4 sg13_lv_nmos ad=0.1428p pd=1.52u as=0 ps=0 w=0.42u l=1u
X562 sg13cmos5l_dlygate4sd3_1_17.A sg13cmos5l_a21oi_1_3.B1 VSS.t106 VSS.t105 sg13_lv_nmos ad=0.1406p pd=1.12u as=0.2516p ps=2.16u w=0.74u l=0.13u
X563 VSS.t1225 VDD VSS.t1226 VSS.t1154 sg13_lv_nmos ad=79.8f pd=0.8u as=0 ps=0 w=0.42u l=1u
X564 VDD VSS.t626 VDD VDD sg13_lv_pmos ad=0.19p pd=1.38u as=0 ps=0 w=1u l=1u
X565 VDD VSS.t617 VDD VDD sg13_lv_pmos ad=0.19p pd=1.38u as=0 ps=0 w=1u l=1u
X566 VDD VSS.t1537 VDD VDD sg13_lv_pmos ad=0.34p pd=2.68u as=0 ps=0 w=1u l=1u
X567 VDD VSS.t2474 VDD VDD sg13_lv_pmos ad=0.19p pd=1.38u as=0 ps=0 w=1u l=1u
X568 VSS.t196 sg13cmos5l_buf_1_0.X a_2490_14447# VSS.t3200 sg13_lv_nmos ad=0.374p pd=2.46u as=0.17462p ps=1.185u w=0.55u l=0.13u
X569 VDD VSS.t961 VDD VDD sg13_lv_pmos ad=0.19p pd=1.38u as=0 ps=0 w=1u l=1u
X570 VSS.t1663 VDD VSS.t1665 VSS.t1664 sg13_lv_nmos ad=79.8f pd=0.8u as=0 ps=0 w=0.42u l=1u
X571 VDD VSS.t2725 VDD VDD sg13_lv_pmos ad=0.34p pd=2.68u as=0 ps=0 w=1u l=1u
X572 VSS.t2080 VDD VSS.t2082 VSS.t2081 sg13_lv_nmos ad=79.8f pd=0.8u as=0 ps=0 w=0.42u l=1u
X573 VSS.t2757 VDD VSS.t2758 VSS.t206 sg13_lv_nmos ad=79.8f pd=0.8u as=0 ps=0 w=0.42u l=1u
X574 VSS.t844 VDD VSS.t846 VSS.t845 sg13_lv_nmos ad=79.8f pd=0.8u as=0 ps=0 w=0.42u l=1u
X575 VSS.t2924 VDD VSS.t2926 VSS.t2925 sg13_lv_nmos ad=79.8f pd=0.8u as=0 ps=0 w=0.42u l=1u
X576 a_2916_15552# a_3435_15356# a_4175_15311# VSS.t115 sg13_lv_nmos ad=0.3473p pd=2.71u as=0.12665p ps=1.145u w=0.74u l=0.13u
X577 VDD a_22030_15423# sg13cmos5l_or3_1_2.A VDD sg13_lv_pmos ad=0.2254p pd=1.53u as=0.4256p ps=3u w=1.12u l=0.13u
X578 VSS.t1965 VDD VSS.t1967 VSS.t1966 sg13_lv_nmos ad=79.8f pd=0.8u as=0 ps=0 w=0.42u l=1u
X579 VDD VSS.t1922 VDD VDD sg13_lv_pmos ad=0.19p pd=1.38u as=0 ps=0 w=1u l=1u
X580 VDD VSS.t2660 VDD VDD sg13_lv_pmos ad=0.19p pd=1.38u as=0 ps=0 w=1u l=1u
X581 VSS.t2337 VDD VSS.t2336 VSS.t2335 sg13_lv_nmos ad=0.1428p pd=1.52u as=0 ps=0 w=0.42u l=1u
X582 VDD VSS.t635 VDD VDD sg13_lv_pmos ad=0.19p pd=1.38u as=0 ps=0 w=1u l=1u
X583 VDD VSS.t3028 VDD VDD sg13_lv_pmos ad=0.34p pd=2.68u as=0 ps=0 w=1u l=1u
X584 VDD VSS.t2241 VDD VDD sg13_lv_pmos ad=0.34p pd=2.68u as=0 ps=0 w=1u l=1u
X585 VSS.t1593 VDD VSS.t1595 VSS.t1594 sg13_lv_nmos ad=79.8f pd=0.8u as=0 ps=0 w=0.42u l=1u
X586 VSS.t3114 VDD VSS.t3116 VSS.t3115 sg13_lv_nmos ad=79.8f pd=0.8u as=0 ps=0 w=0.42u l=1u
X587 VDD VSS.t2269 VDD VDD sg13_lv_pmos ad=0.19p pd=1.38u as=0 ps=0 w=1u l=1u
X588 a_4175_15311# a_3333_15213# a_2916_15552# VDD sg13_lv_pmos ad=0.2048p pd=1.63u as=0.34p ps=2.68u w=1u l=0.13u
X589 VSS.t566 VDD VSS.t568 VSS.t567 sg13_lv_nmos ad=79.8f pd=0.8u as=0 ps=0 w=0.42u l=1u
X590 VDD VSS.t1605 VDD VDD sg13_lv_pmos ad=0.19p pd=1.38u as=0 ps=0 w=1u l=1u
X591 a_7532_15960# sg13cmos5l_dlygate4sd3_1_1.A VDD VDD sg13_lv_pmos ad=0.2856p pd=2.36u as=0.2114p ps=1.54u w=0.84u l=0.13u
X592 VSS.t1207 VDD VSS.t1206 VSS.t1154 sg13_lv_nmos ad=0.1428p pd=1.52u as=0 ps=0 w=0.42u l=1u
X593 a_26182_14909# sg13cmos5l_dfrbpq_1_7.RESET_B VSS.t3 VSS.t5 sg13_lv_nmos ad=37.8f pd=0.6u as=0.1701p ps=1.65u w=0.42u l=0.13u
X594 VSS.t1493 VDD VSS.t1495 VSS.t1494 sg13_lv_nmos ad=79.8f pd=0.8u as=0 ps=0 w=0.42u l=1u
X595 VSS.t2402 VDD VSS.t2404 VSS.t2403 sg13_lv_nmos ad=79.8f pd=0.8u as=0 ps=0 w=0.42u l=1u
X596 VSS.t1875 VDD VSS.t1877 VSS.t1876 sg13_lv_nmos ad=79.8f pd=0.8u as=0 ps=0 w=0.42u l=1u
X597 VDD VSS.t580 VDD VDD sg13_lv_pmos ad=0.34p pd=2.68u as=0 ps=0 w=1u l=1u
X598 VDD VSS.t928 VDD VDD sg13_lv_pmos ad=0.34p pd=2.68u as=0 ps=0 w=1u l=1u
X599 VSS.t361 VDD VSS.t361 VSS.t365 sg13_lv_nmos ad=0.1428p pd=1.52u as=0 ps=0 w=0.42u l=1u
X600 VSS.t799 VDD VSS.t798 VSS.t797 sg13_lv_nmos ad=0.1428p pd=1.52u as=0 ps=0 w=0.42u l=1u
X601 VDD VSS.t1249 VDD VDD sg13_lv_pmos ad=0.19p pd=1.38u as=0 ps=0 w=1u l=1u
X602 VDD VSS.t1894 VDD VDD sg13_lv_pmos ad=0.34p pd=2.68u as=0 ps=0 w=1u l=1u
X603 VDD VSS.t2742 VDD VDD sg13_lv_pmos ad=0.19p pd=1.38u as=0 ps=0 w=1u l=1u
X604 VSS.t2686 VDD VSS.t2687 VSS.t206 sg13_lv_nmos ad=79.8f pd=0.8u as=0 ps=0 w=0.42u l=1u
X605 VDD VSS.t2718 VDD VDD sg13_lv_pmos ad=0.34p pd=2.68u as=0 ps=0 w=1u l=1u
X606 VSS.t2452 VDD VSS.t2451 VSS.t2450 sg13_lv_nmos ad=0.1428p pd=1.52u as=0 ps=0 w=0.42u l=1u
X607 a_17318_14922# a_18123_14495# a_17578_14452# VDD sg13_lv_pmos ad=0.1428p pd=1.52u as=79.8f ps=0.8u w=0.42u l=0.13u
X608 VSS.t434 VDD VSS.t435 VSS.t4 sg13_lv_nmos ad=79.8f pd=0.8u as=0 ps=0 w=0.42u l=1u
X609 VSS.t2909 VDD VSS.t2911 VSS.t2910 sg13_lv_nmos ad=79.8f pd=0.8u as=0 ps=0 w=0.42u l=1u
X610 VDD VSS.t991 VDD VDD sg13_lv_pmos ad=0.19p pd=1.38u as=0 ps=0 w=1u l=1u
X611 VSS.t1034 VDD VSS.t1033 VSS.t1032 sg13_lv_nmos ad=0.1428p pd=1.52u as=0 ps=0 w=0.42u l=1u
X612 VSS.t1618 VDD VSS.t1617 VSS.t1616 sg13_lv_nmos ad=0.1428p pd=1.52u as=0 ps=0 w=0.42u l=1u
X613 VSS.t2730 VDD VSS.t2729 VSS.t206 sg13_lv_nmos ad=0.1428p pd=1.52u as=0 ps=0 w=0.42u l=1u
X614 VDD VSS.t2486 VDD VDD sg13_lv_pmos ad=0.34p pd=2.68u as=0 ps=0 w=1u l=1u
X615 VDD VSS.t2309 VDD VDD sg13_lv_pmos ad=0.19p pd=1.38u as=0 ps=0 w=1u l=1u
X616 VSS.t396 VDD VSS.t396 VSS.t395 sg13_lv_nmos ad=0.1428p pd=1.52u as=0 ps=0 w=0.42u l=1u
X617 VDD VSS.t2261 VDD VDD sg13_lv_pmos ad=0.34p pd=2.68u as=0 ps=0 w=1u l=1u
X618 a_16175_15238# a_16140_15424# sg13cmos5l_nor2_1_0.B VSS.t17 sg13_lv_nmos ad=0.1406p pd=1.12u as=0.2516p ps=2.16u w=0.74u l=0.13u
X619 VDD VSS.t543 VDD VDD sg13_lv_pmos ad=0.19p pd=1.38u as=0 ps=0 w=1u l=1u
X620 VDD VSS.t1585 VDD VDD sg13_lv_pmos ad=0.19p pd=1.38u as=0 ps=0 w=1u l=1u
X621 VDD VSS.t3048 VDD VDD sg13_lv_pmos ad=0.34p pd=2.68u as=0 ps=0 w=1u l=1u
X622 VSS.t2095 VDD VSS.t2094 VSS.t2093 sg13_lv_nmos ad=0.1428p pd=1.52u as=0 ps=0 w=0.42u l=1u
X623 VSS.t1915 VDD VSS.t1917 VSS.t1916 sg13_lv_nmos ad=79.8f pd=0.8u as=0 ps=0 w=0.42u l=1u
X624 VSS.t536 VDD VSS.t535 VSS.t534 sg13_lv_nmos ad=0.1428p pd=1.52u as=0 ps=0 w=0.42u l=1u
X625 VDD VSS.t2434 VDD VDD sg13_lv_pmos ad=0.19p pd=1.38u as=0 ps=0 w=1u l=1u
X626 VDD VSS.t2092 VDD VDD sg13_lv_pmos ad=0.19p pd=1.38u as=0 ps=0 w=1u l=1u
X627 VSS.t1183 VDD VSS.t1184 VSS.t1154 sg13_lv_nmos ad=79.8f pd=0.8u as=0 ps=0 w=0.42u l=1u
X628 VSS.t1221 VDD VSS.t1220 VSS.t1154 sg13_lv_nmos ad=0.1428p pd=1.52u as=0 ps=0 w=0.42u l=1u
X629 VDD VSS.t1590 VDD VDD sg13_lv_pmos ad=0.19p pd=1.38u as=0 ps=0 w=1u l=1u
X630 VDD VSS.t1867 VDD VDD sg13_lv_pmos ad=0.19p pd=1.38u as=0 ps=0 w=1u l=1u
X631 VDD VSS.t2648 VDD VDD sg13_lv_pmos ad=0.19p pd=1.38u as=0 ps=0 w=1u l=1u
X632 VDD VSS.t2703 VDD VDD sg13_lv_pmos ad=0.19p pd=1.38u as=0 ps=0 w=1u l=1u
X633 a_4175_15311# a_3333_15213# a_4081_15311# VSS.t261 sg13_lv_nmos ad=0.12665p pd=1.145u as=0.1428p ps=1.52u w=0.42u l=0.13u
X634 VDD VSS.t1314 VDD VDD sg13_lv_pmos ad=0.34p pd=2.68u as=0 ps=0 w=1u l=1u
X635 VSS.t1548 VDD VSS.t1547 VSS.t1546 sg13_lv_nmos ad=0.1428p pd=1.52u as=0 ps=0 w=0.42u l=1u
X636 VSS.t3069 VDD VSS.t3068 VSS.t3067 sg13_lv_nmos ad=0.1428p pd=1.52u as=0 ps=0 w=0.42u l=1u
X637 VSS.t2282 VDD VSS.t2281 VSS.t2280 sg13_lv_nmos ad=0.1428p pd=1.52u as=0 ps=0 w=0.42u l=1u
X638 VSS.t193 a_7888_14726# a_7537_14845# VSS.t238 sg13_lv_nmos ad=79.8f pd=0.8u as=0.1428p ps=1.52u w=0.42u l=0.13u
X639 VSS.t602 VDD VSS.t602 VSS.t603 sg13_lv_nmos ad=79.8f pd=0.8u as=0 ps=0 w=0.42u l=1u
X640 VSS.t954 VDD VSS.t953 VSS.t952 sg13_lv_nmos ad=0.1428p pd=1.52u as=0 ps=0 w=0.42u l=1u
X641 VDD VSS.t2459 VDD VDD sg13_lv_pmos ad=0.19p pd=1.38u as=0 ps=0 w=1u l=1u
X642 VSS.t2322 VDD VSS.t2321 VSS.t2320 sg13_lv_nmos ad=0.1428p pd=1.52u as=0 ps=0 w=0.42u l=1u
X643 VSS.t844 VDD VSS.t846 VSS.t845 sg13_lv_nmos ad=79.8f pd=0.8u as=0 ps=0 w=0.42u l=1u
X644 VDD VSS.t818 VDD VDD sg13_lv_pmos ad=0.34p pd=2.68u as=0 ps=0 w=1u l=1u
X645 VSS.t2679 VDD VSS.t2680 VSS.t206 sg13_lv_nmos ad=79.8f pd=0.8u as=0 ps=0 w=0.42u l=1u
X646 VSS.t416 VDD VSS.t415 VSS.t4 sg13_lv_nmos ad=0.1428p pd=1.52u as=0 ps=0 w=0.42u l=1u
X647 VSS.t2065 VDD VSS.t2067 VSS.t2066 sg13_lv_nmos ad=79.8f pd=0.8u as=0 ps=0 w=0.42u l=1u
X648 VSS.t2748 VDD VSS.t2749 VSS.t206 sg13_lv_nmos ad=79.8f pd=0.8u as=0 ps=0 w=0.42u l=1u
X649 VDD VSS.t231 VDD VDD sg13_lv_pmos ad=0.19p pd=1.38u as=0 ps=0 w=1u l=1u
X650 a_27826_13722# sg13cmos5l_dfrbpq_1_5.RESET_B VSS.t191 VSS.t248 sg13_lv_nmos ad=37.8f pd=0.6u as=79.8f ps=0.8u w=0.42u l=0.13u
X651 VSS.t509 VDD VSS.t516 VSS.t515 sg13_lv_nmos ad=79.8f pd=0.8u as=0 ps=0 w=0.42u l=1u
X652 VDD VSS.t1276 VDD VDD sg13_lv_pmos ad=0.34p pd=2.68u as=0 ps=0 w=1u l=1u
X653 VDD VSS.t2084 VDD VDD sg13_lv_pmos ad=0.34p pd=2.68u as=0 ps=0 w=1u l=1u
X654 VDD VSS.t343 VDD VDD sg13_lv_pmos ad=0.19p pd=1.38u as=0 ps=0 w=1u l=1u
X655 VSS.t1165 VDD VSS.t1164 VSS.t1154 sg13_lv_nmos ad=0.1428p pd=1.52u as=0 ps=0 w=0.42u l=1u
X656 VDD VSS.t2748 VDD VDD sg13_lv_pmos ad=0.34p pd=2.68u as=0 ps=0 w=1u l=1u
X657 VSS.t1935 VDD VSS.t1937 VSS.t1936 sg13_lv_nmos ad=79.8f pd=0.8u as=0 ps=0 w=0.42u l=1u
X658 VDD VSS.t881 VDD VDD sg13_lv_pmos ad=0.19p pd=1.38u as=0 ps=0 w=1u l=1u
X659 VSS.t969 VDD VSS.t968 VSS.t967 sg13_lv_nmos ad=0.1428p pd=1.52u as=0 ps=0 w=0.42u l=1u
X660 VSS.t1578 VDD VSS.t1580 VSS.t1579 sg13_lv_nmos ad=79.8f pd=0.8u as=0 ps=0 w=0.42u l=1u
X661 VSS.t3099 VDD VSS.t3101 VSS.t3100 sg13_lv_nmos ad=79.8f pd=0.8u as=0 ps=0 w=0.42u l=1u
X662 VDD VSS.t2254 VDD VDD sg13_lv_pmos ad=0.19p pd=1.38u as=0 ps=0 w=1u l=1u
X663 sg13cmos5l_a21oi_1_3.A1 a_25206_15302# VSS.t9 VSS.t57 sg13_lv_nmos ad=0.2516p pd=2.16u as=0.1426p ps=1.16u w=0.74u l=0.13u
X664 VDD VSS.t2639 VDD VDD sg13_lv_pmos ad=0.19p pd=1.38u as=0 ps=0 w=1u l=1u
X665 VSS.t1970 VDD VSS.t1969 VSS.t1968 sg13_lv_nmos ad=0.1428p pd=1.52u as=0 ps=0 w=0.42u l=1u
X666 VSS.t3054 VDD VSS.t3053 VSS.t3052 sg13_lv_nmos ad=0.1428p pd=1.52u as=0 ps=0 w=0.42u l=1u
X667 VSS.t2267 VDD VSS.t2266 VSS.t2265 sg13_lv_nmos ad=0.1428p pd=1.52u as=0 ps=0 w=0.42u l=1u
X668 VSS.t1478 VDD VSS.t1480 VSS.t1479 sg13_lv_nmos ad=79.8f pd=0.8u as=0 ps=0 w=0.42u l=1u
X669 VSS.t2387 VDD VSS.t2389 VSS.t2388 sg13_lv_nmos ad=79.8f pd=0.8u as=0 ps=0 w=0.42u l=1u
X670 a_6729_14531# a_6372_14488# VDD VDD sg13_lv_pmos ad=63f pd=0.72u as=0.1563p ps=1.22u w=0.42u l=0.13u
X671 VDD VSS.t1542 VDD VDD sg13_lv_pmos ad=0.34p pd=2.68u as=0 ps=0 w=1u l=1u
X672 VSS.t4 a_27034_15202# a_26753_15424# VSS.t90 sg13_lv_nmos ad=79.8f pd=0.8u as=0.1428p ps=1.52u w=0.42u l=0.5u
X673 VDD VSS.t1597 VDD VDD sg13_lv_pmos ad=0.34p pd=2.68u as=0 ps=0 w=1u l=1u
X674 VSS.t2342 VDD VSS.t2341 VSS.t2340 sg13_lv_nmos ad=0.1428p pd=1.52u as=0 ps=0 w=0.42u l=1u
X675 VSS.t799 VDD VSS.t798 VSS.t797 sg13_lv_nmos ad=0.1428p pd=1.52u as=0 ps=0 w=0.42u l=1u
X676 VDD VSS.t973 VDD VDD sg13_lv_pmos ad=0.34p pd=2.68u as=0 ps=0 w=1u l=1u
X677 VDD VSS.t2444 VDD VDD sg13_lv_pmos ad=0.19p pd=1.38u as=0 ps=0 w=1u l=1u
X678 VSS.t556 VDD VSS.t555 VSS.t554 sg13_lv_nmos ad=0.1428p pd=1.52u as=0 ps=0 w=0.42u l=1u
X679 VDD VSS.t1211 VDD VDD sg13_lv_pmos ad=0.19p pd=1.38u as=0 ps=0 w=1u l=1u
X680 VSS.t1668 VDD VSS.t1670 VSS.t1669 sg13_lv_nmos ad=79.8f pd=0.8u as=0 ps=0 w=0.42u l=1u
X681 VDD VSS.t1879 VDD VDD sg13_lv_pmos ad=0.34p pd=2.68u as=0 ps=0 w=1u l=1u
X682 VDD VSS.t2710 VDD VDD sg13_lv_pmos ad=0.34p pd=2.68u as=0 ps=0 w=1u l=1u
X683 VDD VSS.t911 VDD VDD sg13_lv_pmos ad=0.19p pd=1.38u as=0 ps=0 w=1u l=1u
X684 VSS.t2050 VDD VSS.t2052 VSS.t2051 sg13_lv_nmos ad=79.8f pd=0.8u as=0 ps=0 w=0.42u l=1u
X685 a_37484_15960# sg13cmos5l_dfrbpq_1_5.Q VSS.t377 VSS.t3166 sg13_lv_nmos ad=0.187p pd=1.78u as=0.14875p ps=1.16u w=0.55u l=0.13u
X686 VDD VSS.t1297 VDD VDD sg13_lv_pmos ad=0.19p pd=1.38u as=0 ps=0 w=1u l=1u
X687 VSS.t2894 VDD VSS.t2896 VSS.t2895 sg13_lv_nmos ad=79.8f pd=0.8u as=0 ps=0 w=0.42u l=1u
X688 VDD a_26170_16237# sg13cmos5l_dfrbpq_1_7.RESET_B VDD sg13_lv_pmos ad=2.8961p pd=18.25u as=0.3927p ps=2.99u w=1.155u l=0.13u
X689 VSS.t1258 VDD VSS.t1257 VSS.t1154 sg13_lv_nmos ad=0.1428p pd=1.52u as=0 ps=0 w=0.42u l=1u
X690 VSS.t1179 VDD VSS.t1178 VSS.t1154 sg13_lv_nmos ad=0.1428p pd=1.52u as=0 ps=0 w=0.42u l=1u
X691 VDD VSS.t2471 VDD VDD sg13_lv_pmos ad=0.34p pd=2.68u as=0 ps=0 w=1u l=1u
X692 VDD sg13cmos5l_tiehi_1.L_HI a_9158_15234# VDD sg13_lv_pmos ad=0.36237p pd=2.605u as=79.8f ps=0.8u w=0.42u l=0.13u
X693 sg13cmos5l_and2_1_0.X a_1965_14832# VSS.t134 VSS.t3277 sg13_lv_nmos ad=0.2516p pd=2.16u as=0.1331p ps=1.12u w=0.74u l=0.13u
X694 VDD VSS.t848 VDD VDD sg13_lv_pmos ad=0.34p pd=2.68u as=0 ps=0 w=1u l=1u
X695 VDD VSS.t2663 VDD VDD sg13_lv_pmos ad=0.19p pd=1.38u as=0 ps=0 w=1u l=1u
X696 VSS.t2307 VDD VSS.t2306 VSS.t2305 sg13_lv_nmos ad=0.1428p pd=1.52u as=0 ps=0 w=0.42u l=1u
X697 VDD VSS.t3033 VDD VDD sg13_lv_pmos ad=0.34p pd=2.68u as=0 ps=0 w=1u l=1u
X698 VDD VSS.t2246 VDD VDD sg13_lv_pmos ad=0.34p pd=2.68u as=0 ps=0 w=1u l=1u
X699 VDD VSS.t2274 VDD VDD sg13_lv_pmos ad=0.19p pd=1.38u as=0 ps=0 w=1u l=1u
X700 VSS.t2080 VDD VSS.t2079 VSS.t2078 sg13_lv_nmos ad=0.1428p pd=1.52u as=0 ps=0 w=0.42u l=1u
X701 a_27898_15202# sg13cmos5l_dfrbpq_1_5.Q VSS.t246 VSS.t4 sg13_lv_nmos ad=0.1428p pd=1.52u as=79.8f ps=0.8u w=0.42u l=0.13u
X702 VSS.t1463 VDD VSS.t1465 VSS.t1464 sg13_lv_nmos ad=79.8f pd=0.8u as=0 ps=0 w=0.42u l=1u
X703 VSS.t2372 VDD VSS.t2374 VSS.t2373 sg13_lv_nmos ad=79.8f pd=0.8u as=0 ps=0 w=0.42u l=1u
X704 VSS.t1880 VDD VSS.t1882 VSS.t1881 sg13_lv_nmos ad=79.8f pd=0.8u as=0 ps=0 w=0.42u l=1u
X705 a_26633_16334# a_26757_16033# VDD VDD sg13_lv_pmos ad=0.2442p pd=2.06u as=2.8961p ps=18.25u w=0.66u l=0.13u
X706 VDD VSS.t2436 VDD VDD sg13_lv_pmos ad=0.34p pd=2.68u as=0 ps=0 w=1u l=1u
X707 a_18863_14845# a_18021_14495# a_18769_14845# VSS.t13 sg13_lv_nmos ad=0.12665p pd=1.145u as=0.1428p ps=1.52u w=0.42u l=0.13u
X708 VSS.t954 VDD VSS.t953 VSS.t952 sg13_lv_nmos ad=0.1428p pd=1.52u as=0 ps=0 w=0.42u l=1u
X709 a_3204_15247# a_2916_15552# a_3142_15247# VSS.t222 sg13_lv_nmos ad=0.1428p pd=1.52u as=37.8f ps=0.6u w=0.42u l=0.13u
X710 VSS.t999 VDD VSS.t998 VSS.t997 sg13_lv_nmos ad=0.1428p pd=1.52u as=0 ps=0 w=0.42u l=1u
X711 VDD VSS.t1947 VDD VDD sg13_lv_pmos ad=0.19p pd=1.38u as=0 ps=0 w=1u l=1u
X712 VSS.t1267 VDD VSS.t1266 VSS.t1154 sg13_lv_nmos ad=0.1428p pd=1.52u as=0 ps=0 w=0.42u l=1u
X713 a_10960_15454# sg13cmos5l_tiehi_1.L_HI VDD VDD sg13_lv_pmos ad=79.8f pd=0.8u as=2.8961p ps=18.25u w=0.42u l=0.13u
X714 VSS.t1830 VDD VSS.t1832 VSS.t1831 sg13_lv_nmos ad=79.8f pd=0.8u as=0 ps=0 w=0.42u l=1u
X715 VSS.t2914 VDD VSS.t2916 VSS.t2915 sg13_lv_nmos ad=79.8f pd=0.8u as=0 ps=0 w=0.42u l=1u
X716 VDD VSS.t319 VDD VDD sg13_lv_pmos ad=0.34p pd=2.68u as=0 ps=0 w=1u l=1u
X717 sg13cmos5l_nand4_1_0.Y sg13cmos5l_dlygate4sd3_1_8.X a_7262_15242# VSS.t3185 sg13_lv_nmos ad=0.2516p pd=2.16u as=0.1406p ps=1.12u w=0.74u l=0.13u
X718 VSS.t1623 VDD VSS.t1622 VSS.t1621 sg13_lv_nmos ad=0.1428p pd=1.52u as=0 ps=0 w=0.42u l=1u
X719 VDD VSS.t2314 VDD VDD sg13_lv_pmos ad=0.19p pd=1.38u as=0 ps=0 w=1u l=1u
X720 VDD VSS.t605 VDD VDD sg13_lv_pmos ad=0.19p pd=1.38u as=0 ps=0 w=1u l=1u
X721 VDD VSS.t811 VDD VDD sg13_lv_pmos ad=0.19p pd=1.38u as=0 ps=0 w=1u l=1u
X722 VSS.t969 VDD VSS.t968 VSS.t967 sg13_lv_nmos ad=0.1428p pd=1.52u as=0 ps=0 w=0.42u l=1u
X723 VSS.t1303 VDD VSS.t1303 VSS.t1154 sg13_lv_nmos ad=79.8f pd=0.8u as=0 ps=0 w=0.42u l=1u
X724 VDD VSS.t1268 VDD VDD sg13_lv_pmos ad=0.34p pd=2.68u as=0 ps=0 w=1u l=1u
X725 VDD VSS.t2231 VDD VDD sg13_lv_pmos ad=0.34p pd=2.68u as=0 ps=0 w=1u l=1u
X726 VSS.t2100 VDD VSS.t2099 VSS.t2098 sg13_lv_nmos ad=0.1428p pd=1.52u as=0 ps=0 w=0.42u l=1u
X727 VSS.t1920 VDD VSS.t1922 VSS.t1921 sg13_lv_nmos ad=79.8f pd=0.8u as=0 ps=0 w=0.42u l=1u
X728 VDD VSS.t51 VDD VDD sg13_lv_pmos ad=0.19p pd=1.38u as=0 ps=0 w=1u l=1u
X729 VDD VSS.t2097 VDD VDD sg13_lv_pmos ad=0.19p pd=1.38u as=0 ps=0 w=1u l=1u
X730 VDD VSS.t2630 VDD VDD sg13_lv_pmos ad=0.19p pd=1.38u as=0 ps=0 w=1u l=1u
X731 VDD VSS.t442 VDD VDD sg13_lv_pmos ad=0.34p pd=2.68u as=0 ps=0 w=1u l=1u
X732 VSS.t3039 VDD VSS.t3038 VSS.t3037 sg13_lv_nmos ad=0.1428p pd=1.52u as=0 ps=0 w=0.42u l=1u
X733 VSS.t2252 VDD VSS.t2251 VSS.t2250 sg13_lv_nmos ad=0.1428p pd=1.52u as=0 ps=0 w=0.42u l=1u
X734 VDD VSS.t1169 VDD VDD sg13_lv_pmos ad=0.19p pd=1.38u as=0 ps=0 w=1u l=1u
X735 VDD VSS.t1018 VDD VDD sg13_lv_pmos ad=0.34p pd=2.68u as=0 ps=0 w=1u l=1u
X736 VDD VSS.t1582 VDD VDD sg13_lv_pmos ad=0.34p pd=2.68u as=0 ps=0 w=1u l=1u
X737 VDD VSS.t2740 VDD VDD sg13_lv_pmos ad=0.19p pd=1.38u as=0 ps=0 w=1u l=1u
X738 VSS.t2050 VDD VSS.t2049 VSS.t2048 sg13_lv_nmos ad=0.1428p pd=1.52u as=0 ps=0 w=0.42u l=1u
X739 VSS.t273 VDD VSS.t273 VSS.t275 sg13_lv_nmos ad=0.1428p pd=1.52u as=0 ps=0 w=0.42u l=1u
X740 VSS.t2954 VDD VSS.t2956 VSS.t2955 sg13_lv_nmos ad=79.8f pd=0.8u as=0 ps=0 w=0.42u l=1u
X741 VDD VSS.t2286 VDD VDD sg13_lv_pmos ad=0.34p pd=2.68u as=0 ps=0 w=1u l=1u
X742 VSS.t2327 VDD VSS.t2326 VSS.t2325 sg13_lv_nmos ad=0.1428p pd=1.52u as=0 ps=0 w=0.42u l=1u
X743 VSS.t2681 VDD VSS.t2682 VSS.t206 sg13_lv_nmos ad=79.8f pd=0.8u as=0 ps=0 w=0.42u l=1u
X744 VDD VSS.t403 VDD VDD sg13_lv_pmos ad=0.34p pd=2.68u as=0 ps=0 w=1u l=1u
X745 VDD VSS.t623 VDD VDD sg13_lv_pmos ad=0.34p pd=2.68u as=0 ps=0 w=1u l=1u
X746 VSS.t1653 VDD VSS.t1655 VSS.t1654 sg13_lv_nmos ad=79.8f pd=0.8u as=0 ps=0 w=0.42u l=1u
X747 VSS.t2751 VDD VSS.t2752 VSS.t206 sg13_lv_nmos ad=79.8f pd=0.8u as=0 ps=0 w=0.42u l=1u
X748 VSS.t1895 VDD VSS.t1894 VSS.t1893 sg13_lv_nmos ad=0.1428p pd=1.52u as=0 ps=0 w=0.42u l=1u
X749 VDD VSS.t778 VDD VDD sg13_lv_pmos ad=0.34p pd=2.68u as=0 ps=0 w=1u l=1u
X750 VDD VSS.t3021 VDD VDD sg13_lv_pmos ad=0.19p pd=1.38u as=0 ps=0 w=1u l=1u
X751 VDD VSS.t1892 VDD VDD sg13_lv_pmos ad=0.19p pd=1.38u as=0 ps=0 w=1u l=1u
X752 VSS.t4 a_3333_15213# a_3435_15356# VSS.t260 sg13_lv_nmos ad=4.11262p pd=27.15u as=0.2516p ps=2.16u w=0.74u l=0.13u
X753 VSS.t121 a_14261_15238# sg13cmos5l_or3_1_1.B VSS.t212 sg13_lv_nmos ad=0.1406p pd=1.12u as=0.1406p ps=1.12u w=0.74u l=0.13u
X754 VDD VSS.t187 VDD VDD sg13_lv_pmos ad=0.34p pd=2.68u as=0 ps=0 w=1u l=1u
X755 VSS.t1608 VDD VSS.t1607 VSS.t1606 sg13_lv_nmos ad=0.1428p pd=1.52u as=0 ps=0 w=0.42u l=1u
X756 VSS.t1285 VDD VSS.t1284 VSS.t1154 sg13_lv_nmos ad=0.1428p pd=1.52u as=0 ps=0 w=0.42u l=1u
X757 VSS.t1317 VDD VSS.t1318 VSS.t1154 sg13_lv_nmos ad=79.8f pd=0.8u as=0 ps=0 w=0.42u l=1u
X758 VDD VSS.t1258 VDD VDD sg13_lv_pmos ad=0.34p pd=2.68u as=0 ps=0 w=1u l=1u
X759 VDD VSS.t2752 VDD VDD sg13_lv_pmos ad=0.34p pd=2.68u as=0 ps=0 w=1u l=1u
X760 VDD VSS.t2054 VDD VDD sg13_lv_pmos ad=0.34p pd=2.68u as=0 ps=0 w=1u l=1u
X761 VSS.t147 VDD VSS.t147 VSS.t463 sg13_lv_nmos ad=0.1428p pd=1.52u as=0 ps=0 w=0.42u l=1u
X762 VSS.t1583 VDD VSS.t1585 VSS.t1584 sg13_lv_nmos ad=79.8f pd=0.8u as=0 ps=0 w=0.42u l=1u
X763 VDD VSS.t2259 VDD VDD sg13_lv_pmos ad=0.19p pd=1.38u as=0 ps=0 w=1u l=1u
X764 a_2890_15457# a_3333_15213# a_3273_15625# VDD sg13_lv_pmos ad=79.8f pd=0.8u as=63f ps=0.72u w=0.42u l=0.13u
X765 VSS.t121 VDD VSS.t110 VSS.t467 sg13_lv_nmos ad=0.1428p pd=1.52u as=0 ps=0 w=0.42u l=1u
X766 VDD VSS.t629 VDD VDD sg13_lv_pmos ad=0.19p pd=1.38u as=0 ps=0 w=1u l=1u
X767 VDD VSS.t831 VDD VDD sg13_lv_pmos ad=0.19p pd=1.38u as=0 ps=0 w=1u l=1u
X768 VSS.t1237 VDD VSS.t1238 VSS.t1154 sg13_lv_nmos ad=79.8f pd=0.8u as=0 ps=0 w=0.42u l=1u
X769 VDD VSS.t1262 VDD VDD sg13_lv_pmos ad=0.19p pd=1.38u as=0 ps=0 w=1u l=1u
X770 VSS.t1448 VDD VSS.t1450 VSS.t1449 sg13_lv_nmos ad=79.8f pd=0.8u as=0 ps=0 w=0.42u l=1u
X771 VSS.t1865 VDD VSS.t1867 VSS.t1866 sg13_lv_nmos ad=79.8f pd=0.8u as=0 ps=0 w=0.42u l=1u
X772 VSS.t999 VDD VSS.t998 VSS.t997 sg13_lv_nmos ad=0.1428p pd=1.52u as=0 ps=0 w=0.42u l=1u
X773 VDD VSS.t1547 VDD VDD sg13_lv_pmos ad=0.34p pd=2.68u as=0 ps=0 w=1u l=1u
X774 VDD VSS.t1602 VDD VDD sg13_lv_pmos ad=0.34p pd=2.68u as=0 ps=0 w=1u l=1u
X775 VSS.t1162 VDD VSS.t1163 VSS.t1154 sg13_lv_nmos ad=79.8f pd=0.8u as=0 ps=0 w=0.42u l=1u
X776 VDD VSS.t1884 VDD VDD sg13_lv_pmos ad=0.34p pd=2.68u as=0 ps=0 w=1u l=1u
X777 VDD VSS.t2713 VDD VDD sg13_lv_pmos ad=0.34p pd=2.68u as=0 ps=0 w=1u l=1u
X778 VSS.t310 VDD VSS.t309 VSS.t308 sg13_lv_nmos ad=0.1428p pd=1.52u as=0 ps=0 w=0.42u l=1u
X779 VDD VSS.t289 VDD VDD sg13_lv_pmos ad=0.19p pd=1.38u as=0 ps=0 w=1u l=1u
X780 VSS.t1299 VDD VSS.t1297 VSS.t1154 sg13_lv_nmos ad=0.1428p pd=1.52u as=0 ps=0 w=0.42u l=1u
X781 VSS.t2901 VDD VSS.t2899 VSS.t2900 sg13_lv_nmos ad=79.8f pd=0.8u as=0 ps=0 w=0.42u l=1u
X782 VSS.t632 VDD VSS.t632 VSS.t758 sg13_lv_nmos ad=0.1428p pd=1.52u as=0 ps=0 w=0.42u l=1u
X783 VDD VSS.t1897 VDD VDD sg13_lv_pmos ad=0.19p pd=1.38u as=0 ps=0 w=1u l=1u
X784 VSS.t2724 VDD VSS.t2723 VSS.t206 sg13_lv_nmos ad=0.1428p pd=1.52u as=0 ps=0 w=0.42u l=1u
X785 VDD VSS.t2476 VDD VDD sg13_lv_pmos ad=0.34p pd=2.68u as=0 ps=0 w=1u l=1u
X786 VDD VSS.t576 VDD VDD sg13_lv_pmos ad=0.34p pd=2.68u as=0 ps=0 w=1u l=1u
X787 VDD VSS.t2666 VDD VDD sg13_lv_pmos ad=0.19p pd=1.38u as=0 ps=0 w=1u l=1u
X788 VSS.t2312 VDD VSS.t2311 VSS.t2310 sg13_lv_nmos ad=0.1428p pd=1.52u as=0 ps=0 w=0.42u l=1u
X789 VSS.t690 VDD VSS.t93 VSS.t691 sg13_lv_nmos ad=79.8f pd=0.8u as=0 ps=0 w=0.42u l=1u
X790 VDD VSS.t783 VDD VDD sg13_lv_pmos ad=0.34p pd=2.68u as=0 ps=0 w=1u l=1u
X791 VSS.t1219 VDD VSS.t1218 VSS.t1154 sg13_lv_nmos ad=0.1428p pd=1.52u as=0 ps=0 w=0.42u l=1u
X792 VSS.t2085 VDD VSS.t2084 VSS.t2083 sg13_lv_nmos ad=0.1428p pd=1.52u as=0 ps=0 w=0.42u l=1u
X793 a_3333_16033# a_3333_16033# VSS.t7 VSS.t63 sg13_lv_nmos ad=0.111p pd=1.34u as=7.70437p ps=50.66u w=0.3u l=0.13u
X794 VSS.t294 VDD VSS.t294 VSS.t296 sg13_lv_nmos ad=0.1428p pd=1.52u as=0 ps=0 w=0.42u l=1u
X795 VSS.t4 a_6789_14495# a_6891_14495# VSS.t54 sg13_lv_nmos ad=4.11262p pd=27.15u as=0.2516p ps=2.16u w=0.74u l=0.13u
X796 VSS.t551 VDD VSS.t553 VSS.t552 sg13_lv_nmos ad=79.8f pd=0.8u as=0 ps=0 w=0.42u l=1u
X797 VDD VSS.t608 VDD VDD sg13_lv_pmos ad=0.34p pd=2.68u as=0 ps=0 w=1u l=1u
X798 VSS.t144 a_10222_14751# sg13cmos5l_dlygate4sd3_1_8.X VSS.t168 sg13_lv_nmos ad=0.1426p pd=1.16u as=0.2516p ps=2.16u w=0.74u l=0.13u
X799 VDD VSS.t1580 VDD VDD sg13_lv_pmos ad=0.19p pd=1.38u as=0 ps=0 w=1u l=1u
X800 VDD a_21070_15423# sg13cmos5l_dlygate4sd3_1_9.X VDD sg13_lv_pmos ad=0.2254p pd=1.53u as=0.4256p ps=3u w=1.12u l=0.13u
X801 VDD VSS.t948 VDD VDD sg13_lv_pmos ad=0.34p pd=2.68u as=0 ps=0 w=1u l=1u
X802 VSS.t1468 VDD VSS.t1470 VSS.t1469 sg13_lv_nmos ad=79.8f pd=0.8u as=0 ps=0 w=0.42u l=1u
X803 VSS.t2377 VDD VSS.t2379 VSS.t2378 sg13_lv_nmos ad=79.8f pd=0.8u as=0 ps=0 w=0.42u l=1u
X804 VDD VSS.t361 VDD VDD sg13_lv_pmos ad=0.34p pd=2.68u as=0 ps=0 w=1u l=1u
X805 VSS.t819 VDD VSS.t818 VSS.t817 sg13_lv_nmos ad=0.1428p pd=1.52u as=0 ps=0 w=0.42u l=1u
X806 VDD VSS.t1177 VDD VDD sg13_lv_pmos ad=0.19p pd=1.38u as=0 ps=0 w=1u l=1u
X807 VDD VSS.t1952 VDD VDD sg13_lv_pmos ad=0.19p pd=1.38u as=0 ps=0 w=1u l=1u
X808 VSS.t1176 VDD VSS.t1177 VSS.t1154 sg13_lv_nmos ad=79.8f pd=0.8u as=0 ps=0 w=0.42u l=1u
X809 VSS.t1598 VDD VSS.t1597 VSS.t1596 sg13_lv_nmos ad=0.1428p pd=1.52u as=0 ps=0 w=0.42u l=1u
X810 VSS.t3119 VDD VSS.t3118 VSS.t3117 sg13_lv_nmos ad=0.1428p pd=1.52u as=0 ps=0 w=0.42u l=1u
X811 VDD VSS.t2271 VDD VDD sg13_lv_pmos ad=0.34p pd=2.68u as=0 ps=0 w=1u l=1u
X812 VSS.t2674 VDD VSS.t2675 VSS.t206 sg13_lv_nmos ad=79.8f pd=0.8u as=0 ps=0 w=0.42u l=1u
X813 VSS.t576 a_19323_13726# sg13cmos5l_buf_8_2.X VSS.t3254 sg13_lv_nmos ad=0.2516p pd=2.16u as=0.1406p ps=1.12u w=0.74u l=0.13u
X814 a_9418_15457# a_9861_15213# a_9158_15234# VSS.t97 sg13_lv_nmos ad=79.8f pd=0.8u as=0.1296p ps=1.52u w=0.42u l=0.13u
X815 VSS.t1880 VDD VSS.t1879 VSS.t1878 sg13_lv_nmos ad=0.1428p pd=1.52u as=0 ps=0 w=0.42u l=1u
X816 VSS.t605 VDD VSS.t605 VSS.t606 sg13_lv_nmos ad=79.8f pd=0.8u as=0 ps=0 w=0.42u l=1u
X817 VDD VSS.t1011 VDD VDD sg13_lv_pmos ad=0.19p pd=1.38u as=0 ps=0 w=1u l=1u
X818 VSS.t1593 VDD VSS.t1592 VSS.t1591 sg13_lv_nmos ad=0.1428p pd=1.52u as=0 ps=0 w=0.42u l=1u
X819 VDD VSS.t352 VDD VDD sg13_lv_pmos ad=0.19p pd=1.38u as=0 ps=0 w=1u l=1u
X820 VSS.t556 VDD VSS.t555 VSS.t554 sg13_lv_nmos ad=0.1428p pd=1.52u as=0 ps=0 w=0.42u l=1u
X821 VDD VSS.t938 VDD VDD sg13_lv_pmos ad=0.34p pd=2.68u as=0 ps=0 w=1u l=1u
X822 VSS.t1233 VDD VSS.t1231 VSS.t1154 sg13_lv_nmos ad=0.1428p pd=1.52u as=0 ps=0 w=0.42u l=1u
X823 VSS.t1508 VDD VSS.t1510 VSS.t1509 sg13_lv_nmos ad=79.8f pd=0.8u as=0 ps=0 w=0.42u l=1u
X824 VDD VSS.t3023 VDD VDD sg13_lv_pmos ad=0.34p pd=2.68u as=0 ps=0 w=1u l=1u
X825 VDD VSS.t2236 VDD VDD sg13_lv_pmos ad=0.34p pd=2.68u as=0 ps=0 w=1u l=1u
X826 VDD a_3333_15213# a_3435_15356# VDD sg13_lv_pmos ad=2.8961p pd=18.25u as=0.3864p ps=2.93u w=1.12u l=0.13u
X827 VDD sg13cmos5l_dfrbpq_1_2.RESET_B a_16042_13945# VDD sg13_lv_pmos ad=0.1563p pd=1.22u as=0.147p ps=1.54u w=0.42u l=0.13u
X828 VSS.t2672 VDD VSS.t2673 VSS.t206 sg13_lv_nmos ad=79.8f pd=0.8u as=0 ps=0 w=0.42u l=1u
X829 VDD VSS.t2409 VDD VDD sg13_lv_pmos ad=0.19p pd=1.38u as=0 ps=0 w=1u l=1u
X830 VDD VSS.t2637 VDD VDD sg13_lv_pmos ad=0.19p pd=1.38u as=0 ps=0 w=1u l=1u
X831 VDD VSS.t106 VDD VDD sg13_lv_pmos ad=0.19p pd=1.38u as=0 ps=0 w=1u l=1u
X832 VDD VSS.t1944 VDD VDD sg13_lv_pmos ad=0.34p pd=2.68u as=0 ps=0 w=1u l=1u
X833 VSS.t704 VDD VSS.t578 VSS.t705 sg13_lv_nmos ad=79.8f pd=0.8u as=0 ps=0 w=0.42u l=1u
X834 VSS.t974 VDD VSS.t973 VSS.t972 sg13_lv_nmos ad=0.1428p pd=1.52u as=0 ps=0 w=0.42u l=1u
X835 VDD VSS.t1532 VDD VDD sg13_lv_pmos ad=0.34p pd=2.68u as=0 ps=0 w=1u l=1u
X836 VSS.t1158 VDD VSS.t1157 VSS.t1154 sg13_lv_nmos ad=0.1428p pd=1.52u as=0 ps=0 w=0.42u l=1u
X837 VSS.t1269 VDD VSS.t1270 VSS.t1154 sg13_lv_nmos ad=79.8f pd=0.8u as=0 ps=0 w=0.42u l=1u
X838 VDD VSS.t1587 VDD VDD sg13_lv_pmos ad=0.34p pd=2.68u as=0 ps=0 w=1u l=1u
X839 VSS.t428 VDD VSS.t427 VSS.t4 sg13_lv_nmos ad=0.1428p pd=1.52u as=0 ps=0 w=0.42u l=1u
X840 VSS.t2959 VDD VSS.t2961 VSS.t2960 sg13_lv_nmos ad=79.8f pd=0.8u as=0 ps=0 w=0.42u l=1u
X841 VSS.t2332 VDD VSS.t2331 VSS.t2330 sg13_lv_nmos ad=0.1428p pd=1.52u as=0 ps=0 w=0.42u l=1u
X842 VSS.t909 VDD VSS.t911 VSS.t910 sg13_lv_nmos ad=79.8f pd=0.8u as=0 ps=0 w=0.42u l=1u
X843 VSS.t2684 VDD VSS.t2685 VSS.t206 sg13_lv_nmos ad=79.8f pd=0.8u as=0 ps=0 w=0.42u l=1u
X844 a_21460_14020# sg13cmos5l_or3_1_2.A VDD VDD sg13_lv_pmos ad=0.1575p pd=1.315u as=0.3822p ps=1.84u w=1u l=0.13u
X845 VDD VSS.t978 VDD VDD sg13_lv_pmos ad=0.34p pd=2.68u as=0 ps=0 w=1u l=1u
X846 VDD VSS.t2649 VDD VDD sg13_lv_pmos ad=0.34p pd=2.68u as=0 ps=0 w=1u l=1u
X847 VSS.t699 a_19323_13726# sg13cmos5l_buf_8_2.X VSS.t3250 sg13_lv_nmos ad=0.1406p pd=1.12u as=0.1406p ps=1.12u w=0.74u l=0.13u
X848 VSS.t2754 VDD VSS.t2755 VSS.t206 sg13_lv_nmos ad=79.8f pd=0.8u as=0 ps=0 w=0.42u l=1u
X849 VSS.t655 VDD VSS.t257 VSS.t656 sg13_lv_nmos ad=79.8f pd=0.8u as=0 ps=0 w=0.42u l=1u
X850 VDD VSS.t1213 VDD VDD sg13_lv_pmos ad=0.19p pd=1.38u as=0 ps=0 w=1u l=1u
X851 VDD a_12524_15960# counter_value_o[2] VDD sg13_lv_pmos ad=0.2114p pd=1.54u as=0.42p ps=2.99u w=1.12u l=0.13u
X852 VSS.t506 VDD VSS.t509 VSS.t508 sg13_lv_nmos ad=79.8f pd=0.8u as=0 ps=0 w=0.42u l=1u
X853 VSS.t586 VDD VSS.t588 VSS.t711 sg13_lv_nmos ad=79.8f pd=0.8u as=0 ps=0 w=0.42u l=1u
X854 VDD VSS.t901 VDD VDD sg13_lv_pmos ad=0.19p pd=1.38u as=0 ps=0 w=1u l=1u
X855 VDD VSS.t1262 VDD VDD sg13_lv_pmos ad=0.34p pd=2.68u as=0 ps=0 w=1u l=1u
X856 VDD VSS.t2657 VDD VDD sg13_lv_pmos ad=0.19p pd=1.38u as=0 ps=0 w=1u l=1u
X857 VDD VSS.t2755 VDD VDD sg13_lv_pmos ad=0.34p pd=2.68u as=0 ps=0 w=1u l=1u
X858 VSS.t2297 VDD VSS.t2296 VSS.t2295 sg13_lv_nmos ad=0.1428p pd=1.52u as=0 ps=0 w=0.42u l=1u
X859 VDD VSS.t2059 VDD VDD sg13_lv_pmos ad=0.34p pd=2.68u as=0 ps=0 w=1u l=1u
X860 VSS.t1246 VDD VSS.t1245 VSS.t1154 sg13_lv_nmos ad=0.1428p pd=1.52u as=0 ps=0 w=0.42u l=1u
X861 VSS.t1910 VDD VSS.t1912 VSS.t1911 sg13_lv_nmos ad=79.8f pd=0.8u as=0 ps=0 w=0.42u l=1u
X862 VSS.t273 VDD VSS.t273 VSS.t274 sg13_lv_nmos ad=79.8f pd=0.8u as=0 ps=0 w=0.42u l=1u
X863 sg13cmos5l_o21ai_1_2.A2 sg13cmos5l_dfrbpq_1_2.Q VDD VDD sg13_lv_pmos ad=0.2128p pd=1.5u as=0.3808p ps=2.92u w=1.12u l=0.13u
X864 VDD VSS.t2628 VDD VDD sg13_lv_pmos ad=0.19p pd=1.38u as=0 ps=0 w=1u l=1u
X865 VSS.t1850 VDD VSS.t1849 VSS.t1848 sg13_lv_nmos ad=0.1428p pd=1.52u as=0 ps=0 w=0.42u l=1u
X866 VSS.t41 a_4474_14448# a_4193_14750# VSS.t96 sg13_lv_nmos ad=79.8f pd=0.8u as=0.1428p ps=1.52u w=0.42u l=0.5u
X867 a_24263_14508# sg13cmos5l_o21ai_1_2.A2 a_24169_14508# VDD sg13_lv_pmos ad=0.19p pd=1.38u as=0.34p ps=2.68u w=1u l=0.13u
X868 a_21060_14488# a_21034_14452# VDD VDD sg13_lv_pmos ad=0.34p pd=2.68u as=0.36237p ps=2.605u w=1u l=0.13u
X869 VSS.t1453 VDD VSS.t1455 VSS.t1454 sg13_lv_nmos ad=79.8f pd=0.8u as=0 ps=0 w=0.42u l=1u
X870 VSS.t819 VDD VSS.t818 VSS.t817 sg13_lv_nmos ad=0.1428p pd=1.52u as=0 ps=0 w=0.42u l=1u
X871 VSS.t1251 VDD VSS.t1250 VSS.t1154 sg13_lv_nmos ad=0.1428p pd=1.52u as=0 ps=0 w=0.42u l=1u
X872 VSS.t2639 VDD VSS.t2640 VSS.t206 sg13_lv_nmos ad=79.8f pd=0.8u as=0 ps=0 w=0.42u l=1u
X873 VSS.t2362 VDD VSS.t2364 VSS.t2363 sg13_lv_nmos ad=79.8f pd=0.8u as=0 ps=0 w=0.42u l=1u
X874 VDD VSS.t776 VDD VDD sg13_lv_pmos ad=0.19p pd=1.38u as=0 ps=0 w=1u l=1u
X875 VDD VSS.t1223 VDD VDD sg13_lv_pmos ad=0.19p pd=1.38u as=0 ps=0 w=1u l=1u
X876 VDD VSS.t2886 VDD VDD sg13_lv_pmos ad=0.19p pd=1.38u as=0 ps=0 w=1u l=1u
X877 VDD VSS.t1937 VDD VDD sg13_lv_pmos ad=0.19p pd=1.38u as=0 ps=0 w=1u l=1u
X878 VSS.t16 sg13cmos5l_or3_1_2.B a_16175_15238# VSS.t80 sg13_lv_nmos ad=0.1898p pd=1.36u as=0.1406p ps=1.12u w=0.74u l=0.13u
X879 VSS.t573 VDD VSS.t573 VSS.t574 sg13_lv_nmos ad=79.8f pd=0.8u as=0 ps=0 w=0.42u l=1u
X880 VDD VSS.t1889 VDD VDD sg13_lv_pmos ad=0.34p pd=2.68u as=0 ps=0 w=1u l=1u
X881 VDD VSS.t2715 VDD VDD sg13_lv_pmos ad=0.34p pd=2.68u as=0 ps=0 w=1u l=1u
X882 VSS.t2765 VDD VSS.t2764 VSS.t206 sg13_lv_nmos ad=0.1428p pd=1.52u as=0 ps=0 w=0.42u l=1u
X883 VDD VSS.t2640 VDD VDD sg13_lv_pmos ad=0.34p pd=2.68u as=0 ps=0 w=1u l=1u
X884 VSS.t25 VDD VSS.t30 VSS.t462 sg13_lv_nmos ad=79.8f pd=0.8u as=0 ps=0 w=0.42u l=1u
X885 sg13cmos5l_buf_1_10.X a_1192_9948# VSS.t1155 VSS.t1154 sg13_lv_nmos ad=0.2886p pd=2.26u as=0.14875p ps=1.16u w=0.74u l=0.13u
X886 VDD VSS.t1185 VDD VDD sg13_lv_pmos ad=0.34p pd=2.68u as=0 ps=0 w=1u l=1u
X887 VSS.t2904 VDD VSS.t2906 VSS.t2905 sg13_lv_nmos ad=79.8f pd=0.8u as=0 ps=0 w=0.42u l=1u
X888 sg13cmos5l_dfrbpq_1_5.Q a_28074_14020# VSS.t187 VSS.t186 sg13_lv_nmos ad=0.2516p pd=2.16u as=0.1406p ps=1.12u w=0.74u l=0.13u
X889 VDD VSS.t868 VDD VDD sg13_lv_pmos ad=0.34p pd=2.68u as=0 ps=0 w=1u l=1u
X890 VSS.t1191 VDD VSS.t1190 VSS.t1154 sg13_lv_nmos ad=0.1428p pd=1.52u as=0 ps=0 w=0.42u l=1u
X891 VDD VSS.t2446 VDD VDD sg13_lv_pmos ad=0.34p pd=2.68u as=0 ps=0 w=1u l=1u
X892 sg13cmos5l_or3_1_2.B a_16168_15996# VDD VDD sg13_lv_pmos ad=0.42p pd=2.99u as=0.2114p ps=1.54u w=1.12u l=0.13u
X893 VDD VSS.t983 VDD VDD sg13_lv_pmos ad=0.34p pd=2.68u as=0 ps=0 w=1u l=1u
X894 VDD VSS.t2669 VDD VDD sg13_lv_pmos ad=0.19p pd=1.38u as=0 ps=0 w=1u l=1u
X895 VSS.t2691 VDD VSS.t2691 VSS.t206 sg13_lv_nmos ad=0.1428p pd=1.52u as=0 ps=0 w=0.42u l=1u
X896 VSS.t2317 VDD VSS.t2316 VSS.t2315 sg13_lv_nmos ad=0.1428p pd=1.52u as=0 ps=0 w=0.42u l=1u
X897 VDD VSS.t2221 VDD VDD sg13_lv_pmos ad=0.34p pd=2.68u as=0 ps=0 w=1u l=1u
X898 VSS.t1673 VDD VSS.t1672 VSS.t1671 sg13_lv_nmos ad=0.1428p pd=1.52u as=0 ps=0 w=0.42u l=1u
X899 VSS.t2055 VDD VSS.t2054 VSS.t2053 sg13_lv_nmos ad=0.1428p pd=1.52u as=0 ps=0 w=0.42u l=1u
X900 VDD a_7680_15549# sg13cmos5l_xnor2_1_0.Y VDD sg13_lv_pmos ad=0.3808p pd=2.92u as=0.2408p ps=1.55u w=1.12u l=0.13u
X901 VDD VSS.t1575 VDD VDD sg13_lv_pmos ad=0.19p pd=1.38u as=0 ps=0 w=1u l=1u
X902 VSS.t2763 VDD VSS.t2762 VSS.t206 sg13_lv_nmos ad=0.1428p pd=1.52u as=0 ps=0 w=0.42u l=1u
X903 VSS.t2663 VDD VSS.t2664 VSS.t206 sg13_lv_nmos ad=79.8f pd=0.8u as=0 ps=0 w=0.42u l=1u
X904 VDD VSS.t1585 VDD VDD sg13_lv_pmos ad=0.19p pd=1.38u as=0 ps=0 w=1u l=1u
X905 VSS.t7 a_3209_16334# a_3130_16237# VSS.t3182 sg13_lv_nmos ad=7.70437p pd=50.66u as=0.27427p ps=2.28u w=0.795u l=0.13u
X906 VSS.t974 VDD VSS.t973 VSS.t972 sg13_lv_nmos ad=0.1428p pd=1.52u as=0 ps=0 w=0.42u l=1u
X907 VSS.t1019 VDD VSS.t1018 VSS.t1017 sg13_lv_nmos ad=0.1428p pd=1.52u as=0 ps=0 w=0.42u l=1u
X908 VSS.t909 VDD VSS.t911 VSS.t910 sg13_lv_nmos ad=79.8f pd=0.8u as=0 ps=0 w=0.42u l=1u
X909 VDD VSS.t1203 VDD VDD sg13_lv_pmos ad=0.34p pd=2.68u as=0 ps=0 w=1u l=1u
X910 VSS.t1296 VDD VSS.t1297 VSS.t1154 sg13_lv_nmos ad=79.8f pd=0.8u as=0 ps=0 w=0.42u l=1u
X911 VDD VSS.t1180 VDD VDD sg13_lv_pmos ad=0.19p pd=1.38u as=0 ps=0 w=1u l=1u
X912 VDD VSS.t2734 VDD VDD sg13_lv_pmos ad=0.19p pd=1.38u as=0 ps=0 w=1u l=1u
X913 VDD VSS.t1957 VDD VDD sg13_lv_pmos ad=0.19p pd=1.38u as=0 ps=0 w=1u l=1u
X914 VSS.t1603 VDD VSS.t1602 VSS.t1601 sg13_lv_nmos ad=0.1428p pd=1.52u as=0 ps=0 w=0.42u l=1u
X915 VSS.t3124 VDD VSS.t3123 VSS.t3122 sg13_lv_nmos ad=0.1428p pd=1.52u as=0 ps=0 w=0.42u l=1u
X916 VDD VSS.t2276 VDD VDD sg13_lv_pmos ad=0.34p pd=2.68u as=0 ps=0 w=1u l=1u
X917 a_27215_14845# a_26373_14495# a_27121_14845# VSS.t4 sg13_lv_nmos ad=0.12665p pd=1.145u as=0.1428p ps=1.52u w=0.42u l=0.13u
X918 VSS.t2676 VDD VSS.t2677 VSS.t206 sg13_lv_nmos ad=79.8f pd=0.8u as=0 ps=0 w=0.42u l=1u
X919 VDD VSS.t1023 VDD VDD sg13_lv_pmos ad=0.34p pd=2.68u as=0 ps=0 w=1u l=1u
X920 VSS.t1885 VDD VSS.t1884 VSS.t1883 sg13_lv_nmos ad=0.1428p pd=1.52u as=0 ps=0 w=0.42u l=1u
X921 VDD VSS.t608 VDD VDD sg13_lv_pmos ad=0.19p pd=1.38u as=0 ps=0 w=1u l=1u
X922 VSS.t2889 VDD VSS.t2891 VSS.t2890 sg13_lv_nmos ad=79.8f pd=0.8u as=0 ps=0 w=0.42u l=1u
X923 VSS.t2745 VDD VSS.t2746 VSS.t206 sg13_lv_nmos ad=79.8f pd=0.8u as=0 ps=0 w=0.42u l=1u
X924 VDD VSS.t1241 VDD VDD sg13_lv_pmos ad=0.19p pd=1.38u as=0 ps=0 w=1u l=1u
X925 VSS.t1315 VDD VSS.t1316 VSS.t1154 sg13_lv_nmos ad=79.8f pd=0.8u as=0 ps=0 w=0.42u l=1u
X926 VDD VSS.t2289 VDD VDD sg13_lv_pmos ad=0.19p pd=1.38u as=0 ps=0 w=1u l=1u
X927 VSS.t333 VDD VSS.t332 VSS.t331 sg13_lv_nmos ad=0.1428p pd=1.52u as=0 ps=0 w=0.42u l=1u
X928 VDD VSS.t946 VDD VDD sg13_lv_pmos ad=0.19p pd=1.38u as=0 ps=0 w=1u l=1u
X929 VDD sg13cmos5l_dfrbpq_1_2.Q a_16552_15996# VDD sg13_lv_pmos ad=0.2114p pd=1.54u as=0.2856p ps=2.36u w=0.84u l=0.13u
X930 VDD VSS.t1252 VDD VDD sg13_lv_pmos ad=0.34p pd=2.68u as=0 ps=0 w=1u l=1u
X931 VSS.t1513 VDD VSS.t1515 VSS.t1514 sg13_lv_nmos ad=79.8f pd=0.8u as=0 ps=0 w=0.42u l=1u
X932 VDD VSS.t2746 VDD VDD sg13_lv_pmos ad=0.34p pd=2.68u as=0 ps=0 w=1u l=1u
X933 VSS.t2675 VDD VSS.t2676 VSS.t206 sg13_lv_nmos ad=79.8f pd=0.8u as=0 ps=0 w=0.42u l=1u
X934 VDD VSS.t2414 VDD VDD sg13_lv_pmos ad=0.19p pd=1.38u as=0 ps=0 w=1u l=1u
X935 VSS.t2075 VDD VSS.t2074 VSS.t2073 sg13_lv_nmos ad=0.1428p pd=1.52u as=0 ps=0 w=0.42u l=1u
X936 VSS.t1895 VDD VSS.t1897 VSS.t1896 sg13_lv_nmos ad=79.8f pd=0.8u as=0 ps=0 w=0.42u l=1u
X937 VSS.t829 VDD VSS.t831 VSS.t830 sg13_lv_nmos ad=79.8f pd=0.8u as=0 ps=0 w=0.42u l=1u
X938 VDD VSS.t2619 VDD VDD sg13_lv_pmos ad=0.19p pd=1.38u as=0 ps=0 w=1u l=1u
X939 VSS.t1835 VDD VSS.t1834 VSS.t1833 sg13_lv_nmos ad=0.1428p pd=1.52u as=0 ps=0 w=0.42u l=1u
X940 a_21417_14531# a_21060_14488# VDD VDD sg13_lv_pmos ad=63f pd=0.72u as=0.1563p ps=1.22u w=0.42u l=0.13u
X941 VSS.t1320 VDD VSS.t1321 VSS.t1154 sg13_lv_nmos ad=79.8f pd=0.8u as=0 ps=0 w=0.42u l=1u
X942 VSS.t2919 VDD VSS.t2918 VSS.t2917 sg13_lv_nmos ad=0.1428p pd=1.52u as=0 ps=0 w=0.42u l=1u
X943 VDD VSS.t1309 VDD VDD sg13_lv_pmos ad=0.34p pd=2.68u as=0 ps=0 w=1u l=1u
X944 VDD VSS.t1038 VDD VDD sg13_lv_pmos ad=0.34p pd=2.68u as=0 ps=0 w=1u l=1u
X945 VDD VSS.t2676 VDD VDD sg13_lv_pmos ad=0.34p pd=2.68u as=0 ps=0 w=1u l=1u
X946 VDD VSS.t1914 VDD VDD sg13_lv_pmos ad=0.34p pd=2.68u as=0 ps=0 w=1u l=1u
X947 a_3204_15247# a_3435_15356# a_2890_15457# VSS.t114 sg13_lv_nmos ad=0.2373p pd=1.97u as=79.8f ps=0.8u w=0.42u l=0.13u
X948 VDD VSS.t2099 VDD VDD sg13_lv_pmos ad=0.34p pd=2.68u as=0 ps=0 w=1u l=1u
X949 a_3142_15247# sg13cmos5l_dfrbpq_1_0.RESET_B VSS.t196 VSS.t3164 sg13_lv_nmos ad=37.8f pd=0.6u as=0.1701p ps=1.65u w=0.42u l=0.13u
X950 VSS.t551 VDD VSS.t553 VSS.t552 sg13_lv_nmos ad=79.8f pd=0.8u as=0 ps=0 w=0.42u l=1u
X951 VDD VSS.t1597 VDD VDD sg13_lv_pmos ad=0.34p pd=2.68u as=0 ps=0 w=1u l=1u
X952 VDD VSS.t1874 VDD VDD sg13_lv_pmos ad=0.34p pd=2.68u as=0 ps=0 w=1u l=1u
X953 VDD VSS.t2707 VDD VDD sg13_lv_pmos ad=0.34p pd=2.68u as=0 ps=0 w=1u l=1u
X954 VSS.t257 a_8218_13690# a_7937_13912# VSS.t256 sg13_lv_nmos ad=79.8f pd=0.8u as=0.1428p ps=1.52u w=0.42u l=0.5u
X955 VSS.t2736 VDD VSS.t2737 VSS.t206 sg13_lv_nmos ad=79.8f pd=0.8u as=0 ps=0 w=0.42u l=1u
X956 VDD VSS.t913 VDD VDD sg13_lv_pmos ad=0.34p pd=2.68u as=0 ps=0 w=1u l=1u
X957 VSS.t16 clock_i a_15579_14854# VSS.t3233 sg13_lv_nmos ad=0.1406p pd=1.12u as=0.2553p ps=2.17u w=0.74u l=0.13u
X958 VSS.t2684 VDD VSS.t2683 VSS.t206 sg13_lv_nmos ad=0.1428p pd=1.52u as=0 ps=0 w=0.42u l=1u
X959 VSS.t2302 VDD VSS.t2301 VSS.t2300 sg13_lv_nmos ad=0.1428p pd=1.52u as=0 ps=0 w=0.42u l=1u
X960 VDD VSS.t289 VDD VDD sg13_lv_pmos ad=0.19p pd=1.38u as=0 ps=0 w=1u l=1u
X961 VDD sg13cmos5l_dfrbpq_1_1.RESET_B a_6346_14452# VDD sg13_lv_pmos ad=0.1563p pd=1.22u as=0.147p ps=1.54u w=0.42u l=0.13u
X962 VDD VSS.t520 VDD VDD sg13_lv_pmos ad=0.34p pd=2.68u as=0 ps=0 w=1u l=1u
X963 VSS.t2754 VDD VSS.t2753 VSS.t206 sg13_lv_nmos ad=0.1428p pd=1.52u as=0 ps=0 w=0.42u l=1u
X964 VSS.t2025 VDD VSS.t2027 VSS.t2026 sg13_lv_nmos ad=79.8f pd=0.8u as=0 ps=0 w=0.42u l=1u
X965 VSS.t1019 VDD VSS.t1018 VSS.t1017 sg13_lv_nmos ad=0.1428p pd=1.52u as=0 ps=0 w=0.42u l=1u
X966 VSS.t1458 VDD VSS.t1460 VSS.t1459 sg13_lv_nmos ad=79.8f pd=0.8u as=0 ps=0 w=0.42u l=1u
X967 VDD VSS.t2336 VDD VDD sg13_lv_pmos ad=0.34p pd=2.68u as=0 ps=0 w=1u l=1u
X968 VSS.t2642 VDD VSS.t2643 VSS.t206 sg13_lv_nmos ad=79.8f pd=0.8u as=0 ps=0 w=0.42u l=1u
X969 VSS.t2367 VDD VSS.t2369 VSS.t2368 sg13_lv_nmos ad=79.8f pd=0.8u as=0 ps=0 w=0.42u l=1u
X970 VSS.t404 VDD VSS.t403 VSS.t4 sg13_lv_nmos ad=0.1428p pd=1.52u as=0 ps=0 w=0.42u l=1u
X971 a_6575_13342# a_6540_13238# sg13cmos5l_dlygate4sd3_1_0.A VSS.t173 sg13_lv_nmos ad=0.1406p pd=1.12u as=0.2516p ps=2.16u w=0.74u l=0.13u
X972 VDD VSS.t1577 VDD VDD sg13_lv_pmos ad=0.34p pd=2.68u as=0 ps=0 w=1u l=1u
X973 VSS.t1945 VDD VSS.t1944 VSS.t1943 sg13_lv_nmos ad=0.1428p pd=1.52u as=0 ps=0 w=0.42u l=1u
X974 VDD VSS.t1171 VDD VDD sg13_lv_pmos ad=0.19p pd=1.38u as=0 ps=0 w=1u l=1u
X975 VDD VSS.t1942 VDD VDD sg13_lv_pmos ad=0.19p pd=1.38u as=0 ps=0 w=1u l=1u
X976 VSS.t1212 VDD VSS.t1359 VSS.t1154 sg13_lv_nmos ad=0.1428p pd=1.52u as=0 ps=0 w=0.42u l=1u
X977 VSS.t1588 VDD VSS.t1587 VSS.t1586 sg13_lv_nmos ad=0.1428p pd=1.52u as=0 ps=0 w=0.42u l=1u
X978 sg13cmos5l_o21ai_1_1.Y sg13cmos5l_or3_1_2.C a_20376_14464# VDD sg13_lv_pmos ad=0.2128p pd=1.5u as=0.2128p ps=1.5u w=1.12u l=0.15u
X979 VDD VSS.t1859 VDD VDD sg13_lv_pmos ad=0.34p pd=2.68u as=0 ps=0 w=1u l=1u
X980 VDD VSS.t1305 VDD VDD sg13_lv_pmos ad=0.34p pd=2.68u as=0 ps=0 w=1u l=1u
X981 VDD VSS.t2643 VDD VDD sg13_lv_pmos ad=0.34p pd=2.68u as=0 ps=0 w=1u l=1u
X982 VDD VSS.t2699 VDD VDD sg13_lv_pmos ad=0.34p pd=2.68u as=0 ps=0 w=1u l=1u
X983 a_12524_15960# sg13cmos5l_dlygate4sd3_1_8.A VSS.t302 VSS.t3201 sg13_lv_nmos ad=0.187p pd=1.78u as=0.14875p ps=1.16u w=0.55u l=0.13u
X984 VDD VSS.t1285 VDD VDD sg13_lv_pmos ad=0.19p pd=1.38u as=0 ps=0 w=1u l=1u
X985 VDD VSS.t2655 VDD VDD sg13_lv_pmos ad=0.19p pd=1.38u as=0 ps=0 w=1u l=1u
X986 VSS.t939 VDD VSS.t938 VSS.t937 sg13_lv_nmos ad=0.1428p pd=1.52u as=0 ps=0 w=0.42u l=1u
X987 VDD VSS.t2451 VDD VDD sg13_lv_pmos ad=0.34p pd=2.68u as=0 ps=0 w=1u l=1u
X988 VSS.t829 VDD VSS.t831 VSS.t830 sg13_lv_nmos ad=79.8f pd=0.8u as=0 ps=0 w=0.42u l=1u
X989 VSS.t1231 VDD VSS.t1230 VSS.t1154 sg13_lv_nmos ad=0.1428p pd=1.52u as=0 ps=0 w=0.42u l=1u
X990 sg13cmos5l_or3_1_1.C sg13cmos5l_dfrbpq_1_2.Q VDD VDD sg13_lv_pmos ad=0.2128p pd=1.5u as=0.3808p ps=2.92u w=1.12u l=0.13u
X991 a_24408_15552# sg13cmos5l_or3_1_2.B VDD VDD sg13_lv_pmos ad=0.2128p pd=1.5u as=0.3808p ps=2.92u w=1.12u l=0.15u
X992 VDD VSS.t620 VDD VDD sg13_lv_pmos ad=0.34p pd=2.68u as=0 ps=0 w=1u l=1u
X993 VSS.t1678 VDD VSS.t1677 VSS.t1676 sg13_lv_nmos ad=0.1428p pd=1.52u as=0 ps=0 w=0.42u l=1u
X994 VSS.t2666 VDD VSS.t2667 VSS.t206 sg13_lv_nmos ad=79.8f pd=0.8u as=0 ps=0 w=0.42u l=1u
X995 VSS.t2060 VDD VSS.t2059 VSS.t2058 sg13_lv_nmos ad=0.1428p pd=1.52u as=0 ps=0 w=0.42u l=1u
X996 VSS.t4 a_27502_15423# sg13cmos5l_or3_1_1.A VSS.t4 sg13_lv_nmos ad=0.1426p pd=1.16u as=0.2516p ps=2.16u w=0.74u l=0.13u
X997 VSS.t2766 VDD VSS.t2765 VSS.t206 sg13_lv_nmos ad=0.1428p pd=1.52u as=0 ps=0 w=0.42u l=1u
X998 VSS.t377 VDD VSS.t377 VSS.t383 sg13_lv_nmos ad=79.8f pd=0.8u as=0 ps=0 w=0.42u l=1u
X999 a_7058_15242# sg13cmos5l_xor2_1_0.B VSS.t193 VSS.t192 sg13_lv_nmos ad=0.1406p pd=1.12u as=0.2516p ps=2.16u w=0.74u l=0.13u
X1000 VSS.t1443 VDD VSS.t1445 VSS.t1444 sg13_lv_nmos ad=79.8f pd=0.8u as=0 ps=0 w=0.42u l=1u
X1001 VDD VSS.t2494 VDD VDD sg13_lv_pmos ad=0.19p pd=1.38u as=0 ps=0 w=1u l=1u
X1002 VDD VSS.t231 VDD VDD sg13_lv_pmos ad=0.34p pd=2.68u as=0 ps=0 w=1u l=1u
X1003 VSS.t506 VDD VSS.t509 VSS.t508 sg13_lv_nmos ad=79.8f pd=0.8u as=0 ps=0 w=0.42u l=1u
X1004 VSS.t1156 VDD VSS.t1155 VSS.t1154 sg13_lv_nmos ad=0.1428p pd=1.52u as=0 ps=0 w=0.42u l=1u
X1005 VDD VSS.t1899 VDD VDD sg13_lv_pmos ad=0.34p pd=2.68u as=0 ps=0 w=1u l=1u
X1006 VDD VSS.t2808 VDD VDD sg13_lv_pmos ad=0.34p pd=2.68u as=0 ps=0 w=1u l=1u
X1007 VDD VSS.t442 VDD VDD sg13_lv_pmos ad=0.34p pd=2.68u as=0 ps=0 w=1u l=1u
X1008 a_25862_13722# sg13cmos5l_dfrbpq_1_5.D VDD VDD sg13_lv_pmos ad=79.8f pd=0.8u as=0.1428p ps=1.52u w=0.42u l=0.13u
X1009 VSS.t1267 VDD VSS.t1268 VSS.t1154 sg13_lv_nmos ad=79.8f pd=0.8u as=0 ps=0 w=0.42u l=1u
X1010 VSS.t1188 VDD VSS.t1189 VSS.t1154 sg13_lv_nmos ad=79.8f pd=0.8u as=0 ps=0 w=0.42u l=1u
X1011 VDD VSS.t1927 VDD VDD sg13_lv_pmos ad=0.19p pd=1.38u as=0 ps=0 w=1u l=1u
X1012 a_7822_13911# a_7937_13912# VDD VDD sg13_lv_pmos ad=0.34p pd=2.68u as=0.2254p ps=1.53u w=1u l=0.5u
X1013 VDD VSS.t1162 VDD VDD sg13_lv_pmos ad=0.19p pd=1.38u as=0 ps=0 w=1u l=1u
X1014 VDD VSS.t2281 VDD VDD sg13_lv_pmos ad=0.34p pd=2.68u as=0 ps=0 w=1u l=1u
X1015 a_6286_13911# a_6401_13912# VDD VDD sg13_lv_pmos ad=0.34p pd=2.68u as=0.2254p ps=1.53u w=1u l=0.5u
X1016 VSS.t617 VDD VSS.t617 VSS.t618 sg13_lv_nmos ad=79.8f pd=0.8u as=0 ps=0 w=0.42u l=1u
X1017 VDD VSS.t1031 VDD VDD sg13_lv_pmos ad=0.19p pd=1.38u as=0 ps=0 w=1u l=1u
X1018 VDD VSS.t1582 VDD VDD sg13_lv_pmos ad=0.34p pd=2.68u as=0 ps=0 w=1u l=1u
X1019 a_26249_16334# a_26373_16033# VDD VDD sg13_lv_pmos ad=0.2442p pd=2.06u as=2.8961p ps=18.25u w=0.66u l=0.13u
X1020 VSS.t1473 VDD VSS.t1472 VSS.t1471 sg13_lv_nmos ad=0.1428p pd=1.52u as=0 ps=0 w=0.42u l=1u
X1021 VSS.t1890 VDD VSS.t1889 VSS.t1888 sg13_lv_nmos ad=0.1428p pd=1.52u as=0 ps=0 w=0.42u l=1u
X1022 VSS.t372 VDD VSS.t372 VSS.t373 sg13_lv_nmos ad=79.8f pd=0.8u as=0 ps=0 w=0.42u l=1u
X1023 VSS.t431 VDD VSS.t432 VSS.t4 sg13_lv_nmos ad=79.8f pd=0.8u as=0 ps=0 w=0.42u l=1u
X1024 VDD VSS.t3016 VDD VDD sg13_lv_pmos ad=0.19p pd=1.38u as=0 ps=0 w=1u l=1u
X1025 VSS.t2651 VDD VSS.t2650 VSS.t206 sg13_lv_nmos ad=0.1428p pd=1.52u as=0 ps=0 w=0.42u l=1u
X1026 VSS.t2382 VDD VSS.t2381 VSS.t2380 sg13_lv_nmos ad=0.1428p pd=1.52u as=0 ps=0 w=0.42u l=1u
X1027 a_12010_15202# sg13cmos5l_buf_8_2.A VSS.t147 VSS.t148 sg13_lv_nmos ad=0.2553p pd=2.17u as=0.1406p ps=1.12u w=0.74u l=0.13u
X1028 VSS.t681 VDD VSS.t44 VSS.t680 sg13_lv_nmos ad=0.1428p pd=1.52u as=0 ps=0 w=0.42u l=1u
X1029 VSS.t2710 VDD VSS.t2711 VSS.t206 sg13_lv_nmos ad=79.8f pd=0.8u as=0 ps=0 w=0.42u l=1u
X1030 VDD a_14261_15238# sg13cmos5l_or3_1_1.B VDD sg13_lv_pmos ad=0.2128p pd=1.5u as=0.2128p ps=1.5u w=1.12u l=0.13u
X1031 VDD VSS.t958 VDD VDD sg13_lv_pmos ad=0.34p pd=2.68u as=0 ps=0 w=1u l=1u
X1032 VSS.t69 VDD VSS.t69 VSS.t287 sg13_lv_nmos ad=79.8f pd=0.8u as=0 ps=0 w=0.42u l=1u
X1033 VSS.t541 VDD VSS.t540 VSS.t539 sg13_lv_nmos ad=0.1428p pd=1.52u as=0 ps=0 w=0.42u l=1u
X1034 VDD VSS.t1440 VDD VDD sg13_lv_pmos ad=0.19p pd=1.38u as=0 ps=0 w=1u l=1u
X1035 VDD VSS.t273 VDD VDD sg13_lv_pmos ad=0.34p pd=2.68u as=0 ps=0 w=1u l=1u
X1036 a_9737_14822# a_9861_14521# VDD VDD sg13_lv_pmos ad=0.2442p pd=2.06u as=2.42015p ps=15.68u w=0.66u l=0.13u
X1037 a_17604_14488# a_17578_14452# VDD VDD sg13_lv_pmos ad=0.34p pd=2.68u as=0.36237p ps=2.605u w=1u l=0.13u
X1038 VDD VSS.t520 VDD VDD sg13_lv_pmos ad=0.34p pd=2.68u as=0 ps=0 w=1u l=1u
X1039 VDD VSS.t2622 VDD VDD sg13_lv_pmos ad=0.19p pd=1.38u as=0 ps=0 w=1u l=1u
X1040 sg13cmos5l_dfrbpq_1_3.D a_17238_15302# VDD VDD sg13_lv_pmos ad=0.4256p pd=3u as=0.2254p ps=1.53u w=1.12u l=0.13u
X1041 VDD a_27472_14726# a_27417_14607# VDD sg13_lv_pmos ad=2.42015p pd=15.68u as=93.45f ps=0.865u w=0.42u l=0.13u
X1042 a_19323_13726# sg13cmos5l_buf_8_2.A VSS.t150 VSS.t151 sg13_lv_nmos ad=0.1406p pd=1.12u as=0.1406p ps=1.12u w=0.74u l=0.13u
X1043 VSS.t2924 VDD VSS.t2923 VSS.t2922 sg13_lv_nmos ad=0.1428p pd=1.52u as=0 ps=0 w=0.42u l=1u
X1044 VSS.t713 VDD VSS.t590 VSS.t714 sg13_lv_nmos ad=79.8f pd=0.8u as=0 ps=0 w=0.42u l=1u
X1045 VDD VSS.t1292 VDD VDD sg13_lv_pmos ad=0.34p pd=2.68u as=0 ps=0 w=1u l=1u
X1046 VSS.t1573 VDD VSS.t1575 VSS.t1574 sg13_lv_nmos ad=79.8f pd=0.8u as=0 ps=0 w=0.42u l=1u
X1047 VSS.t3094 VDD VSS.t3096 VSS.t3095 sg13_lv_nmos ad=79.8f pd=0.8u as=0 ps=0 w=0.42u l=1u
X1048 VSS.t1249 VDD VSS.t1248 VSS.t1154 sg13_lv_nmos ad=0.1428p pd=1.52u as=0 ps=0 w=0.42u l=1u
X1049 VSS.t1170 VDD VSS.t1169 VSS.t1154 sg13_lv_nmos ad=0.1428p pd=1.52u as=0 ps=0 w=0.42u l=1u
X1050 VSS.t1965 VDD VSS.t1964 VSS.t1963 sg13_lv_nmos ad=0.1428p pd=1.52u as=0 ps=0 w=0.42u l=1u
X1051 VDD VSS.t833 VDD VDD sg13_lv_pmos ad=0.34p pd=2.68u as=0 ps=0 w=1u l=1u
X1052 VSS.t1281 VDD VSS.t1282 VSS.t1154 sg13_lv_nmos ad=79.8f pd=0.8u as=0 ps=0 w=0.42u l=1u
X1053 VSS.t2633 VDD VSS.t2634 VSS.t206 sg13_lv_nmos ad=79.8f pd=0.8u as=0 ps=0 w=0.42u l=1u
X1054 VDD VSS.t1919 VDD VDD sg13_lv_pmos ad=0.34p pd=2.68u as=0 ps=0 w=1u l=1u
X1055 VDD VSS.t2104 VDD VDD sg13_lv_pmos ad=0.34p pd=2.68u as=0 ps=0 w=1u l=1u
X1056 VSS.t2497 VDD VSS.t2499 VSS.t2498 sg13_lv_nmos ad=79.8f pd=0.8u as=0 ps=0 w=0.42u l=1u
X1057 VDD VSS.t1602 VDD VDD sg13_lv_pmos ad=0.34p pd=2.68u as=0 ps=0 w=1u l=1u
X1058 VDD VSS.t2634 VDD VDD sg13_lv_pmos ad=0.34p pd=2.68u as=0 ps=0 w=1u l=1u
X1059 sg13cmos5l_buf_8_2.A a_15579_14854# VDD VDD sg13_lv_pmos ad=0.2128p pd=1.5u as=0.2128p ps=1.5u w=1.12u l=0.13u
X1060 VSS.t728 VDD VSS.t187 VSS.t729 sg13_lv_nmos ad=79.8f pd=0.8u as=0 ps=0 w=0.42u l=1u
X1061 VSS.t1875 VDD VSS.t1874 VSS.t1873 sg13_lv_nmos ad=0.1428p pd=1.52u as=0 ps=0 w=0.42u l=1u
X1062 VSS.t939 VDD VSS.t938 VSS.t937 sg13_lv_nmos ad=0.1428p pd=1.52u as=0 ps=0 w=0.42u l=1u
X1063 counter_value_o[3] a_16552_15996# VSS.t11 VSS.t10 sg13_lv_nmos ad=0.2886p pd=2.26u as=0.14875p ps=1.16u w=0.74u l=0.13u
X1064 a_26757_16033# a_26757_16033# VSS.t7 VSS.t3275 sg13_lv_nmos ad=0.111p pd=1.34u as=7.70437p ps=50.66u w=0.3u l=0.13u
X1065 VDD VSS.t2744 VDD VDD sg13_lv_pmos ad=0.34p pd=2.68u as=0 ps=0 w=1u l=1u
X1066 VSS.t2686 VDD VSS.t2686 VSS.t206 sg13_lv_nmos ad=0.1428p pd=1.52u as=0 ps=0 w=0.42u l=1u
X1067 VDD VSS.t576 VDD VDD sg13_lv_pmos ad=0.19p pd=1.38u as=0 ps=0 w=1u l=1u
X1068 VSS.t103 VDD VSS.t103 VSS.t517 sg13_lv_nmos ad=0.1428p pd=1.52u as=0 ps=0 w=0.42u l=1u
X1069 VSS.t699 VDD VSS.t699 VSS.t698 sg13_lv_nmos ad=0.1428p pd=1.52u as=0 ps=0 w=0.42u l=1u
X1070 VSS.t2757 VDD VSS.t2756 VSS.t206 sg13_lv_nmos ad=0.1428p pd=1.52u as=0 ps=0 w=0.42u l=1u
X1071 VSS.t2030 VDD VSS.t2032 VSS.t2031 sg13_lv_nmos ad=79.8f pd=0.8u as=0 ps=0 w=0.42u l=1u
X1072 VDD VSS.t302 VDD VDD sg13_lv_pmos ad=0.34p pd=2.68u as=0 ps=0 w=1u l=1u
X1073 VDD VSS.t988 VDD VDD sg13_lv_pmos ad=0.34p pd=2.68u as=0 ps=0 w=1u l=1u
X1074 VSS.t1263 VDD VSS.t1262 VSS.t1154 sg13_lv_nmos ad=0.1428p pd=1.52u as=0 ps=0 w=0.42u l=1u
X1075 VDD VSS.t1198 VDD VDD sg13_lv_pmos ad=0.19p pd=1.38u as=0 ps=0 w=1u l=1u
X1076 VDD VSS.t2695 VDD VDD sg13_lv_pmos ad=0.19p pd=1.38u as=0 ps=0 w=1u l=1u
X1077 VSS.t2367 VDD VSS.t2366 VSS.t2365 sg13_lv_nmos ad=0.1428p pd=1.52u as=0 ps=0 w=0.42u l=1u
X1078 VDD VSS.t796 VDD VDD sg13_lv_pmos ad=0.19p pd=1.38u as=0 ps=0 w=1u l=1u
X1079 VDD VSS.t2306 VDD VDD sg13_lv_pmos ad=0.34p pd=2.68u as=0 ps=0 w=1u l=1u
X1080 VDD VSS.t2479 VDD VDD sg13_lv_pmos ad=0.19p pd=1.38u as=0 ps=0 w=1u l=1u
X1081 VDD VSS.t605 VDD VDD sg13_lv_pmos ad=0.34p pd=2.68u as=0 ps=0 w=1u l=1u
X1082 VDD VSS.t1234 VDD VDD sg13_lv_pmos ad=0.19p pd=1.38u as=0 ps=0 w=1u l=1u
X1083 VSS.t323 VDD VSS.t79 VSS.t322 sg13_lv_nmos ad=0.1428p pd=1.52u as=0 ps=0 w=0.42u l=1u
X1084 VDD VSS.t2431 VDD VDD sg13_lv_pmos ad=0.34p pd=2.68u as=0 ps=0 w=1u l=1u
X1085 VDD VSS.t1912 VDD VDD sg13_lv_pmos ad=0.19p pd=1.38u as=0 ps=0 w=1u l=1u
X1086 VSS.t1915 VDD VSS.t1914 VSS.t1913 sg13_lv_nmos ad=0.1428p pd=1.52u as=0 ps=0 w=0.42u l=1u
X1087 VDD VSS.t2089 VDD VDD sg13_lv_pmos ad=0.34p pd=2.68u as=0 ps=0 w=1u l=1u
X1088 VDD VSS.t459 VDD VDD sg13_lv_pmos ad=0.34p pd=2.68u as=0 ps=0 w=1u l=1u
X1089 VDD VSS.t2266 VDD VDD sg13_lv_pmos ad=0.34p pd=2.68u as=0 ps=0 w=1u l=1u
X1090 VSS.t1024 VDD VSS.t1023 VSS.t1022 sg13_lv_nmos ad=0.1428p pd=1.52u as=0 ps=0 w=0.42u l=1u
X1091 VDD VSS.t2646 VDD VDD sg13_lv_pmos ad=0.34p pd=2.68u as=0 ps=0 w=1u l=1u
X1092 VDD VSS.t533 VDD VDD sg13_lv_pmos ad=0.19p pd=1.38u as=0 ps=0 w=1u l=1u
X1093 VSS.t1299 VDD VSS.t1300 VSS.t1154 sg13_lv_nmos ad=79.8f pd=0.8u as=0 ps=0 w=0.42u l=1u
X1094 VDD VSS.t2037 VDD VDD sg13_lv_pmos ad=0.19p pd=1.38u as=0 ps=0 w=1u l=1u
X1095 a_17063_16020# sg13cmos5l_or3_1_2.B a_16969_16020# VDD sg13_lv_pmos ad=0.19p pd=1.38u as=0.34p ps=2.68u w=1u l=0.13u
X1096 VDD sg13cmos5l_dlygate4sd3_1_4.X sg13cmos5l_dlygate4sd3_1_5.A VDD sg13_lv_pmos ad=0.3808p pd=2.92u as=0.2128p ps=1.5u w=1.12u l=0.15u
X1097 VSS.t47 a_19450_15202# a_19169_15424# VSS.t107 sg13_lv_nmos ad=79.8f pd=0.8u as=0.1428p ps=1.52u w=0.42u l=0.5u
X1098 VDD VSS.t888 VDD VDD sg13_lv_pmos ad=0.34p pd=2.68u as=0 ps=0 w=1u l=1u
X1099 VDD VSS.t1160 VDD VDD sg13_lv_pmos ad=0.19p pd=1.38u as=0 ps=0 w=1u l=1u
X1100 VSS.t41 a_4175_15311# a_4842_15532# VSS.t40 sg13_lv_nmos ad=0.1406p pd=1.12u as=0.2516p ps=2.16u w=0.74u l=0.13u
X1101 sg13cmos5l_xnor2_1_0.Y sg13cmos5l_nand3_1_0.Y a_7923_15532# VDD sg13_lv_pmos ad=0.2408p pd=1.55u as=0.1428p ps=1.375u w=1.12u l=0.13u
X1102 VDD VSS.t866 VDD VDD sg13_lv_pmos ad=0.19p pd=1.38u as=0 ps=0 w=1u l=1u
X1103 VSS.t2642 VDD VSS.t2640 VSS.t206 sg13_lv_nmos ad=0.1428p pd=1.52u as=0 ps=0 w=0.42u l=1u
X1104 VDD VSS.t2658 VDD VDD sg13_lv_pmos ad=0.19p pd=1.38u as=0 ps=0 w=1u l=1u
X1105 VSS.t2701 VDD VSS.t2702 VSS.t206 sg13_lv_nmos ad=79.8f pd=0.8u as=0 ps=0 w=0.42u l=1u
X1106 VDD a_8582_15238# a_8694_15302# VDD sg13_lv_pmos ad=0.2254p pd=1.53u as=0.34p ps=2.68u w=1u l=0.5u
X1107 VDD VSS.t2888 VDD VDD sg13_lv_pmos ad=0.34p pd=2.68u as=0 ps=0 w=1u l=1u
X1108 VDD sg13cmos5l_xor2_1_0.X a_1965_14832# VDD sg13_lv_pmos ad=0.1918p pd=1.5u as=0.1596p ps=1.22u w=0.84u l=0.13u
X1109 VSS.t605 VDD VSS.t608 VSS.t741 sg13_lv_nmos ad=79.8f pd=0.8u as=0 ps=0 w=0.42u l=1u
X1110 a_17318_14922# sg13cmos5l_dfrbpq_1_3.D VDD VDD sg13_lv_pmos ad=79.8f pd=0.8u as=0.1428p ps=1.52u w=0.42u l=0.13u
X1111 VDD VSS.t763 VDD VDD sg13_lv_pmos ad=0.34p pd=2.68u as=0 ps=0 w=1u l=1u
X1112 VDD VSS.t951 VDD VDD sg13_lv_pmos ad=0.19p pd=1.38u as=0 ps=0 w=1u l=1u
X1113 VSS.t2909 VDD VSS.t2908 VSS.t2907 sg13_lv_nmos ad=0.1428p pd=1.52u as=0 ps=0 w=0.42u l=1u
X1114 VSS.t1039 VDD VSS.t1038 VSS.t1037 sg13_lv_nmos ad=0.1428p pd=1.52u as=0 ps=0 w=0.42u l=1u
X1115 VSS.t1425 VDD VSS.t1309 VSS.t1154 sg13_lv_nmos ad=79.8f pd=0.8u as=0 ps=0 w=0.42u l=1u
X1116 VDD VSS.t2464 VDD VDD sg13_lv_pmos ad=0.19p pd=1.38u as=0 ps=0 w=1u l=1u
X1117 VSS.t11 a_17710_16263# sg13cmos5l_a21oi_1_0.A1 VSS.t265 sg13_lv_nmos ad=0.1426p pd=1.16u as=0.2516p ps=2.16u w=0.74u l=0.13u
X1118 VSS.t9 a_25094_14484# a_25206_14508# VSS.t8 sg13_lv_nmos ad=0.1426p pd=1.16u as=0.1428p ps=1.52u w=0.42u l=0.5u
X1119 sg13cmos5l_or3_1_1.X a_24841_13726# VSS.t60 VSS.t250 sg13_lv_nmos ad=0.2516p pd=2.16u as=0.13395p ps=1.12u w=0.74u l=0.13u
X1120 VDD VSS.t1904 VDD VDD sg13_lv_pmos ad=0.34p pd=2.68u as=0 ps=0 w=1u l=1u
X1121 VDD VSS.t2670 VDD VDD sg13_lv_pmos ad=0.34p pd=2.68u as=0 ps=0 w=1u l=1u
X1122 sg13cmos5l_dfrbpq_1_2.D sg13cmos5l_nor2_1_0.B a_15338_14484# VDD sg13_lv_pmos ad=0.3808p pd=2.92u as=0.1176p ps=1.33u w=1.12u l=0.13u
X1123 VSS.t456 VDD VSS.t144 VSS.t455 sg13_lv_nmos ad=0.1428p pd=1.52u as=0 ps=0 w=0.42u l=1u
X1124 VDD VSS.t1165 VDD VDD sg13_lv_pmos ad=0.19p pd=1.38u as=0 ps=0 w=1u l=1u
X1125 a_25109_12972# sg13cmos5l_a21oi_1_3.A1 VDD VDD sg13_lv_pmos ad=0.2128p pd=1.5u as=0.2128p ps=1.5u w=1.12u l=0.13u
X1126 VSS.t1578 VDD VSS.t1577 VSS.t1576 sg13_lv_nmos ad=0.1428p pd=1.52u as=0 ps=0 w=0.42u l=1u
X1127 VSS.t3099 VDD VSS.t3098 VSS.t3097 sg13_lv_nmos ad=0.1428p pd=1.52u as=0 ps=0 w=0.42u l=1u
X1128 VDD VSS.t2251 VDD VDD sg13_lv_pmos ad=0.34p pd=2.68u as=0 ps=0 w=1u l=1u
X1129 VSS.t2482 VDD VSS.t2484 VSS.t2483 sg13_lv_nmos ad=79.8f pd=0.8u as=0 ps=0 w=0.42u l=1u
X1130 VDD VSS.t509 VDD VDD sg13_lv_pmos ad=0.34p pd=2.68u as=0 ps=0 w=1u l=1u
X1131 VDD VSS.t1587 VDD VDD sg13_lv_pmos ad=0.34p pd=2.68u as=0 ps=0 w=1u l=1u
X1132 VSS.t153 a_19323_13726# sg13cmos5l_buf_8_2.X VSS.t3248 sg13_lv_nmos ad=0.1406p pd=1.12u as=0.1406p ps=1.12u w=0.74u l=0.13u
X1133 VDD VSS.t1252 VDD VDD sg13_lv_pmos ad=0.19p pd=1.38u as=0 ps=0 w=1u l=1u
X1134 VSS.t1478 VDD VSS.t1477 VSS.t1476 sg13_lv_nmos ad=0.1428p pd=1.52u as=0 ps=0 w=0.42u l=1u
X1135 VSS.t2387 VDD VSS.t2386 VSS.t2385 sg13_lv_nmos ad=0.1428p pd=1.52u as=0 ps=0 w=0.42u l=1u
X1136 VSS.t1860 VDD VSS.t1859 VSS.t1858 sg13_lv_nmos ad=0.1428p pd=1.52u as=0 ps=0 w=0.42u l=1u
X1137 VSS.t1648 VDD VSS.t1650 VSS.t1649 sg13_lv_nmos ad=79.8f pd=0.8u as=0 ps=0 w=0.42u l=1u
X1138 VSS.t1201 VDD VSS.t1202 VSS.t1154 sg13_lv_nmos ad=79.8f pd=0.8u as=0 ps=0 w=0.42u l=1u
X1139 VDD VSS.t1959 VDD VDD sg13_lv_pmos ad=0.34p pd=2.68u as=0 ps=0 w=1u l=1u
X1140 VDD VSS.t2735 VDD VDD sg13_lv_pmos ad=0.34p pd=2.68u as=0 ps=0 w=1u l=1u
X1141 VSS.t2352 VDD VSS.t2354 VSS.t2353 sg13_lv_nmos ad=79.8f pd=0.8u as=0 ps=0 w=0.42u l=1u
X1142 VDD VSS.t3081 VDD VDD sg13_lv_pmos ad=0.19p pd=1.38u as=0 ps=0 w=1u l=1u
X1143 a_16485_13701# sg13cmos5l_dfrbpq_1_2.CLK VDD VDD sg13_lv_pmos ad=0.4088p pd=2.97u as=2.3367p ps=15.135u w=1.12u l=0.13u
X1144 VDD VSS.t918 VDD VDD sg13_lv_pmos ad=0.34p pd=2.68u as=0 ps=0 w=1u l=1u
X1145 VSS.t2660 VDD VSS.t2661 VSS.t206 sg13_lv_nmos ad=79.8f pd=0.8u as=0 ps=0 w=0.42u l=1u
X1146 VDD VSS.t2625 VDD VDD sg13_lv_pmos ad=0.19p pd=1.38u as=0 ps=0 w=1u l=1u
X1147 VDD VSS.t330 VDD VDD sg13_lv_pmos ad=0.19p pd=1.38u as=0 ps=0 w=1u l=1u
X1148 VSS.t1290 VDD VSS.t1289 VSS.t1154 sg13_lv_nmos ad=0.1428p pd=1.52u as=0 ps=0 w=0.42u l=1u
X1149 VSS.t2894 VDD VSS.t2893 VSS.t2892 sg13_lv_nmos ad=0.1428p pd=1.52u as=0 ps=0 w=0.42u l=1u
X1150 VDD a_4474_14448# a_4193_14750# VDD sg13_lv_pmos ad=0.1523p pd=1.38u as=0.34p ps=2.68u w=1u l=0.5u
X1151 VDD VSS.t1295 VDD VDD sg13_lv_pmos ad=0.34p pd=2.68u as=0 ps=0 w=1u l=1u
X1152 VDD VSS.t2291 VDD VDD sg13_lv_pmos ad=0.34p pd=2.68u as=0 ps=0 w=1u l=1u
X1153 VDD VSS.t2661 VDD VDD sg13_lv_pmos ad=0.34p pd=2.68u as=0 ps=0 w=1u l=1u
X1154 VDD sg13cmos5l_buf_1_0.X a_2942_14484# VDD sg13_lv_pmos ad=0.36p pd=2.72u as=0.1225p ps=1.245u w=1u l=0.13u
X1155 a_6540_13238# sg13cmos5l_xnor2_1_2.B VDD VDD sg13_lv_pmos ad=0.1596p pd=1.22u as=0.2891p ps=1.695u w=0.84u l=0.13u
X1156 VSS.t1024 VDD VSS.t1023 VSS.t1022 sg13_lv_nmos ad=0.1428p pd=1.52u as=0 ps=0 w=0.42u l=1u
X1157 VDD VSS.t2416 VDD VDD sg13_lv_pmos ad=0.34p pd=2.68u as=0 ps=0 w=1u l=1u
X1158 VDD VSS.t599 VDD VDD sg13_lv_pmos ad=0.34p pd=2.68u as=0 ps=0 w=1u l=1u
X1159 VDD VSS.t2074 VDD VDD sg13_lv_pmos ad=0.34p pd=2.68u as=0 ps=0 w=1u l=1u
X1160 VDD VSS.t533 VDD VDD sg13_lv_pmos ad=0.19p pd=1.38u as=0 ps=0 w=1u l=1u
X1161 VDD VSS.t2637 VDD VDD sg13_lv_pmos ad=0.34p pd=2.68u as=0 ps=0 w=1u l=1u
X1162 VDD VSS.t933 VDD VDD sg13_lv_pmos ad=0.34p pd=2.68u as=0 ps=0 w=1u l=1u
X1163 a_21034_14452# a_21477_14495# a_20774_14922# VSS.t3280 sg13_lv_nmos ad=79.8f pd=0.8u as=0.1296p ps=1.52u w=0.42u l=0.13u
X1164 VDD VSS.t2747 VDD VDD sg13_lv_pmos ad=0.34p pd=2.68u as=0 ps=0 w=1u l=1u
X1165 VDD VSS.t1172 VDD VDD sg13_lv_pmos ad=0.34p pd=2.68u as=0 ps=0 w=1u l=1u
X1166 VSS.t2689 VDD VSS.t2688 VSS.t206 sg13_lv_nmos ad=0.1428p pd=1.52u as=0 ps=0 w=0.42u l=1u
X1167 VSS.t1438 VDD VSS.t1440 VSS.t1439 sg13_lv_nmos ad=79.8f pd=0.8u as=0 ps=0 w=0.42u l=1u
X1168 VSS.t1039 VDD VSS.t1038 VSS.t1037 sg13_lv_nmos ad=0.1428p pd=1.52u as=0 ps=0 w=0.42u l=1u
X1169 sg13cmos5l_a21oi_1_3.A2 a_24169_14508# VSS.t3220 VSS.t8 sg13_lv_nmos ad=0.2516p pd=2.16u as=0.13395p ps=1.12u w=0.74u l=0.13u
X1170 VDD VSS.t996 VDD VDD sg13_lv_pmos ad=0.19p pd=1.38u as=0 ps=0 w=1u l=1u
X1171 VSS.t944 VDD VSS.t946 VSS.t945 sg13_lv_nmos ad=79.8f pd=0.8u as=0 ps=0 w=0.42u l=1u
X1172 VDD reset_n_i a_1192_9948# VDD sg13_lv_pmos ad=0.2114p pd=1.54u as=0.2856p ps=2.36u w=0.84u l=0.13u
X1173 VDD VSS.t1570 VDD VDD sg13_lv_pmos ad=0.19p pd=1.38u as=0 ps=0 w=1u l=1u
X1174 VSS.t2739 VDD VSS.t2737 VSS.t206 sg13_lv_nmos ad=0.1428p pd=1.52u as=0 ps=0 w=0.42u l=1u
X1175 VSS.t2000 VDD VSS.t2002 VSS.t2001 sg13_lv_nmos ad=79.8f pd=0.8u as=0 ps=0 w=0.42u l=1u
X1176 VSS.t410 VDD VSS.t411 VSS.t4 sg13_lv_nmos ad=79.8f pd=0.8u as=0 ps=0 w=0.42u l=1u
X1177 VDD VSS.t2311 VDD VDD sg13_lv_pmos ad=0.34p pd=2.68u as=0 ps=0 w=1u l=1u
X1178 a_16969_16020# sg13cmos5l_inv_1_0.Y VSS.t11 VSS.t3224 sg13_lv_nmos ad=0.198p pd=1.27u as=0.1045p ps=0.93u w=0.55u l=0.13u
X1179 VDD VSS.t352 VDD VDD sg13_lv_pmos ad=0.34p pd=2.68u as=0 ps=0 w=1u l=1u
X1180 VSS.t541 VDD VSS.t540 VSS.t539 sg13_lv_nmos ad=0.1428p pd=1.52u as=0 ps=0 w=0.42u l=1u
X1181 VDD VSS.t1575 VDD VDD sg13_lv_pmos ad=0.19p pd=1.38u as=0 ps=0 w=1u l=1u
X1182 VDD VSS.t121 VDD VDD sg13_lv_pmos ad=0.34p pd=2.68u as=0 ps=0 w=1u l=1u
X1183 VSS.t1920 VDD VSS.t1919 VSS.t1918 sg13_lv_nmos ad=0.1428p pd=1.52u as=0 ps=0 w=0.42u l=1u
X1184 a_25774_15423# a_25889_15424# VDD VDD sg13_lv_pmos ad=0.34p pd=2.68u as=0.2254p ps=1.53u w=1u l=0.5u
X1185 VDD VSS.t1317 VDD VDD sg13_lv_pmos ad=0.34p pd=2.68u as=0 ps=0 w=1u l=1u
X1186 VDD VSS.t2632 VDD VDD sg13_lv_pmos ad=0.34p pd=2.68u as=0 ps=0 w=1u l=1u
X1187 VDD VSS.t509 VDD VDD sg13_lv_pmos ad=0.34p pd=2.68u as=0 ps=0 w=1u l=1u
X1188 a_18552_15976# sg13cmos5l_inv_1_0.Y VDD VDD sg13_lv_pmos ad=0.2128p pd=1.5u as=0.3808p ps=2.92u w=1.12u l=0.15u
X1189 VSS.t356 VDD VSS.t356 VSS.t357 sg13_lv_nmos ad=79.8f pd=0.8u as=0 ps=0 w=0.42u l=1u
X1190 VSS.t1658 VDD VSS.t1657 VSS.t1656 sg13_lv_nmos ad=0.1428p pd=1.52u as=0 ps=0 w=0.42u l=1u
X1191 VSS.t1463 VDD VSS.t1462 VSS.t1461 sg13_lv_nmos ad=0.1428p pd=1.52u as=0 ps=0 w=0.42u l=1u
X1192 VSS.t2372 VDD VSS.t2371 VSS.t2370 sg13_lv_nmos ad=0.1428p pd=1.52u as=0 ps=0 w=0.42u l=1u
X1193 VSS.t2645 VDD VSS.t2644 VSS.t206 sg13_lv_nmos ad=0.1428p pd=1.52u as=0 ps=0 w=0.42u l=1u
X1194 VDD VSS.t76 VDD VDD sg13_lv_pmos ad=0.19p pd=1.38u as=0 ps=0 w=1u l=1u
X1195 VSS.t2704 VDD VSS.t2705 VSS.t206 sg13_lv_nmos ad=79.8f pd=0.8u as=0 ps=0 w=0.42u l=1u
X1196 VSS.t2954 VDD VSS.t2953 VSS.t2952 sg13_lv_nmos ad=0.1428p pd=1.52u as=0 ps=0 w=0.42u l=1u
X1197 a_22319_14845# a_21477_14495# a_21060_14488# VDD sg13_lv_pmos ad=0.2048p pd=1.63u as=0.34p ps=2.68u w=1u l=0.13u
X1198 VSS.t2337 VDD VSS.t2339 VSS.t2338 sg13_lv_nmos ad=79.8f pd=0.8u as=0 ps=0 w=0.42u l=1u
X1199 VDD VSS.t3066 VDD VDD sg13_lv_pmos ad=0.19p pd=1.38u as=0 ps=0 w=1u l=1u
X1200 VDD VSS.t2279 VDD VDD sg13_lv_pmos ad=0.19p pd=1.38u as=0 ps=0 w=1u l=1u
X1201 a_24062_15242# sg13cmos5l_dfrbpq_1_6.Q a_23960_15242# VSS.t57 sg13_lv_nmos ad=0.1406p pd=1.12u as=0.1406p ps=1.12u w=0.74u l=0.13u
X1202 VSS.t1653 VDD VSS.t1652 VSS.t1651 sg13_lv_nmos ad=0.1428p pd=1.52u as=0 ps=0 w=0.42u l=1u
X1203 VDD VSS.t966 VDD VDD sg13_lv_pmos ad=0.19p pd=1.38u as=0 ps=0 w=1u l=1u
X1204 VDD VSS.t3018 VDD VDD sg13_lv_pmos ad=0.34p pd=2.68u as=0 ps=0 w=1u l=1u
X1205 VSS.t2751 VDD VSS.t2750 VSS.t206 sg13_lv_nmos ad=0.1428p pd=1.52u as=0 ps=0 w=0.42u l=1u
X1206 VSS.t2651 VDD VSS.t2652 VSS.t206 sg13_lv_nmos ad=79.8f pd=0.8u as=0 ps=0 w=0.42u l=1u
X1207 VDD VSS.t2617 VDD VDD sg13_lv_pmos ad=0.19p pd=1.38u as=0 ps=0 w=1u l=1u
X1208 a_8779_14832# sg13cmos5l_buf_1_10.X a_8685_14832# VSS.t119 sg13_lv_nmos ad=0.1216p pd=1.02u as=0.2176p ps=1.96u w=0.64u l=0.13u
X1209 VDD VSS.t1205 VDD VDD sg13_lv_pmos ad=0.19p pd=1.38u as=0 ps=0 w=1u l=1u
X1210 VDD VSS.t1286 VDD VDD sg13_lv_pmos ad=0.34p pd=2.68u as=0 ps=0 w=1u l=1u
X1211 VDD VSS.t2469 VDD VDD sg13_lv_pmos ad=0.19p pd=1.38u as=0 ps=0 w=1u l=1u
X1212 VDD VSS.t2652 VDD VDD sg13_lv_pmos ad=0.34p pd=2.68u as=0 ps=0 w=1u l=1u
X1213 VSS.t1955 VDD VSS.t1954 VSS.t1953 sg13_lv_nmos ad=0.1428p pd=1.52u as=0 ps=0 w=0.42u l=1u
X1214 VDD VSS.t1909 VDD VDD sg13_lv_pmos ad=0.34p pd=2.68u as=0 ps=0 w=1u l=1u
X1215 a_15579_14854# clock_i VSS.t16 VSS.t3234 sg13_lv_nmos ad=0.1406p pd=1.12u as=0.1406p ps=1.12u w=0.74u l=0.13u
X1216 VSS.t157 sg13cmos5l_dfrbpq_1_6.RESET_B a_20868_14922# VSS.t3270 sg13_lv_nmos ad=0.1626p pd=1.415u as=60.89999f ps=0.71u w=0.42u l=0.13u
X1217 VSS.t509 VDD VSS.t509 VSS.t510 sg13_lv_nmos ad=0.1428p pd=1.52u as=0 ps=0 w=0.42u l=1u
X1218 a_17578_14452# a_18021_14495# a_17318_14922# VSS.t45 sg13_lv_nmos ad=79.8f pd=0.8u as=0.1296p ps=1.52u w=0.42u l=0.13u
X1219 VSS.t2487 VDD VSS.t2489 VSS.t2488 sg13_lv_nmos ad=79.8f pd=0.8u as=0 ps=0 w=0.42u l=1u
X1220 a_25956_14488# a_25930_14452# VSS.t3 VSS.t236 sg13_lv_nmos ad=0.2516p pd=2.16u as=0.1626p ps=1.415u w=0.74u l=0.13u
X1221 VSS.t443 VDD VSS.t444 VSS.t4 sg13_lv_nmos ad=79.8f pd=0.8u as=0 ps=0 w=0.42u l=1u
X1222 VDD VSS.t841 VDD VDD sg13_lv_pmos ad=0.19p pd=1.38u as=0 ps=0 w=1u l=1u
X1223 VDD VSS.t2429 VDD VDD sg13_lv_pmos ad=0.19p pd=1.38u as=0 ps=0 w=1u l=1u
X1224 VSS.t1242 VDD VSS.t1241 VSS.t1154 sg13_lv_nmos ad=0.1428p pd=1.52u as=0 ps=0 w=0.42u l=1u
X1225 VSS.t1448 VDD VSS.t1447 VSS.t1446 sg13_lv_nmos ad=0.1428p pd=1.52u as=0 ps=0 w=0.42u l=1u
X1226 VSS.t349 VDD VSS.t349 VSS.t348 sg13_lv_nmos ad=0.1428p pd=1.52u as=0 ps=0 w=0.42u l=1u
X1227 VDD VSS.t278 VDD VDD sg13_lv_pmos ad=0.34p pd=2.68u as=0 ps=0 w=1u l=1u
X1228 a_6372_14488# a_6891_14495# a_7631_14845# VSS.t229 sg13_lv_nmos ad=0.3473p pd=2.71u as=0.12665p ps=1.145u w=0.74u l=0.13u
X1229 VSS.t2696 VDD VSS.t2697 VSS.t206 sg13_lv_nmos ad=79.8f pd=0.8u as=0 ps=0 w=0.42u l=1u
X1230 VDD VSS.t32 VDD VDD sg13_lv_pmos ad=0.19p pd=1.38u as=0 ps=0 w=1u l=1u
X1231 a_20278_14862# sg13cmos5l_or3_1_2.C VSS.t86 VSS.t13 sg13_lv_nmos ad=0.1406p pd=1.12u as=0.1406p ps=1.12u w=0.74u l=0.15u
X1232 a_27634_14922# sg13cmos5l_dfrbpq_1_7.RESET_B VSS.t4 VSS.t4 sg13_lv_nmos ad=37.8f pd=0.6u as=79.8f ps=0.8u w=0.42u l=0.13u
X1233 VSS.t38 sg13cmos5l_xnor2_1_2.B a_6575_13342# VSS.t3188 sg13_lv_nmos ad=0.1898p pd=1.36u as=0.1406p ps=1.12u w=0.74u l=0.13u
X1234 VDD VSS.t1163 VDD VDD sg13_lv_pmos ad=0.34p pd=2.68u as=0 ps=0 w=1u l=1u
X1235 VDD VSS.t1929 VDD VDD sg13_lv_pmos ad=0.34p pd=2.68u as=0 ps=0 w=1u l=1u
X1236 VSS.t187 VDD VSS.t593 VSS.t731 sg13_lv_nmos ad=79.8f pd=0.8u as=0 ps=0 w=0.42u l=1u
X1237 VDD VSS.t1224 VDD VDD sg13_lv_pmos ad=0.34p pd=2.68u as=0 ps=0 w=1u l=1u
X1238 VDD VSS.t3086 VDD VDD sg13_lv_pmos ad=0.19p pd=1.38u as=0 ps=0 w=1u l=1u
X1239 VSS.t944 VDD VSS.t946 VSS.t945 sg13_lv_nmos ad=79.8f pd=0.8u as=0 ps=0 w=0.42u l=1u
X1240 VSS.t989 VDD VSS.t988 VSS.t987 sg13_lv_nmos ad=0.1428p pd=1.52u as=0 ps=0 w=0.42u l=1u
X1241 VSS.t2899 VDD VSS.t2898 VSS.t2897 sg13_lv_nmos ad=0.1428p pd=1.52u as=0 ps=0 w=0.42u l=1u
X1242 VSS.t443 VDD VSS.t442 VSS.t4 sg13_lv_nmos ad=0.1428p pd=1.52u as=0 ps=0 w=0.42u l=1u
X1243 a_7888_14726# a_7631_14845# a_8050_14922# VSS.t155 sg13_lv_nmos ad=0.1428p pd=1.52u as=37.8f ps=0.6u w=0.42u l=0.13u
X1244 VSS.t1182 VDD VSS.t1181 VSS.t1154 sg13_lv_nmos ad=0.1428p pd=1.52u as=0 ps=0 w=0.42u l=1u
X1245 VSS.t3069 VDD VSS.t3071 VSS.t3070 sg13_lv_nmos ad=79.8f pd=0.8u as=0 ps=0 w=0.42u l=1u
X1246 VSS.t2282 VDD VSS.t2284 VSS.t2283 sg13_lv_nmos ad=79.8f pd=0.8u as=0 ps=0 w=0.42u l=1u
X1247 VSS.t4 a_18665_15180# a_18586_15455# VSS.t258 sg13_lv_nmos ad=4.11262p pd=27.15u as=0.27427p ps=2.28u w=0.795u l=0.13u
X1248 VDD VSS.t429 VDD VDD sg13_lv_pmos ad=0.19p pd=1.38u as=0 ps=0 w=1u l=1u
X1249 VDD VSS.t2296 VDD VDD sg13_lv_pmos ad=0.34p pd=2.68u as=0 ps=0 w=1u l=1u
X1250 VDD VSS.t1442 VDD VDD sg13_lv_pmos ad=0.34p pd=2.68u as=0 ps=0 w=1u l=1u
X1251 VDD a_10703_15311# a_11370_15532# VDD sg13_lv_pmos ad=0.2128p pd=1.5u as=0.3864p ps=2.93u w=1.12u l=0.13u
X1252 VSS.t147 sg13cmos5l_buf_8_2.A a_12010_15202# VSS.t146 sg13_lv_nmos ad=0.1406p pd=1.12u as=0.1406p ps=1.12u w=0.74u l=0.13u
X1253 VSS.t2357 VDD VSS.t2359 VSS.t2358 sg13_lv_nmos ad=79.8f pd=0.8u as=0 ps=0 w=0.42u l=1u
X1254 VDD VSS.t2421 VDD VDD sg13_lv_pmos ad=0.34p pd=2.68u as=0 ps=0 w=1u l=1u
X1255 VSS.t1905 VDD VSS.t1904 VSS.t1903 sg13_lv_nmos ad=0.1428p pd=1.52u as=0 ps=0 w=0.42u l=1u
X1256 VSS.t2680 VDD VSS.t2679 VSS.t206 sg13_lv_nmos ad=0.1428p pd=1.52u as=0 ps=0 w=0.42u l=1u
X1257 VDD VSS.t2623 VDD VDD sg13_lv_pmos ad=0.34p pd=2.68u as=0 ps=0 w=1u l=1u
X1258 VSS.t583 VDD VSS.t583 VSS.t584 sg13_lv_nmos ad=0.1428p pd=1.52u as=0 ps=0 w=0.42u l=1u
X1259 VDD VSS.t1577 VDD VDD sg13_lv_pmos ad=0.34p pd=2.68u as=0 ps=0 w=1u l=1u
X1260 VSS.t341 VDD VSS.t340 VSS.t339 sg13_lv_nmos ad=0.1428p pd=1.52u as=0 ps=0 w=0.42u l=1u
X1261 a_25862_13722# a_26667_13844# a_26122_13945# VDD sg13_lv_pmos ad=0.1428p pd=1.52u as=79.8f ps=0.8u w=0.42u l=0.13u
X1262 VSS.t864 VDD VSS.t866 VSS.t865 sg13_lv_nmos ad=79.8f pd=0.8u as=0 ps=0 w=0.42u l=1u
X1263 VDD VSS.t1997 VDD VDD sg13_lv_pmos ad=0.19p pd=1.38u as=0 ps=0 w=1u l=1u
X1264 VSS.t1 VDD VSS.t1 VSS.t97 sg13_lv_nmos ad=0.1428p pd=1.52u as=0 ps=0 w=0.42u l=1u
X1265 VDD VSS.t25 VDD VDD sg13_lv_pmos ad=0.34p pd=2.68u as=0 ps=0 w=1u l=1u
X1266 VDD VSS.t1175 VDD VDD sg13_lv_pmos ad=0.34p pd=2.68u as=0 ps=0 w=1u l=1u
X1267 VDD VSS.t1279 VDD VDD sg13_lv_pmos ad=0.19p pd=1.38u as=0 ps=0 w=1u l=1u
X1268 VDD a_27664_13942# a_27609_14037# VDD sg13_lv_pmos ad=2.42015p pd=15.68u as=93.45f ps=0.865u w=0.42u l=0.13u
X1269 VSS.t2674 VDD VSS.t2673 VSS.t206 sg13_lv_nmos ad=0.1428p pd=1.52u as=0 ps=0 w=0.42u l=1u
X1270 VDD VSS.t1008 VDD VDD sg13_lv_pmos ad=0.34p pd=2.68u as=0 ps=0 w=1u l=1u
X1271 VDD VSS.t3003 VDD VDD sg13_lv_pmos ad=0.34p pd=2.68u as=0 ps=0 w=1u l=1u
X1272 VSS.t2742 VDD VSS.t2741 VSS.t206 sg13_lv_nmos ad=0.1428p pd=1.52u as=0 ps=0 w=0.42u l=1u
X1273 VSS.t2005 VDD VSS.t2007 VSS.t2006 sg13_lv_nmos ad=79.8f pd=0.8u as=0 ps=0 w=0.42u l=1u
X1274 VSS.t93 a_17327_13799# a_17994_14020# VSS.t92 sg13_lv_nmos ad=0.1406p pd=1.12u as=0.2516p ps=2.16u w=0.74u l=0.13u
X1275 VSS.t3089 VDD VSS.t3091 VSS.t3090 sg13_lv_nmos ad=79.8f pd=0.8u as=0 ps=0 w=0.42u l=1u
X1276 sg13cmos5l_and2_1_2.B a_8694_15302# VSS.t1 VSS.t3283 sg13_lv_nmos ad=0.2516p pd=2.16u as=0.1426p ps=1.16u w=0.74u l=0.13u
X1277 VDD VSS.t617 VDD VDD sg13_lv_pmos ad=0.34p pd=2.68u as=0 ps=0 w=1u l=1u
X1278 VDD VSS.t2454 VDD VDD sg13_lv_pmos ad=0.19p pd=1.38u as=0 ps=0 w=1u l=1u
X1279 VSS.t1318 VDD VSS.t1317 VSS.t1154 sg13_lv_nmos ad=0.1428p pd=1.52u as=0 ps=0 w=0.42u l=1u
X1280 VDD VSS.t1635 VDD VDD sg13_lv_pmos ad=0.19p pd=1.38u as=0 ps=0 w=1u l=1u
X1281 VSS.t1508 VDD VSS.t1507 VSS.t1506 sg13_lv_nmos ad=0.1428p pd=1.52u as=0 ps=0 w=0.42u l=1u
X1282 VSS.t1925 VDD VSS.t1924 VSS.t1923 sg13_lv_nmos ad=0.1428p pd=1.52u as=0 ps=0 w=0.42u l=1u
X1283 VSS.t719 VDD VSS.t243 VSS.t718 sg13_lv_nmos ad=0.1428p pd=1.52u as=0 ps=0 w=0.42u l=1u
X1284 VDD VSS.t2634 VDD VDD sg13_lv_pmos ad=0.34p pd=2.68u as=0 ps=0 w=1u l=1u
X1285 VSS.t7 a_22025_16334# a_21946_16237# VSS.t3256 sg13_lv_nmos ad=7.70437p pd=50.66u as=0.27427p ps=2.28u w=0.795u l=0.13u
X1286 VSS.t1428 VDD VSS.t1312 VSS.t1154 sg13_lv_nmos ad=79.8f pd=0.8u as=0 ps=0 w=0.42u l=1u
X1287 VDD VSS.t2731 VDD VDD sg13_lv_pmos ad=0.19p pd=1.38u as=0 ps=0 w=1u l=1u
X1288 VSS.t2035 VDD VSS.t2034 VSS.t2033 sg13_lv_nmos ad=0.1428p pd=1.52u as=0 ps=0 w=0.42u l=1u
X1289 VSS.t361 VDD VSS.t361 VSS.t363 sg13_lv_nmos ad=0.1428p pd=1.52u as=0 ps=0 w=0.42u l=1u
X1290 VSS.t834 VDD VSS.t833 VSS.t832 sg13_lv_nmos ad=0.1428p pd=1.52u as=0 ps=0 w=0.42u l=1u
X1291 VDD VSS.t886 VDD VDD sg13_lv_pmos ad=0.19p pd=1.38u as=0 ps=0 w=1u l=1u
X1292 VDD VSS.t2324 VDD VDD sg13_lv_pmos ad=0.19p pd=1.38u as=0 ps=0 w=1u l=1u
X1293 VDD VSS.t1982 VDD VDD sg13_lv_pmos ad=0.19p pd=1.38u as=0 ps=0 w=1u l=1u
X1294 VDD a_27215_14845# a_27882_14484# VDD sg13_lv_pmos ad=0.2128p pd=1.5u as=0.3864p ps=2.93u w=1.12u l=0.13u
X1295 VSS.t2648 VDD VSS.t2646 VSS.t206 sg13_lv_nmos ad=0.1428p pd=1.52u as=0 ps=0 w=0.42u l=1u
X1296 VSS.t131 a_2540_15960# counter_value_o[0] VSS.t130 sg13_lv_nmos ad=0.14875p pd=1.16u as=0.2886p ps=2.26u w=0.74u l=0.13u
X1297 a_12010_15202# sg13cmos5l_buf_8_2.A VDD VDD sg13_lv_pmos ad=0.3808p pd=2.92u as=0.2128p ps=1.5u w=1.12u l=0.13u
X1298 VSS.t617 VDD VSS.t620 VSS.t749 sg13_lv_nmos ad=79.8f pd=0.8u as=0 ps=0 w=0.42u l=1u
X1299 VSS.t2342 VDD VSS.t2344 VSS.t2343 sg13_lv_nmos ad=79.8f pd=0.8u as=0 ps=0 w=0.42u l=1u
X1300 VDD VSS.t2107 VDD VDD sg13_lv_pmos ad=0.19p pd=1.38u as=0 ps=0 w=1u l=1u
X1301 a_25670_14922# a_26475_14495# a_25930_14452# VDD sg13_lv_pmos ad=0.1428p pd=1.52u as=79.8f ps=0.8u w=0.42u l=0.13u
X1302 VDD a_19323_13726# sg13cmos5l_buf_8_2.X VDD sg13_lv_pmos ad=0.3864p pd=2.93u as=0.2128p ps=1.5u w=1.12u l=0.13u
X1303 VSS.t989 VDD VSS.t988 VSS.t987 sg13_lv_nmos ad=0.1428p pd=1.52u as=0 ps=0 w=0.42u l=1u
X1304 VDD VSS.t971 VDD VDD sg13_lv_pmos ad=0.19p pd=1.38u as=0 ps=0 w=1u l=1u
X1305 VSS.t207 enable_i a_1192_3900# VSS.t206 sg13_lv_nmos ad=0.14875p pd=1.16u as=0.187p ps=1.78u w=0.55u l=0.13u
X1306 VSS.t1204 VDD VSS.t1205 VSS.t1154 sg13_lv_nmos ad=79.8f pd=0.8u as=0 ps=0 w=0.42u l=1u
X1307 VDD VSS.t1440 VDD VDD sg13_lv_pmos ad=0.19p pd=1.38u as=0 ps=0 w=1u l=1u
X1308 VSS.t268 VDD VSS.t267 VSS.t266 sg13_lv_nmos ad=0.1428p pd=1.52u as=0 ps=0 w=0.42u l=1u
X1309 VSS.t76 VDD VSS.t41 VSS.t392 sg13_lv_nmos ad=0.1428p pd=1.52u as=0 ps=0 w=0.42u l=1u
X1310 VSS.t2884 VDD VSS.t2883 VSS.t2882 sg13_lv_nmos ad=0.1428p pd=1.52u as=0 ps=0 w=0.42u l=1u
X1311 VDD VSS.t369 VDD VDD sg13_lv_pmos ad=0.19p pd=1.38u as=0 ps=0 w=1u l=1u
X1312 sg13cmos5l_dfrbpq_1_5.D a_25206_14508# VDD VDD sg13_lv_pmos ad=0.4256p pd=3u as=0.2254p ps=1.53u w=1.12u l=0.13u
X1313 VDD sg13cmos5l_or3_1_1.A a_25037_14020# VDD sg13_lv_pmos ad=0.3822p pd=1.84u as=0.1575p ps=1.315u w=1u l=0.13u
X1314 VDD VSS.t1289 VDD VDD sg13_lv_pmos ad=0.34p pd=2.68u as=0 ps=0 w=1u l=1u
X1315 VDD VSS.t2474 VDD VDD sg13_lv_pmos ad=0.19p pd=1.38u as=0 ps=0 w=1u l=1u
X1316 VSS.t3220 sg13cmos5l_o21ai_1_2.B1 a_24169_14508# VSS.t8 sg13_lv_nmos ad=0.13395p pd=1.12u as=0.198p ps=1.27u w=0.55u l=0.13u
X1317 VDD VSS.t580 VDD VDD sg13_lv_pmos ad=0.19p pd=1.38u as=0 ps=0 w=1u l=1u
X1318 VDD VSS.t2655 VDD VDD sg13_lv_pmos ad=0.34p pd=2.68u as=0 ps=0 w=1u l=1u
X1319 VSS.t16 sg13cmos5l_a21oi_1_0.A2 a_17057_14832# VSS.t175 sg13_lv_nmos ad=0.2516p pd=2.16u as=0.1406p ps=1.12u w=0.74u l=0.13u
X1320 VSS.t1458 VDD VSS.t1457 VSS.t1456 sg13_lv_nmos ad=0.1428p pd=1.52u as=0 ps=0 w=0.42u l=1u
X1321 VSS.t794 VDD VSS.t796 VSS.t795 sg13_lv_nmos ad=79.8f pd=0.8u as=0 ps=0 w=0.42u l=1u
X1322 VSS.t2020 VDD VSS.t2019 VSS.t2018 sg13_lv_nmos ad=0.1428p pd=1.52u as=0 ps=0 w=0.42u l=1u
X1323 a_4594_15234# sg13cmos5l_dfrbpq_1_0.RESET_B VSS.t41 VSS.t3165 sg13_lv_nmos ad=37.8f pd=0.6u as=79.8f ps=0.8u w=0.42u l=0.13u
X1324 VSS.t16 a_17806_15423# sg13cmos5l_inv_1_0.A VSS.t263 sg13_lv_nmos ad=0.1426p pd=1.16u as=0.2516p ps=2.16u w=0.74u l=0.13u
X1325 a_5707_14832# sg13cmos5l_buf_1_10.X a_5613_14832# VSS.t118 sg13_lv_nmos ad=0.1216p pd=1.02u as=0.2176p ps=1.96u w=0.64u l=0.13u
X1326 VSS.t864 VDD VSS.t866 VSS.t865 sg13_lv_nmos ad=79.8f pd=0.8u as=0 ps=0 w=0.42u l=1u
X1327 VDD VSS.t853 VDD VDD sg13_lv_pmos ad=0.34p pd=2.68u as=0 ps=0 w=1u l=1u
X1328 sg13cmos5l_and2_1_2.X a_8685_14832# VDD VDD sg13_lv_pmos ad=0.3808p pd=2.92u as=0.1918p ps=1.5u w=1.12u l=0.13u
X1329 VSS.t1453 VDD VSS.t1452 VSS.t1451 sg13_lv_nmos ad=0.1428p pd=1.52u as=0 ps=0 w=0.42u l=1u
X1330 VSS.t2362 VDD VSS.t2361 VSS.t2360 sg13_lv_nmos ad=0.1428p pd=1.52u as=0 ps=0 w=0.42u l=1u
X1331 a_6598_14909# sg13cmos5l_dfrbpq_1_1.RESET_B VSS.t76 VSS.t219 sg13_lv_nmos ad=37.8f pd=0.6u as=0.1701p ps=1.65u w=0.42u l=0.13u
X1332 VSS.t599 VDD VSS.t599 VSS.t736 sg13_lv_nmos ad=0.1428p pd=1.52u as=0 ps=0 w=0.42u l=1u
X1333 VSS.t1623 VDD VSS.t1625 VSS.t1624 sg13_lv_nmos ad=79.8f pd=0.8u as=0 ps=0 w=0.42u l=1u
X1334 VSS.t2639 VDD VSS.t2638 VSS.t206 sg13_lv_nmos ad=0.1428p pd=1.52u as=0 ps=0 w=0.42u l=1u
X1335 VDD VSS.t377 VDD VDD sg13_lv_pmos ad=0.19p pd=1.38u as=0 ps=0 w=1u l=1u
X1336 VDD VSS.t1329 VDD VDD sg13_lv_pmos ad=0.34p pd=2.68u as=0 ps=0 w=1u l=1u
X1337 VDD VSS.t1934 VDD VDD sg13_lv_pmos ad=0.34p pd=2.68u as=0 ps=0 w=1u l=1u
X1338 a_9444_15552# a_9418_15457# VDD VDD sg13_lv_pmos ad=0.34p pd=2.68u as=0.36237p ps=2.605u w=1u l=0.13u
X1339 VSS.t3 a_26170_15202# a_25889_15424# VSS.t3279 sg13_lv_nmos ad=79.8f pd=0.8u as=0.1428p ps=1.52u w=0.42u l=0.5u
X1340 VDD VSS.t3056 VDD VDD sg13_lv_pmos ad=0.19p pd=1.38u as=0 ps=0 w=1u l=1u
X1341 VDD VSS.t2269 VDD VDD sg13_lv_pmos ad=0.19p pd=1.38u as=0 ps=0 w=1u l=1u
X1342 VDD a_19323_13726# sg13cmos5l_buf_8_2.X VDD sg13_lv_pmos ad=0.2128p pd=1.5u as=0.2128p ps=1.5u w=1.12u l=0.13u
X1343 VDD VSS.t916 VDD VDD sg13_lv_pmos ad=0.19p pd=1.38u as=0 ps=0 w=1u l=1u
X1344 VSS.t1177 VDD VSS.t1176 VSS.t1154 sg13_lv_nmos ad=0.1428p pd=1.52u as=0 ps=0 w=0.42u l=1u
X1345 VSS.t3074 VDD VSS.t3076 VSS.t3075 sg13_lv_nmos ad=79.8f pd=0.8u as=0 ps=0 w=0.42u l=1u
X1346 VSS.t1990 VDD VSS.t1992 VSS.t1991 sg13_lv_nmos ad=79.8f pd=0.8u as=0 ps=0 w=0.42u l=1u
X1347 VSS.t2715 VDD VSS.t2714 VSS.t206 sg13_lv_nmos ad=0.1428p pd=1.52u as=0 ps=0 w=0.42u l=1u
X1348 VDD VSS.t2301 VDD VDD sg13_lv_pmos ad=0.34p pd=2.68u as=0 ps=0 w=1u l=1u
X1349 VDD VSS.t1620 VDD VDD sg13_lv_pmos ad=0.19p pd=1.38u as=0 ps=0 w=1u l=1u
X1350 VSS.t834 VDD VSS.t833 VSS.t832 sg13_lv_nmos ad=0.1428p pd=1.52u as=0 ps=0 w=0.42u l=1u
X1351 VDD VSS.t816 VDD VDD sg13_lv_pmos ad=0.19p pd=1.38u as=0 ps=0 w=1u l=1u
X1352 VSS.t1910 VDD VSS.t1909 VSS.t1908 sg13_lv_nmos ad=0.1428p pd=1.52u as=0 ps=0 w=0.42u l=1u
X1353 sg13cmos5l_nand4_1_0.Y sg13cmos5l_buf_1_0.X VDD VDD sg13_lv_pmos ad=0.2128p pd=1.5u as=0.2128p ps=1.5u w=1.12u l=0.13u
X1354 a_6578_15242# sg13cmos5l_dlygate4sd3_1_3.A VSS.t76 VSS.t3232 sg13_lv_nmos ad=0.1406p pd=1.12u as=0.2886p ps=2.26u w=0.74u l=0.13u
X1355 VSS.t413 VDD VSS.t414 VSS.t4 sg13_lv_nmos ad=79.8f pd=0.8u as=0 ps=0 w=0.42u l=1u
X1356 VDD VSS.t1572 VDD VDD sg13_lv_pmos ad=0.34p pd=2.68u as=0 ps=0 w=1u l=1u
X1357 VSS.t2663 VDD VSS.t2662 VSS.t206 sg13_lv_nmos ad=0.1428p pd=1.52u as=0 ps=0 w=0.42u l=1u
X1358 VDD VSS.t2625 VDD VDD sg13_lv_pmos ad=0.34p pd=2.68u as=0 ps=0 w=1u l=1u
X1359 VDD a_18106_15960# a_17825_16262# VDD sg13_lv_pmos ad=0.1523p pd=1.38u as=0.34p ps=2.68u w=1u l=0.5u
X1360 VDD VSS.t352 VDD VDD sg13_lv_pmos ad=0.34p pd=2.68u as=0 ps=0 w=1u l=1u
X1361 VDD VSS.t931 VDD VDD sg13_lv_pmos ad=0.19p pd=1.38u as=0 ps=0 w=1u l=1u
X1362 a_18863_14845# a_18021_14495# a_17604_14488# VDD sg13_lv_pmos ad=0.2048p pd=1.63u as=0.34p ps=2.68u w=1u l=0.13u
X1363 VSS.t1227 VDD VSS.t1226 VSS.t1154 sg13_lv_nmos ad=0.1428p pd=1.52u as=0 ps=0 w=0.42u l=1u
X1364 VDD VSS.t2486 VDD VDD sg13_lv_pmos ad=0.34p pd=2.68u as=0 ps=0 w=1u l=1u
X1365 VDD VSS.t2309 VDD VDD sg13_lv_pmos ad=0.19p pd=1.38u as=0 ps=0 w=1u l=1u
X1366 VSS.t1643 VDD VSS.t1645 VSS.t1644 sg13_lv_nmos ad=79.8f pd=0.8u as=0 ps=0 w=0.42u l=1u
X1367 VSS.t509 VDD VSS.t509 VSS.t510 sg13_lv_nmos ad=0.1428p pd=1.52u as=0 ps=0 w=0.42u l=1u
X1368 VSS.t246 a_27215_14845# a_27882_14484# VSS.t4 sg13_lv_nmos ad=0.1406p pd=1.12u as=0.2516p ps=2.16u w=0.74u l=0.13u
X1369 VDD VSS.t2731 VDD VDD sg13_lv_pmos ad=0.34p pd=2.68u as=0 ps=0 w=1u l=1u
X1370 VSS.t1270 VDD VSS.t1269 VSS.t1154 sg13_lv_nmos ad=0.1428p pd=1.52u as=0 ps=0 w=0.42u l=1u
X1371 VDD VSS.t1282 VDD VDD sg13_lv_pmos ad=0.19p pd=1.38u as=0 ps=0 w=1u l=1u
X1372 VDD VSS.t2092 VDD VDD sg13_lv_pmos ad=0.19p pd=1.38u as=0 ps=0 w=1u l=1u
X1373 VSS.t103 VDD VSS.t216 VSS.t518 sg13_lv_nmos ad=79.8f pd=0.8u as=0 ps=0 w=0.42u l=1u
X1374 VSS.t608 VDD VSS.t608 VSS.t609 sg13_lv_nmos ad=79.8f pd=0.8u as=0 ps=0 w=0.42u l=1u
X1375 sg13cmos5l_a21oi_1_3.Y sg13cmos5l_a21oi_1_3.B1 a_25109_12972# VDD sg13_lv_pmos ad=0.3808p pd=2.92u as=0.2128p ps=1.5u w=1.12u l=0.13u
X1376 VSS.t964 VDD VSS.t966 VSS.t965 sg13_lv_nmos ad=79.8f pd=0.8u as=0 ps=0 w=0.42u l=1u
X1377 a_26373_16033# a_26373_16033# VSS.t7 VSS.t6 sg13_lv_nmos ad=0.111p pd=1.34u as=7.70437p ps=50.66u w=0.3u l=0.13u
X1378 a_4377_15549# a_3435_15356# a_4175_15311# VDD sg13_lv_pmos ad=93.45f pd=0.865u as=0.2048p ps=1.63u w=0.42u l=0.13u
X1379 VSS.t422 VDD VSS.t423 VSS.t4 sg13_lv_nmos ad=79.8f pd=0.8u as=0 ps=0 w=0.42u l=1u
X1380 VDD VSS.t3008 VDD VDD sg13_lv_pmos ad=0.34p pd=2.68u as=0 ps=0 w=1u l=1u
X1381 VSS.t2222 VDD VSS.t2224 VSS.t2223 sg13_lv_nmos ad=79.8f pd=0.8u as=0 ps=0 w=0.42u l=1u
X1382 VDD VSS.t2459 VDD VDD sg13_lv_pmos ad=0.19p pd=1.38u as=0 ps=0 w=1u l=1u
X1383 VSS.t794 VDD VSS.t796 VSS.t795 sg13_lv_nmos ad=79.8f pd=0.8u as=0 ps=0 w=0.42u l=1u
X1384 VDD VSS.t1640 VDD VDD sg13_lv_pmos ad=0.19p pd=1.38u as=0 ps=0 w=1u l=1u
X1385 VSS.t289 VDD VSS.t69 VSS.t288 sg13_lv_nmos ad=0.1428p pd=1.52u as=0 ps=0 w=0.42u l=1u
X1386 VDD VSS.t22 VDD VDD sg13_lv_pmos ad=0.19p pd=1.38u as=0 ps=0 w=1u l=1u
X1387 VSS.t1443 VDD VSS.t1442 VSS.t1441 sg13_lv_nmos ad=0.1428p pd=1.52u as=0 ps=0 w=0.42u l=1u
X1388 a_7680_15549# sg13cmos5l_nand3_1_0.Y a_7643_15280# VSS.t3176 sg13_lv_nmos ad=0.2176p pd=1.96u as=78.39999f ps=0.885u w=0.64u l=0.13u
X1389 sg13cmos5l_dfrbpq_1_6.Q a_22986_14484# VDD VDD sg13_lv_pmos ad=0.3808p pd=2.92u as=0.2128p ps=1.5u w=1.12u l=0.13u
X1390 VSS.t1279 VDD VSS.t1278 VSS.t1154 sg13_lv_nmos ad=0.1428p pd=1.52u as=0 ps=0 w=0.42u l=1u
X1391 VDD VSS.t2618 VDD VDD sg13_lv_pmos ad=0.34p pd=2.68u as=0 ps=0 w=1u l=1u
X1392 VDD VSS.t1202 VDD VDD sg13_lv_pmos ad=0.34p pd=2.68u as=0 ps=0 w=1u l=1u
X1393 VSS.t2005 VDD VSS.t2004 VSS.t2003 sg13_lv_nmos ad=0.1428p pd=1.52u as=0 ps=0 w=0.42u l=1u
X1394 VSS.t1438 VDD VSS.t1437 VSS.t1436 sg13_lv_nmos ad=0.1428p pd=1.52u as=0 ps=0 w=0.42u l=1u
X1395 VDD VSS.t1172 VDD VDD sg13_lv_pmos ad=0.19p pd=1.38u as=0 ps=0 w=1u l=1u
X1396 VSS.t2630 VDD VSS.t2629 VSS.t206 sg13_lv_nmos ad=0.1428p pd=1.52u as=0 ps=0 w=0.42u l=1u
X1397 VSS.t278 VDD VSS.t273 VSS.t277 sg13_lv_nmos ad=0.1428p pd=1.52u as=0 ps=0 w=0.42u l=1u
X1398 sg13cmos5l_dfrbpq_1_3.D a_17238_15302# VSS.t16 VSS.t15 sg13_lv_nmos ad=0.2516p pd=2.16u as=0.1426p ps=1.16u w=0.74u l=0.13u
X1399 VSS.t1284 VDD VSS.t1282 VSS.t1154 sg13_lv_nmos ad=0.1428p pd=1.52u as=0 ps=0 w=0.42u l=1u
X1400 VSS.t2691 VDD VSS.t2692 VSS.t206 sg13_lv_nmos ad=79.8f pd=0.8u as=0 ps=0 w=0.42u l=1u
X1401 VSS.t2347 VDD VSS.t2349 VSS.t2348 sg13_lv_nmos ad=79.8f pd=0.8u as=0 ps=0 w=0.42u l=1u
X1402 VDD VSS.t3041 VDD VDD sg13_lv_pmos ad=0.19p pd=1.38u as=0 ps=0 w=1u l=1u
X1403 VSS.t2442 VDD VSS.t2441 VSS.t2440 sg13_lv_nmos ad=0.1428p pd=1.52u as=0 ps=0 w=0.42u l=1u
X1404 VDD VSS.t2254 VDD VDD sg13_lv_pmos ad=0.19p pd=1.38u as=0 ps=0 w=1u l=1u
X1405 a_9444_15552# a_9418_15457# VSS.t1 VSS.t97 sg13_lv_nmos ad=0.2516p pd=2.16u as=0.1626p ps=1.415u w=0.74u l=0.13u
X1406 VSS.t112 VDD VSS.t243 VSS.t717 sg13_lv_nmos ad=79.8f pd=0.8u as=0 ps=0 w=0.42u l=1u
X1407 VDD VSS.t593 VDD VDD sg13_lv_pmos ad=0.34p pd=2.68u as=0 ps=0 w=1u l=1u
X1408 VSS.t399 VDD VSS.t138 VSS.t57 sg13_lv_nmos ad=0.1428p pd=1.52u as=0 ps=0 w=0.42u l=1u
X1409 sg13cmos5l_a21oi_1_3.B1 sg13cmos5l_buf_1_10.X VSS.t121 VSS.t120 sg13_lv_nmos ad=0.2516p pd=2.16u as=0.2516p ps=2.16u w=0.74u l=0.13u
X1410 VSS.t2707 VDD VSS.t2706 VSS.t206 sg13_lv_nmos ad=0.1428p pd=1.52u as=0 ps=0 w=0.42u l=1u
X1411 VDD VSS.t568 VDD VDD sg13_lv_pmos ad=0.19p pd=1.38u as=0 ps=0 w=1u l=1u
X1412 VSS.t994 VDD VSS.t996 VSS.t995 sg13_lv_nmos ad=79.8f pd=0.8u as=0 ps=0 w=0.42u l=1u
X1413 VDD VSS.t2444 VDD VDD sg13_lv_pmos ad=0.19p pd=1.38u as=0 ps=0 w=1u l=1u
X1414 VSS.t16 sg13cmos5l_nor2_1_0.B sg13cmos5l_dfrbpq_1_2.D VSS.t3276 sg13_lv_nmos ad=0.2516p pd=2.16u as=0.1406p ps=1.12u w=0.74u l=0.13u
X1415 VDD VSS.t1181 VDD VDD sg13_lv_pmos ad=0.19p pd=1.38u as=0 ps=0 w=1u l=1u
X1416 VDD sg13cmos5l_xor2_1_0.B a_2516_14484# VDD sg13_lv_pmos ad=0.2128p pd=1.5u as=0.2128p ps=1.5u w=1.12u l=0.13u
X1417 a_20774_14922# sg13cmos5l_dfrbpq_1_6.D VDD VDD sg13_lv_pmos ad=79.8f pd=0.8u as=0.1428p ps=1.52u w=0.42u l=0.13u
X1418 VSS.t1633 VDD VSS.t1635 VSS.t1634 sg13_lv_nmos ad=79.8f pd=0.8u as=0 ps=0 w=0.42u l=1u
X1419 VSS.t3154 VDD VSS.t3156 VSS.t3155 sg13_lv_nmos ad=79.8f pd=0.8u as=0 ps=0 w=0.42u l=1u
X1420 VDD VSS.t1557 VDD VDD sg13_lv_pmos ad=0.34p pd=2.68u as=0 ps=0 w=1u l=1u
X1421 VSS.t2025 VDD VSS.t2024 VSS.t2023 sg13_lv_nmos ad=0.1428p pd=1.52u as=0 ps=0 w=0.42u l=1u
X1422 a_17327_13799# a_16485_13701# a_17233_13799# VSS.t3193 sg13_lv_nmos ad=0.12665p pd=1.145u as=0.1428p ps=1.52u w=0.42u l=0.13u
X1423 VDD VSS.t349 VDD VDD sg13_lv_pmos ad=0.34p pd=2.68u as=0 ps=0 w=1u l=1u
X1424 VDD VSS.t2471 VDD VDD sg13_lv_pmos ad=0.34p pd=2.68u as=0 ps=0 w=1u l=1u
X1425 VDD VSS.t798 VDD VDD sg13_lv_pmos ad=0.34p pd=2.68u as=0 ps=0 w=1u l=1u
X1426 VSS.t1628 VDD VSS.t1630 VSS.t1629 sg13_lv_nmos ad=79.8f pd=0.8u as=0 ps=0 w=0.42u l=1u
X1427 VSS.t1297 VDD VSS.t1296 VSS.t1154 sg13_lv_nmos ad=0.1428p pd=1.52u as=0 ps=0 w=0.42u l=1u
X1428 VDD VSS.t2499 VDD VDD sg13_lv_pmos ad=0.19p pd=1.38u as=0 ps=0 w=1u l=1u
X1429 VSS.t964 VDD VSS.t966 VSS.t965 sg13_lv_nmos ad=79.8f pd=0.8u as=0 ps=0 w=0.42u l=1u
X1430 VDD VSS.t1169 VDD VDD sg13_lv_pmos ad=0.34p pd=2.68u as=0 ps=0 w=1u l=1u
X1431 VDD VSS.t1939 VDD VDD sg13_lv_pmos ad=0.34p pd=2.68u as=0 ps=0 w=1u l=1u
X1432 VSS.t89 a_21562_15960# a_21281_16262# VSS.t239 sg13_lv_nmos ad=79.8f pd=0.8u as=0.1428p ps=1.52u w=0.42u l=0.5u
X1433 VSS.t346 VDD VSS.t345 VSS.t344 sg13_lv_nmos ad=0.1428p pd=1.52u as=0 ps=0 w=0.42u l=1u
X1434 a_2490_14447# sg13cmos5l_xor2_1_0.B VSS.t196 VSS.t195 sg13_lv_nmos ad=0.17462p pd=1.185u as=0.15245p ps=1.17u w=0.55u l=0.13u
X1435 VDD VSS.t3061 VDD VDD sg13_lv_pmos ad=0.19p pd=1.38u as=0 ps=0 w=1u l=1u
X1436 VDD VSS.t2274 VDD VDD sg13_lv_pmos ad=0.19p pd=1.38u as=0 ps=0 w=1u l=1u
X1437 VSS.t2105 VDD VSS.t2107 VSS.t2106 sg13_lv_nmos ad=79.8f pd=0.8u as=0 ps=0 w=0.42u l=1u
X1438 VSS.t315 VDD VSS.t314 VSS.t313 sg13_lv_nmos ad=0.1428p pd=1.52u as=0 ps=0 w=0.42u l=1u
X1439 sg13cmos5l_and2_1_1.X a_5613_14832# VDD VDD sg13_lv_pmos ad=0.3808p pd=2.92u as=0.1918p ps=1.5u w=1.12u l=0.13u
X1440 VDD VSS.t441 VDD VDD sg13_lv_pmos ad=0.19p pd=1.38u as=0 ps=0 w=1u l=1u
X1441 VDD VSS.t851 VDD VDD sg13_lv_pmos ad=0.19p pd=1.38u as=0 ps=0 w=1u l=1u
X1442 VSS.t2699 VDD VSS.t2698 VSS.t206 sg13_lv_nmos ad=0.1428p pd=1.52u as=0 ps=0 w=0.42u l=1u
X1443 VSS.t349 a_27500_15960# counter_value_o[5] VSS.t3284 sg13_lv_nmos ad=0.14875p pd=1.16u as=0.2886p ps=2.26u w=0.74u l=0.13u
X1444 VDD VSS.t1016 VDD VDD sg13_lv_pmos ad=0.19p pd=1.38u as=0 ps=0 w=1u l=1u
X1445 VDD VSS.t1273 VDD VDD sg13_lv_pmos ad=0.19p pd=1.38u as=0 ps=0 w=1u l=1u
X1446 VDD VSS.t1570 VDD VDD sg13_lv_pmos ad=0.19p pd=1.38u as=0 ps=0 w=1u l=1u
X1447 VDD VSS.t1947 VDD VDD sg13_lv_pmos ad=0.19p pd=1.38u as=0 ps=0 w=1u l=1u
X1448 VDD VSS.t3088 VDD VDD sg13_lv_pmos ad=0.34p pd=2.68u as=0 ps=0 w=1u l=1u
X1449 VSS.t3139 VDD VSS.t3141 VSS.t3140 sg13_lv_nmos ad=79.8f pd=0.8u as=0 ps=0 w=0.42u l=1u
X1450 VSS.t2055 VDD VSS.t2057 VSS.t2056 sg13_lv_nmos ad=79.8f pd=0.8u as=0 ps=0 w=0.42u l=1u
X1451 VSS.t2666 VDD VSS.t2664 VSS.t206 sg13_lv_nmos ad=0.1428p pd=1.52u as=0 ps=0 w=0.42u l=1u
X1452 a_4432_15454# a_4175_15311# a_4594_15234# VSS.t39 sg13_lv_nmos ad=0.1428p pd=1.52u as=37.8f ps=0.6u w=0.42u l=0.13u
X1453 VSS.t884 VDD VSS.t886 VSS.t885 sg13_lv_nmos ad=79.8f pd=0.8u as=0 ps=0 w=0.42u l=1u
X1454 sg13cmos5l_dfrbpq_1_6.Q a_22986_14484# VSS.t138 VSS.t8 sg13_lv_nmos ad=0.2516p pd=2.16u as=0.1406p ps=1.12u w=0.74u l=0.13u
X1455 a_6202_15238# sg13cmos5l_dlygate4sd3_1_3.A VSS.t76 VSS.t3229 sg13_lv_nmos ad=0.1406p pd=1.12u as=0.2516p ps=2.16u w=0.74u l=0.13u
X1456 a_7829_15238# sg13cmos5l_nand3_1_0.Y VSS.t193 VSS.t3177 sg13_lv_nmos ad=0.1406p pd=1.12u as=0.1898p ps=1.36u w=0.74u l=0.13u
X1457 VSS.t144 a_10618_14448# a_10337_14750# VSS.t3195 sg13_lv_nmos ad=79.8f pd=0.8u as=0.1428p ps=1.52u w=0.42u l=0.5u
X1458 VDD VSS.t953 VDD VDD sg13_lv_pmos ad=0.34p pd=2.68u as=0 ps=0 w=1u l=1u
X1459 VDD VSS.t2314 VDD VDD sg13_lv_pmos ad=0.19p pd=1.38u as=0 ps=0 w=1u l=1u
X1460 VSS.t1975 VDD VSS.t1974 VSS.t1973 sg13_lv_nmos ad=0.1428p pd=1.52u as=0 ps=0 w=0.42u l=1u
X1461 VDD VSS.t1972 VDD VDD sg13_lv_pmos ad=0.19p pd=1.38u as=0 ps=0 w=1u l=1u
X1462 VDD sg13cmos5l_or3_1_2.A sg13cmos5l_o21ai_1_1.Y VDD sg13_lv_pmos ad=0.3808p pd=2.92u as=0.2128p ps=1.5u w=1.12u l=0.15u
X1463 VSS.t1428 VDD VSS.t1309 VSS.t1154 sg13_lv_nmos ad=0.1428p pd=1.52u as=0 ps=0 w=0.42u l=1u
X1464 a_2630_15234# sg13cmos5l_and2_1_0.X VDD VDD sg13_lv_pmos ad=79.8f pd=0.8u as=0.1428p ps=1.52u w=0.42u l=0.13u
X1465 VSS.t2332 VDD VSS.t2334 VSS.t2333 sg13_lv_nmos ad=79.8f pd=0.8u as=0 ps=0 w=0.42u l=1u
X1466 VDD VSS.t2097 VDD VDD sg13_lv_pmos ad=0.19p pd=1.38u as=0 ps=0 w=1u l=1u
X1467 a_6372_14488# a_6346_14452# VSS.t76 VSS.t184 sg13_lv_nmos ad=0.2516p pd=2.16u as=0.1626p ps=1.415u w=0.74u l=0.13u
X1468 VDD VSS.t421 VDD VDD sg13_lv_pmos ad=0.34p pd=2.68u as=0 ps=0 w=1u l=1u
X1469 VSS.t1885 VDD VSS.t1887 VSS.t1886 sg13_lv_nmos ad=79.8f pd=0.8u as=0 ps=0 w=0.42u l=1u
X1470 VSS.t2734 VDD VSS.t2736 VSS.t206 sg13_lv_nmos ad=79.8f pd=0.8u as=0 ps=0 w=0.42u l=1u
X1471 VDD VSS.t629 VDD VDD sg13_lv_pmos ad=0.34p pd=2.68u as=0 ps=0 w=1u l=1u
X1472 VDD VSS.t1254 VDD VDD sg13_lv_pmos ad=0.34p pd=2.68u as=0 ps=0 w=1u l=1u
X1473 VSS.t7 a_26249_16334# a_26170_16237# VSS.t228 sg13_lv_nmos ad=7.70437p pd=50.66u as=0.27427p ps=2.28u w=0.795u l=0.13u
X1474 VDD VSS.t352 VDD VDD sg13_lv_pmos ad=0.19p pd=1.38u as=0 ps=0 w=1u l=1u
X1475 VDD VSS.t568 VDD VDD sg13_lv_pmos ad=0.19p pd=1.38u as=0 ps=0 w=1u l=1u
X1476 VSS.t994 VDD VSS.t996 VSS.t995 sg13_lv_nmos ad=79.8f pd=0.8u as=0 ps=0 w=0.42u l=1u
X1477 a_8050_14922# sg13cmos5l_dfrbpq_1_1.RESET_B VSS.t193 VSS.t217 sg13_lv_nmos ad=37.8f pd=0.6u as=79.8f ps=0.8u w=0.42u l=0.13u
X1478 VDD VSS.t968 VDD VDD sg13_lv_pmos ad=0.34p pd=2.68u as=0 ps=0 w=1u l=1u
X1479 VDD VSS.t1610 VDD VDD sg13_lv_pmos ad=0.19p pd=1.38u as=0 ps=0 w=1u l=1u
X1480 VDD VSS.t3073 VDD VDD sg13_lv_pmos ad=0.34p pd=2.68u as=0 ps=0 w=1u l=1u
X1481 VDD VSS.t2286 VDD VDD sg13_lv_pmos ad=0.34p pd=2.68u as=0 ps=0 w=1u l=1u
X1482 VSS.t854 VDD VSS.t853 VSS.t852 sg13_lv_nmos ad=0.1428p pd=1.52u as=0 ps=0 w=0.42u l=1u
X1483 VSS.t1197 VDD VSS.t1198 VSS.t1154 sg13_lv_nmos ad=79.8f pd=0.8u as=0 ps=0 w=0.42u l=1u
X1484 VDD VSS.t2620 VDD VDD sg13_lv_pmos ad=0.34p pd=2.68u as=0 ps=0 w=1u l=1u
X1485 VDD VSS.t1292 VDD VDD sg13_lv_pmos ad=0.19p pd=1.38u as=0 ps=0 w=1u l=1u
X1486 VDD VSS.t1892 VDD VDD sg13_lv_pmos ad=0.19p pd=1.38u as=0 ps=0 w=1u l=1u
X1487 VDD VSS.t2717 VDD VDD sg13_lv_pmos ad=0.19p pd=1.38u as=0 ps=0 w=1u l=1u
X1488 VSS.t2010 VDD VSS.t2009 VSS.t2008 sg13_lv_nmos ad=0.1428p pd=1.52u as=0 ps=0 w=0.42u l=1u
X1489 VSS.t1573 VDD VSS.t1572 VSS.t1571 sg13_lv_nmos ad=0.1428p pd=1.52u as=0 ps=0 w=0.42u l=1u
X1490 VSS.t3094 VDD VSS.t3093 VSS.t3092 sg13_lv_nmos ad=0.1428p pd=1.52u as=0 ps=0 w=0.42u l=1u
X1491 VSS.t629 VDD VSS.t632 VSS.t757 sg13_lv_nmos ad=79.8f pd=0.8u as=0 ps=0 w=0.42u l=1u
X1492 VDD VSS.t2484 VDD VDD sg13_lv_pmos ad=0.19p pd=1.38u as=0 ps=0 w=1u l=1u
X1493 sg13cmos5l_dlygate4sd3_1_8.A a_11370_15532# VDD VDD sg13_lv_pmos ad=0.3808p pd=2.92u as=0.2128p ps=1.5u w=1.12u l=0.13u
X1494 sg13cmos5l_a21oi_1_1.Y sg13cmos5l_a21oi_1_3.B1 VSS.t86 VSS.t107 sg13_lv_nmos ad=0.1406p pd=1.12u as=0.2516p ps=2.16u w=0.74u l=0.13u
X1495 VSS.t914 VDD VSS.t916 VSS.t915 sg13_lv_nmos ad=79.8f pd=0.8u as=0 ps=0 w=0.42u l=1u
X1496 VDD VSS.t1924 VDD VDD sg13_lv_pmos ad=0.34p pd=2.68u as=0 ps=0 w=1u l=1u
X1497 VDD VSS.t781 VDD VDD sg13_lv_pmos ad=0.19p pd=1.38u as=0 ps=0 w=1u l=1u
X1498 VDD VSS.t3046 VDD VDD sg13_lv_pmos ad=0.19p pd=1.38u as=0 ps=0 w=1u l=1u
X1499 VSS.t2317 VDD VSS.t2319 VSS.t2318 sg13_lv_nmos ad=79.8f pd=0.8u as=0 ps=0 w=0.42u l=1u
X1500 VDD VSS.t2259 VDD VDD sg13_lv_pmos ad=0.19p pd=1.38u as=0 ps=0 w=1u l=1u
X1501 VSS.t294 VDD VSS.t294 VSS.t295 sg13_lv_nmos ad=79.8f pd=0.8u as=0 ps=0 w=0.42u l=1u
X1502 VSS.t1708 VDD VSS.t1710 VSS.t1709 sg13_lv_nmos ad=79.8f pd=0.8u as=0 ps=0 w=0.42u l=1u
X1503 VSS.t2090 VDD VSS.t2092 VSS.t2091 sg13_lv_nmos ad=79.8f pd=0.8u as=0 ps=0 w=0.42u l=1u
X1504 VDD VSS.t377 VDD VDD sg13_lv_pmos ad=0.19p pd=1.38u as=0 ps=0 w=1u l=1u
X1505 VSS.t814 VDD VSS.t816 VSS.t815 sg13_lv_nmos ad=79.8f pd=0.8u as=0 ps=0 w=0.42u l=1u
X1506 VSS.t1960 VDD VSS.t1962 VSS.t1961 sg13_lv_nmos ad=79.8f pd=0.8u as=0 ps=0 w=0.42u l=1u
X1507 VDD VSS.t429 VDD VDD sg13_lv_pmos ad=0.19p pd=1.38u as=0 ps=0 w=1u l=1u
X1508 VSS.t884 VDD VSS.t886 VSS.t885 sg13_lv_nmos ad=79.8f pd=0.8u as=0 ps=0 w=0.42u l=1u
X1509 VDD VSS.t873 VDD VDD sg13_lv_pmos ad=0.34p pd=2.68u as=0 ps=0 w=1u l=1u
X1510 VSS.t1638 VDD VSS.t1640 VSS.t1639 sg13_lv_nmos ad=79.8f pd=0.8u as=0 ps=0 w=0.42u l=1u
X1511 a_19323_13726# sg13cmos5l_buf_8_2.A VDD VDD sg13_lv_pmos ad=0.2128p pd=1.5u as=0.2128p ps=1.5u w=1.12u l=0.13u
X1512 VSS.t929 VDD VSS.t931 VSS.t930 sg13_lv_nmos ad=79.8f pd=0.8u as=0 ps=0 w=0.42u l=1u
X1513 VDD VSS.t1562 VDD VDD sg13_lv_pmos ad=0.34p pd=2.68u as=0 ps=0 w=1u l=1u
X1514 VDD VSS.t1442 VDD VDD sg13_lv_pmos ad=0.34p pd=2.68u as=0 ps=0 w=1u l=1u
X1515 VSS.t3124 VDD VSS.t3126 VSS.t3125 sg13_lv_nmos ad=79.8f pd=0.8u as=0 ps=0 w=0.42u l=1u
X1516 VSS.t2657 VDD VSS.t2656 VSS.t206 sg13_lv_nmos ad=0.1428p pd=1.52u as=0 ps=0 w=0.42u l=1u
X1517 VDD sg13cmos5l_buf_8_2.A a_12010_15202# VDD sg13_lv_pmos ad=0.2128p pd=1.5u as=0.2128p ps=1.5u w=1.12u l=0.13u
X1518 VSS.t576 VDD VSS.t576 VSS.t575 sg13_lv_nmos ad=0.1428p pd=1.52u as=0 ps=0 w=0.42u l=1u
X1519 VDD VSS.t998 VDD VDD sg13_lv_pmos ad=0.34p pd=2.68u as=0 ps=0 w=1u l=1u
X1520 VSS.t2242 VDD VSS.t2241 VSS.t2240 sg13_lv_nmos ad=0.1428p pd=1.52u as=0 ps=0 w=0.42u l=1u
X1521 VDD a_22426_15202# a_22145_15424# VDD sg13_lv_pmos ad=0.1523p pd=1.38u as=0.34p ps=2.68u w=1u l=0.5u
X1522 VSS.t611 VDD VSS.t611 VSS.t744 sg13_lv_nmos ad=0.1428p pd=1.52u as=0 ps=0 w=0.42u l=1u
X1523 VDD VSS.t2476 VDD VDD sg13_lv_pmos ad=0.34p pd=2.68u as=0 ps=0 w=1u l=1u
X1524 a_22508_15960# sg13cmos5l_dfrbpq_1_3.Q VDD VDD sg13_lv_pmos ad=0.2856p pd=2.36u as=0.2114p ps=1.54u w=0.84u l=0.13u
X1525 VDD VSS.t936 VDD VDD sg13_lv_pmos ad=0.19p pd=1.38u as=0 ps=0 w=1u l=1u
X1526 VDD VSS.t1226 VDD VDD sg13_lv_pmos ad=0.19p pd=1.38u as=0 ps=0 w=1u l=1u
X1527 VSS.t1189 VDD VSS.t1188 VSS.t1154 sg13_lv_nmos ad=0.1428p pd=1.52u as=0 ps=0 w=0.42u l=1u
X1528 VSS.t1230 VDD VSS.t1231 VSS.t1154 sg13_lv_nmos ad=79.8f pd=0.8u as=0 ps=0 w=0.42u l=1u
X1529 sg13cmos5l_dfrbpq_1_2.CLK a_12010_15202# VSS.t25 VSS.t28 sg13_lv_nmos ad=0.1406p pd=1.12u as=0.1406p ps=1.12u w=0.74u l=0.13u
X1530 VDD VSS.t112 VDD VDD sg13_lv_pmos ad=0.34p pd=2.68u as=0 ps=0 w=1u l=1u
X1531 VDD VSS.t1276 VDD VDD sg13_lv_pmos ad=0.19p pd=1.38u as=0 ps=0 w=1u l=1u
X1532 VDD VSS.t2769 VDD VDD sg13_lv_pmos ad=0.19p pd=1.38u as=0 ps=0 w=1u l=1u
X1533 VSS.t1693 VDD VSS.t1695 VSS.t1694 sg13_lv_nmos ad=79.8f pd=0.8u as=0 ps=0 w=0.42u l=1u
X1534 VSS.t2497 VDD VSS.t2496 VSS.t2495 sg13_lv_nmos ad=0.1428p pd=1.52u as=0 ps=0 w=0.42u l=1u
X1535 VSS.t1870 VDD VSS.t1872 VSS.t1871 sg13_lv_nmos ad=79.8f pd=0.8u as=0 ps=0 w=0.42u l=1u
X1536 VDD VSS.t123 VDD VDD sg13_lv_pmos ad=0.34p pd=2.68u as=0 ps=0 w=1u l=1u
X1537 VDD a_18863_14845# a_19120_14726# VDD sg13_lv_pmos ad=2.42015p pd=15.68u as=79.8f ps=0.8u w=0.42u l=0.13u
X1538 VSS.t1194 VDD VSS.t1193 VSS.t1154 sg13_lv_nmos ad=0.1428p pd=1.52u as=0 ps=0 w=0.42u l=1u
X1539 VSS.t356 VDD VSS.t356 VSS.t358 sg13_lv_nmos ad=0.1428p pd=1.52u as=0 ps=0 w=0.42u l=1u
X1540 a_20218_15238# sg13cmos5l_dfrbpq_1_2.Q VSS.t468 VSS.t107 sg13_lv_nmos ad=0.1406p pd=1.12u as=0.2516p ps=2.16u w=0.74u l=0.13u
X1541 sg13cmos5l_o21ai_1_2.A2 sg13cmos5l_dfrbpq_1_6.Q a_23480_15242# VSS.t57 sg13_lv_nmos ad=0.2516p pd=2.16u as=0.1406p ps=1.12u w=0.74u l=0.13u
X1542 a_15338_14484# sg13cmos5l_a21oi_1_3.B1 VDD VDD sg13_lv_pmos ad=0.1176p pd=1.33u as=0.4032p ps=2.96u w=1.12u l=0.13u
X1543 VSS.t2701 VDD VSS.t2701 VSS.t206 sg13_lv_nmos ad=0.1428p pd=1.52u as=0 ps=0 w=0.42u l=1u
X1544 VDD VSS.t402 VDD VDD sg13_lv_pmos ad=0.19p pd=1.38u as=0 ps=0 w=1u l=1u
X1545 VSS.t854 VDD VSS.t853 VSS.t852 sg13_lv_nmos ad=0.1428p pd=1.52u as=0 ps=0 w=0.42u l=1u
X1546 VSS.t969 VDD VSS.t971 VSS.t970 sg13_lv_nmos ad=79.8f pd=0.8u as=0 ps=0 w=0.42u l=1u
X1547 VDD VSS.t1952 VDD VDD sg13_lv_pmos ad=0.19p pd=1.38u as=0 ps=0 w=1u l=1u
X1548 sg13cmos5l_dlygate4sd3_1_5.A sg13cmos5l_dlygate4sd3_1_4.X a_18454_16374# VSS.t3269 sg13_lv_nmos ad=0.2516p pd=2.16u as=0.1406p ps=1.12u w=0.74u l=0.15u
X1549 VSS.t416 VDD VSS.t417 VSS.t4 sg13_lv_nmos ad=79.8f pd=0.8u as=0 ps=0 w=0.42u l=1u
X1550 VDD VSS.t3058 VDD VDD sg13_lv_pmos ad=0.34p pd=2.68u as=0 ps=0 w=1u l=1u
X1551 VDD VSS.t2271 VDD VDD sg13_lv_pmos ad=0.34p pd=2.68u as=0 ps=0 w=1u l=1u
X1552 VDD sg13cmos5l_dlygate4sd3_1_9.X a_20603_15532# VDD sg13_lv_pmos ad=0.2128p pd=1.5u as=0.2128p ps=1.5u w=1.12u l=0.13u
X1553 VDD VSS.t1595 VDD VDD sg13_lv_pmos ad=0.19p pd=1.38u as=0 ps=0 w=1u l=1u
X1554 VSS.t2060 VDD VSS.t2062 VSS.t2061 sg13_lv_nmos ad=79.8f pd=0.8u as=0 ps=0 w=0.42u l=1u
X1555 VSS.t2669 VDD VSS.t2668 VSS.t206 sg13_lv_nmos ad=0.1428p pd=1.52u as=0 ps=0 w=0.42u l=1u
X1556 VDD VSS.t1635 VDD VDD sg13_lv_pmos ad=0.19p pd=1.38u as=0 ps=0 w=1u l=1u
X1557 VDD VSS.t207 VDD VDD sg13_lv_pmos ad=0.34p pd=2.68u as=0 ps=0 w=1u l=1u
X1558 a_20376_14464# sg13cmos5l_or3_1_2.B VDD VDD sg13_lv_pmos ad=0.2128p pd=1.5u as=0.3808p ps=2.92u w=1.12u l=0.15u
X1559 sg13cmos5l_dfrbpq_1_5.D a_25206_14508# VSS.t9 VSS.t8 sg13_lv_nmos ad=0.2516p pd=2.16u as=0.1426p ps=1.16u w=0.74u l=0.13u
X1560 VDD VSS.t1206 VDD VDD sg13_lv_pmos ad=0.34p pd=2.68u as=0 ps=0 w=1u l=1u
X1561 VDD VSS.t1977 VDD VDD sg13_lv_pmos ad=0.19p pd=1.38u as=0 ps=0 w=1u l=1u
X1562 VSS.t914 VDD VSS.t916 VSS.t915 sg13_lv_nmos ad=79.8f pd=0.8u as=0 ps=0 w=0.42u l=1u
X1563 VDD VSS.t903 VDD VDD sg13_lv_pmos ad=0.34p pd=2.68u as=0 ps=0 w=1u l=1u
X1564 VSS.t1282 VDD VSS.t1281 VSS.t1154 sg13_lv_nmos ad=0.1428p pd=1.52u as=0 ps=0 w=0.42u l=1u
X1565 VSS.t66 VDD VSS.t66 VSS.t502 sg13_lv_nmos ad=0.1428p pd=1.52u as=0 ps=0 w=0.42u l=1u
X1566 VSS.t1243 VDD VSS.t1244 VSS.t1154 sg13_lv_nmos ad=79.8f pd=0.8u as=0 ps=0 w=0.42u l=1u
X1567 VDD VSS.t2760 VDD VDD sg13_lv_pmos ad=0.19p pd=1.38u as=0 ps=0 w=1u l=1u
X1568 VSS.t2482 VDD VSS.t2481 VSS.t2480 sg13_lv_nmos ad=0.1428p pd=1.52u as=0 ps=0 w=0.42u l=1u
X1569 VDD VSS.t356 VDD VDD sg13_lv_pmos ad=0.34p pd=2.68u as=0 ps=0 w=1u l=1u
X1570 sg13cmos5l_dfrbpq_1_2.CLK a_12010_15202# VSS.t22 VSS.t23 sg13_lv_nmos ad=0.1406p pd=1.12u as=0.1406p ps=1.12u w=0.74u l=0.13u
X1571 VSS.t1855 VDD VSS.t1857 VSS.t1856 sg13_lv_nmos ad=79.8f pd=0.8u as=0 ps=0 w=0.42u l=1u
X1572 VDD a_27407_13799# a_28074_14020# VDD sg13_lv_pmos ad=0.2128p pd=1.5u as=0.3864p ps=2.93u w=1.12u l=0.13u
X1573 VSS.t1648 VDD VSS.t1647 VSS.t1646 sg13_lv_nmos ad=0.1428p pd=1.52u as=0 ps=0 w=0.42u l=1u
X1574 VSS.t814 VDD VSS.t816 VSS.t815 sg13_lv_nmos ad=79.8f pd=0.8u as=0 ps=0 w=0.42u l=1u
X1575 VDD VSS.t2339 VDD VDD sg13_lv_pmos ad=0.19p pd=1.38u as=0 ps=0 w=1u l=1u
X1576 VSS.t719 VDD VSS.t721 VSS.t720 sg13_lv_nmos ad=79.8f pd=0.8u as=0 ps=0 w=0.42u l=1u
X1577 VDD VSS.t1282 VDD VDD sg13_lv_pmos ad=0.34p pd=2.68u as=0 ps=0 w=1u l=1u
X1578 VDD VSS.t1615 VDD VDD sg13_lv_pmos ad=0.19p pd=1.38u as=0 ps=0 w=1u l=1u
X1579 VSS.t929 VDD VSS.t931 VSS.t930 sg13_lv_nmos ad=79.8f pd=0.8u as=0 ps=0 w=0.42u l=1u
X1580 VSS.t1945 VDD VSS.t1947 VSS.t1946 sg13_lv_nmos ad=79.8f pd=0.8u as=0 ps=0 w=0.42u l=1u
X1581 sg13cmos5l_a21oi_1_0.A2 a_16969_16020# VDD VDD sg13_lv_pmos ad=0.3808p pd=2.92u as=0.3822p ps=1.84u w=1.12u l=0.13u
X1582 VDD VSS.t2719 VDD VDD sg13_lv_pmos ad=0.19p pd=1.38u as=0 ps=0 w=1u l=1u
X1583 VSS.t2015 VDD VSS.t2014 VSS.t2013 sg13_lv_nmos ad=0.1428p pd=1.52u as=0 ps=0 w=0.42u l=1u
X1584 VDD VSS.t420 VDD VDD sg13_lv_pmos ad=0.19p pd=1.38u as=0 ps=0 w=1u l=1u
X1585 VDD VSS.t1184 VDD VDD sg13_lv_pmos ad=0.19p pd=1.38u as=0 ps=0 w=1u l=1u
X1586 VSS.t2227 VDD VSS.t2226 VSS.t2225 sg13_lv_nmos ad=0.1428p pd=1.52u as=0 ps=0 w=0.42u l=1u
X1587 VDD VSS.t1642 VDD VDD sg13_lv_pmos ad=0.34p pd=2.68u as=0 ps=0 w=1u l=1u
X1588 VSS.t2778 VDD VSS.t2624 VSS.t206 sg13_lv_nmos ad=79.8f pd=0.8u as=0 ps=0 w=0.42u l=1u
X1589 VDD VSS.t981 VDD VDD sg13_lv_pmos ad=0.19p pd=1.38u as=0 ps=0 w=1u l=1u
X1590 VDD VSS.t2489 VDD VDD sg13_lv_pmos ad=0.19p pd=1.38u as=0 ps=0 w=1u l=1u
X1591 VSS.t171 a_19054_15423# sg13cmos5l_dlygate4sd3_1_4.X VSS.t107 sg13_lv_nmos ad=0.1426p pd=1.16u as=0.2516p ps=2.16u w=0.74u l=0.13u
X1592 a_16356_13735# a_16587_13844# a_16042_13945# VSS.t48 sg13_lv_nmos ad=0.2373p pd=1.97u as=79.8f ps=0.8u w=0.42u l=0.13u
X1593 VDD a_19323_13726# sg13cmos5l_buf_8_2.X VDD sg13_lv_pmos ad=0.2128p pd=1.5u as=0.2128p ps=1.5u w=1.12u l=0.13u
X1594 VDD VSS.t602 VDD VDD sg13_lv_pmos ad=0.19p pd=1.38u as=0 ps=0 w=1u l=1u
X1595 VSS.t1678 VDD VSS.t1680 VSS.t1679 sg13_lv_nmos ad=79.8f pd=0.8u as=0 ps=0 w=0.42u l=1u
X1596 VSS.t2095 VDD VSS.t2097 VSS.t2096 sg13_lv_nmos ad=79.8f pd=0.8u as=0 ps=0 w=0.42u l=1u
X1597 a_16294_13735# sg13cmos5l_dfrbpq_1_2.RESET_B VSS.t44 VSS.t253 sg13_lv_nmos ad=37.8f pd=0.6u as=0.1701p ps=1.65u w=0.42u l=0.13u
X1598 a_25956_13722# sg13cmos5l_dfrbpq_1_5.D a_25862_13722# VSS.t170 sg13_lv_nmos ad=60.89999f pd=0.71u as=0.1428p ps=1.52u w=0.42u l=0.13u
X1599 VSS.t849 VDD VSS.t851 VSS.t850 sg13_lv_nmos ad=79.8f pd=0.8u as=0 ps=0 w=0.42u l=1u
X1600 VSS.t969 VDD VSS.t971 VSS.t970 sg13_lv_nmos ad=79.8f pd=0.8u as=0 ps=0 w=0.42u l=1u
X1601 VDD VSS.t1989 VDD VDD sg13_lv_pmos ad=0.34p pd=2.68u as=0 ps=0 w=1u l=1u
X1602 VSS.t526 VDD VSS.t525 VSS.t524 sg13_lv_nmos ad=0.1428p pd=1.52u as=0 ps=0 w=0.42u l=1u
X1603 VSS.t1014 VDD VSS.t1016 VSS.t1015 sg13_lv_nmos ad=79.8f pd=0.8u as=0 ps=0 w=0.42u l=1u
X1604 VDD VSS.t3111 VDD VDD sg13_lv_pmos ad=0.19p pd=1.38u as=0 ps=0 w=1u l=1u
X1605 sg13cmos5l_nor2_1_0.B a_16140_15424# VDD VDD sg13_lv_pmos ad=0.2408p pd=1.55u as=0.3808p ps=2.92u w=1.12u l=0.13u
X1606 VSS.t2694 VDD VSS.t2693 VSS.t206 sg13_lv_nmos ad=0.1428p pd=1.52u as=0 ps=0 w=0.42u l=1u
X1607 VSS.t450 VDD VSS.t196 VSS.t449 sg13_lv_nmos ad=0.1428p pd=1.52u as=0 ps=0 w=0.42u l=1u
X1608 VDD VSS.t2687 VDD VDD sg13_lv_pmos ad=0.19p pd=1.38u as=0 ps=0 w=1u l=1u
X1609 VDD VSS.t1937 VDD VDD sg13_lv_pmos ad=0.19p pd=1.38u as=0 ps=0 w=1u l=1u
X1610 VSS.t2352 VDD VSS.t2351 VSS.t2350 sg13_lv_nmos ad=0.1428p pd=1.52u as=0 ps=0 w=0.42u l=1u
X1611 VSS.t2045 VDD VSS.t2047 VSS.t2046 sg13_lv_nmos ad=79.8f pd=0.8u as=0 ps=0 w=0.42u l=1u
X1612 VSS.t1608 VDD VSS.t1610 VSS.t1609 sg13_lv_nmos ad=79.8f pd=0.8u as=0 ps=0 w=0.42u l=1u
X1613 VSS.t3129 VDD VSS.t3131 VSS.t3130 sg13_lv_nmos ad=79.8f pd=0.8u as=0 ps=0 w=0.42u l=1u
X1614 VSS.t2660 VDD VSS.t2658 VSS.t206 sg13_lv_nmos ad=0.1428p pd=1.52u as=0 ps=0 w=0.42u l=1u
X1615 VDD VSS.t2284 VDD VDD sg13_lv_pmos ad=0.19p pd=1.38u as=0 ps=0 w=1u l=1u
X1616 VDD VSS.t1164 VDD VDD sg13_lv_pmos ad=0.34p pd=2.68u as=0 ps=0 w=1u l=1u
X1617 VDD VSS.t1620 VDD VDD sg13_lv_pmos ad=0.19p pd=1.38u as=0 ps=0 w=1u l=1u
X1618 VSS.t2000 VDD VSS.t1999 VSS.t1998 sg13_lv_nmos ad=0.1428p pd=1.52u as=0 ps=0 w=0.42u l=1u
X1619 VSS.t163 a_25786_15960# a_25505_16262# VSS.t255 sg13_lv_nmos ad=79.8f pd=0.8u as=0.1428p ps=1.52u w=0.42u l=0.5u
X1620 VDD VSS.t818 VDD VDD sg13_lv_pmos ad=0.34p pd=2.68u as=0 ps=0 w=1u l=1u
X1621 VDD VSS.t1572 VDD VDD sg13_lv_pmos ad=0.34p pd=2.68u as=0 ps=0 w=1u l=1u
X1622 VSS.t2417 VDD VSS.t2419 VSS.t2418 sg13_lv_nmos ad=79.8f pd=0.8u as=0 ps=0 w=0.42u l=1u
X1623 VSS.t1890 VDD VSS.t1892 VSS.t1891 sg13_lv_nmos ad=79.8f pd=0.8u as=0 ps=0 w=0.42u l=1u
X1624 VSS.t1309 VDD VSS.t1308 VSS.t1154 sg13_lv_nmos ad=0.1428p pd=1.52u as=0 ps=0 w=0.42u l=1u
X1625 VDD VSS.t1627 VDD VDD sg13_lv_pmos ad=0.34p pd=2.68u as=0 ps=0 w=1u l=1u
X1626 VDD VSS.t2446 VDD VDD sg13_lv_pmos ad=0.34p pd=2.68u as=0 ps=0 w=1u l=1u
X1627 a_8218_13690# sg13cmos5l_dlygate4sd3_1_1.A VSS.t257 VSS.t3288 sg13_lv_nmos ad=0.1428p pd=1.52u as=79.8f ps=0.8u w=0.42u l=0.13u
X1628 VSS.t16 a_17126_15238# a_17238_15302# VSS.t3170 sg13_lv_nmos ad=0.1426p pd=1.16u as=0.1428p ps=1.52u w=0.42u l=0.5u
X1629 a_16042_13945# a_16485_13701# a_16425_14113# VDD sg13_lv_pmos ad=79.8f pd=0.8u as=63f ps=0.72u w=0.42u l=0.13u
X1630 VDD VSS.t871 VDD VDD sg13_lv_pmos ad=0.19p pd=1.38u as=0 ps=0 w=1u l=1u
X1631 VSS.t1314 VDD VSS.t1312 VSS.t1154 sg13_lv_nmos ad=0.1428p pd=1.52u as=0 ps=0 w=0.42u l=1u
X1632 VDD VSS.t555 VDD VDD sg13_lv_pmos ad=0.34p pd=2.68u as=0 ps=0 w=1u l=1u
X1633 VSS.t1840 VDD VSS.t1842 VSS.t1841 sg13_lv_nmos ad=79.8f pd=0.8u as=0 ps=0 w=0.42u l=1u
X1634 VDD VSS.t1315 VDD VDD sg13_lv_pmos ad=0.19p pd=1.38u as=0 ps=0 w=1u l=1u
X1635 VSS.t2704 VDD VSS.t2703 VSS.t206 sg13_lv_nmos ad=0.1428p pd=1.52u as=0 ps=0 w=0.42u l=1u
X1636 VSS.t79 sg13cmos5l_inv_1_0.Y a_18454_16374# VSS.t3222 sg13_lv_nmos ad=0.1406p pd=1.12u as=0.2516p ps=2.16u w=0.74u l=0.15u
X1637 VDD VSS.t377 VDD VDD sg13_lv_pmos ad=0.34p pd=2.68u as=0 ps=0 w=1u l=1u
X1638 VSS.t608 VDD VSS.t611 VSS.t743 sg13_lv_nmos ad=79.8f pd=0.8u as=0 ps=0 w=0.42u l=1u
X1639 VDD VSS.t2680 VDD VDD sg13_lv_pmos ad=0.19p pd=1.38u as=0 ps=0 w=1u l=1u
X1640 VDD VSS.t1957 VDD VDD sg13_lv_pmos ad=0.19p pd=1.38u as=0 ps=0 w=1u l=1u
X1641 VDD VSS.t3063 VDD VDD sg13_lv_pmos ad=0.34p pd=2.68u as=0 ps=0 w=1u l=1u
X1642 VDD VSS.t2276 VDD VDD sg13_lv_pmos ad=0.34p pd=2.68u as=0 ps=0 w=1u l=1u
X1643 VDD VSS.t1600 VDD VDD sg13_lv_pmos ad=0.19p pd=1.38u as=0 ps=0 w=1u l=1u
X1644 VSS.t1195 VDD VSS.t1196 VSS.t1154 sg13_lv_nmos ad=79.8f pd=0.8u as=0 ps=0 w=0.42u l=1u
X1645 VDD VSS.t973 VDD VDD sg13_lv_pmos ad=0.34p pd=2.68u as=0 ps=0 w=1u l=1u
X1646 VDD VSS.t1640 VDD VDD sg13_lv_pmos ad=0.19p pd=1.38u as=0 ps=0 w=1u l=1u
X1647 VDD VSS.t134 VDD VDD sg13_lv_pmos ad=0.34p pd=2.68u as=0 ps=0 w=1u l=1u
X1648 VSS.t4 a_26638_15423# sg13cmos5l_o21ai_1_2.B1 VSS.t3209 sg13_lv_nmos ad=0.1426p pd=1.16u as=0.2516p ps=2.16u w=0.74u l=0.13u
X1649 VDD VSS.t911 VDD VDD sg13_lv_pmos ad=0.19p pd=1.38u as=0 ps=0 w=1u l=1u
X1650 VSS.t1563 VDD VSS.t1562 VSS.t1561 sg13_lv_nmos ad=0.1428p pd=1.52u as=0 ps=0 w=0.42u l=1u
X1651 VSS.t3084 VDD VSS.t3083 VSS.t3082 sg13_lv_nmos ad=0.1428p pd=1.52u as=0 ps=0 w=0.42u l=1u
X1652 VDD VSS.t2289 VDD VDD sg13_lv_pmos ad=0.19p pd=1.38u as=0 ps=0 w=1u l=1u
X1653 VSS.t2615 VDD VSS.t2616 VSS.t206 sg13_lv_nmos ad=79.8f pd=0.8u as=0 ps=0 w=0.42u l=1u
X1654 VSS.t779 VDD VSS.t781 VSS.t780 sg13_lv_nmos ad=79.8f pd=0.8u as=0 ps=0 w=0.42u l=1u
X1655 VDD VSS.t2767 VDD VDD sg13_lv_pmos ad=0.19p pd=1.38u as=0 ps=0 w=1u l=1u
X1656 VDD VSS.t69 VDD VDD sg13_lv_pmos ad=0.34p pd=2.68u as=0 ps=0 w=1u l=1u
X1657 sg13cmos5l_dlygate4sd3_1_5.A sg13cmos5l_or3_1_2.B a_18552_15976# VDD sg13_lv_pmos ad=0.2128p pd=1.5u as=0.2128p ps=1.5u w=1.12u l=0.15u
X1658 VDD VSS.t1 VDD VDD sg13_lv_pmos ad=0.34p pd=2.68u as=0 ps=0 w=1u l=1u
X1659 VDD VSS.t632 VDD VDD sg13_lv_pmos ad=0.34p pd=2.68u as=0 ps=0 w=1u l=1u
X1660 VSS.t849 VDD VSS.t851 VSS.t850 sg13_lv_nmos ad=79.8f pd=0.8u as=0 ps=0 w=0.42u l=1u
X1661 VDD VSS.t838 VDD VDD sg13_lv_pmos ad=0.34p pd=2.68u as=0 ps=0 w=1u l=1u
X1662 VSS.t1860 VDD VSS.t1862 VSS.t1861 sg13_lv_nmos ad=79.8f pd=0.8u as=0 ps=0 w=0.42u l=1u
X1663 VSS.t1014 VDD VSS.t1016 VSS.t1015 sg13_lv_nmos ad=79.8f pd=0.8u as=0 ps=0 w=0.42u l=1u
X1664 VDD VSS.t1266 VDD VDD sg13_lv_pmos ad=0.34p pd=2.68u as=0 ps=0 w=1u l=1u
X1665 VSS.t593 VDD VSS.t187 VSS.t592 sg13_lv_nmos ad=0.1428p pd=1.52u as=0 ps=0 w=0.42u l=1u
X1666 VDD VSS.t93 VDD VDD sg13_lv_pmos ad=0.19p pd=1.38u as=0 ps=0 w=1u l=1u
X1667 VSS.t2402 VDD VSS.t2404 VSS.t2403 sg13_lv_nmos ad=79.8f pd=0.8u as=0 ps=0 w=0.42u l=1u
X1668 VDD VSS.t1974 VDD VDD sg13_lv_pmos ad=0.34p pd=2.68u as=0 ps=0 w=1u l=1u
X1669 VDD sg13cmos5l_nand3_1_0.Y a_7680_15549# VDD sg13_lv_pmos ad=0.2891p pd=1.695u as=0.1596p ps=1.22u w=0.84u l=0.13u
X1670 VDD VSS.t2344 VDD VDD sg13_lv_pmos ad=0.19p pd=1.38u as=0 ps=0 w=1u l=1u
X1671 VSS.t401 VDD VSS.t402 VSS.t4 sg13_lv_nmos ad=79.8f pd=0.8u as=0 ps=0 w=0.42u l=1u
X1672 VSS.t874 VDD VSS.t873 VSS.t872 sg13_lv_nmos ad=0.1428p pd=1.52u as=0 ps=0 w=0.42u l=1u
X1673 VDD VSS.t2099 VDD VDD sg13_lv_pmos ad=0.34p pd=2.68u as=0 ps=0 w=1u l=1u
X1674 VSS.t1209 VDD VSS.t1210 VSS.t1154 sg13_lv_nmos ad=79.8f pd=0.8u as=0 ps=0 w=0.42u l=1u
X1675 VSS.t1950 VDD VSS.t1952 VSS.t1951 sg13_lv_nmos ad=79.8f pd=0.8u as=0 ps=0 w=0.42u l=1u
X1676 VDD VSS.t1303 VDD VDD sg13_lv_pmos ad=0.19p pd=1.38u as=0 ps=0 w=1u l=1u
X1677 VSS.t1985 VDD VSS.t1984 VSS.t1983 sg13_lv_nmos ad=0.1428p pd=1.52u as=0 ps=0 w=0.42u l=1u
X1678 VSS.t629 VDD VSS.t629 VSS.t630 sg13_lv_nmos ad=79.8f pd=0.8u as=0 ps=0 w=0.42u l=1u
X1679 sg13cmos5l_nand3_1_0.Y sg13cmos5l_buf_1_0.X VDD VDD sg13_lv_pmos ad=0.3808p pd=2.92u as=0.2128p ps=1.5u w=1.12u l=0.13u
X1680 VSS.t1173 VDD VSS.t1172 VSS.t1154 sg13_lv_nmos ad=0.1428p pd=1.52u as=0 ps=0 w=0.42u l=1u
X1681 VSS.t934 VDD VSS.t936 VSS.t935 sg13_lv_nmos ad=79.8f pd=0.8u as=0 ps=0 w=0.42u l=1u
X1682 VDD VSS.t1557 VDD VDD sg13_lv_pmos ad=0.34p pd=2.68u as=0 ps=0 w=1u l=1u
X1683 VSS.t16 sg13cmos5l_a21oi_1_0.Y a_16856_15238# VSS.t3168 sg13_lv_nmos ad=79.8f pd=0.8u as=0.1428p ps=1.52u w=0.42u l=0.13u
X1684 VSS.t573 VDD VSS.t573 VSS.t694 sg13_lv_nmos ad=0.1428p pd=1.52u as=0 ps=0 w=0.42u l=1u
X1685 VDD VSS.t801 VDD VDD sg13_lv_pmos ad=0.19p pd=1.38u as=0 ps=0 w=1u l=1u
X1686 VDD VSS.t1612 VDD VDD sg13_lv_pmos ad=0.34p pd=2.68u as=0 ps=0 w=1u l=1u
X1687 VSS.t2984 VDD VSS.t2986 VSS.t2985 sg13_lv_nmos ad=79.8f pd=0.8u as=0 ps=0 w=0.42u l=1u
X1688 VSS.t2357 VDD VSS.t2356 VSS.t2355 sg13_lv_nmos ad=0.1428p pd=1.52u as=0 ps=0 w=0.42u l=1u
X1689 VSS.t1900 VDD VSS.t1902 VSS.t1901 sg13_lv_nmos ad=79.8f pd=0.8u as=0 ps=0 w=0.42u l=1u
X1690 VDD VSS.t2926 VDD VDD sg13_lv_pmos ad=0.19p pd=1.38u as=0 ps=0 w=1u l=1u
X1691 a_22030_15423# a_22145_15424# VDD VDD sg13_lv_pmos ad=0.34p pd=2.68u as=0.2254p ps=1.53u w=1u l=0.5u
X1692 VDD VSS.t555 VDD VDD sg13_lv_pmos ad=0.34p pd=2.68u as=0 ps=0 w=1u l=1u
X1693 VSS.t1683 VDD VSS.t1685 VSS.t1684 sg13_lv_nmos ad=79.8f pd=0.8u as=0 ps=0 w=0.42u l=1u
X1694 a_18106_15960# sg13cmos5l_dlygate4sd3_1_5.A VDD VDD sg13_lv_pmos ad=0.1428p pd=1.52u as=0.1523p ps=1.38u w=0.42u l=0.13u
X1695 VSS.t2769 VDD VSS.t2770 VSS.t206 sg13_lv_nmos ad=79.8f pd=0.8u as=0 ps=0 w=0.42u l=1u
X1696 VDD VSS.t2336 VDD VDD sg13_lv_pmos ad=0.34p pd=2.68u as=0 ps=0 w=1u l=1u
X1697 VDD VSS.t1994 VDD VDD sg13_lv_pmos ad=0.34p pd=2.68u as=0 ps=0 w=1u l=1u
X1698 sg13cmos5l_o21ai_1_1.Y sg13cmos5l_or3_1_2.A a_20278_14862# VSS.t13 sg13_lv_nmos ad=0.2516p pd=2.16u as=0.1406p ps=1.12u w=0.74u l=0.15u
X1699 VDD VSS.t1306 VDD VDD sg13_lv_pmos ad=0.19p pd=1.38u as=0 ps=0 w=1u l=1u
X1700 VSS.t66 VDD VSS.t66 VSS.t502 sg13_lv_nmos ad=0.1428p pd=1.52u as=0 ps=0 w=0.42u l=1u
X1701 VSS.t2696 VDD VSS.t2696 VSS.t206 sg13_lv_nmos ad=0.1428p pd=1.52u as=0 ps=0 w=0.42u l=1u
X1702 VSS.t1261 VDD VSS.t1260 VSS.t1154 sg13_lv_nmos ad=0.1428p pd=1.52u as=0 ps=0 w=0.42u l=1u
X1703 VDD VSS.t2672 VDD VDD sg13_lv_pmos ad=0.19p pd=1.38u as=0 ps=0 w=1u l=1u
X1704 VDD VSS.t1942 VDD VDD sg13_lv_pmos ad=0.19p pd=1.38u as=0 ps=0 w=1u l=1u
X1705 VDD VSS.t441 VDD VDD sg13_lv_pmos ad=0.19p pd=1.38u as=0 ps=0 w=1u l=1u
X1706 VDD VSS.t1284 VDD VDD sg13_lv_pmos ad=0.34p pd=2.68u as=0 ps=0 w=1u l=1u
X1707 VSS.t2322 VDD VSS.t2321 VSS.t2320 sg13_lv_nmos ad=0.1428p pd=1.52u as=0 ps=0 w=0.42u l=1u
X1708 VDD sg13cmos5l_a21oi_1_0.A1 a_16955_14484# VDD sg13_lv_pmos ad=0.2128p pd=1.5u as=0.2128p ps=1.5u w=1.12u l=0.13u
X1709 VDD VSS.t578 VDD VDD sg13_lv_pmos ad=0.19p pd=1.38u as=0 ps=0 w=1u l=1u
X1710 VSS.t611 VDD VSS.t608 VSS.t610 sg13_lv_nmos ad=0.1428p pd=1.52u as=0 ps=0 w=0.42u l=1u
X1711 VDD VSS.t1018 VDD VDD sg13_lv_pmos ad=0.34p pd=2.68u as=0 ps=0 w=1u l=1u
X1712 VSS.t1613 VDD VSS.t1615 VSS.t1614 sg13_lv_nmos ad=79.8f pd=0.8u as=0 ps=0 w=0.42u l=1u
X1713 VSS.t3134 VDD VSS.t3136 VSS.t3135 sg13_lv_nmos ad=79.8f pd=0.8u as=0 ps=0 w=0.42u l=1u
X1714 sg13cmos5l_buf_8_2.A a_15579_14854# VSS.t16 VSS.t3245 sg13_lv_nmos ad=0.1406p pd=1.12u as=0.1406p ps=1.12u w=0.74u l=0.13u
X1715 VSS.t231 VDD VSS.t231 VSS.t366 sg13_lv_nmos ad=0.1428p pd=1.52u as=0 ps=0 w=0.42u l=1u
X1716 VDD VSS.t405 VDD VDD sg13_lv_pmos ad=0.19p pd=1.38u as=0 ps=0 w=1u l=1u
X1717 VSS.t904 VDD VSS.t903 VSS.t902 sg13_lv_nmos ad=0.1428p pd=1.52u as=0 ps=0 w=0.42u l=1u
X1718 VSS.t2422 VDD VSS.t2424 VSS.t2423 sg13_lv_nmos ad=79.8f pd=0.8u as=0 ps=0 w=0.42u l=1u
X1719 a_17126_15238# a_16856_15238# VDD VDD sg13_lv_pmos ad=0.34p pd=2.68u as=0.1523p ps=1.38u w=1u l=0.5u
X1720 VSS.t779 VDD VSS.t781 VSS.t780 sg13_lv_nmos ad=79.8f pd=0.8u as=0 ps=0 w=0.42u l=1u
X1721 VDD VSS.t956 VDD VDD sg13_lv_pmos ad=0.19p pd=1.38u as=0 ps=0 w=1u l=1u
X1722 VDD VSS.t1238 VDD VDD sg13_lv_pmos ad=0.19p pd=1.38u as=0 ps=0 w=1u l=1u
X1723 VSS.t2695 VDD VSS.t2694 VSS.t206 sg13_lv_nmos ad=0.1428p pd=1.52u as=0 ps=0 w=0.42u l=1u
X1724 VDD VSS.t2451 VDD VDD sg13_lv_pmos ad=0.34p pd=2.68u as=0 ps=0 w=1u l=1u
X1725 VSS.t328 VDD VSS.t327 VSS.t326 sg13_lv_nmos ad=0.1428p pd=1.52u as=0 ps=0 w=0.42u l=1u
X1726 sg13cmos5l_xnor2_1_2.B sg13cmos5l_dlygate4sd3_1_3.A VDD VDD sg13_lv_pmos ad=0.2128p pd=1.5u as=0.3808p ps=2.92u w=1.12u l=0.13u
X1727 VDD a_10618_14448# a_10337_14750# VDD sg13_lv_pmos ad=0.1523p pd=1.38u as=0.34p ps=2.68u w=1u l=0.5u
X1728 VDD a_17327_13799# a_17584_13942# VDD sg13_lv_pmos ad=2.42015p pd=15.68u as=79.8f ps=0.8u w=0.42u l=0.13u
X1729 VSS.t1643 VDD VSS.t1642 VSS.t1641 sg13_lv_nmos ad=0.1428p pd=1.52u as=0 ps=0 w=0.42u l=1u
X1730 VDD VSS.t2911 VDD VDD sg13_lv_pmos ad=0.19p pd=1.38u as=0 ps=0 w=1u l=1u
X1731 VDD VSS.t2758 VDD VDD sg13_lv_pmos ad=0.19p pd=1.38u as=0 ps=0 w=1u l=1u
X1732 VDD VSS.t257 VDD VDD sg13_lv_pmos ad=0.19p pd=1.38u as=0 ps=0 w=1u l=1u
X1733 VDD a_21466_15202# a_21185_15424# VDD sg13_lv_pmos ad=0.1523p pd=1.38u as=0.34p ps=2.68u w=1u l=0.5u
X1734 a_16356_13735# a_16068_14040# a_16294_13735# VSS.t3213 sg13_lv_nmos ad=0.1428p pd=1.52u as=37.8f ps=0.6u w=0.42u l=0.13u
X1735 VSS.t216 VDD VSS.t103 VSS.t652 sg13_lv_nmos ad=0.1428p pd=1.52u as=0 ps=0 w=0.42u l=1u
X1736 VDD VSS.t2729 VDD VDD sg13_lv_pmos ad=0.34p pd=2.68u as=0 ps=0 w=1u l=1u
X1737 VSS.t66 VDD VSS.t66 VSS.t504 sg13_lv_nmos ad=0.1428p pd=1.52u as=0 ps=0 w=0.42u l=1u
X1738 VSS.t583 VDD VSS.t580 VSS.t708 sg13_lv_nmos ad=0.1428p pd=1.52u as=0 ps=0 w=0.42u l=1u
X1739 VDD VSS.t588 VDD VDD sg13_lv_pmos ad=0.19p pd=1.38u as=0 ps=0 w=1u l=1u
X1740 VSS.t2929 VDD VSS.t2931 VSS.t2930 sg13_lv_nmos ad=79.8f pd=0.8u as=0 ps=0 w=0.42u l=1u
X1741 VSS.t1845 VDD VSS.t1847 VSS.t1846 sg13_lv_nmos ad=79.8f pd=0.8u as=0 ps=0 w=0.42u l=1u
X1742 VDD VSS.t1163 VDD VDD sg13_lv_pmos ad=0.19p pd=1.38u as=0 ps=0 w=1u l=1u
X1743 VDD VSS.t1318 VDD VDD sg13_lv_pmos ad=0.19p pd=1.38u as=0 ps=0 w=1u l=1u
X1744 VSS.t1638 VDD VSS.t1637 VSS.t1636 sg13_lv_nmos ad=0.1428p pd=1.52u as=0 ps=0 w=0.42u l=1u
X1745 VSS.t428 VDD VSS.t429 VSS.t4 sg13_lv_nmos ad=79.8f pd=0.8u as=0 ps=0 w=0.42u l=1u
X1746 VDD VSS.t421 VDD VDD sg13_lv_pmos ad=0.34p pd=2.68u as=0 ps=0 w=1u l=1u
X1747 VDD VSS.t831 VDD VDD sg13_lv_pmos ad=0.19p pd=1.38u as=0 ps=0 w=1u l=1u
X1748 VSS.t874 VDD VSS.t873 VSS.t872 sg13_lv_nmos ad=0.1428p pd=1.52u as=0 ps=0 w=0.42u l=1u
X1749 VSS.t1275 VDD VSS.t1273 VSS.t1154 sg13_lv_nmos ad=0.1428p pd=1.52u as=0 ps=0 w=0.42u l=1u
X1750 VDD VSS.t2329 VDD VDD sg13_lv_pmos ad=0.19p pd=1.38u as=0 ps=0 w=1u l=1u
X1751 VSS.t2387 VDD VSS.t2389 VSS.t2388 sg13_lv_nmos ad=79.8f pd=0.8u as=0 ps=0 w=0.42u l=1u
X1752 VDD VSS.t2682 VDD VDD sg13_lv_pmos ad=0.19p pd=1.38u as=0 ps=0 w=1u l=1u
X1753 VDD VSS.t1927 VDD VDD sg13_lv_pmos ad=0.19p pd=1.38u as=0 ps=0 w=1u l=1u
X1754 VDD VSS.t3068 VDD VDD sg13_lv_pmos ad=0.34p pd=2.68u as=0 ps=0 w=1u l=1u
X1755 VSS.t2342 VDD VSS.t2341 VSS.t2340 sg13_lv_nmos ad=0.1428p pd=1.52u as=0 ps=0 w=0.42u l=1u
X1756 VDD VSS.t2281 VDD VDD sg13_lv_pmos ad=0.34p pd=2.68u as=0 ps=0 w=1u l=1u
X1757 VDD VSS.t723 VDD VDD sg13_lv_pmos ad=0.34p pd=2.68u as=0 ps=0 w=1u l=1u
X1758 VDD VSS.t1610 VDD VDD sg13_lv_pmos ad=0.19p pd=1.38u as=0 ps=0 w=1u l=1u
X1759 VSS.t526 VDD VSS.t525 VSS.t524 sg13_lv_nmos ad=0.1428p pd=1.52u as=0 ps=0 w=0.42u l=1u
X1760 VDD VSS.t1218 VDD VDD sg13_lv_pmos ad=0.34p pd=2.68u as=0 ps=0 w=1u l=1u
X1761 VDD a_7888_14726# a_7833_14607# VDD sg13_lv_pmos ad=2.42015p pd=15.68u as=93.45f ps=0.865u w=0.42u l=0.13u
X1762 sg13cmos5l_buf_8_2.A a_15579_14854# VSS.t16 VSS.t3241 sg13_lv_nmos ad=0.1406p pd=1.12u as=0.1406p ps=1.12u w=0.74u l=0.13u
X1763 VSS.t934 VDD VSS.t936 VSS.t935 sg13_lv_nmos ad=79.8f pd=0.8u as=0 ps=0 w=0.42u l=1u
X1764 VDD VSS.t1665 VDD VDD sg13_lv_pmos ad=0.19p pd=1.38u as=0 ps=0 w=1u l=1u
X1765 VSS.t377 VDD VSS.t377 VSS.t7 sg13_lv_nmos ad=0.1428p pd=1.52u as=0 ps=0 w=0.42u l=1u
X1766 VSS.t509 VDD VSS.t509 VSS.t512 sg13_lv_nmos ad=0.1428p pd=1.52u as=0 ps=0 w=0.42u l=1u
X1767 VDD VSS.t553 VDD VDD sg13_lv_pmos ad=0.19p pd=1.38u as=0 ps=0 w=1u l=1u
X1768 VSS.t979 VDD VSS.t981 VSS.t980 sg13_lv_nmos ad=79.8f pd=0.8u as=0 ps=0 w=0.42u l=1u
X1769 VDD VSS.t1195 VDD VDD sg13_lv_pmos ad=0.19p pd=1.38u as=0 ps=0 w=1u l=1u
X1770 VDD VSS.t2749 VDD VDD sg13_lv_pmos ad=0.19p pd=1.38u as=0 ps=0 w=1u l=1u
X1771 VSS.t2065 VDD VSS.t2064 VSS.t2063 sg13_lv_nmos ad=0.1428p pd=1.52u as=0 ps=0 w=0.42u l=1u
X1772 VDD VSS.t270 VDD VDD sg13_lv_pmos ad=0.19p pd=1.38u as=0 ps=0 w=1u l=1u
X1773 VSS.t1628 VDD VSS.t1627 VSS.t1626 sg13_lv_nmos ad=0.1428p pd=1.52u as=0 ps=0 w=0.42u l=1u
X1774 VSS.t3149 VDD VSS.t3148 VSS.t3147 sg13_lv_nmos ad=0.1428p pd=1.52u as=0 ps=0 w=0.42u l=1u
X1775 VSS.t2969 VDD VSS.t2971 VSS.t2970 sg13_lv_nmos ad=79.8f pd=0.8u as=0 ps=0 w=0.42u l=1u
X1776 a_6346_14452# a_6789_14495# a_6729_14531# VDD sg13_lv_pmos ad=79.8f pd=0.8u as=63f ps=0.72u w=0.42u l=0.13u
X1777 VSS.t2689 VDD VSS.t2690 VSS.t206 sg13_lv_nmos ad=79.8f pd=0.8u as=0 ps=0 w=0.42u l=1u
X1778 VDD VSS.t302 VDD VDD sg13_lv_pmos ad=0.19p pd=1.38u as=0 ps=0 w=1u l=1u
X1779 VDD VSS.t986 VDD VDD sg13_lv_pmos ad=0.19p pd=1.38u as=0 ps=0 w=1u l=1u
X1780 VSS.t2760 VDD VSS.t2761 VSS.t206 sg13_lv_nmos ad=79.8f pd=0.8u as=0 ps=0 w=0.42u l=1u
X1781 VSS.t410 VDD VSS.t409 VSS.t4 sg13_lv_nmos ad=0.1428p pd=1.52u as=0 ps=0 w=0.42u l=1u
X1782 VDD VSS.t783 VDD VDD sg13_lv_pmos ad=0.34p pd=2.68u as=0 ps=0 w=1u l=1u
X1783 VDD VSS.t1979 VDD VDD sg13_lv_pmos ad=0.34p pd=2.68u as=0 ps=0 w=1u l=1u
X1784 VSS.t593 VDD VSS.t596 VSS.t733 sg13_lv_nmos ad=79.8f pd=0.8u as=0 ps=0 w=0.42u l=1u
X1785 VDD VSS.t3101 VDD VDD sg13_lv_pmos ad=0.19p pd=1.38u as=0 ps=0 w=1u l=1u
X1786 VDD VSS.t2349 VDD VDD sg13_lv_pmos ad=0.19p pd=1.38u as=0 ps=0 w=1u l=1u
X1787 VSS.t2372 VDD VSS.t2374 VSS.t2373 sg13_lv_nmos ad=79.8f pd=0.8u as=0 ps=0 w=0.42u l=1u
X1788 VDD VSS.t2104 VDD VDD sg13_lv_pmos ad=0.34p pd=2.68u as=0 ps=0 w=1u l=1u
X1789 VSS.t1538 VDD VSS.t1540 VSS.t1539 sg13_lv_nmos ad=79.8f pd=0.8u as=0 ps=0 w=0.42u l=1u
X1790 VDD VSS.t2761 VDD VDD sg13_lv_pmos ad=0.34p pd=2.68u as=0 ps=0 w=1u l=1u
X1791 VSS.t1955 VDD VSS.t1957 VSS.t1956 sg13_lv_nmos ad=79.8f pd=0.8u as=0 ps=0 w=0.42u l=1u
X1792 VSS.t396 VDD VSS.t147 VSS.t465 sg13_lv_nmos ad=0.1428p pd=1.52u as=0 ps=0 w=0.42u l=1u
X1793 VSS.t2687 VDD VSS.t2688 VSS.t206 sg13_lv_nmos ad=79.8f pd=0.8u as=0 ps=0 w=0.42u l=1u
X1794 VSS.t1598 VDD VSS.t1600 VSS.t1599 sg13_lv_nmos ad=79.8f pd=0.8u as=0 ps=0 w=0.42u l=1u
X1795 VSS.t3119 VDD VSS.t3121 VSS.t3120 sg13_lv_nmos ad=79.8f pd=0.8u as=0 ps=0 w=0.42u l=1u
X1796 VDD VSS.t432 VDD VDD sg13_lv_pmos ad=0.19p pd=1.38u as=0 ps=0 w=1u l=1u
X1797 VSS.t904 VDD VSS.t903 VSS.t902 sg13_lv_nmos ad=0.1428p pd=1.52u as=0 ps=0 w=0.42u l=1u
X1798 VSS.t1293 VDD VSS.t1292 VSS.t1154 sg13_lv_nmos ad=0.1428p pd=1.52u as=0 ps=0 w=0.42u l=1u
X1799 a_26244_14909# a_25956_14488# a_26182_14909# VSS.t237 sg13_lv_nmos ad=0.1428p pd=1.52u as=37.8f ps=0.6u w=0.42u l=0.13u
X1800 VDD VSS.t1001 VDD VDD sg13_lv_pmos ad=0.19p pd=1.38u as=0 ps=0 w=1u l=1u
X1801 VDD VSS.t1265 VDD VDD sg13_lv_pmos ad=0.19p pd=1.38u as=0 ps=0 w=1u l=1u
X1802 VSS.t377 VDD VSS.t377 VSS.t381 sg13_lv_nmos ad=0.1428p pd=1.52u as=0 ps=0 w=0.42u l=1u
X1803 VDD VSS.t1562 VDD VDD sg13_lv_pmos ad=0.34p pd=2.68u as=0 ps=0 w=1u l=1u
X1804 a_19450_15202# sg13cmos5l_dfrbpq_1_3.Q VDD VDD sg13_lv_pmos ad=0.1428p pd=1.52u as=0.1523p ps=1.38u w=0.42u l=0.13u
X1805 VDD VSS.t1617 VDD VDD sg13_lv_pmos ad=0.34p pd=2.68u as=0 ps=0 w=1u l=1u
X1806 VSS.t2989 VDD VSS.t2991 VSS.t2990 sg13_lv_nmos ad=79.8f pd=0.8u as=0 ps=0 w=0.42u l=1u
X1807 VSS.t1905 VDD VSS.t1907 VSS.t1906 sg13_lv_nmos ad=79.8f pd=0.8u as=0 ps=0 w=0.42u l=1u
X1808 a_20603_15532# sg13cmos5l_or3_1_2.X VDD VDD sg13_lv_pmos ad=0.3808p pd=2.92u as=0.2128p ps=1.5u w=1.12u l=0.13u
X1809 VDD VSS.t2896 VDD VDD sg13_lv_pmos ad=0.19p pd=1.38u as=0 ps=0 w=1u l=1u
X1810 VSS.t1312 VDD VSS.t1311 VSS.t1154 sg13_lv_nmos ad=0.1428p pd=1.52u as=0 ps=0 w=0.42u l=1u
X1811 VSS.t1688 VDD VSS.t1690 VSS.t1689 sg13_lv_nmos ad=79.8f pd=0.8u as=0 ps=0 w=0.42u l=1u
X1812 VDD VSS.t2720 VDD VDD sg13_lv_pmos ad=0.34p pd=2.68u as=0 ps=0 w=1u l=1u
X1813 sg13cmos5l_dfrbpq_1_2.CLK a_12010_15202# VDD VDD sg13_lv_pmos ad=0.2128p pd=1.5u as=0.2128p ps=1.5u w=1.12u l=0.13u
X1814 VDD VSS.t147 VDD VDD sg13_lv_pmos ad=0.34p pd=2.68u as=0 ps=0 w=1u l=1u
X1815 VSS.t86 sg13cmos5l_or3_1_2.B a_20278_14862# VSS.t13 sg13_lv_nmos ad=0.1406p pd=1.12u as=0.2516p ps=2.16u w=0.74u l=0.15u
X1816 VDD VSS.t938 VDD VDD sg13_lv_pmos ad=0.34p pd=2.68u as=0 ps=0 w=1u l=1u
X1817 VDD VSS.t294 VDD VDD sg13_lv_pmos ad=0.19p pd=1.38u as=0 ps=0 w=1u l=1u
X1818 VDD VSS.t2306 VDD VDD sg13_lv_pmos ad=0.34p pd=2.68u as=0 ps=0 w=1u l=1u
X1819 VDD VSS.t1309 VDD VDD sg13_lv_pmos ad=0.19p pd=1.38u as=0 ps=0 w=1u l=1u
X1820 VDD VSS.t2491 VDD VDD sg13_lv_pmos ad=0.34p pd=2.68u as=0 ps=0 w=1u l=1u
X1821 VDD VSS.t1279 VDD VDD sg13_lv_pmos ad=0.34p pd=2.68u as=0 ps=0 w=1u l=1u
X1822 VDD VSS.t2675 VDD VDD sg13_lv_pmos ad=0.19p pd=1.38u as=0 ps=0 w=1u l=1u
X1823 VDD VSS.t2089 VDD VDD sg13_lv_pmos ad=0.34p pd=2.68u as=0 ps=0 w=1u l=1u
X1824 VDD VSS.t1912 VDD VDD sg13_lv_pmos ad=0.19p pd=1.38u as=0 ps=0 w=1u l=1u
X1825 sg13cmos5l_or3_1_2.C sg13cmos5l_dfrbpq_1_2.Q VDD VDD sg13_lv_pmos ad=0.2128p pd=1.5u as=0.3808p ps=2.92u w=1.12u l=0.13u
X1826 VSS.t2327 VDD VSS.t2326 VSS.t2325 sg13_lv_nmos ad=0.1428p pd=1.52u as=0 ps=0 w=0.42u l=1u
X1827 VDD VSS.t2266 VDD VDD sg13_lv_pmos ad=0.34p pd=2.68u as=0 ps=0 w=1u l=1u
X1828 VDD VSS.t412 VDD VDD sg13_lv_pmos ad=0.34p pd=2.68u as=0 ps=0 w=1u l=1u
X1829 VDD VSS.t3053 VDD VDD sg13_lv_pmos ad=0.34p pd=2.68u as=0 ps=0 w=1u l=1u
X1830 VDD VSS.t509 VDD VDD sg13_lv_pmos ad=0.19p pd=1.38u as=0 ps=0 w=1u l=1u
X1831 VSS.t3104 VDD VSS.t3106 VSS.t3105 sg13_lv_nmos ad=79.8f pd=0.8u as=0 ps=0 w=0.42u l=1u
X1832 VDD VSS.t402 VDD VDD sg13_lv_pmos ad=0.19p pd=1.38u as=0 ps=0 w=1u l=1u
X1833 VDD VSS.t1245 VDD VDD sg13_lv_pmos ad=0.34p pd=2.68u as=0 ps=0 w=1u l=1u
X1834 VDD VSS.t553 VDD VDD sg13_lv_pmos ad=0.19p pd=1.38u as=0 ps=0 w=1u l=1u
X1835 VSS.t979 VDD VSS.t981 VSS.t980 sg13_lv_nmos ad=79.8f pd=0.8u as=0 ps=0 w=0.42u l=1u
X1836 VSS.t1321 VDD VSS.t1320 VSS.t1154 sg13_lv_nmos ad=0.1428p pd=1.52u as=0 ps=0 w=0.42u l=1u
X1837 VDD VSS.t1595 VDD VDD sg13_lv_pmos ad=0.19p pd=1.38u as=0 ps=0 w=1u l=1u
X1838 VSS.t1483 VDD VSS.t1485 VSS.t1484 sg13_lv_nmos ad=79.8f pd=0.8u as=0 ps=0 w=0.42u l=1u
X1839 VSS.t2392 VDD VSS.t2394 VSS.t2393 sg13_lv_nmos ad=79.8f pd=0.8u as=0 ps=0 w=0.42u l=1u
X1840 VSS.t839 VDD VSS.t838 VSS.t837 sg13_lv_nmos ad=0.1428p pd=1.52u as=0 ps=0 w=0.42u l=1u
X1841 VDD VSS.t1186 VDD VDD sg13_lv_pmos ad=0.19p pd=1.38u as=0 ps=0 w=1u l=1u
X1842 VDD VSS.t1967 VDD VDD sg13_lv_pmos ad=0.19p pd=1.38u as=0 ps=0 w=1u l=1u
X1843 VSS.t1613 VDD VSS.t1612 VSS.t1611 sg13_lv_nmos ad=0.1428p pd=1.52u as=0 ps=0 w=0.42u l=1u
X1844 VSS.t3134 VDD VSS.t3133 VSS.t3132 sg13_lv_nmos ad=0.1428p pd=1.52u as=0 ps=0 w=0.42u l=1u
X1845 a_17327_13799# a_16485_13701# a_16068_14040# VDD sg13_lv_pmos ad=0.2048p pd=1.63u as=0.34p ps=2.68u w=1u l=0.13u
X1846 sg13cmos5l_dfrbpq_1_2.CLK a_12010_15202# VDD VDD sg13_lv_pmos ad=0.2128p pd=1.5u as=0.2128p ps=1.5u w=1.12u l=0.13u
X1847 VDD VSS.t573 VDD VDD sg13_lv_pmos ad=0.19p pd=1.38u as=0 ps=0 w=1u l=1u
X1848 VSS.t2934 VDD VSS.t2936 VSS.t2935 sg13_lv_nmos ad=79.8f pd=0.8u as=0 ps=0 w=0.42u l=1u
X1849 VSS.t1850 VDD VSS.t1852 VSS.t1851 sg13_lv_nmos ad=79.8f pd=0.8u as=0 ps=0 w=0.42u l=1u
X1850 VDD VSS.t1300 VDD VDD sg13_lv_pmos ad=0.19p pd=1.38u as=0 ps=0 w=1u l=1u
X1851 VDD sg13cmos5l_dfrbpq_1_5.RESET_B a_25862_13722# VDD sg13_lv_pmos ad=0.36237p pd=2.605u as=79.8f ps=0.8u w=0.42u l=0.13u
X1852 VDD VSS.t2334 VDD VDD sg13_lv_pmos ad=0.19p pd=1.38u as=0 ps=0 w=1u l=1u
X1853 VDD VSS.t1480 VDD VDD sg13_lv_pmos ad=0.19p pd=1.38u as=0 ps=0 w=1u l=1u
X1854 VDD a_15579_14854# sg13cmos5l_buf_8_2.A VDD sg13_lv_pmos ad=0.2128p pd=1.5u as=0.2128p ps=1.5u w=1.12u l=0.13u
X1855 VSS.t1523 VDD VSS.t1525 VSS.t1524 sg13_lv_nmos ad=79.8f pd=0.8u as=0 ps=0 w=0.42u l=1u
X1856 VSS.t1703 VDD VSS.t1702 VSS.t1701 sg13_lv_nmos ad=0.1428p pd=1.52u as=0 ps=0 w=0.42u l=1u
X1857 VDD VSS.t3038 VDD VDD sg13_lv_pmos ad=0.34p pd=2.68u as=0 ps=0 w=1u l=1u
X1858 VDD VSS.t2251 VDD VDD sg13_lv_pmos ad=0.34p pd=2.68u as=0 ps=0 w=1u l=1u
X1859 VSS.t1940 VDD VSS.t1942 VSS.t1941 sg13_lv_nmos ad=79.8f pd=0.8u as=0 ps=0 w=0.42u l=1u
X1860 VDD a_22319_14845# a_22576_14726# VDD sg13_lv_pmos ad=2.42015p pd=15.68u as=79.8f ps=0.8u w=0.42u l=0.13u
X1861 a_25094_14484# a_24824_14525# VSS.t113 VSS.t8 sg13_lv_nmos ad=0.1428p pd=1.52u as=79.8f ps=0.8u w=0.42u l=0.5u
X1862 VSS.t596 VDD VSS.t593 VSS.t595 sg13_lv_nmos ad=0.1428p pd=1.52u as=0 ps=0 w=0.42u l=1u
X1863 VSS.t2680 VDD VSS.t2681 VSS.t206 sg13_lv_nmos ad=79.8f pd=0.8u as=0 ps=0 w=0.42u l=1u
X1864 VDD VSS.t2646 VDD VDD sg13_lv_pmos ad=0.19p pd=1.38u as=0 ps=0 w=1u l=1u
X1865 VDD VSS.t1615 VDD VDD sg13_lv_pmos ad=0.19p pd=1.38u as=0 ps=0 w=1u l=1u
X1866 VDD VSS.t2956 VDD VDD sg13_lv_pmos ad=0.19p pd=1.38u as=0 ps=0 w=1u l=1u
X1867 VDD VSS.t1959 VDD VDD sg13_lv_pmos ad=0.34p pd=2.68u as=0 ps=0 w=1u l=1u
X1868 VSS.t799 VDD VSS.t801 VSS.t800 sg13_lv_nmos ad=79.8f pd=0.8u as=0 ps=0 w=0.42u l=1u
X1869 VDD VSS.t420 VDD VDD sg13_lv_pmos ad=0.19p pd=1.38u as=0 ps=0 w=1u l=1u
X1870 VDD VSS.t858 VDD VDD sg13_lv_pmos ad=0.34p pd=2.68u as=0 ps=0 w=1u l=1u
X1871 VDD VSS.t2752 VDD VDD sg13_lv_pmos ad=0.19p pd=1.38u as=0 ps=0 w=1u l=1u
X1872 VSS.t2347 VDD VSS.t2346 VSS.t2345 sg13_lv_nmos ad=0.1428p pd=1.52u as=0 ps=0 w=0.42u l=1u
X1873 VSS.t2070 VDD VSS.t2069 VSS.t2068 sg13_lv_nmos ad=0.1428p pd=1.52u as=0 ps=0 w=0.42u l=1u
X1874 VSS.t1633 VDD VSS.t1632 VSS.t1631 sg13_lv_nmos ad=0.1428p pd=1.52u as=0 ps=0 w=0.42u l=1u
X1875 VSS.t3154 VDD VSS.t3153 VSS.t3152 sg13_lv_nmos ad=0.1428p pd=1.52u as=0 ps=0 w=0.42u l=1u
X1876 VSS.t2974 VDD VSS.t2976 VSS.t2975 sg13_lv_nmos ad=79.8f pd=0.8u as=0 ps=0 w=0.42u l=1u
X1877 VDD a_16485_13701# a_16587_13844# VDD sg13_lv_pmos ad=2.42015p pd=15.68u as=0.3864p ps=2.93u w=1.12u l=0.13u
X1878 VDD VSS.t1642 VDD VDD sg13_lv_pmos ad=0.34p pd=2.68u as=0 ps=0 w=1u l=1u
X1879 a_10618_14448# sg13cmos5l_dlygate4sd3_1_8.A VDD VDD sg13_lv_pmos ad=0.1428p pd=1.52u as=0.1523p ps=1.38u w=0.42u l=0.13u
X1880 VDD VSS.t983 VDD VDD sg13_lv_pmos ad=0.34p pd=2.68u as=0 ps=0 w=1u l=1u
X1881 VSS.t1673 VDD VSS.t1675 VSS.t1674 sg13_lv_nmos ad=79.8f pd=0.8u as=0 ps=0 w=0.42u l=1u
X1882 VSS.t153 VDD VSS.t150 VSS.t696 sg13_lv_nmos ad=0.1428p pd=1.52u as=0 ps=0 w=0.42u l=1u
X1883 VSS.t602 VDD VSS.t602 VSS.t738 sg13_lv_nmos ad=0.1428p pd=1.52u as=0 ps=0 w=0.42u l=1u
X1884 VSS.t2763 VDD VSS.t2764 VSS.t206 sg13_lv_nmos ad=79.8f pd=0.8u as=0 ps=0 w=0.42u l=1u
X1885 VSS.t1835 VDD VSS.t1837 VSS.t1836 sg13_lv_nmos ad=79.8f pd=0.8u as=0 ps=0 w=0.42u l=1u
X1886 a_25025_16344# sg13cmos5l_a21oi_1_2.A1 sg13cmos5l_dlygate4sd3_1_17.A VSS.t18 sg13_lv_nmos ad=0.1406p pd=1.12u as=0.1406p ps=1.12u w=0.74u l=0.13u
X1887 VDD VSS.t2291 VDD VDD sg13_lv_pmos ad=0.34p pd=2.68u as=0 ps=0 w=1u l=1u
X1888 VSS.t566 VDD VSS.t565 VSS.t564 sg13_lv_nmos ad=0.1428p pd=1.52u as=0 ps=0 w=0.42u l=1u
X1889 VDD VSS.t2319 VDD VDD sg13_lv_pmos ad=0.19p pd=1.38u as=0 ps=0 w=1u l=1u
X1890 VSS.t2377 VDD VSS.t2379 VSS.t2378 sg13_lv_nmos ad=79.8f pd=0.8u as=0 ps=0 w=0.42u l=1u
X1891 VDD VSS.t921 VDD VDD sg13_lv_pmos ad=0.19p pd=1.38u as=0 ps=0 w=1u l=1u
X1892 VSS.t1221 VDD VSS.t1222 VSS.t1154 sg13_lv_nmos ad=79.8f pd=0.8u as=0 ps=0 w=0.42u l=1u
X1893 VDD VSS.t1465 VDD VDD sg13_lv_pmos ad=0.19p pd=1.38u as=0 ps=0 w=1u l=1u
X1894 a_22025_16334# a_22149_16033# VDD VDD sg13_lv_pmos ad=0.2442p pd=2.06u as=2.8961p ps=18.25u w=0.66u l=0.13u
X1895 VDD VSS.t2074 VDD VDD sg13_lv_pmos ad=0.34p pd=2.68u as=0 ps=0 w=1u l=1u
X1896 VDD VSS.t1316 VDD VDD sg13_lv_pmos ad=0.19p pd=1.38u as=0 ps=0 w=1u l=1u
X1897 VDD VSS.t1271 VDD VDD sg13_lv_pmos ad=0.34p pd=2.68u as=0 ps=0 w=1u l=1u
X1898 VSS.t1543 VDD VSS.t1545 VSS.t1544 sg13_lv_nmos ad=79.8f pd=0.8u as=0 ps=0 w=0.42u l=1u
X1899 VDD VSS.t2764 VDD VDD sg13_lv_pmos ad=0.34p pd=2.68u as=0 ps=0 w=1u l=1u
X1900 VSS.t1925 VDD VSS.t1927 VSS.t1926 sg13_lv_nmos ad=79.8f pd=0.8u as=0 ps=0 w=0.42u l=1u
X1901 VDD VSS.t509 VDD VDD sg13_lv_pmos ad=0.19p pd=1.38u as=0 ps=0 w=1u l=1u
X1902 VDD a_15579_14854# sg13cmos5l_buf_8_2.A VDD sg13_lv_pmos ad=0.2128p pd=1.5u as=0.2128p ps=1.5u w=1.12u l=0.13u
X1903 VSS.t66 VDD VSS.t66 VSS.t504 sg13_lv_nmos ad=0.1428p pd=1.52u as=0 ps=0 w=0.42u l=1u
X1904 VSS.t1264 VDD VSS.t1265 VSS.t1154 sg13_lv_nmos ad=79.8f pd=0.8u as=0 ps=0 w=0.42u l=1u
X1905 VSS.t2949 VDD VSS.t2948 VSS.t2947 sg13_lv_nmos ad=0.1428p pd=1.52u as=0 ps=0 w=0.42u l=1u
X1906 VSS.t1865 VDD VSS.t1864 VSS.t1863 sg13_lv_nmos ad=0.1428p pd=1.52u as=0 ps=0 w=0.42u l=1u
X1907 VSS.t1185 VDD VSS.t1184 VSS.t1154 sg13_lv_nmos ad=0.1428p pd=1.52u as=0 ps=0 w=0.42u l=1u
X1908 VSS.t349 VDD VSS.t349 VSS.t350 sg13_lv_nmos ad=0.1428p pd=1.52u as=0 ps=0 w=0.42u l=1u
X1909 a_16314_15532# sg13cmos5l_or3_1_2.B sg13cmos5l_nor2_1_0.B VDD sg13_lv_pmos ad=0.1428p pd=1.375u as=0.2408p ps=1.55u w=1.12u l=0.13u
X1910 VSS.t954 VDD VSS.t956 VSS.t955 sg13_lv_nmos ad=79.8f pd=0.8u as=0 ps=0 w=0.42u l=1u
X1911 VDD VSS.t1023 VDD VDD sg13_lv_pmos ad=0.34p pd=2.68u as=0 ps=0 w=1u l=1u
X1912 VSS.t839 VDD VSS.t838 VSS.t837 sg13_lv_nmos ad=0.1428p pd=1.52u as=0 ps=0 w=0.42u l=1u
X1913 VSS.t1663 VDD VSS.t1665 VSS.t1664 sg13_lv_nmos ad=79.8f pd=0.8u as=0 ps=0 w=0.42u l=1u
X1914 VSS.t2648 VDD VSS.t2649 VSS.t206 sg13_lv_nmos ad=79.8f pd=0.8u as=0 ps=0 w=0.42u l=1u
X1915 a_25930_14452# a_26373_14495# a_25670_14922# VSS.t233 sg13_lv_nmos ad=79.8f pd=0.8u as=0.1296p ps=1.52u w=0.42u l=0.13u
X1916 VDD VSS.t1622 VDD VDD sg13_lv_pmos ad=0.34p pd=2.68u as=0 ps=0 w=1u l=1u
X1917 VDD VSS.t2901 VDD VDD sg13_lv_pmos ad=0.19p pd=1.38u as=0 ps=0 w=1u l=1u
X1918 VDD VSS.t44 VDD VDD sg13_lv_pmos ad=0.34p pd=2.68u as=0 ps=0 w=1u l=1u
X1919 VDD VSS.t1627 VDD VDD sg13_lv_pmos ad=0.34p pd=2.68u as=0 ps=0 w=1u l=1u
X1920 VDD VSS.t2723 VDD VDD sg13_lv_pmos ad=0.34p pd=2.68u as=0 ps=0 w=1u l=1u
X1921 VDD a_27502_15423# sg13cmos5l_or3_1_1.A VDD sg13_lv_pmos ad=0.2254p pd=1.53u as=0.4256p ps=3u w=1.12u l=0.13u
X1922 VSS.t1658 VDD VSS.t1660 VSS.t1659 sg13_lv_nmos ad=79.8f pd=0.8u as=0 ps=0 w=0.42u l=1u
X1923 VSS.t526 VDD VSS.t528 VSS.t527 sg13_lv_nmos ad=79.8f pd=0.8u as=0 ps=0 w=0.42u l=1u
X1924 VSS.t509 VDD VSS.t509 VSS.t512 sg13_lv_nmos ad=0.1428p pd=1.52u as=0 ps=0 w=0.42u l=1u
X1925 VDD VSS.t1197 VDD VDD sg13_lv_pmos ad=0.34p pd=2.68u as=0 ps=0 w=1u l=1u
X1926 VDD VSS.t2311 VDD VDD sg13_lv_pmos ad=0.34p pd=2.68u as=0 ps=0 w=1u l=1u
X1927 VDD VSS.t1969 VDD VDD sg13_lv_pmos ad=0.34p pd=2.68u as=0 ps=0 w=1u l=1u
X1928 VSS.t58 sg13cmos5l_o21ai_1_2.A2 a_24169_14508# VSS.t8 sg13_lv_nmos ad=0.1045p pd=0.93u as=0.187p ps=1.78u w=0.55u l=0.13u
X1929 VSS.t2919 VDD VSS.t2921 VSS.t2920 sg13_lv_nmos ad=79.8f pd=0.8u as=0 ps=0 w=0.42u l=1u
X1930 VDD VSS.t1291 VDD VDD sg13_lv_pmos ad=0.19p pd=1.38u as=0 ps=0 w=1u l=1u
X1931 VDD VSS.t2496 VDD VDD sg13_lv_pmos ad=0.34p pd=2.68u as=0 ps=0 w=1u l=1u
X1932 a_3333_15213# sg13cmos5l_dfrbpq_1_2.CLK VSS.t4 VSS.t3180 sg13_lv_nmos ad=0.2516p pd=2.16u as=3.8707p ps=25.555u w=0.74u l=0.13u
X1933 a_21070_15423# a_21185_15424# VDD VDD sg13_lv_pmos ad=0.34p pd=2.68u as=0.2254p ps=1.53u w=1u l=0.5u
X1934 VDD VSS.t2677 VDD VDD sg13_lv_pmos ad=0.19p pd=1.38u as=0 ps=0 w=1u l=1u
X1935 sg13cmos5l_dfrbpq_1_3.Q a_19530_14484# VDD VDD sg13_lv_pmos ad=0.3808p pd=2.92u as=0.2128p ps=1.5u w=1.12u l=0.13u
X1936 VDD VSS.t590 VDD VDD sg13_lv_pmos ad=0.19p pd=1.38u as=0 ps=0 w=1u l=1u
X1937 VDD VSS.t1038 VDD VDD sg13_lv_pmos ad=0.34p pd=2.68u as=0 ps=0 w=1u l=1u
X1938 VSS.t1493 VDD VSS.t1495 VSS.t1494 sg13_lv_nmos ad=79.8f pd=0.8u as=0 ps=0 w=0.42u l=1u
X1939 VSS.t2332 VDD VSS.t2331 VSS.t2330 sg13_lv_nmos ad=0.1428p pd=1.52u as=0 ps=0 w=0.42u l=1u
X1940 a_26373_14495# sg13cmos5l_buf_8_2.X VDD VDD sg13_lv_pmos ad=0.4088p pd=2.97u as=2.3367p ps=15.135u w=1.12u l=0.13u
X1941 VSS.t623 VDD VSS.t620 VSS.t622 sg13_lv_nmos ad=0.1428p pd=1.52u as=0 ps=0 w=0.42u l=1u
X1942 VSS.t1688 VDD VSS.t1687 VSS.t1686 sg13_lv_nmos ad=0.1428p pd=1.52u as=0 ps=0 w=0.42u l=1u
X1943 VSS.t2105 VDD VSS.t2104 VSS.t2103 sg13_lv_nmos ad=0.1428p pd=1.52u as=0 ps=0 w=0.42u l=1u
X1944 VSS.t377 VDD VSS.t372 VSS.t376 sg13_lv_nmos ad=0.1428p pd=1.52u as=0 ps=0 w=0.42u l=1u
X1945 sg13cmos5l_dlygate4sd3_1_3.A a_4842_15532# VSS.t41 VSS.t140 sg13_lv_nmos ad=0.2516p pd=2.16u as=0.1406p ps=1.12u w=0.74u l=0.13u
X1946 VSS.t799 VDD VSS.t801 VSS.t800 sg13_lv_nmos ad=79.8f pd=0.8u as=0 ps=0 w=0.42u l=1u
X1947 VSS.t1239 VDD VSS.t1240 VSS.t1154 sg13_lv_nmos ad=79.8f pd=0.8u as=0 ps=0 w=0.42u l=1u
X1948 VDD VSS.t1600 VDD VDD sg13_lv_pmos ad=0.19p pd=1.38u as=0 ps=0 w=1u l=1u
X1949 VDD VSS.t1655 VDD VDD sg13_lv_pmos ad=0.19p pd=1.38u as=0 ps=0 w=1u l=1u
X1950 VSS.t1488 VDD VSS.t1490 VSS.t1489 sg13_lv_nmos ad=79.8f pd=0.8u as=0 ps=0 w=0.42u l=1u
X1951 VDD VSS.t3118 VDD VDD sg13_lv_pmos ad=0.34p pd=2.68u as=0 ps=0 w=1u l=1u
X1952 VSS.t2397 VDD VSS.t2399 VSS.t2398 sg13_lv_nmos ad=79.8f pd=0.8u as=0 ps=0 w=0.42u l=1u
X1953 VDD VSS.t187 VDD VDD sg13_lv_pmos ad=0.19p pd=1.38u as=0 ps=0 w=1u l=1u
X1954 VSS.t216 a_7822_13911# sg13cmos5l_xnor2_1_2.A VSS.t215 sg13_lv_nmos ad=0.1426p pd=1.16u as=0.2516p ps=2.16u w=0.74u l=0.13u
X1955 VSS.t724 VDD VSS.t723 VSS.t722 sg13_lv_nmos ad=0.1428p pd=1.52u as=0 ps=0 w=0.42u l=1u
X1956 VDD VSS.t1189 VDD VDD sg13_lv_pmos ad=0.19p pd=1.38u as=0 ps=0 w=1u l=1u
X1957 VDD VSS.t2743 VDD VDD sg13_lv_pmos ad=0.19p pd=1.38u as=0 ps=0 w=1u l=1u
X1958 VSS.t1618 VDD VSS.t1617 VSS.t1616 sg13_lv_nmos ad=0.1428p pd=1.52u as=0 ps=0 w=0.42u l=1u
X1959 sg13cmos5l_buf_1_0.X a_1192_3900# VDD VDD sg13_lv_pmos ad=0.42p pd=2.99u as=0.2114p ps=1.54u w=1.12u l=0.13u
X1960 VSS.t3139 VDD VSS.t3138 VSS.t3137 sg13_lv_nmos ad=0.1428p pd=1.52u as=0 ps=0 w=0.42u l=1u
X1961 VSS.t509 VDD VSS.t509 VSS.t514 sg13_lv_nmos ad=0.1428p pd=1.52u as=0 ps=0 w=0.42u l=1u
X1962 VSS.t984 VDD VSS.t986 VSS.t985 sg13_lv_nmos ad=79.8f pd=0.8u as=0 ps=0 w=0.42u l=1u
X1963 VDD VSS.t1175 VDD VDD sg13_lv_pmos ad=0.19p pd=1.38u as=0 ps=0 w=1u l=1u
X1964 VSS.t278 VDD VSS.t278 VSS.t280 sg13_lv_nmos ad=0.1428p pd=1.52u as=0 ps=0 w=0.42u l=1u
X1965 VSS.t440 VDD VSS.t441 VSS.t4 sg13_lv_nmos ad=79.8f pd=0.8u as=0 ps=0 w=0.42u l=1u
X1966 a_16955_14484# sg13cmos5l_a21oi_1_3.B1 sg13cmos5l_a21oi_1_0.Y VDD sg13_lv_pmos ad=0.2128p pd=1.5u as=0.3808p ps=2.92u w=1.12u l=0.13u
X1967 VSS.t2427 VDD VSS.t2426 VSS.t2425 sg13_lv_nmos ad=0.1428p pd=1.52u as=0 ps=0 w=0.42u l=1u
X1968 VDD VSS.t1303 VDD VDD sg13_lv_pmos ad=0.19p pd=1.38u as=0 ps=0 w=1u l=1u
X1969 VSS.t2620 VDD VSS.t2619 VSS.t206 sg13_lv_nmos ad=0.1428p pd=1.52u as=0 ps=0 w=0.42u l=1u
X1970 VDD VSS.t699 VDD VDD sg13_lv_pmos ad=0.34p pd=2.68u as=0 ps=0 w=1u l=1u
X1971 VDD VSS.t2673 VDD VDD sg13_lv_pmos ad=0.19p pd=1.38u as=0 ps=0 w=1u l=1u
X1972 VSS.t2362 VDD VSS.t2364 VSS.t2363 sg13_lv_nmos ad=79.8f pd=0.8u as=0 ps=0 w=0.42u l=1u
X1973 a_9418_15457# a_9861_15213# a_9801_15625# VDD sg13_lv_pmos ad=79.8f pd=0.8u as=63f ps=0.72u w=0.42u l=0.13u
X1974 VDD VSS.t2481 VDD VDD sg13_lv_pmos ad=0.34p pd=2.68u as=0 ps=0 w=1u l=1u
X1975 VDD VSS.t2304 VDD VDD sg13_lv_pmos ad=0.19p pd=1.38u as=0 ps=0 w=1u l=1u
X1976 VDD VSS.t1450 VDD VDD sg13_lv_pmos ad=0.19p pd=1.38u as=0 ps=0 w=1u l=1u
X1977 VSS.t3 sg13cmos5l_dfrbpq_1_7.RESET_B a_25764_14922# VSS.t2 sg13_lv_nmos ad=0.1626p pd=1.415u as=60.89999f ps=0.71u w=0.42u l=0.13u
X1978 VSS.t1528 VDD VSS.t1530 VSS.t1529 sg13_lv_nmos ad=79.8f pd=0.8u as=0 ps=0 w=0.42u l=1u
X1979 VSS.t1708 VDD VSS.t1707 VSS.t1706 sg13_lv_nmos ad=0.1428p pd=1.52u as=0 ps=0 w=0.42u l=1u
X1980 VSS.t2682 VDD VSS.t2683 VSS.t206 sg13_lv_nmos ad=79.8f pd=0.8u as=0 ps=0 w=0.42u l=1u
X1981 VDD VSS.t2429 VDD VDD sg13_lv_pmos ad=0.19p pd=1.38u as=0 ps=0 w=1u l=1u
X1982 VSS.t2090 VDD VSS.t2089 VSS.t2088 sg13_lv_nmos ad=0.1428p pd=1.52u as=0 ps=0 w=0.42u l=1u
X1983 VSS.t954 VDD VSS.t956 VSS.t955 sg13_lv_nmos ad=79.8f pd=0.8u as=0 ps=0 w=0.42u l=1u
X1984 VDD VSS.t1230 VDD VDD sg13_lv_pmos ad=0.34p pd=2.68u as=0 ps=0 w=1u l=1u
X1985 VSS.t1291 VDD VSS.t1290 VSS.t1154 sg13_lv_nmos ad=0.1428p pd=1.52u as=0 ps=0 w=0.42u l=1u
X1986 VSS.t336 VDD VSS.t338 VSS.t337 sg13_lv_nmos ad=79.8f pd=0.8u as=0 ps=0 w=0.42u l=1u
X1987 VDD VSS.t1319 VDD VDD sg13_lv_pmos ad=0.34p pd=2.68u as=0 ps=0 w=1u l=1u
X1988 VDD VSS.t2961 VDD VDD sg13_lv_pmos ad=0.19p pd=1.38u as=0 ps=0 w=1u l=1u
X1989 VSS.t2934 VDD VSS.t2933 VSS.t2932 sg13_lv_nmos ad=0.1428p pd=1.52u as=0 ps=0 w=0.42u l=1u
X1990 VDD VSS.t377 VDD VDD sg13_lv_pmos ad=0.34p pd=2.68u as=0 ps=0 w=1u l=1u
X1991 VSS.t999 VDD VSS.t1001 VSS.t1000 sg13_lv_nmos ad=79.8f pd=0.8u as=0 ps=0 w=0.42u l=1u
X1992 VDD VSS.t1832 VDD VDD sg13_lv_pmos ad=0.19p pd=1.38u as=0 ps=0 w=1u l=1u
X1993 VSS.t305 VDD VSS.t307 VSS.t306 sg13_lv_nmos ad=79.8f pd=0.8u as=0 ps=0 w=0.42u l=1u
X1994 VSS.t387 VDD VSS.t386 VSS.t385 sg13_lv_nmos ad=0.1428p pd=1.52u as=0 ps=0 w=0.42u l=1u
X1995 VDD VSS.t2683 VDD VDD sg13_lv_pmos ad=0.34p pd=2.68u as=0 ps=0 w=1u l=1u
X1996 VDD VSS.t1929 VDD VDD sg13_lv_pmos ad=0.34p pd=2.68u as=0 ps=0 w=1u l=1u
X1997 VSS.t243 sg13cmos5l_dfrbpq_1_5.RESET_B a_25956_13722# VSS.t247 sg13_lv_nmos ad=0.1626p pd=1.415u as=60.89999f ps=0.71u w=0.42u l=0.13u
X1998 VDD VSS.t1607 VDD VDD sg13_lv_pmos ad=0.34p pd=2.68u as=0 ps=0 w=1u l=1u
X1999 VDD VSS.t2755 VDD VDD sg13_lv_pmos ad=0.19p pd=1.38u as=0 ps=0 w=1u l=1u
X2000 VDD VSS.t1155 VDD VDD sg13_lv_pmos ad=0.34p pd=2.68u as=0 ps=0 w=1u l=1u
X2001 VDD VSS.t1268 VDD VDD sg13_lv_pmos ad=0.19p pd=1.38u as=0 ps=0 w=1u l=1u
X2002 VSS.t422 VDD VSS.t421 VSS.t4 sg13_lv_nmos ad=0.1428p pd=1.52u as=0 ps=0 w=0.42u l=1u
X2003 VSS.t446 VDD VSS.t445 VSS.t4 sg13_lv_nmos ad=0.1428p pd=1.52u as=0 ps=0 w=0.42u l=1u
X2004 VDD VSS.t1612 VDD VDD sg13_lv_pmos ad=0.34p pd=2.68u as=0 ps=0 w=1u l=1u
X2005 VSS.t593 VDD VSS.t593 VSS.t594 sg13_lv_nmos ad=79.8f pd=0.8u as=0 ps=0 w=0.42u l=1u
X2006 VSS.t1216 VDD VSS.t1217 VSS.t1154 sg13_lv_nmos ad=79.8f pd=0.8u as=0 ps=0 w=0.42u l=1u
X2007 VSS.t1503 VDD VSS.t1502 VSS.t1501 sg13_lv_nmos ad=0.1428p pd=1.52u as=0 ps=0 w=0.42u l=1u
X2008 VSS.t2412 VDD VSS.t2411 VSS.t2410 sg13_lv_nmos ad=0.1428p pd=1.52u as=0 ps=0 w=0.42u l=1u
X2009 VDD VSS.t2296 VDD VDD sg13_lv_pmos ad=0.34p pd=2.68u as=0 ps=0 w=1u l=1u
X2010 VSS.t407 VDD VSS.t408 VSS.t4 sg13_lv_nmos ad=79.8f pd=0.8u as=0 ps=0 w=0.42u l=1u
X2011 VDD VSS.t617 VDD VDD sg13_lv_pmos ad=0.19p pd=1.38u as=0 ps=0 w=1u l=1u
X2012 VDD sg13cmos5l_xnor2_1_2.A a_6540_13238# VDD sg13_lv_pmos ad=0.4536p pd=2.76u as=0.1596p ps=1.22u w=0.84u l=0.13u
X2013 a_22426_15202# sg13cmos5l_dfrbpq_1_6.Q VDD VDD sg13_lv_pmos ad=0.1428p pd=1.52u as=0.1523p ps=1.38u w=0.42u l=0.13u
X2014 VDD VSS.t396 VDD VDD sg13_lv_pmos ad=0.19p pd=1.38u as=0 ps=0 w=1u l=1u
X2015 VSS.t1478 VDD VSS.t1480 VSS.t1479 sg13_lv_nmos ad=79.8f pd=0.8u as=0 ps=0 w=0.42u l=1u
X2016 sg13cmos5l_dfrbpq_1_3.Q a_19530_14484# VSS.t47 VSS.t13 sg13_lv_nmos ad=0.2516p pd=2.16u as=0.1406p ps=1.12u w=0.74u l=0.13u
X2017 VSS.t1422 VDD VSS.t1303 VSS.t1154 sg13_lv_nmos ad=0.1428p pd=1.52u as=0 ps=0 w=0.42u l=1u
X2018 VDD VSS.t540 VDD VDD sg13_lv_pmos ad=0.34p pd=2.68u as=0 ps=0 w=1u l=1u
X2019 VDD VSS.t2640 VDD VDD sg13_lv_pmos ad=0.19p pd=1.38u as=0 ps=0 w=1u l=1u
X2020 VSS.t1870 VDD VSS.t1869 VSS.t1868 sg13_lv_nmos ad=0.1428p pd=1.52u as=0 ps=0 w=0.42u l=1u
X2021 a_3333_15213# sg13cmos5l_dfrbpq_1_2.CLK VDD VDD sg13_lv_pmos ad=0.4088p pd=2.97u as=2.77542p ps=17.49u w=1.12u l=0.13u
X2022 VSS.t2040 VDD VSS.t2042 VSS.t2041 sg13_lv_nmos ad=79.8f pd=0.8u as=0 ps=0 w=0.42u l=1u
X2023 VDD VSS.t1997 VDD VDD sg13_lv_pmos ad=0.19p pd=1.38u as=0 ps=0 w=1u l=1u
X2024 VDD VSS.t1204 VDD VDD sg13_lv_pmos ad=0.19p pd=1.38u as=0 ps=0 w=1u l=1u
X2025 VDD VSS.t2351 VDD VDD sg13_lv_pmos ad=0.34p pd=2.68u as=0 ps=0 w=1u l=1u
X2026 VDD VSS.t377 VDD VDD sg13_lv_pmos ad=0.34p pd=2.68u as=0 ps=0 w=1u l=1u
X2027 VSS.t1473 VDD VSS.t1475 VSS.t1474 sg13_lv_nmos ad=79.8f pd=0.8u as=0 ps=0 w=0.42u l=1u
X2028 VDD VSS.t3103 VDD VDD sg13_lv_pmos ad=0.34p pd=2.68u as=0 ps=0 w=1u l=1u
X2029 VSS.t2382 VDD VSS.t2384 VSS.t2383 sg13_lv_nmos ad=79.8f pd=0.8u as=0 ps=0 w=0.42u l=1u
X2030 VSS.t1668 VDD VSS.t1670 VSS.t1669 sg13_lv_nmos ad=79.8f pd=0.8u as=0 ps=0 w=0.42u l=1u
X2031 VDD VSS.t405 VDD VDD sg13_lv_pmos ad=0.19p pd=1.38u as=0 ps=0 w=1u l=1u
X2032 VDD VSS.t1592 VDD VDD sg13_lv_pmos ad=0.34p pd=2.68u as=0 ps=0 w=1u l=1u
X2033 VSS.t1960 VDD VSS.t1959 VSS.t1958 sg13_lv_nmos ad=0.1428p pd=1.52u as=0 ps=0 w=0.42u l=1u
X2034 VSS.t984 VDD VSS.t986 VSS.t985 sg13_lv_nmos ad=79.8f pd=0.8u as=0 ps=0 w=0.42u l=1u
X2035 VDD VSS.t1248 VDD VDD sg13_lv_pmos ad=0.34p pd=2.68u as=0 ps=0 w=1u l=1u
X2036 VDD VSS.t2906 VDD VDD sg13_lv_pmos ad=0.19p pd=1.38u as=0 ps=0 w=1u l=1u
X2037 VSS.t2964 VDD VSS.t2966 VSS.t2965 sg13_lv_nmos ad=79.8f pd=0.8u as=0 ps=0 w=0.42u l=1u
X2038 VDD a_7532_15960# counter_value_o[1] VDD sg13_lv_pmos ad=0.2114p pd=1.54u as=0.42p ps=2.99u w=1.12u l=0.13u
X2039 VDD VSS.t958 VDD VDD sg13_lv_pmos ad=0.34p pd=2.68u as=0 ps=0 w=1u l=1u
X2040 VSS.t1198 VDD VSS.t1197 VSS.t1154 sg13_lv_nmos ad=0.1428p pd=1.52u as=0 ps=0 w=0.42u l=1u
X2041 VDD VSS.t1510 VDD VDD sg13_lv_pmos ad=0.19p pd=1.38u as=0 ps=0 w=1u l=1u
X2042 VSS.t16 a_15579_14854# sg13cmos5l_buf_8_2.A VSS.t3242 sg13_lv_nmos ad=0.1406p pd=1.12u as=0.1406p ps=1.12u w=0.74u l=0.13u
X2043 a_27502_15423# a_27617_15424# VSS.t4 VSS.t4 sg13_lv_nmos ad=0.1428p pd=1.52u as=0.1426p ps=1.16u w=0.42u l=0.5u
X2044 VDD VSS.t1294 VDD VDD sg13_lv_pmos ad=0.19p pd=1.38u as=0 ps=0 w=1u l=1u
X2045 VDD VSS.t2762 VDD VDD sg13_lv_pmos ad=0.34p pd=2.68u as=0 ps=0 w=1u l=1u
X2046 VDD VSS.t2664 VDD VDD sg13_lv_pmos ad=0.19p pd=1.38u as=0 ps=0 w=1u l=1u
X2047 VSS.t144 a_10960_15454# a_10609_15311# VSS.t143 sg13_lv_nmos ad=79.8f pd=0.8u as=0.1428p ps=1.52u w=0.42u l=0.13u
X2048 VDD VSS.t2466 VDD VDD sg13_lv_pmos ad=0.34p pd=2.68u as=0 ps=0 w=1u l=1u
X2049 VSS.t784 VDD VSS.t783 VSS.t782 sg13_lv_nmos ad=0.1428p pd=1.52u as=0 ps=0 w=0.42u l=1u
X2050 VSS.t171 a_19120_14726# a_18769_14845# VSS.t13 sg13_lv_nmos ad=79.8f pd=0.8u as=0.1428p ps=1.52u w=0.42u l=0.13u
X2051 VSS.t1463 VDD VSS.t1465 VSS.t1464 sg13_lv_nmos ad=79.8f pd=0.8u as=0 ps=0 w=0.42u l=1u
X2052 VSS.t1693 VDD VSS.t1692 VSS.t1691 sg13_lv_nmos ad=0.1428p pd=1.52u as=0 ps=0 w=0.42u l=1u
X2053 VDD a_10703_15311# a_10960_15454# VDD sg13_lv_pmos ad=2.8961p pd=18.25u as=79.8f ps=0.8u w=0.42u l=0.13u
X2054 a_6086_14922# a_6891_14495# a_6346_14452# VDD sg13_lv_pmos ad=0.1428p pd=1.52u as=79.8f ps=0.8u w=0.42u l=0.13u
X2055 VSS.t425 VDD VSS.t426 VSS.t4 sg13_lv_nmos ad=79.8f pd=0.8u as=0 ps=0 w=0.42u l=1u
X2056 VSS.t999 VDD VSS.t1001 VSS.t1000 sg13_lv_nmos ad=79.8f pd=0.8u as=0 ps=0 w=0.42u l=1u
X2057 VDD VSS.t1257 VDD VDD sg13_lv_pmos ad=0.34p pd=2.68u as=0 ps=0 w=1u l=1u
X2058 VDD VSS.t679 VDD VDD sg13_lv_pmos ad=0.19p pd=1.38u as=0 ps=0 w=1u l=1u
X2059 VDD VSS.t1982 VDD VDD sg13_lv_pmos ad=0.19p pd=1.38u as=0 ps=0 w=1u l=1u
X2060 VDD VSS.t516 VDD VDD sg13_lv_pmos ad=0.34p pd=2.68u as=0 ps=0 w=1u l=1u
X2061 VSS.t566 VDD VSS.t565 VSS.t564 sg13_lv_nmos ad=0.1428p pd=1.52u as=0 ps=0 w=0.42u l=1u
X2062 VDD VSS.t103 VDD VDD sg13_lv_pmos ad=0.34p pd=2.68u as=0 ps=0 w=1u l=1u
X2063 VDD VSS.t3123 VDD VDD sg13_lv_pmos ad=0.34p pd=2.68u as=0 ps=0 w=1u l=1u
X2064 VDD VSS.t1192 VDD VDD sg13_lv_pmos ad=0.19p pd=1.38u as=0 ps=0 w=1u l=1u
X2065 VDD VSS.t1665 VDD VDD sg13_lv_pmos ad=0.19p pd=1.38u as=0 ps=0 w=1u l=1u
X2066 VDD VSS.t2746 VDD VDD sg13_lv_pmos ad=0.19p pd=1.38u as=0 ps=0 w=1u l=1u
X2067 VDD VSS.t1295 VDD VDD sg13_lv_pmos ad=0.19p pd=1.38u as=0 ps=0 w=1u l=1u
X2068 VSS.t1174 VDD VSS.t1175 VSS.t1154 sg13_lv_nmos ad=79.8f pd=0.8u as=0 ps=0 w=0.42u l=1u
X2069 VSS.t1623 VDD VSS.t1622 VSS.t1621 sg13_lv_nmos ad=0.1428p pd=1.52u as=0 ps=0 w=0.42u l=1u
X2070 VSS.t3109 VDD VSS.t3108 VSS.t3107 sg13_lv_nmos ad=0.1428p pd=1.52u as=0 ps=0 w=0.42u l=1u
X2071 a_26170_15202# sg13cmos5l_a21oi_1_3.Y VDD VDD sg13_lv_pmos ad=0.1428p pd=1.52u as=0.1523p ps=1.38u w=0.42u l=0.13u
X2072 VSS.t1488 VDD VSS.t1487 VSS.t1486 sg13_lv_nmos ad=0.1428p pd=1.52u as=0 ps=0 w=0.42u l=1u
X2073 VSS.t2397 VDD VSS.t2396 VSS.t2395 sg13_lv_nmos ad=0.1428p pd=1.52u as=0 ps=0 w=0.42u l=1u
X2074 VSS.t196 sg13cmos5l_dfrbpq_1_0.RESET_B a_2724_15234# VSS.t3163 sg13_lv_nmos ad=0.1626p pd=1.415u as=60.89999f ps=0.71u w=0.42u l=0.13u
X2075 VSS.t2717 VDD VSS.t2718 VSS.t206 sg13_lv_nmos ad=79.8f pd=0.8u as=0 ps=0 w=0.42u l=1u
X2076 VSS.t2367 VDD VSS.t2369 VSS.t2368 sg13_lv_nmos ad=79.8f pd=0.8u as=0 ps=0 w=0.42u l=1u
X2077 VDD VSS.t988 VDD VDD sg13_lv_pmos ad=0.34p pd=2.68u as=0 ps=0 w=1u l=1u
X2078 VDD VSS.t2918 VDD VDD sg13_lv_pmos ad=0.34p pd=2.68u as=0 ps=0 w=1u l=1u
X2079 VDD VSS.t147 VDD VDD sg13_lv_pmos ad=0.19p pd=1.38u as=0 ps=0 w=1u l=1u
X2080 VDD VSS.t803 VDD VDD sg13_lv_pmos ad=0.34p pd=2.68u as=0 ps=0 w=1u l=1u
X2081 VDD VSS.t1455 VDD VDD sg13_lv_pmos ad=0.19p pd=1.38u as=0 ps=0 w=1u l=1u
X2082 VSS.t41 VDD VSS.t41 VSS.t452 sg13_lv_nmos ad=0.1428p pd=1.52u as=0 ps=0 w=0.42u l=1u
X2083 VDD VSS.t540 VDD VDD sg13_lv_pmos ad=0.34p pd=2.68u as=0 ps=0 w=1u l=1u
X2084 VSS.t526 VDD VSS.t528 VSS.t527 sg13_lv_nmos ad=79.8f pd=0.8u as=0 ps=0 w=0.42u l=1u
X2085 VSS.t2685 VDD VSS.t2686 VSS.t206 sg13_lv_nmos ad=79.8f pd=0.8u as=0 ps=0 w=0.42u l=1u
X2086 VSS.t131 VDD VSS.t131 VSS.t271 sg13_lv_nmos ad=0.1428p pd=1.52u as=0 ps=0 w=0.42u l=1u
X2087 VDD VSS.t2631 VDD VDD sg13_lv_pmos ad=0.19p pd=1.38u as=0 ps=0 w=1u l=1u
X2088 VSS.t1855 VDD VSS.t1854 VSS.t1853 sg13_lv_nmos ad=0.1428p pd=1.52u as=0 ps=0 w=0.42u l=1u
X2089 VSS.t2939 VDD VSS.t2938 VSS.t2937 sg13_lv_nmos ad=0.1428p pd=1.52u as=0 ps=0 w=0.42u l=1u
X2090 sg13cmos5l_or3_1_1.B a_14261_15238# VSS.t121 VSS.t213 sg13_lv_nmos ad=0.1406p pd=1.12u as=0.1406p ps=1.12u w=0.74u l=0.13u
X2091 VDD VSS.t1419 VDD VDD sg13_lv_pmos ad=0.34p pd=2.68u as=0 ps=0 w=1u l=1u
X2092 VSS.t2010 VDD VSS.t2012 VSS.t2011 sg13_lv_nmos ad=79.8f pd=0.8u as=0 ps=0 w=0.42u l=1u
X2093 VDD VSS.t2686 VDD VDD sg13_lv_pmos ad=0.34p pd=2.68u as=0 ps=0 w=1u l=1u
X2094 VDD VSS.t1934 VDD VDD sg13_lv_pmos ad=0.34p pd=2.68u as=0 ps=0 w=1u l=1u
X2095 VDD VSS.t432 VDD VDD sg13_lv_pmos ad=0.19p pd=1.38u as=0 ps=0 w=1u l=1u
X2096 VSS.t1653 VDD VSS.t1655 VSS.t1654 sg13_lv_nmos ad=79.8f pd=0.8u as=0 ps=0 w=0.42u l=1u
X2097 VDD VSS.t866 VDD VDD sg13_lv_pmos ad=0.19p pd=1.38u as=0 ps=0 w=1u l=1u
X2098 VDD VSS.t1183 VDD VDD sg13_lv_pmos ad=0.19p pd=1.38u as=0 ps=0 w=1u l=1u
X2099 VDD VSS.t2737 VDD VDD sg13_lv_pmos ad=0.19p pd=1.38u as=0 ps=0 w=1u l=1u
X2100 VSS.t2045 VDD VSS.t2044 VSS.t2043 sg13_lv_nmos ad=0.1428p pd=1.52u as=0 ps=0 w=0.42u l=1u
X2101 a_24923_15996# sg13cmos5l_a21oi_1_3.B1 sg13cmos5l_dlygate4sd3_1_17.A VDD sg13_lv_pmos ad=0.2128p pd=1.5u as=0.3808p ps=2.92u w=1.12u l=0.13u
X2102 VSS.t602 VDD VSS.t599 VSS.t601 sg13_lv_nmos ad=0.1428p pd=1.52u as=0 ps=0 w=0.42u l=1u
X2103 VSS.t1608 VDD VSS.t1607 VSS.t1606 sg13_lv_nmos ad=0.1428p pd=1.52u as=0 ps=0 w=0.42u l=1u
X2104 VDD VSS.t2891 VDD VDD sg13_lv_pmos ad=0.19p pd=1.38u as=0 ps=0 w=1u l=1u
X2105 VSS.t3129 VDD VSS.t3128 VSS.t3127 sg13_lv_nmos ad=0.1428p pd=1.52u as=0 ps=0 w=0.42u l=1u
X2106 VSS.t2949 VDD VSS.t2951 VSS.t2950 sg13_lv_nmos ad=79.8f pd=0.8u as=0 ps=0 w=0.42u l=1u
X2107 a_18202_15202# sg13cmos5l_dfrbpq_1_2.Q VSS.t16 VSS.t3258 sg13_lv_nmos ad=0.1428p pd=1.52u as=79.8f ps=0.8u w=0.42u l=0.13u
X2108 VDD VSS.t1617 VDD VDD sg13_lv_pmos ad=0.34p pd=2.68u as=0 ps=0 w=1u l=1u
X2109 a_2630_15234# a_3435_15356# a_2890_15457# VDD sg13_lv_pmos ad=0.1428p pd=1.52u as=79.8f ps=0.8u w=0.42u l=0.13u
X2110 VDD VSS.t1672 VDD VDD sg13_lv_pmos ad=0.34p pd=2.68u as=0 ps=0 w=1u l=1u
X2111 VSS.t2417 VDD VSS.t2416 VSS.t2415 sg13_lv_nmos ad=0.1428p pd=1.52u as=0 ps=0 w=0.42u l=1u
X2112 VDD VSS.t406 VDD VDD sg13_lv_pmos ad=0.34p pd=2.68u as=0 ps=0 w=1u l=1u
X2113 VDD VSS.t2301 VDD VDD sg13_lv_pmos ad=0.34p pd=2.68u as=0 ps=0 w=1u l=1u
X2114 VSS.t784 VDD VSS.t783 VSS.t782 sg13_lv_nmos ad=0.1428p pd=1.52u as=0 ps=0 w=0.42u l=1u
X2115 VDD VSS.t2753 VDD VDD sg13_lv_pmos ad=0.34p pd=2.68u as=0 ps=0 w=1u l=1u
X2116 a_25956_14488# a_25930_14452# VDD VDD sg13_lv_pmos ad=0.34p pd=2.68u as=0.36237p ps=2.605u w=1u l=0.13u
X2117 VDD a_4432_15454# a_4377_15549# VDD sg13_lv_pmos ad=2.8961p pd=18.25u as=93.45f ps=0.865u w=0.42u l=0.13u
X2118 VSS.t509 VDD VSS.t509 VSS.t514 sg13_lv_nmos ad=0.1428p pd=1.52u as=0 ps=0 w=0.42u l=1u
X2119 VDD VSS.t1202 VDD VDD sg13_lv_pmos ad=0.19p pd=1.38u as=0 ps=0 w=1u l=1u
X2120 VSS.t1518 VDD VSS.t1520 VSS.t1519 sg13_lv_nmos ad=79.8f pd=0.8u as=0 ps=0 w=0.42u l=1u
X2121 VSS.t1276 VDD VSS.t1276 VSS.t1154 sg13_lv_nmos ad=79.8f pd=0.8u as=0 ps=0 w=0.42u l=1u
X2122 VSS.t1448 VDD VSS.t1450 VSS.t1449 sg13_lv_nmos ad=79.8f pd=0.8u as=0 ps=0 w=0.42u l=1u
X2123 VDD VSS.t2643 VDD VDD sg13_lv_pmos ad=0.19p pd=1.38u as=0 ps=0 w=1u l=1u
X2124 VSS.t1840 VDD VSS.t1839 VSS.t1838 sg13_lv_nmos ad=0.1428p pd=1.52u as=0 ps=0 w=0.42u l=1u
X2125 VSS.t377 a_37484_15960# counter_value_o[7] VSS.t3221 sg13_lv_nmos ad=0.14875p pd=1.16u as=0.2886p ps=2.26u w=0.74u l=0.13u
X2126 VSS.t419 VDD VSS.t420 VSS.t4 sg13_lv_nmos ad=79.8f pd=0.8u as=0 ps=0 w=0.42u l=1u
X2127 VDD VSS.t412 VDD VDD sg13_lv_pmos ad=0.34p pd=2.68u as=0 ps=0 w=1u l=1u
X2128 VDD VSS.t1207 VDD VDD sg13_lv_pmos ad=0.19p pd=1.38u as=0 ps=0 w=1u l=1u
X2129 VDD VSS.t2702 VDD VDD sg13_lv_pmos ad=0.19p pd=1.38u as=0 ps=0 w=1u l=1u
X2130 VSS.t2382 VDD VSS.t2381 VSS.t2380 sg13_lv_nmos ad=0.1428p pd=1.52u as=0 ps=0 w=0.42u l=1u
X2131 VSS.t121 sg13cmos5l_nand4_1_0.Y a_14261_15238# VSS.t3183 sg13_lv_nmos ad=0.3293p pd=1.63u as=0.2516p ps=2.16u w=0.74u l=0.13u
X2132 VSS.t93 a_17584_13942# a_17233_13799# VSS.t161 sg13_lv_nmos ad=79.8f pd=0.8u as=0.1428p ps=1.52u w=0.42u l=0.13u
X2133 VDD VSS.t2321 VDD VDD sg13_lv_pmos ad=0.34p pd=2.68u as=0 ps=0 w=1u l=1u
X2134 a_16596_15280# sg13cmos5l_or3_1_2.B a_16140_15424# VSS.t85 sg13_lv_nmos ad=78.39999f pd=0.885u as=0.2176p ps=1.96u w=0.64u l=0.13u
X2135 a_7833_14607# a_6891_14495# a_7631_14845# VDD sg13_lv_pmos ad=93.45f pd=0.865u as=0.2048p ps=1.63u w=0.42u l=0.13u
X2136 a_16485_13701# sg13cmos5l_dfrbpq_1_2.CLK VSS.t66 VSS.t3181 sg13_lv_nmos ad=0.2516p pd=2.16u as=15.38618p ps=0.10091m w=0.74u l=0.13u
X2137 VSS.t294 VDD VSS.t294 VSS.t300 sg13_lv_nmos ad=0.1428p pd=1.52u as=0 ps=0 w=0.42u l=1u
X2138 VSS.t377 VDD VSS.t377 VSS.t379 sg13_lv_nmos ad=0.1428p pd=1.52u as=0 ps=0 w=0.42u l=1u
X2139 VSS.t440 VDD VSS.t439 VSS.t4 sg13_lv_nmos ad=0.1428p pd=1.52u as=0 ps=0 w=0.42u l=1u
X2140 VDD VSS.t1962 VDD VDD sg13_lv_pmos ad=0.19p pd=1.38u as=0 ps=0 w=1u l=1u
X2141 VSS.t1930 VDD VSS.t1929 VSS.t1928 sg13_lv_nmos ad=0.1428p pd=1.52u as=0 ps=0 w=0.42u l=1u
X2142 VSS.t2447 VDD VSS.t2449 VSS.t2448 sg13_lv_nmos ad=79.8f pd=0.8u as=0 ps=0 w=0.42u l=1u
X2143 VDD VSS.t1515 VDD VDD sg13_lv_pmos ad=0.19p pd=1.38u as=0 ps=0 w=1u l=1u
X2144 a_17584_13942# a_17327_13799# a_17746_13722# VSS.t91 sg13_lv_nmos ad=0.1428p pd=1.52u as=37.8f ps=0.6u w=0.42u l=0.13u
X2145 VSS.t2615 VDD VSS.t2614 VSS.t206 sg13_lv_nmos ad=0.1428p pd=1.52u as=0 ps=0 w=0.42u l=1u
X2146 VSS.t984 VDD VSS.t983 VSS.t982 sg13_lv_nmos ad=0.1428p pd=1.52u as=0 ps=0 w=0.42u l=1u
X2147 VDD VSS.t2667 VDD VDD sg13_lv_pmos ad=0.19p pd=1.38u as=0 ps=0 w=1u l=1u
X2148 VSS.t2999 VDD VSS.t2998 VSS.t2997 sg13_lv_nmos ad=0.1428p pd=1.52u as=0 ps=0 w=0.42u l=1u
X2149 VSS.t283 VDD VSS.t283 VSS.t284 sg13_lv_nmos ad=79.8f pd=0.8u as=0 ps=0 w=0.42u l=1u
X2150 VDD VSS.t1036 VDD VDD sg13_lv_pmos ad=0.19p pd=1.38u as=0 ps=0 w=1u l=1u
X2151 VDD VSS.t2903 VDD VDD sg13_lv_pmos ad=0.34p pd=2.68u as=0 ps=0 w=1u l=1u
X2152 VSS.t1468 VDD VSS.t1470 VSS.t1469 sg13_lv_nmos ad=79.8f pd=0.8u as=0 ps=0 w=0.42u l=1u
X2153 VSS.t1663 VDD VSS.t1662 VSS.t1661 sg13_lv_nmos ad=0.1428p pd=1.52u as=0 ps=0 w=0.42u l=1u
X2154 VDD VSS.t1480 VDD VDD sg13_lv_pmos ad=0.19p pd=1.38u as=0 ps=0 w=1u l=1u
X2155 VSS.t2677 VDD VSS.t2678 VSS.t206 sg13_lv_nmos ad=79.8f pd=0.8u as=0 ps=0 w=0.42u l=1u
X2156 VDD VSS.t2389 VDD VDD sg13_lv_pmos ad=0.19p pd=1.38u as=0 ps=0 w=1u l=1u
X2157 a_18454_16374# sg13cmos5l_or3_1_2.B VSS.t79 VSS.t78 sg13_lv_nmos ad=0.1406p pd=1.12u as=0.1406p ps=1.12u w=0.74u l=0.15u
X2158 a_9732_15247# a_9963_15356# a_9418_15457# VSS.t97 sg13_lv_nmos ad=0.2373p pd=1.97u as=79.8f ps=0.8u w=0.42u l=0.13u
X2159 a_9670_15247# sg13cmos5l_tiehi_1.L_HI VSS.t1 VSS.t97 sg13_lv_nmos ad=37.8f pd=0.6u as=0.1701p ps=1.65u w=0.42u l=0.13u
X2160 a_25094_14484# a_24824_14525# VDD VDD sg13_lv_pmos ad=0.34p pd=2.68u as=0.1523p ps=1.38u w=1u l=0.5u
X2161 sg13cmos5l_dfrbpq_1_7.Q a_27882_14484# VDD VDD sg13_lv_pmos ad=0.3808p pd=2.92u as=0.2128p ps=1.5u w=1.12u l=0.13u
X2162 VSS.t2277 VDD VSS.t2279 VSS.t2278 sg13_lv_nmos ad=79.8f pd=0.8u as=0 ps=0 w=0.42u l=1u
X2163 VSS.t1995 VDD VSS.t1997 VSS.t1996 sg13_lv_nmos ad=79.8f pd=0.8u as=0 ps=0 w=0.42u l=1u
X2164 VSS.t596 VDD VSS.t596 VSS.t734 sg13_lv_nmos ad=0.1428p pd=1.52u as=0 ps=0 w=0.42u l=1u
X2165 a_7532_15960# sg13cmos5l_dlygate4sd3_1_1.A VSS.t69 VSS.t3286 sg13_lv_nmos ad=0.187p pd=1.78u as=0.14875p ps=1.16u w=0.55u l=0.13u
X2166 VSS.t1294 VDD VSS.t1295 VSS.t1154 sg13_lv_nmos ad=79.8f pd=0.8u as=0 ps=0 w=0.42u l=1u
X2167 VDD VSS.t2678 VDD VDD sg13_lv_pmos ad=0.34p pd=2.68u as=0 ps=0 w=1u l=1u
X2168 VSS.t1950 VDD VSS.t1949 VSS.t1948 sg13_lv_nmos ad=0.1428p pd=1.52u as=0 ps=0 w=0.42u l=1u
X2169 VDD VSS.t1174 VDD VDD sg13_lv_pmos ad=0.19p pd=1.38u as=0 ps=0 w=1u l=1u
X2170 VSS.t1593 VDD VSS.t1592 VSS.t1591 sg13_lv_nmos ad=0.1428p pd=1.52u as=0 ps=0 w=0.42u l=1u
X2171 VSS.t3114 VDD VSS.t3113 VSS.t3112 sg13_lv_nmos ad=0.1428p pd=1.52u as=0 ps=0 w=0.42u l=1u
X2172 VDD VSS.t2650 VDD VDD sg13_lv_pmos ad=0.34p pd=2.68u as=0 ps=0 w=1u l=1u
X2173 VSS.t310 VDD VSS.t312 VSS.t311 sg13_lv_nmos ad=79.8f pd=0.8u as=0 ps=0 w=0.42u l=1u
X2174 a_10618_14448# sg13cmos5l_dlygate4sd3_1_8.A VSS.t144 VSS.t3202 sg13_lv_nmos ad=0.1428p pd=1.52u as=79.8f ps=0.8u w=0.42u l=0.13u
X2175 VDD VSS.t433 VDD VDD sg13_lv_pmos ad=0.34p pd=2.68u as=0 ps=0 w=1u l=1u
X2176 VDD VSS.t1657 VDD VDD sg13_lv_pmos ad=0.34p pd=2.68u as=0 ps=0 w=1u l=1u
X2177 VSS.t1493 VDD VSS.t1492 VSS.t1491 sg13_lv_nmos ad=0.1428p pd=1.52u as=0 ps=0 w=0.42u l=1u
X2178 VSS.t2402 VDD VSS.t2401 VSS.t2400 sg13_lv_nmos ad=0.1428p pd=1.52u as=0 ps=0 w=0.42u l=1u
X2179 VSS.t1508 VDD VSS.t1510 VSS.t1509 sg13_lv_nmos ad=79.8f pd=0.8u as=0 ps=0 w=0.42u l=1u
X2180 VDD VSS.t1003 VDD VDD sg13_lv_pmos ad=0.34p pd=2.68u as=0 ps=0 w=1u l=1u
X2181 VSS.t2720 VDD VSS.t2721 VSS.t206 sg13_lv_nmos ad=79.8f pd=0.8u as=0 ps=0 w=0.42u l=1u
X2182 VSS.t1900 VDD VSS.t1899 VSS.t1898 sg13_lv_nmos ad=0.1428p pd=1.52u as=0 ps=0 w=0.42u l=1u
X2183 VDD VSS.t1460 VDD VDD sg13_lv_pmos ad=0.19p pd=1.38u as=0 ps=0 w=1u l=1u
X2184 VDD VSS.t2923 VDD VDD sg13_lv_pmos ad=0.34p pd=2.68u as=0 ps=0 w=1u l=1u
X2185 VDD VSS.t3096 VDD VDD sg13_lv_pmos ad=0.19p pd=1.38u as=0 ps=0 w=1u l=1u
X2186 VSS.t1503 VDD VSS.t1505 VSS.t1504 sg13_lv_nmos ad=79.8f pd=0.8u as=0 ps=0 w=0.42u l=1u
X2187 VSS.t1683 VDD VSS.t1682 VSS.t1681 sg13_lv_nmos ad=0.1428p pd=1.52u as=0 ps=0 w=0.42u l=1u
X2188 VDD VSS.t1465 VDD VDD sg13_lv_pmos ad=0.19p pd=1.38u as=0 ps=0 w=1u l=1u
X2189 sg13cmos5l_buf_8_2.X a_19323_13726# VSS.t699 VSS.t3251 sg13_lv_nmos ad=0.1406p pd=1.12u as=0.1406p ps=1.12u w=0.74u l=0.13u
X2190 VSS.t2669 VDD VSS.t2670 VSS.t206 sg13_lv_nmos ad=79.8f pd=0.8u as=0 ps=0 w=0.42u l=1u
X2191 VDD VSS.t2634 VDD VDD sg13_lv_pmos ad=0.19p pd=1.38u as=0 ps=0 w=1u l=1u
X2192 VDD VSS.t2374 VDD VDD sg13_lv_pmos ad=0.19p pd=1.38u as=0 ps=0 w=1u l=1u
X2193 VSS.t134 VDD VSS.t134 VSS.t390 sg13_lv_nmos ad=0.1428p pd=1.52u as=0 ps=0 w=0.42u l=1u
X2194 VDD VSS.t243 VDD VDD sg13_lv_pmos ad=0.34p pd=2.68u as=0 ps=0 w=1u l=1u
X2195 VSS.t2944 VDD VSS.t2943 VSS.t2942 sg13_lv_nmos ad=0.1428p pd=1.52u as=0 ps=0 w=0.42u l=1u
X2196 VDD VSS.t1303 VDD VDD sg13_lv_pmos ad=0.34p pd=2.68u as=0 ps=0 w=1u l=1u
X2197 VSS.t1980 VDD VSS.t1982 VSS.t1981 sg13_lv_nmos ad=79.8f pd=0.8u as=0 ps=0 w=0.42u l=1u
X2198 VDD a_9658_14725# sg13cmos5l_tiehi_1.L_HI VDD sg13_lv_pmos ad=2.42015p pd=15.68u as=0.3927p ps=2.99u w=1.155u l=0.13u
X2199 VDD VSS.t2688 VDD VDD sg13_lv_pmos ad=0.34p pd=2.68u as=0 ps=0 w=1u l=1u
X2200 VDD VSS.t2499 VDD VDD sg13_lv_pmos ad=0.19p pd=1.38u as=0 ps=0 w=1u l=1u
X2201 VDD VSS.t1939 VDD VDD sg13_lv_pmos ad=0.34p pd=2.68u as=0 ps=0 w=1u l=1u
X2202 a_6789_14495# sg13cmos5l_dfrbpq_1_2.CLK VDD VDD sg13_lv_pmos ad=0.4088p pd=2.97u as=2.3367p ps=15.135u w=1.12u l=0.13u
X2203 VDD VSS.t1279 VDD VDD sg13_lv_pmos ad=0.19p pd=1.38u as=0 ps=0 w=1u l=1u
X2204 VDD sg13cmos5l_dfrbpq_1_3.Q sg13cmos5l_o21ai_1_2.A2 VDD sg13_lv_pmos ad=0.2128p pd=1.5u as=0.2128p ps=1.5u w=1.12u l=0.13u
X2205 a_25764_14922# sg13cmos5l_dfrbpq_1_7.D a_25670_14922# VSS.t8 sg13_lv_nmos ad=60.89999f pd=0.71u as=0.1428p ps=1.52u w=0.42u l=0.13u
X2206 a_24365_14508# sg13cmos5l_or3_1_2.B a_24263_14508# VDD sg13_lv_pmos ad=0.1575p pd=1.315u as=0.19p ps=1.38u w=1u l=0.13u
X2207 VDD VSS.t620 VDD VDD sg13_lv_pmos ad=0.19p pd=1.38u as=0 ps=0 w=1u l=1u
X2208 VSS.t1228 VDD VSS.t1228 VSS.t1154 sg13_lv_nmos ad=79.8f pd=0.8u as=0 ps=0 w=0.42u l=1u
X2209 VDD VSS.t1622 VDD VDD sg13_lv_pmos ad=0.34p pd=2.68u as=0 ps=0 w=1u l=1u
X2210 VSS.t614 VDD VSS.t614 VSS.t746 sg13_lv_nmos ad=0.1428p pd=1.52u as=0 ps=0 w=0.42u l=1u
X2211 VDD VSS.t1677 VDD VDD sg13_lv_pmos ad=0.34p pd=2.68u as=0 ps=0 w=1u l=1u
X2212 VDD VSS.t1834 VDD VDD sg13_lv_pmos ad=0.34p pd=2.68u as=0 ps=0 w=1u l=1u
X2213 VSS.t984 VDD VSS.t983 VSS.t982 sg13_lv_nmos ad=0.1428p pd=1.52u as=0 ps=0 w=0.42u l=1u
X2214 VDD VSS.t966 VDD VDD sg13_lv_pmos ad=0.19p pd=1.38u as=0 ps=0 w=1u l=1u
X2215 VDD VSS.t2756 VDD VDD sg13_lv_pmos ad=0.34p pd=2.68u as=0 ps=0 w=1u l=1u
X2216 VDD a_26373_14495# a_26475_14495# VDD sg13_lv_pmos ad=2.42015p pd=15.68u as=0.3864p ps=2.93u w=1.12u l=0.13u
X2217 sg13cmos5l_or3_1_1.X a_24841_13726# VDD VDD sg13_lv_pmos ad=0.3808p pd=2.92u as=0.3822p ps=1.84u w=1.12u l=0.13u
X2218 VSS.t1317 VDD VSS.t1316 VSS.t1154 sg13_lv_nmos ad=0.1428p pd=1.52u as=0 ps=0 w=0.42u l=1u
X2219 VDD VSS.t560 VDD VDD sg13_lv_pmos ad=0.34p pd=2.68u as=0 ps=0 w=1u l=1u
X2220 VDD VSS.t893 VDD VDD sg13_lv_pmos ad=0.34p pd=2.68u as=0 ps=0 w=1u l=1u
X2221 VSS.t1453 VDD VSS.t1455 VSS.t1454 sg13_lv_nmos ad=79.8f pd=0.8u as=0 ps=0 w=0.42u l=1u
X2222 VSS.t1845 VDD VSS.t1844 VSS.t1843 sg13_lv_nmos ad=0.1428p pd=1.52u as=0 ps=0 w=0.42u l=1u
X2223 a_21466_15202# sg13cmos5l_o21ai_1_1.Y VDD VDD sg13_lv_pmos ad=0.1428p pd=1.52u as=0.1523p ps=1.38u w=0.42u l=0.13u
X2224 VSS.t2929 VDD VSS.t2928 VSS.t2927 sg13_lv_nmos ad=0.1428p pd=1.52u as=0 ps=0 w=0.42u l=1u
X2225 VSS.t2769 VDD VSS.t2768 VSS.t206 sg13_lv_nmos ad=0.1428p pd=1.52u as=0 ps=0 w=0.42u l=1u
X2226 VSS.t2015 VDD VSS.t2017 VSS.t2016 sg13_lv_nmos ad=79.8f pd=0.8u as=0 ps=0 w=0.42u l=1u
X2227 VDD VSS.t1972 VDD VDD sg13_lv_pmos ad=0.19p pd=1.38u as=0 ps=0 w=1u l=1u
X2228 sg13cmos5l_dfrbpq_1_7.Q a_27882_14484# VSS.t246 VSS.t4 sg13_lv_nmos ad=0.2516p pd=2.16u as=0.1406p ps=1.12u w=0.74u l=0.13u
X2229 VDD VSS.t1210 VDD VDD sg13_lv_pmos ad=0.19p pd=1.38u as=0 ps=0 w=1u l=1u
X2230 VDD VSS.t2705 VDD VDD sg13_lv_pmos ad=0.19p pd=1.38u as=0 ps=0 w=1u l=1u
X2231 VSS.t2262 VDD VSS.t2264 VSS.t2263 sg13_lv_nmos ad=79.8f pd=0.8u as=0 ps=0 w=0.42u l=1u
X2232 VSS.t2387 VDD VSS.t2386 VSS.t2385 sg13_lv_nmos ad=0.1428p pd=1.52u as=0 ps=0 w=0.42u l=1u
X2233 VSS.t623 VDD VSS.t623 VSS.t752 sg13_lv_nmos ad=0.1428p pd=1.52u as=0 ps=0 w=0.42u l=1u
X2234 VDD VSS.t2326 VDD VDD sg13_lv_pmos ad=0.34p pd=2.68u as=0 ps=0 w=1u l=1u
X2235 VDD sg13cmos5l_tiehi_1.L_HI a_9418_15457# VDD sg13_lv_pmos ad=0.1563p pd=1.22u as=0.147p ps=1.54u w=0.42u l=0.13u
X2236 VDD VSS.t1472 VDD VDD sg13_lv_pmos ad=0.34p pd=2.68u as=0 ps=0 w=1u l=1u
X2237 VSS.t570 VDD VSS.t679 VSS.t678 sg13_lv_nmos ad=79.8f pd=0.8u as=0 ps=0 w=0.42u l=1u
X2238 VSS.t1553 VDD VSS.t1552 VSS.t1551 sg13_lv_nmos ad=0.1428p pd=1.52u as=0 ps=0 w=0.42u l=1u
X2239 VDD VSS.t768 VDD VDD sg13_lv_pmos ad=0.34p pd=2.68u as=0 ps=0 w=1u l=1u
X2240 VSS.t1210 VDD VSS.t1209 VSS.t1154 sg13_lv_nmos ad=0.1428p pd=1.52u as=0 ps=0 w=0.42u l=1u
X2241 VDD VSS.t1655 VDD VDD sg13_lv_pmos ad=0.19p pd=1.38u as=0 ps=0 w=1u l=1u
X2242 VSS.t1935 VDD VSS.t1934 VSS.t1933 sg13_lv_nmos ad=0.1428p pd=1.52u as=0 ps=0 w=0.42u l=1u
X2243 VDD VSS.t2640 VDD VDD sg13_lv_pmos ad=0.34p pd=2.68u as=0 ps=0 w=1u l=1u
X2244 VSS.t2452 VDD VSS.t2454 VSS.t2453 sg13_lv_nmos ad=79.8f pd=0.8u as=0 ps=0 w=0.42u l=1u
X2245 VDD VSS.t372 VDD VDD sg13_lv_pmos ad=0.34p pd=2.68u as=0 ps=0 w=1u l=1u
X2246 VSS.t401 VDD VSS.t246 VSS.t4 sg13_lv_nmos ad=0.1428p pd=1.52u as=0 ps=0 w=0.42u l=1u
X2247 VSS.t536 VDD VSS.t538 VSS.t537 sg13_lv_nmos ad=79.8f pd=0.8u as=0 ps=0 w=0.42u l=1u
X2248 a_25786_15960# sg13cmos5l_o21ai_1_3.Y VDD VDD sg13_lv_pmos ad=0.1428p pd=1.52u as=0.1523p ps=1.38u w=0.42u l=0.13u
X2249 VDD VSS.t583 VDD VDD sg13_lv_pmos ad=0.34p pd=2.68u as=0 ps=0 w=1u l=1u
X2250 VDD VSS.t2027 VDD VDD sg13_lv_pmos ad=0.19p pd=1.38u as=0 ps=0 w=1u l=1u
X2251 VSS.t1673 VDD VSS.t1672 VSS.t1671 sg13_lv_nmos ad=0.1428p pd=1.52u as=0 ps=0 w=0.42u l=1u
X2252 VSS.t2617 VDD VSS.t2617 VSS.t206 sg13_lv_nmos ad=0.1428p pd=1.52u as=0 ps=0 w=0.42u l=1u
X2253 VSS.t2712 VDD VSS.t2713 VSS.t206 sg13_lv_nmos ad=79.8f pd=0.8u as=0 ps=0 w=0.42u l=1u
X2254 VSS.t804 VDD VSS.t803 VSS.t802 sg13_lv_nmos ad=0.1428p pd=1.52u as=0 ps=0 w=0.42u l=1u
X2255 VSS.t1246 VDD VSS.t1247 VSS.t1154 sg13_lv_nmos ad=79.8f pd=0.8u as=0 ps=0 w=0.42u l=1u
X2256 VSS.t2969 VDD VSS.t2968 VSS.t2967 sg13_lv_nmos ad=0.1428p pd=1.52u as=0 ps=0 w=0.42u l=1u
X2257 VSS.t1167 VDD VSS.t1168 VSS.t1154 sg13_lv_nmos ad=79.8f pd=0.8u as=0 ps=0 w=0.42u l=1u
X2258 VDD VSS.t1445 VDD VDD sg13_lv_pmos ad=0.19p pd=1.38u as=0 ps=0 w=1u l=1u
X2259 VDD VSS.t2908 VDD VDD sg13_lv_pmos ad=0.34p pd=2.68u as=0 ps=0 w=1u l=1u
X2260 VSS.t437 VDD VSS.t438 VSS.t4 sg13_lv_nmos ad=79.8f pd=0.8u as=0 ps=0 w=0.42u l=1u
X2261 VSS.t1668 VDD VSS.t1667 VSS.t1666 sg13_lv_nmos ad=0.1428p pd=1.52u as=0 ps=0 w=0.42u l=1u
X2262 VSS.t404 VDD VSS.t405 VSS.t4 sg13_lv_nmos ad=79.8f pd=0.8u as=0 ps=0 w=0.42u l=1u
X2263 a_21477_14495# sg13cmos5l_buf_8_2.X VSS.t4 VSS.t73 sg13_lv_nmos ad=0.2516p pd=2.16u as=3.8707p ps=25.555u w=0.74u l=0.13u
X2264 VDD VSS.t1450 VDD VDD sg13_lv_pmos ad=0.19p pd=1.38u as=0 ps=0 w=1u l=1u
X2265 VSS.t2760 VDD VSS.t2759 VSS.t206 sg13_lv_nmos ad=0.1428p pd=1.52u as=0 ps=0 w=0.42u l=1u
X2266 VSS.t2035 VDD VSS.t2037 VSS.t2036 sg13_lv_nmos ad=79.8f pd=0.8u as=0 ps=0 w=0.42u l=1u
X2267 VSS.t2247 VDD VSS.t2249 VSS.t2248 sg13_lv_nmos ad=79.8f pd=0.8u as=0 ps=0 w=0.42u l=1u
X2268 VDD VSS.t3098 VDD VDD sg13_lv_pmos ad=0.34p pd=2.68u as=0 ps=0 w=1u l=1u
X2269 VDD VSS.t2484 VDD VDD sg13_lv_pmos ad=0.19p pd=1.38u as=0 ps=0 w=1u l=1u
X2270 VDD VSS.t923 VDD VDD sg13_lv_pmos ad=0.34p pd=2.68u as=0 ps=0 w=1u l=1u
X2271 VSS.t1186 VDD VSS.t1187 VSS.t1154 sg13_lv_nmos ad=79.8f pd=0.8u as=0 ps=0 w=0.42u l=1u
X2272 VSS.t1224 VDD VSS.t1223 VSS.t1154 sg13_lv_nmos ad=0.1428p pd=1.52u as=0 ps=0 w=0.42u l=1u
X2273 VDD VSS.t1924 VDD VDD sg13_lv_pmos ad=0.34p pd=2.68u as=0 ps=0 w=1u l=1u
X2274 a_22149_16033# a_22149_16033# VSS.t7 VSS.t188 sg13_lv_nmos ad=0.111p pd=1.34u as=7.70437p ps=50.66u w=0.3u l=0.13u
X2275 VSS.t1255 VDD VSS.t1256 VSS.t1154 sg13_lv_nmos ad=79.8f pd=0.8u as=0 ps=0 w=0.42u l=1u
X2276 VDD VSS.t1607 VDD VDD sg13_lv_pmos ad=0.34p pd=2.68u as=0 ps=0 w=1u l=1u
X2277 VSS.t1498 VDD VSS.t1497 VSS.t1496 sg13_lv_nmos ad=0.1428p pd=1.52u as=0 ps=0 w=0.42u l=1u
X2278 VSS.t2407 VDD VSS.t2406 VSS.t2405 sg13_lv_nmos ad=0.1428p pd=1.52u as=0 ps=0 w=0.42u l=1u
X2279 VDD VSS.t1008 VDD VDD sg13_lv_pmos ad=0.34p pd=2.68u as=0 ps=0 w=1u l=1u
X2280 VSS.t959 VDD VSS.t958 VSS.t957 sg13_lv_nmos ad=0.1428p pd=1.52u as=0 ps=0 w=0.42u l=1u
X2281 VSS.t1513 VDD VSS.t1515 VSS.t1514 sg13_lv_nmos ad=79.8f pd=0.8u as=0 ps=0 w=0.42u l=1u
X2282 VSS.t2722 VDD VSS.t2724 VSS.t206 sg13_lv_nmos ad=79.8f pd=0.8u as=0 ps=0 w=0.42u l=1u
X2283 VSS.t419 VDD VSS.t418 VSS.t4 sg13_lv_nmos ad=0.1428p pd=1.52u as=0 ps=0 w=0.42u l=1u
X2284 VDD VSS.t823 VDD VDD sg13_lv_pmos ad=0.34p pd=2.68u as=0 ps=0 w=1u l=1u
X2285 VSS.t1260 VDD VSS.t1261 VSS.t1154 sg13_lv_nmos ad=79.8f pd=0.8u as=0 ps=0 w=0.42u l=1u
X2286 VDD VSS.t1193 VDD VDD sg13_lv_pmos ad=0.34p pd=2.68u as=0 ps=0 w=1u l=1u
X2287 VSS.t578 VDD VSS.t578 VSS.t577 sg13_lv_nmos ad=0.1428p pd=1.52u as=0 ps=0 w=0.42u l=1u
X2288 VDD VSS.t560 VDD VDD sg13_lv_pmos ad=0.34p pd=2.68u as=0 ps=0 w=1u l=1u
X2289 VDD VSS.t2893 VDD VDD sg13_lv_pmos ad=0.34p pd=2.68u as=0 ps=0 w=1u l=1u
X2290 VDD VSS.t131 VDD VDD sg13_lv_pmos ad=0.34p pd=2.68u as=0 ps=0 w=1u l=1u
X2291 VSS.t1830 VDD VSS.t1829 VSS.t1828 sg13_lv_nmos ad=0.1428p pd=1.52u as=0 ps=0 w=0.42u l=1u
X2292 VSS.t531 VDD VSS.t530 VSS.t529 sg13_lv_nmos ad=0.1428p pd=1.52u as=0 ps=0 w=0.42u l=1u
X2293 VSS.t2914 VDD VSS.t2913 VSS.t2912 sg13_lv_nmos ad=0.1428p pd=1.52u as=0 ps=0 w=0.42u l=1u
X2294 VSS.t112 VDD VSS.t112 VSS.t591 sg13_lv_nmos ad=0.1428p pd=1.52u as=0 ps=0 w=0.42u l=1u
X2295 VSS.t1019 VDD VSS.t1021 VSS.t1020 sg13_lv_nmos ad=79.8f pd=0.8u as=0 ps=0 w=0.42u l=1u
X2296 VDD VSS.t1201 VDD VDD sg13_lv_pmos ad=0.19p pd=1.38u as=0 ps=0 w=1u l=1u
X2297 VDD VSS.t1306 VDD VDD sg13_lv_pmos ad=0.34p pd=2.68u as=0 ps=0 w=1u l=1u
X2298 VDD VSS.t2697 VDD VDD sg13_lv_pmos ad=0.19p pd=1.38u as=0 ps=0 w=1u l=1u
X2299 VSS.t2372 VDD VSS.t2371 VSS.t2370 sg13_lv_nmos ad=0.1428p pd=1.52u as=0 ps=0 w=0.42u l=1u
X2300 VSS.t1985 VDD VSS.t1987 VSS.t1986 sg13_lv_nmos ad=79.8f pd=0.8u as=0 ps=0 w=0.42u l=1u
X2301 VSS.t83 sg13cmos5l_or3_1_2.B a_21251_13690# VSS.t82 sg13_lv_nmos ad=0.1045p pd=0.93u as=0.198p ps=1.27u w=0.55u l=0.13u
X2302 VSS.t1279 VDD VSS.t1279 VSS.t1154 sg13_lv_nmos ad=79.8f pd=0.8u as=0 ps=0 w=0.42u l=1u
X2303 a_2724_15234# sg13cmos5l_and2_1_0.X a_2630_15234# VSS.t225 sg13_lv_nmos ad=60.89999f pd=0.71u as=0.1428p ps=1.52u w=0.42u l=0.13u
X2304 VSS.t66 VDD VSS.t66 VSS.t501 sg13_lv_nmos ad=79.8f pd=0.8u as=0 ps=0 w=0.42u l=1u
X2305 VDD VSS.t580 VDD VDD sg13_lv_pmos ad=0.19p pd=1.38u as=0 ps=0 w=1u l=1u
X2306 VDD VSS.t886 VDD VDD sg13_lv_pmos ad=0.19p pd=1.38u as=0 ps=0 w=1u l=1u
X2307 VDD VSS.t1457 VDD VDD sg13_lv_pmos ad=0.34p pd=2.68u as=0 ps=0 w=1u l=1u
X2308 VDD VSS.t2673 VDD VDD sg13_lv_pmos ad=0.34p pd=2.68u as=0 ps=0 w=1u l=1u
X2309 VSS.t2687 VDD VSS.t2687 VSS.t206 sg13_lv_nmos ad=0.1428p pd=1.52u as=0 ps=0 w=0.42u l=1u
X2310 VDD VSS.t356 VDD VDD sg13_lv_pmos ad=0.19p pd=1.38u as=0 ps=0 w=1u l=1u
X2311 VDD VSS.t1592 VDD VDD sg13_lv_pmos ad=0.34p pd=2.68u as=0 ps=0 w=1u l=1u
X2312 VSS.t2437 VDD VSS.t2439 VSS.t2438 sg13_lv_nmos ad=79.8f pd=0.8u as=0 ps=0 w=0.42u l=1u
X2313 VSS.t1483 VDD VSS.t1482 VSS.t1481 sg13_lv_nmos ad=0.1428p pd=1.52u as=0 ps=0 w=0.42u l=1u
X2314 VSS.t804 VDD VSS.t803 VSS.t802 sg13_lv_nmos ad=0.1428p pd=1.52u as=0 ps=0 w=0.42u l=1u
X2315 VSS.t2392 VDD VSS.t2391 VSS.t2390 sg13_lv_nmos ad=0.1428p pd=1.52u as=0 ps=0 w=0.42u l=1u
X2316 VDD VSS.t2012 VDD VDD sg13_lv_pmos ad=0.19p pd=1.38u as=0 ps=0 w=1u l=1u
X2317 VDD VSS.t243 VDD VDD sg13_lv_pmos ad=0.19p pd=1.38u as=0 ps=0 w=1u l=1u
X2318 VSS.t4 a_9861_15213# a_9963_15356# VSS.t98 sg13_lv_nmos ad=4.11262p pd=27.15u as=0.2516p ps=2.16u w=0.74u l=0.13u
X2319 VSS.t561 VDD VSS.t560 VSS.t559 sg13_lv_nmos ad=0.1428p pd=1.52u as=0 ps=0 w=0.42u l=1u
X2320 VSS.t1034 VDD VSS.t1036 VSS.t1035 sg13_lv_nmos ad=79.8f pd=0.8u as=0 ps=0 w=0.42u l=1u
X2321 VDD VSS.t1510 VDD VDD sg13_lv_pmos ad=0.19p pd=1.38u as=0 ps=0 w=1u l=1u
X2322 VDD VSS.t1964 VDD VDD sg13_lv_pmos ad=0.34p pd=2.68u as=0 ps=0 w=1u l=1u
X2323 VDD VSS.t1184 VDD VDD sg13_lv_pmos ad=0.34p pd=2.68u as=0 ps=0 w=1u l=1u
X2324 VDD VSS.t2737 VDD VDD sg13_lv_pmos ad=0.34p pd=2.68u as=0 ps=0 w=1u l=1u
X2325 a_2059_14832# sg13cmos5l_buf_1_10.X a_1965_14832# VSS.t117 sg13_lv_nmos ad=0.1216p pd=1.02u as=0.2176p ps=1.96u w=0.64u l=0.13u
X2326 VSS.t1458 VDD VSS.t1460 VSS.t1459 sg13_lv_nmos ad=79.8f pd=0.8u as=0 ps=0 w=0.42u l=1u
X2327 VSS.t2681 VDD VSS.t2681 VSS.t206 sg13_lv_nmos ad=0.1428p pd=1.52u as=0 ps=0 w=0.42u l=1u
X2328 VSS.t1155 reset_n_i a_1192_9948# VSS.t1154 sg13_lv_nmos ad=0.14875p pd=1.16u as=0.187p ps=1.78u w=0.55u l=0.13u
X2329 VDD VSS.t1176 VDD VDD sg13_lv_pmos ad=0.34p pd=2.68u as=0 ps=0 w=1u l=1u
X2330 VSS.t2020 VDD VSS.t2022 VSS.t2021 sg13_lv_nmos ad=79.8f pd=0.8u as=0 ps=0 w=0.42u l=1u
X2331 VDD VSS.t1977 VDD VDD sg13_lv_pmos ad=0.19p pd=1.38u as=0 ps=0 w=1u l=1u
X2332 VDD VSS.t853 VDD VDD sg13_lv_pmos ad=0.34p pd=2.68u as=0 ps=0 w=1u l=1u
X2333 VDD VSS.t1041 VDD VDD sg13_lv_pmos ad=0.19p pd=1.38u as=0 ps=0 w=1u l=1u
X2334 VDD VSS.t1213 VDD VDD sg13_lv_pmos ad=0.19p pd=1.38u as=0 ps=0 w=1u l=1u
X2335 VSS.t2731 VDD VSS.t2731 VSS.t206 sg13_lv_nmos ad=0.1428p pd=1.52u as=0 ps=0 w=0.42u l=1u
X2336 VSS.t2232 VDD VSS.t2234 VSS.t2233 sg13_lv_nmos ad=79.8f pd=0.8u as=0 ps=0 w=0.42u l=1u
X2337 VDD VSS.t294 VDD VDD sg13_lv_pmos ad=0.34p pd=2.68u as=0 ps=0 w=1u l=1u
X2338 VDD VSS.t2331 VDD VDD sg13_lv_pmos ad=0.34p pd=2.68u as=0 ps=0 w=1u l=1u
X2339 VDD sg13cmos5l_or3_1_1.B a_16168_15996# VDD sg13_lv_pmos ad=0.2114p pd=1.54u as=0.2856p ps=2.36u w=0.84u l=0.13u
X2340 VDD VSS.t1477 VDD VDD sg13_lv_pmos ad=0.34p pd=2.68u as=0 ps=0 w=1u l=1u
X2341 VDD VSS.t1650 VDD VDD sg13_lv_pmos ad=0.19p pd=1.38u as=0 ps=0 w=1u l=1u
X2342 VDD sg13cmos5l_dfrbpq_1_3.Q sg13cmos5l_or3_1_1.C VDD sg13_lv_pmos ad=0.2128p pd=1.5u as=0.2128p ps=1.5u w=1.12u l=0.13u
X2343 VSS.t1523 VDD VSS.t1522 VSS.t1521 sg13_lv_nmos ad=0.1428p pd=1.52u as=0 ps=0 w=0.42u l=1u
X2344 VSS.t1940 VDD VSS.t1939 VSS.t1938 sg13_lv_nmos ad=0.1428p pd=1.52u as=0 ps=0 w=0.42u l=1u
X2345 VDD VSS.t2644 VDD VDD sg13_lv_pmos ad=0.34p pd=2.68u as=0 ps=0 w=1u l=1u
X2346 VSS.t959 VDD VSS.t958 VSS.t957 sg13_lv_nmos ad=0.1428p pd=1.52u as=0 ps=0 w=0.42u l=1u
X2347 VDD VSS.t916 VDD VDD sg13_lv_pmos ad=0.19p pd=1.38u as=0 ps=0 w=1u l=1u
X2348 VSS.t1004 VDD VSS.t1003 VSS.t1002 sg13_lv_nmos ad=0.1428p pd=1.52u as=0 ps=0 w=0.42u l=1u
X2349 VDD VSS.t2339 VDD VDD sg13_lv_pmos ad=0.19p pd=1.38u as=0 ps=0 w=1u l=1u
X2350 VDD VSS.t2032 VDD VDD sg13_lv_pmos ad=0.19p pd=1.38u as=0 ps=0 w=1u l=1u
X2351 a_7160_15242# sg13cmos5l_xnor2_1_2.A a_7058_15242# VSS.t101 sg13_lv_nmos ad=0.1406p pd=1.12u as=0.1406p ps=1.12u w=0.74u l=0.13u
X2352 VSS.t1287 VDD VSS.t1288 VSS.t1154 sg13_lv_nmos ad=79.8f pd=0.8u as=0 ps=0 w=0.42u l=1u
X2353 VSS.t1678 VDD VSS.t1677 VSS.t1676 sg13_lv_nmos ad=0.1428p pd=1.52u as=0 ps=0 w=0.42u l=1u
X2354 VSS.t3 a_25774_15423# sg13cmos5l_dfrbpq_1_7.D VSS.t57 sg13_lv_nmos ad=0.1426p pd=1.16u as=0.2516p ps=2.16u w=0.74u l=0.13u
X2355 VSS.t2715 VDD VSS.t2716 VSS.t206 sg13_lv_nmos ad=79.8f pd=0.8u as=0 ps=0 w=0.42u l=1u
X2356 VDD VSS.t2652 VDD VDD sg13_lv_pmos ad=0.19p pd=1.38u as=0 ps=0 w=1u l=1u
X2357 VSS.t2974 VDD VSS.t2973 VSS.t2972 sg13_lv_nmos ad=0.1428p pd=1.52u as=0 ps=0 w=0.42u l=1u
X2358 VDD VSS.t436 VDD VDD sg13_lv_pmos ad=0.34p pd=2.68u as=0 ps=0 w=1u l=1u
X2359 VSS.t2357 VDD VSS.t2359 VSS.t2358 sg13_lv_nmos ad=79.8f pd=0.8u as=0 ps=0 w=0.42u l=1u
X2360 VSS.t413 VDD VSS.t412 VSS.t4 sg13_lv_nmos ad=0.1428p pd=1.52u as=0 ps=0 w=0.42u l=1u
X2361 VSS.t1443 VDD VSS.t1445 VSS.t1444 sg13_lv_nmos ad=79.8f pd=0.8u as=0 ps=0 w=0.42u l=1u
X2362 a_21166_16263# a_21281_16262# VSS.t89 VSS.t94 sg13_lv_nmos ad=0.1428p pd=1.52u as=0.1426p ps=1.16u w=0.42u l=0.5u
X2363 VSS.t1019 VDD VSS.t1021 VSS.t1020 sg13_lv_nmos ad=79.8f pd=0.8u as=0 ps=0 w=0.42u l=1u
X2364 VDD VSS.t1269 VDD VDD sg13_lv_pmos ad=0.34p pd=2.68u as=0 ps=0 w=1u l=1u
X2365 VSS.t1207 VDD VSS.t1208 VSS.t1154 sg13_lv_nmos ad=79.8f pd=0.8u as=0 ps=0 w=0.42u l=1u
X2366 VDD VSS.t216 VDD VDD sg13_lv_pmos ad=0.19p pd=1.38u as=0 ps=0 w=1u l=1u
X2367 VDD VSS.t816 VDD VDD sg13_lv_pmos ad=0.19p pd=1.38u as=0 ps=0 w=1u l=1u
X2368 VDD VSS.t1455 VDD VDD sg13_lv_pmos ad=0.19p pd=1.38u as=0 ps=0 w=1u l=1u
X2369 VDD VSS.t2364 VDD VDD sg13_lv_pmos ad=0.19p pd=1.38u as=0 ps=0 w=1u l=1u
X2370 VSS.t176 a_22426_15202# a_22145_15424# VSS.t57 sg13_lv_nmos ad=79.8f pd=0.8u as=0.1428p ps=1.52u w=0.42u l=0.5u
X2371 VDD VSS.t608 VDD VDD sg13_lv_pmos ad=0.19p pd=1.38u as=0 ps=0 w=1u l=1u
X2372 VSS.t2252 VDD VSS.t2254 VSS.t2253 sg13_lv_nmos ad=79.8f pd=0.8u as=0 ps=0 w=0.42u l=1u
X2373 VSS.t1306 VDD VSS.t1306 VSS.t1154 sg13_lv_nmos ad=79.8f pd=0.8u as=0 ps=0 w=0.42u l=1u
X2374 VDD VSS.t1297 VDD VDD sg13_lv_pmos ad=0.34p pd=2.68u as=0 ps=0 w=1u l=1u
X2375 sg13cmos5l_or3_1_1.B a_14261_15238# VDD VDD sg13_lv_pmos ad=0.2128p pd=1.5u as=0.2128p ps=1.5u w=1.12u l=0.13u
X2376 a_17806_15423# a_17921_15424# VSS.t16 VSS.t264 sg13_lv_nmos ad=0.1428p pd=1.52u as=0.1426p ps=1.16u w=0.42u l=0.5u
X2377 VDD VSS.t583 VDD VDD sg13_lv_pmos ad=0.19p pd=1.38u as=0 ps=0 w=1u l=1u
X2378 VDD VSS.t931 VDD VDD sg13_lv_pmos ad=0.19p pd=1.38u as=0 ps=0 w=1u l=1u
X2379 VSS.t2713 VDD VSS.t2714 VSS.t206 sg13_lv_nmos ad=79.8f pd=0.8u as=0 ps=0 w=0.42u l=1u
X2380 VDD VSS.t2489 VDD VDD sg13_lv_pmos ad=0.19p pd=1.38u as=0 ps=0 w=1u l=1u
X2381 VSS.t1970 VDD VSS.t1972 VSS.t1971 sg13_lv_nmos ad=79.8f pd=0.8u as=0 ps=0 w=0.42u l=1u
X2382 VSS.t176 a_22576_14726# a_22225_14845# VSS.t8 sg13_lv_nmos ad=79.8f pd=0.8u as=0.1428p ps=1.52u w=0.42u l=0.13u
X2383 VDD VSS.t2664 VDD VDD sg13_lv_pmos ad=0.34p pd=2.68u as=0 ps=0 w=1u l=1u
X2384 VSS.t1473 VDD VSS.t1472 VSS.t1471 sg13_lv_nmos ad=0.1428p pd=1.52u as=0 ps=0 w=0.42u l=1u
X2385 a_27472_14726# sg13cmos5l_dfrbpq_1_7.RESET_B VDD VDD sg13_lv_pmos ad=79.8f pd=0.8u as=2.42015p ps=15.68u w=0.42u l=0.13u
X2386 a_8218_13690# sg13cmos5l_dlygate4sd3_1_1.A VDD VDD sg13_lv_pmos ad=0.1428p pd=1.52u as=0.1523p ps=1.38u w=0.42u l=0.13u
X2387 VSS.t153 sg13cmos5l_buf_8_2.A a_19323_13726# VSS.t152 sg13_lv_nmos ad=0.1406p pd=1.12u as=0.1406p ps=1.12u w=0.74u l=0.13u
X2388 a_26148_14040# a_26122_13945# VSS.t243 VSS.t242 sg13_lv_nmos ad=0.2516p pd=2.16u as=0.1626p ps=1.415u w=0.74u l=0.13u
X2389 VDD VSS.t1220 VDD VDD sg13_lv_pmos ad=0.34p pd=2.68u as=0 ps=0 w=1u l=1u
X2390 VDD VSS.t2714 VDD VDD sg13_lv_pmos ad=0.34p pd=2.68u as=0 ps=0 w=1u l=1u
X2391 VDD VSS.t1989 VDD VDD sg13_lv_pmos ad=0.34p pd=2.68u as=0 ps=0 w=1u l=1u
X2392 VSS.t1034 VDD VSS.t1036 VSS.t1035 sg13_lv_nmos ad=79.8f pd=0.8u as=0 ps=0 w=0.42u l=1u
X2393 VDD VSS.t1278 VDD VDD sg13_lv_pmos ad=0.34p pd=2.68u as=0 ps=0 w=1u l=1u
X2394 a_17746_13722# sg13cmos5l_dfrbpq_1_2.RESET_B VSS.t93 VSS.t254 sg13_lv_nmos ad=37.8f pd=0.6u as=79.8f ps=0.8u w=0.42u l=0.13u
X2395 VSS.t1468 VDD VSS.t1467 VSS.t1466 sg13_lv_nmos ad=0.1428p pd=1.52u as=0 ps=0 w=0.42u l=1u
X2396 VSS.t2377 VDD VSS.t2376 VSS.t2375 sg13_lv_nmos ad=0.1428p pd=1.52u as=0 ps=0 w=0.42u l=1u
X2397 VDD VSS.t1672 VDD VDD sg13_lv_pmos ad=0.34p pd=2.68u as=0 ps=0 w=1u l=1u
X2398 VSS.t2707 VDD VSS.t2708 VSS.t206 sg13_lv_nmos ad=79.8f pd=0.8u as=0 ps=0 w=0.42u l=1u
X2399 VDD VSS.t1949 VDD VDD sg13_lv_pmos ad=0.34p pd=2.68u as=0 ps=0 w=1u l=1u
X2400 VDD VSS.t406 VDD VDD sg13_lv_pmos ad=0.34p pd=2.68u as=0 ps=0 w=1u l=1u
X2401 VSS.t536 VDD VSS.t538 VSS.t537 sg13_lv_nmos ad=79.8f pd=0.8u as=0 ps=0 w=0.42u l=1u
X2402 VSS.t894 VDD VSS.t893 VSS.t892 sg13_lv_nmos ad=0.1428p pd=1.52u as=0 ps=0 w=0.42u l=1u
X2403 VDD VSS.t2898 VDD VDD sg13_lv_pmos ad=0.34p pd=2.68u as=0 ps=0 w=1u l=1u
X2404 VSS.t2292 VDD VSS.t2294 VSS.t2293 sg13_lv_nmos ad=79.8f pd=0.8u as=0 ps=0 w=0.42u l=1u
X2405 a_2916_15552# a_2890_15457# VDD VDD sg13_lv_pmos ad=0.34p pd=2.68u as=0.36237p ps=2.605u w=1u l=0.13u
X2406 VDD VSS.t3071 VDD VDD sg13_lv_pmos ad=0.19p pd=1.38u as=0 ps=0 w=1u l=1u
X2407 VDD VSS.t2284 VDD VDD sg13_lv_pmos ad=0.19p pd=1.38u as=0 ps=0 w=1u l=1u
X2408 VDD a_9861_15213# a_9963_15356# VDD sg13_lv_pmos ad=2.8961p pd=18.25u as=0.3864p ps=2.93u w=1.12u l=0.13u
X2409 VDD VSS.t389 VDD VDD sg13_lv_pmos ad=0.19p pd=1.38u as=0 ps=0 w=1u l=1u
X2410 a_4078_14751# a_4193_14750# VDD VDD sg13_lv_pmos ad=0.34p pd=2.68u as=0.2254p ps=1.53u w=1u l=0.5u
X2411 a_22521_14607# a_21579_14495# a_22319_14845# VDD sg13_lv_pmos ad=93.45f pd=0.865u as=0.2048p ps=1.63u w=0.42u l=0.13u
X2412 VSS.t2722 VDD VSS.t2722 VSS.t206 sg13_lv_nmos ad=0.1428p pd=1.52u as=0 ps=0 w=0.42u l=1u
X2413 VDD VSS.t2679 VDD VDD sg13_lv_pmos ad=0.34p pd=2.68u as=0 ps=0 w=1u l=1u
X2414 VDD VSS.t898 VDD VDD sg13_lv_pmos ad=0.34p pd=2.68u as=0 ps=0 w=1u l=1u
X2415 VDD VSS.t2316 VDD VDD sg13_lv_pmos ad=0.34p pd=2.68u as=0 ps=0 w=1u l=1u
X2416 VSS.t769 VDD VSS.t768 VSS.t767 sg13_lv_nmos ad=0.1428p pd=1.52u as=0 ps=0 w=0.42u l=1u
X2417 VDD VSS.t1462 VDD VDD sg13_lv_pmos ad=0.34p pd=2.68u as=0 ps=0 w=1u l=1u
X2418 a_14261_15238# sg13cmos5l_nand4_1_0.Y VDD VDD sg13_lv_pmos ad=0.1596p pd=1.22u as=0.2856p ps=2.36u w=0.84u l=0.13u
X2419 VSS.t2100 VDD VSS.t2102 VSS.t2101 sg13_lv_nmos ad=79.8f pd=0.8u as=0 ps=0 w=0.42u l=1u
X2420 VDD VSS.t632 VDD VDD sg13_lv_pmos ad=0.19p pd=1.38u as=0 ps=0 w=1u l=1u
X2421 VDD VSS.t821 VDD VDD sg13_lv_pmos ad=0.19p pd=1.38u as=0 ps=0 w=1u l=1u
X2422 VSS.t626 VDD VSS.t626 VSS.t754 sg13_lv_nmos ad=0.1428p pd=1.52u as=0 ps=0 w=0.42u l=1u
X2423 VSS.t2672 VDD VSS.t2670 VSS.t206 sg13_lv_nmos ad=0.1428p pd=1.52u as=0 ps=0 w=0.42u l=1u
X2424 VDD VSS.t356 VDD VDD sg13_lv_pmos ad=0.34p pd=2.68u as=0 ps=0 w=1u l=1u
X2425 VSS.t1004 VDD VSS.t1003 VSS.t1002 sg13_lv_nmos ad=0.1428p pd=1.52u as=0 ps=0 w=0.42u l=1u
X2426 VDD VSS.t1652 VDD VDD sg13_lv_pmos ad=0.34p pd=2.68u as=0 ps=0 w=1u l=1u
X2427 VDD VSS.t773 VDD VDD sg13_lv_pmos ad=0.34p pd=2.68u as=0 ps=0 w=1u l=1u
X2428 VDD VSS.t445 VDD VDD sg13_lv_pmos ad=0.34p pd=2.68u as=0 ps=0 w=1u l=1u
X2429 VDD VSS.t1515 VDD VDD sg13_lv_pmos ad=0.19p pd=1.38u as=0 ps=0 w=1u l=1u
X2430 a_18021_14495# sg13cmos5l_buf_8_2.X VSS.t4 VSS.t70 sg13_lv_nmos ad=0.2516p pd=2.16u as=3.8707p ps=25.555u w=0.74u l=0.13u
X2431 VSS.t1165 VDD VSS.t1166 VSS.t1154 sg13_lv_nmos ad=79.8f pd=0.8u as=0 ps=0 w=0.42u l=1u
X2432 VSS.t1203 VDD VSS.t1202 VSS.t1154 sg13_lv_nmos ad=0.1428p pd=1.52u as=0 ps=0 w=0.42u l=1u
X2433 VDD VSS.t1187 VDD VDD sg13_lv_pmos ad=0.34p pd=2.68u as=0 ps=0 w=1u l=1u
X2434 VSS.t2959 VDD VSS.t2958 VSS.t2957 sg13_lv_nmos ad=0.1428p pd=1.52u as=0 ps=0 w=0.42u l=1u
X2435 VDD VSS.t2741 VDD VDD sg13_lv_pmos ad=0.34p pd=2.68u as=0 ps=0 w=1u l=1u
X2436 VDD VSS.t1296 VDD VDD sg13_lv_pmos ad=0.34p pd=2.68u as=0 ps=0 w=1u l=1u
X2437 VSS.t809 VDD VSS.t808 VSS.t807 sg13_lv_nmos ad=0.1428p pd=1.52u as=0 ps=0 w=0.42u l=1u
X2438 VSS.t302 a_12524_15960# counter_value_o[2] VSS.t3172 sg13_lv_nmos ad=0.14875p pd=1.16u as=0.2886p ps=2.26u w=0.74u l=0.13u
X2439 a_17165_16020# sg13cmos5l_inv_1_0.Y a_17063_16020# VDD sg13_lv_pmos ad=0.1575p pd=1.315u as=0.19p ps=1.38u w=1u l=0.13u
X2440 VSS.t1170 VDD VSS.t1171 VSS.t1154 sg13_lv_nmos ad=79.8f pd=0.8u as=0 ps=0 w=0.42u l=1u
X2441 VDD VSS.t2692 VDD VDD sg13_lv_pmos ad=0.19p pd=1.38u as=0 ps=0 w=1u l=1u
X2442 VSS.t2237 VDD VSS.t2239 VSS.t2238 sg13_lv_nmos ad=79.8f pd=0.8u as=0 ps=0 w=0.42u l=1u
X2443 VDD clock_i a_15579_14854# VDD sg13_lv_pmos ad=0.2128p pd=1.5u as=0.3808p ps=2.92u w=1.12u l=0.13u
X2444 VSS.t924 VDD VSS.t923 VSS.t922 sg13_lv_nmos ad=0.1428p pd=1.52u as=0 ps=0 w=0.42u l=1u
X2445 VSS.t2362 VDD VSS.t2361 VSS.t2360 sg13_lv_nmos ad=0.1428p pd=1.52u as=0 ps=0 w=0.42u l=1u
X2446 VSS.t573 VDD VSS.t573 VSS.t693 sg13_lv_nmos ad=79.8f pd=0.8u as=0 ps=0 w=0.42u l=1u
X2447 VDD VSS.t788 VDD VDD sg13_lv_pmos ad=0.34p pd=2.68u as=0 ps=0 w=1u l=1u
X2448 VDD VSS.t1447 VDD VDD sg13_lv_pmos ad=0.34p pd=2.68u as=0 ps=0 w=1u l=1u
X2449 VSS.t2705 VDD VSS.t2706 VSS.t206 sg13_lv_nmos ad=79.8f pd=0.8u as=0 ps=0 w=0.42u l=1u
X2450 VDD VSS.t611 VDD VDD sg13_lv_pmos ad=0.34p pd=2.68u as=0 ps=0 w=1u l=1u
X2451 VDD VSS.t976 VDD VDD sg13_lv_pmos ad=0.19p pd=1.38u as=0 ps=0 w=1u l=1u
X2452 VSS.t1222 VDD VSS.t1221 VSS.t1154 sg13_lv_nmos ad=0.1428p pd=1.52u as=0 ps=0 w=0.42u l=1u
X2453 VSS.t2085 VDD VSS.t2087 VSS.t2086 sg13_lv_nmos ad=79.8f pd=0.8u as=0 ps=0 w=0.42u l=1u
X2454 VDD VSS.t278 VDD VDD sg13_lv_pmos ad=0.19p pd=1.38u as=0 ps=0 w=1u l=1u
X2455 VSS.t294 VDD VSS.t294 VSS.t298 sg13_lv_nmos ad=0.1428p pd=1.52u as=0 ps=0 w=0.42u l=1u
X2456 sg13cmos5l_and2_1_0.X a_1965_14832# VDD VDD sg13_lv_pmos ad=0.3808p pd=2.92u as=0.1918p ps=1.5u w=1.12u l=0.13u
X2457 VSS.t556 VDD VSS.t558 VSS.t557 sg13_lv_nmos ad=79.8f pd=0.8u as=0 ps=0 w=0.42u l=1u
X2458 VSS.t1528 VDD VSS.t1527 VSS.t1526 sg13_lv_nmos ad=0.1428p pd=1.52u as=0 ps=0 w=0.42u l=1u
X2459 VDD VSS.t60 VDD VDD sg13_lv_pmos ad=0.34p pd=2.68u as=0 ps=0 w=1u l=1u
X2460 VSS.t2682 VDD VSS.t2682 VSS.t206 sg13_lv_nmos ad=0.1428p pd=1.52u as=0 ps=0 w=0.42u l=1u
X2461 VDD VSS.t2646 VDD VDD sg13_lv_pmos ad=0.34p pd=2.68u as=0 ps=0 w=1u l=1u
X2462 VSS.t531 VDD VSS.t530 VSS.t529 sg13_lv_nmos ad=0.1428p pd=1.52u as=0 ps=0 w=0.42u l=1u
X2463 VDD sg13cmos5l_dfrbpq_1_3.RESET_B a_17318_14922# VDD sg13_lv_pmos ad=0.36237p pd=2.605u as=79.8f ps=0.8u w=0.42u l=0.13u
X2464 VDD VSS.t1359 VDD VDD sg13_lv_pmos ad=0.34p pd=2.68u as=0 ps=0 w=1u l=1u
X2465 VDD VSS.t2706 VDD VDD sg13_lv_pmos ad=0.34p pd=2.68u as=0 ps=0 w=1u l=1u
X2466 VDD VSS.t1974 VDD VDD sg13_lv_pmos ad=0.34p pd=2.68u as=0 ps=0 w=1u l=1u
X2467 VDD VSS.t2344 VDD VDD sg13_lv_pmos ad=0.19p pd=1.38u as=0 ps=0 w=1u l=1u
X2468 VDD VSS.t2002 VDD VDD sg13_lv_pmos ad=0.19p pd=1.38u as=0 ps=0 w=1u l=1u
X2469 VSS.t66 VDD VSS.t66 VSS.t501 sg13_lv_nmos ad=79.8f pd=0.8u as=0 ps=0 w=0.42u l=1u
X2470 VSS.t824 VDD VSS.t823 VSS.t822 sg13_lv_nmos ad=0.1428p pd=1.52u as=0 ps=0 w=0.42u l=1u
X2471 VSS.t894 VDD VSS.t893 VSS.t892 sg13_lv_nmos ad=0.1428p pd=1.52u as=0 ps=0 w=0.42u l=1u
X2472 VSS.t1258 VDD VSS.t1258 VSS.t1154 sg13_lv_nmos ad=79.8f pd=0.8u as=0 ps=0 w=0.42u l=1u
X2473 VSS.t1179 VDD VSS.t1180 VSS.t1154 sg13_lv_nmos ad=79.8f pd=0.8u as=0 ps=0 w=0.42u l=1u
X2474 VDD VSS.t433 VDD VDD sg13_lv_pmos ad=0.34p pd=2.68u as=0 ps=0 w=1u l=1u
X2475 VDD VSS.t851 VDD VDD sg13_lv_pmos ad=0.19p pd=1.38u as=0 ps=0 w=1u l=1u
X2476 VDD VSS.t1657 VDD VDD sg13_lv_pmos ad=0.34p pd=2.68u as=0 ps=0 w=1u l=1u
X2477 VSS.t2979 VDD VSS.t2978 VSS.t2977 sg13_lv_nmos ad=0.1428p pd=1.52u as=0 ps=0 w=0.42u l=1u
X2478 VSS.t2699 VDD VSS.t2700 VSS.t206 sg13_lv_nmos ad=79.8f pd=0.8u as=0 ps=0 w=0.42u l=1u
X2479 VDD VSS.t2883 VDD VDD sg13_lv_pmos ad=0.34p pd=2.68u as=0 ps=0 w=1u l=1u
X2480 a_6180_14922# sg13cmos5l_and2_1_1.X a_6086_14922# VSS.t142 sg13_lv_nmos ad=60.89999f pd=0.71u as=0.1428p ps=1.52u w=0.42u l=0.13u
X2481 VDD VSS.t1016 VDD VDD sg13_lv_pmos ad=0.19p pd=1.38u as=0 ps=0 w=1u l=1u
X2482 VSS.t2457 VDD VSS.t2456 VSS.t2455 sg13_lv_nmos ad=0.1428p pd=1.52u as=0 ps=0 w=0.42u l=1u
X2483 VSS.t2753 VDD VSS.t2754 VSS.t206 sg13_lv_nmos ad=79.8f pd=0.8u as=0 ps=0 w=0.42u l=1u
X2484 sg13cmos5l_buf_8_2.X a_19323_13726# VSS.t153 VSS.t3249 sg13_lv_nmos ad=0.1406p pd=1.12u as=0.1406p ps=1.12u w=0.74u l=0.13u
X2485 VDD VSS.t1460 VDD VDD sg13_lv_pmos ad=0.19p pd=1.38u as=0 ps=0 w=1u l=1u
X2486 VDD VSS.t2369 VDD VDD sg13_lv_pmos ad=0.19p pd=1.38u as=0 ps=0 w=1u l=1u
X2487 sg13cmos5l_or3_1_2.B a_16168_15996# VSS.t160 VSS.t159 sg13_lv_nmos ad=0.2886p pd=2.26u as=0.14875p ps=1.16u w=0.74u l=0.13u
X2488 VSS.t580 VDD VSS.t583 VSS.t582 sg13_lv_nmos ad=79.8f pd=0.8u as=0 ps=0 w=0.42u l=1u
X2489 VSS.t561 VDD VSS.t560 VSS.t559 sg13_lv_nmos ad=0.1428p pd=1.52u as=0 ps=0 w=0.42u l=1u
X2490 VSS.t769 VDD VSS.t768 VSS.t767 sg13_lv_nmos ad=0.1428p pd=1.52u as=0 ps=0 w=0.42u l=1u
X2491 VDD VSS.t943 VDD VDD sg13_lv_pmos ad=0.34p pd=2.68u as=0 ps=0 w=1u l=1u
X2492 VSS.t323 VDD VSS.t325 VSS.t324 sg13_lv_nmos ad=79.8f pd=0.8u as=0 ps=0 w=0.42u l=1u
X2493 VDD a_6789_14495# a_6891_14495# VDD sg13_lv_pmos ad=2.42015p pd=15.68u as=0.3864p ps=2.93u w=1.12u l=0.13u
X2494 VSS.t1236 VDD VSS.t1234 VSS.t1154 sg13_lv_nmos ad=0.1428p pd=1.52u as=0 ps=0 w=0.42u l=1u
X2495 VSS.t1975 VDD VSS.t1977 VSS.t1976 sg13_lv_nmos ad=79.8f pd=0.8u as=0 ps=0 w=0.42u l=1u
X2496 VSS.t2697 VDD VSS.t2698 VSS.t206 sg13_lv_nmos ad=79.8f pd=0.8u as=0 ps=0 w=0.42u l=1u
X2497 VSS.t1478 VDD VSS.t1477 VSS.t1476 sg13_lv_nmos ad=0.1428p pd=1.52u as=0 ps=0 w=0.42u l=1u
X2498 VDD a_21166_16263# sg13cmos5l_dfrbpq_1_6.D VDD sg13_lv_pmos ad=0.2254p pd=1.53u as=0.4256p ps=3u w=1.12u l=0.13u
X2499 VSS.t1648 VDD VSS.t1650 VSS.t1649 sg13_lv_nmos ad=79.8f pd=0.8u as=0 ps=0 w=0.42u l=1u
X2500 VDD VSS.t435 VDD VDD sg13_lv_pmos ad=0.19p pd=1.38u as=0 ps=0 w=1u l=1u
X2501 VSS.t2040 VDD VSS.t2039 VSS.t2038 sg13_lv_nmos ad=0.1428p pd=1.52u as=0 ps=0 w=0.42u l=1u
X2502 VSS.t66 VDD VSS.t66 VSS.t503 sg13_lv_nmos ad=79.8f pd=0.8u as=0 ps=0 w=0.42u l=1u
X2503 VDD VSS.t2698 VDD VDD sg13_lv_pmos ad=0.34p pd=2.68u as=0 ps=0 w=1u l=1u
X2504 VDD VSS.t1994 VDD VDD sg13_lv_pmos ad=0.34p pd=2.68u as=0 ps=0 w=1u l=1u
X2505 VDD VSS.t160 VDD VDD sg13_lv_pmos ad=0.19p pd=1.38u as=0 ps=0 w=1u l=1u
X2506 VSS.t580 VDD VSS.t580 VSS.t707 sg13_lv_nmos ad=79.8f pd=0.8u as=0 ps=0 w=0.42u l=1u
X2507 VSS.t1240 VDD VSS.t1239 VSS.t1154 sg13_lv_nmos ad=0.1428p pd=1.52u as=0 ps=0 w=0.42u l=1u
X2508 VDD VSS.t1006 VDD VDD sg13_lv_pmos ad=0.19p pd=1.38u as=0 ps=0 w=1u l=1u
X2509 VSS.t1161 VDD VSS.t1160 VSS.t1154 sg13_lv_nmos ad=0.1428p pd=1.52u as=0 ps=0 w=0.42u l=1u
X2510 VSS.t1272 VDD VSS.t1273 VSS.t1154 sg13_lv_nmos ad=79.8f pd=0.8u as=0 ps=0 w=0.42u l=1u
X2511 VSS.t2222 VDD VSS.t2224 VSS.t2223 sg13_lv_nmos ad=79.8f pd=0.8u as=0 ps=0 w=0.42u l=1u
X2512 VSS.t431 VDD VSS.t430 VSS.t4 sg13_lv_nmos ad=0.1428p pd=1.52u as=0 ps=0 w=0.42u l=1u
X2513 a_27898_15202# sg13cmos5l_dfrbpq_1_5.Q VDD VDD sg13_lv_pmos ad=0.1428p pd=1.52u as=0.1523p ps=1.38u w=0.42u l=0.13u
X2514 VDD VSS.t1677 VDD VDD sg13_lv_pmos ad=0.34p pd=2.68u as=0 ps=0 w=1u l=1u
X2515 VDD VSS.t1954 VDD VDD sg13_lv_pmos ad=0.34p pd=2.68u as=0 ps=0 w=1u l=1u
X2516 VDD VSS.t1178 VDD VDD sg13_lv_pmos ad=0.34p pd=2.68u as=0 ps=0 w=1u l=1u
X2517 VSS.t2297 VDD VSS.t2299 VSS.t2298 sg13_lv_nmos ad=79.8f pd=0.8u as=0 ps=0 w=0.42u l=1u
X2518 VSS.t809 VDD VSS.t808 VSS.t807 sg13_lv_nmos ad=0.1428p pd=1.52u as=0 ps=0 w=0.42u l=1u
X2519 VDD VSS.t3076 VDD VDD sg13_lv_pmos ad=0.19p pd=1.38u as=0 ps=0 w=1u l=1u
X2520 VDD VSS.t721 VDD VDD sg13_lv_pmos ad=0.19p pd=1.38u as=0 ps=0 w=1u l=1u
X2521 VSS.t1039 VDD VSS.t1041 VSS.t1040 sg13_lv_nmos ad=79.8f pd=0.8u as=0 ps=0 w=0.42u l=1u
X2522 VSS.t924 VDD VSS.t923 VSS.t922 sg13_lv_nmos ad=0.1428p pd=1.52u as=0 ps=0 w=0.42u l=1u
X2523 VSS.t11 sg13cmos5l_dfrbpq_1_2.Q a_16552_15996# VSS.t3257 sg13_lv_nmos ad=0.14875p pd=1.16u as=0.187p ps=1.78u w=0.55u l=0.13u
X2524 VSS.t361 VDD VSS.t361 VSS.t362 sg13_lv_nmos ad=79.8f pd=0.8u as=0 ps=0 w=0.42u l=1u
X2525 VSS.t509 VDD VSS.t509 VSS.t511 sg13_lv_nmos ad=79.8f pd=0.8u as=0 ps=0 w=0.42u l=1u
X2526 VSS.t2725 VDD VSS.t2725 VSS.t206 sg13_lv_nmos ad=0.1428p pd=1.52u as=0 ps=0 w=0.42u l=1u
X2527 a_21348_14909# a_21579_14495# a_21034_14452# VSS.t181 sg13_lv_nmos ad=0.2373p pd=1.97u as=79.8f ps=0.8u w=0.42u l=0.13u
X2528 VDD VSS.t2662 VDD VDD sg13_lv_pmos ad=0.34p pd=2.68u as=0 ps=0 w=1u l=1u
X2529 VSS.t273 VDD VSS.t273 VSS.t276 sg13_lv_nmos ad=79.8f pd=0.8u as=0 ps=0 w=0.42u l=1u
X2530 VDD VSS.t1021 VDD VDD sg13_lv_pmos ad=0.19p pd=1.38u as=0 ps=0 w=1u l=1u
X2531 VDD a_27898_15202# a_27617_15424# VDD sg13_lv_pmos ad=0.1523p pd=1.38u as=0.34p ps=2.68u w=1u l=0.5u
X2532 VDD VSS.t415 VDD VDD sg13_lv_pmos ad=0.34p pd=2.68u as=0 ps=0 w=1u l=1u
X2533 VSS.t2070 VDD VSS.t2072 VSS.t2071 sg13_lv_nmos ad=79.8f pd=0.8u as=0 ps=0 w=0.42u l=1u
X2534 VDD VSS.t1243 VDD VDD sg13_lv_pmos ad=0.19p pd=1.38u as=0 ps=0 w=1u l=1u
X2535 VSS.t1513 VDD VSS.t1512 VSS.t1511 sg13_lv_nmos ad=0.1428p pd=1.52u as=0 ps=0 w=0.42u l=1u
X2536 VDD VSS.t2736 VDD VDD sg13_lv_pmos ad=0.19p pd=1.38u as=0 ps=0 w=1u l=1u
X2537 VSS.t2442 VDD VSS.t2441 VSS.t2440 sg13_lv_nmos ad=0.1428p pd=1.52u as=0 ps=0 w=0.42u l=1u
X2538 VDD VSS.t1472 VDD VDD sg13_lv_pmos ad=0.34p pd=2.68u as=0 ps=0 w=1u l=1u
X2539 VSS.t2675 VDD VSS.t2674 VSS.t206 sg13_lv_nmos ad=0.1428p pd=1.52u as=0 ps=0 w=0.42u l=1u
X2540 VDD VSS.t2638 VDD VDD sg13_lv_pmos ad=0.34p pd=2.68u as=0 ps=0 w=1u l=1u
X2541 VDD VSS.t2381 VDD VDD sg13_lv_pmos ad=0.34p pd=2.68u as=0 ps=0 w=1u l=1u
X2542 VSS.t824 VDD VSS.t823 VSS.t822 sg13_lv_nmos ad=0.1428p pd=1.52u as=0 ps=0 w=0.42u l=1u
X2543 VSS.t1254 VDD VSS.t1252 VSS.t1154 sg13_lv_nmos ad=0.1428p pd=1.52u as=0 ps=0 w=0.42u l=1u
X2544 VDD VSS.t593 VDD VDD sg13_lv_pmos ad=0.19p pd=1.38u as=0 ps=0 w=1u l=1u
X2545 VDD VSS.t781 VDD VDD sg13_lv_pmos ad=0.19p pd=1.38u as=0 ps=0 w=1u l=1u
X2546 VSS.t728 VDD VSS.t191 VSS.t727 sg13_lv_nmos ad=0.1428p pd=1.52u as=0 ps=0 w=0.42u l=1u
X2547 VDD VSS.t2329 VDD VDD sg13_lv_pmos ad=0.19p pd=1.38u as=0 ps=0 w=1u l=1u
X2548 VDD VSS.t1987 VDD VDD sg13_lv_pmos ad=0.19p pd=1.38u as=0 ps=0 w=1u l=1u
X2549 VSS.t1990 VDD VSS.t1989 VSS.t1988 sg13_lv_nmos ad=0.1428p pd=1.52u as=0 ps=0 w=0.42u l=1u
X2550 VSS.t1285 VDD VSS.t1286 VSS.t1154 sg13_lv_nmos ad=79.8f pd=0.8u as=0 ps=0 w=0.42u l=1u
X2551 a_26148_14040# a_26122_13945# VDD VDD sg13_lv_pmos ad=0.34p pd=2.68u as=0.36237p ps=2.605u w=1u l=0.13u
X2552 VDD VSS.t1190 VDD VDD sg13_lv_pmos ad=0.34p pd=2.68u as=0 ps=0 w=1u l=1u
X2553 VSS.t2964 VDD VSS.t2963 VSS.t2962 sg13_lv_nmos ad=0.1428p pd=1.52u as=0 ps=0 w=0.42u l=1u
X2554 VSS.t147 VDD VSS.t147 VSS.t464 sg13_lv_nmos ad=79.8f pd=0.8u as=0 ps=0 w=0.42u l=1u
X2555 VSS.t1009 VDD VSS.t1008 VSS.t1007 sg13_lv_nmos ad=0.1428p pd=1.52u as=0 ps=0 w=0.42u l=1u
X2556 VDD VSS.t1188 VDD VDD sg13_lv_pmos ad=0.34p pd=2.68u as=0 ps=0 w=1u l=1u
X2557 VDD VSS.t424 VDD VDD sg13_lv_pmos ad=0.34p pd=2.68u as=0 ps=0 w=1u l=1u
X2558 VSS.t1290 VDD VSS.t1291 VSS.t1154 sg13_lv_nmos ad=79.8f pd=0.8u as=0 ps=0 w=0.42u l=1u
X2559 VSS.t623 VDD VSS.t626 VSS.t753 sg13_lv_nmos ad=79.8f pd=0.8u as=0 ps=0 w=0.42u l=1u
X2560 VDD VSS.t873 VDD VDD sg13_lv_pmos ad=0.34p pd=2.68u as=0 ps=0 w=1u l=1u
X2561 VDD VSS.t1445 VDD VDD sg13_lv_pmos ad=0.19p pd=1.38u as=0 ps=0 w=1u l=1u
X2562 VSS.t2744 VDD VSS.t2745 VSS.t206 sg13_lv_nmos ad=79.8f pd=0.8u as=0 ps=0 w=0.42u l=1u
X2563 VSS.t2242 VDD VSS.t2244 VSS.t2243 sg13_lv_nmos ad=79.8f pd=0.8u as=0 ps=0 w=0.42u l=1u
X2564 VSS.t2717 VDD VSS.t2717 VSS.t206 sg13_lv_nmos ad=0.1428p pd=1.52u as=0 ps=0 w=0.42u l=1u
X2565 VDD VSS.t1452 VDD VDD sg13_lv_pmos ad=0.34p pd=2.68u as=0 ps=0 w=1u l=1u
X2566 VDD VSS.t1625 VDD VDD sg13_lv_pmos ad=0.19p pd=1.38u as=0 ps=0 w=1u l=1u
X2567 VSS.t1463 VDD VSS.t1462 VSS.t1461 sg13_lv_nmos ad=0.1428p pd=1.52u as=0 ps=0 w=0.42u l=1u
X2568 VSS.t1533 VDD VSS.t1532 VSS.t1531 sg13_lv_nmos ad=0.1428p pd=1.52u as=0 ps=0 w=0.42u l=1u
X2569 sg13cmos5l_or3_1_1.C sg13cmos5l_o21ai_1_2.B1 a_24062_15242# VSS.t57 sg13_lv_nmos ad=0.2516p pd=2.16u as=0.1406p ps=1.12u w=0.74u l=0.13u
X2570 VDD VSS.t2629 VDD VDD sg13_lv_pmos ad=0.34p pd=2.68u as=0 ps=0 w=1u l=1u
X2571 VDD VSS.t936 VDD VDD sg13_lv_pmos ad=0.19p pd=1.38u as=0 ps=0 w=1u l=1u
X2572 VSS.t1 sg13cmos5l_and2_1_2.B a_8779_14832# VSS.t0 sg13_lv_nmos ad=0.1331p pd=1.12u as=0.1216p ps=1.02u w=0.64u l=0.13u
X2573 a_27407_13799# a_26565_13701# a_27313_13799# VSS.t67 sg13_lv_nmos ad=0.12665p pd=1.145u as=0.1428p ps=1.52u w=0.42u l=0.13u
X2574 VDD VSS.t1213 VDD VDD sg13_lv_pmos ad=0.34p pd=2.68u as=0 ps=0 w=1u l=1u
X2575 VDD VSS.t1979 VDD VDD sg13_lv_pmos ad=0.34p pd=2.68u as=0 ps=0 w=1u l=1u
X2576 VDD VSS.t2349 VDD VDD sg13_lv_pmos ad=0.19p pd=1.38u as=0 ps=0 w=1u l=1u
X2577 VDD VSS.t2007 VDD VDD sg13_lv_pmos ad=0.19p pd=1.38u as=0 ps=0 w=1u l=1u
X2578 a_6660_14909# a_6372_14488# a_6598_14909# VSS.t169 sg13_lv_nmos ad=0.1428p pd=1.52u as=37.8f ps=0.6u w=0.42u l=0.13u
X2579 a_25203_13320# sg13cmos5l_a21oi_1_3.A2 VSS.t60 VSS.t235 sg13_lv_nmos ad=0.1406p pd=1.12u as=0.2516p ps=2.16u w=0.74u l=0.13u
X2580 VSS.t1653 VDD VSS.t1652 VSS.t1651 sg13_lv_nmos ad=0.1428p pd=1.52u as=0 ps=0 w=0.42u l=1u
X2581 VDD VSS.t863 VDD VDD sg13_lv_pmos ad=0.34p pd=2.68u as=0 ps=0 w=1u l=1u
X2582 VSS.t16 clock_i a_15579_14854# VSS.t3235 sg13_lv_nmos ad=0.1406p pd=1.12u as=0.1406p ps=1.12u w=0.74u l=0.13u
X2583 VDD VSS.t1281 VDD VDD sg13_lv_pmos ad=0.34p pd=2.68u as=0 ps=0 w=1u l=1u
X2584 a_17892_14909# a_18123_14495# a_17578_14452# VSS.t12 sg13_lv_nmos ad=0.2373p pd=1.97u as=79.8f ps=0.8u w=0.42u l=0.13u
X2585 a_17961_14531# a_17604_14488# VDD VDD sg13_lv_pmos ad=63f pd=0.72u as=0.1563p ps=1.22u w=0.42u l=0.13u
X2586 VDD VSS.t66 VDD VDD sg13_lv_pmos ad=0.34p pd=2.68u as=0 ps=0 w=1u l=1u
X2587 VDD VSS.t611 VDD VDD sg13_lv_pmos ad=0.19p pd=1.38u as=0 ps=0 w=1u l=1u
X2588 VSS.t1039 VDD VSS.t1041 VSS.t1040 sg13_lv_nmos ad=79.8f pd=0.8u as=0 ps=0 w=0.42u l=1u
X2589 VSS.t2462 VDD VSS.t2461 VSS.t2460 sg13_lv_nmos ad=0.1428p pd=1.52u as=0 ps=0 w=0.42u l=1u
X2590 VDD a_32492_15960# counter_value_o[6] VDD sg13_lv_pmos ad=0.2114p pd=1.54u as=0.42p ps=2.99u w=1.12u l=0.13u
X2591 VSS.t605 VDD VSS.t605 VSS.t740 sg13_lv_nmos ad=0.1428p pd=1.52u as=0 ps=0 w=0.42u l=1u
X2592 VDD VSS.t1244 VDD VDD sg13_lv_pmos ad=0.19p pd=1.38u as=0 ps=0 w=1u l=1u
X2593 VDD VSS.t2034 VDD VDD sg13_lv_pmos ad=0.34p pd=2.68u as=0 ps=0 w=1u l=1u
X2594 a_17126_15238# a_16856_15238# VSS.t16 VSS.t183 sg13_lv_nmos ad=0.1428p pd=1.52u as=79.8f ps=0.8u w=0.42u l=0.5u
X2595 VSS.t899 VDD VSS.t898 VSS.t897 sg13_lv_nmos ad=0.1428p pd=1.52u as=0 ps=0 w=0.42u l=1u
X2596 VDD VSS.t3156 VDD VDD sg13_lv_pmos ad=0.19p pd=1.38u as=0 ps=0 w=1u l=1u
X2597 VSS.t2227 VDD VSS.t2229 VSS.t2228 sg13_lv_nmos ad=79.8f pd=0.8u as=0 ps=0 w=0.42u l=1u
X2598 VSS.t1224 VDD VSS.t1225 VSS.t1154 sg13_lv_nmos ad=79.8f pd=0.8u as=0 ps=0 w=0.42u l=1u
X2599 VDD VSS.t2652 VDD VDD sg13_lv_pmos ad=0.34p pd=2.68u as=0 ps=0 w=1u l=1u
X2600 VSS.t2700 VDD VSS.t2701 VSS.t206 sg13_lv_nmos ad=79.8f pd=0.8u as=0 ps=0 w=0.42u l=1u
X2601 VSS.t1448 VDD VSS.t1447 VSS.t1446 sg13_lv_nmos ad=0.1428p pd=1.52u as=0 ps=0 w=0.42u l=1u
X2602 VSS.t179 a_21466_15202# a_21185_15424# VSS.t178 sg13_lv_nmos ad=79.8f pd=0.8u as=0.1428p ps=1.52u w=0.42u l=0.5u
X2603 VDD VSS.t903 VDD VDD sg13_lv_pmos ad=0.34p pd=2.68u as=0 ps=0 w=1u l=1u
X2604 VDD VSS.t1457 VDD VDD sg13_lv_pmos ad=0.34p pd=2.68u as=0 ps=0 w=1u l=1u
X2605 VDD VSS.t2366 VDD VDD sg13_lv_pmos ad=0.34p pd=2.68u as=0 ps=0 w=1u l=1u
X2606 VSS.t774 VDD VSS.t773 VSS.t772 sg13_lv_nmos ad=0.1428p pd=1.52u as=0 ps=0 w=0.42u l=1u
X2607 VDD VSS.t1205 VDD VDD sg13_lv_pmos ad=0.34p pd=2.68u as=0 ps=0 w=1u l=1u
X2608 VDD VSS.t2701 VDD VDD sg13_lv_pmos ad=0.34p pd=2.68u as=0 ps=0 w=1u l=1u
X2609 VSS.t2257 VDD VSS.t2256 VSS.t2255 sg13_lv_nmos ad=0.1428p pd=1.52u as=0 ps=0 w=0.42u l=1u
X2610 VSS.t11 a_18106_15960# a_17825_16262# VSS.t3255 sg13_lv_nmos ad=79.8f pd=0.8u as=0.1428p ps=1.52u w=0.42u l=0.5u
X2611 a_32492_15960# sg13cmos5l_dfrbpq_1_7.Q VDD VDD sg13_lv_pmos ad=0.2856p pd=2.36u as=0.2114p ps=1.54u w=0.84u l=0.13u
X2612 VDD VSS.t826 VDD VDD sg13_lv_pmos ad=0.19p pd=1.38u as=0 ps=0 w=1u l=1u
X2613 VSS.t2640 VDD VSS.t2642 VSS.t206 sg13_lv_nmos ad=79.8f pd=0.8u as=0 ps=0 w=0.42u l=1u
X2614 VDD VSS.t2491 VDD VDD sg13_lv_pmos ad=0.34p pd=2.68u as=0 ps=0 w=1u l=1u
X2615 VSS.t556 VDD VSS.t558 VSS.t557 sg13_lv_nmos ad=79.8f pd=0.8u as=0 ps=0 w=0.42u l=1u
X2616 VSS.t1009 VDD VSS.t1008 VSS.t1007 sg13_lv_nmos ad=0.1428p pd=1.52u as=0 ps=0 w=0.42u l=1u
X2617 VSS.t1201 VDD VSS.t1200 VSS.t1154 sg13_lv_nmos ad=0.1428p pd=1.52u as=0 ps=0 w=0.42u l=1u
X2618 VSS.t147 VDD VSS.t147 VSS.t394 sg13_lv_nmos ad=79.8f pd=0.8u as=0 ps=0 w=0.42u l=1u
X2619 VSS.t1233 VDD VSS.t1234 VSS.t1154 sg13_lv_nmos ad=79.8f pd=0.8u as=0 ps=0 w=0.42u l=1u
X2620 VDD VSS.t1181 VDD VDD sg13_lv_pmos ad=0.34p pd=2.68u as=0 ps=0 w=1u l=1u
X2621 VDD VSS.t2019 VDD VDD sg13_lv_pmos ad=0.34p pd=2.68u as=0 ps=0 w=1u l=1u
X2622 VSS.t1206 VDD VSS.t1205 VSS.t1154 sg13_lv_nmos ad=0.1428p pd=1.52u as=0 ps=0 w=0.42u l=1u
X2623 a_2540_15960# sg13cmos5l_dlygate4sd3_1_3.A VDD VDD sg13_lv_pmos ad=0.2856p pd=2.36u as=0.2114p ps=1.54u w=0.84u l=0.13u
X2624 VSS.t789 VDD VSS.t788 VSS.t787 sg13_lv_nmos ad=0.1428p pd=1.52u as=0 ps=0 w=0.42u l=1u
X2625 VSS.t974 VDD VSS.t976 VSS.t975 sg13_lv_nmos ad=79.8f pd=0.8u as=0 ps=0 w=0.42u l=1u
X2626 VSS.t2710 VDD VSS.t2709 VSS.t206 sg13_lv_nmos ad=0.1428p pd=1.52u as=0 ps=0 w=0.42u l=1u
X2627 VDD VSS.t2664 VDD VDD sg13_lv_pmos ad=0.34p pd=2.68u as=0 ps=0 w=1u l=1u
X2628 VDD VSS.t1967 VDD VDD sg13_lv_pmos ad=0.19p pd=1.38u as=0 ps=0 w=1u l=1u
X2629 VSS.t1158 VDD VSS.t1159 VSS.t1154 sg13_lv_nmos ad=79.8f pd=0.8u as=0 ps=0 w=0.42u l=1u
X2630 VDD VSS.t1437 VDD VDD sg13_lv_pmos ad=0.34p pd=2.68u as=0 ps=0 w=1u l=1u
X2631 VDD VSS.t525 VDD VDD sg13_lv_pmos ad=0.34p pd=2.68u as=0 ps=0 w=1u l=1u
X2632 VSS.t2075 VDD VSS.t2077 VSS.t2076 sg13_lv_nmos ad=79.8f pd=0.8u as=0 ps=0 w=0.42u l=1u
X2633 VSS.t1518 VDD VSS.t1517 VSS.t1516 sg13_lv_nmos ad=0.1428p pd=1.52u as=0 ps=0 w=0.42u l=1u
X2634 VSS.t3159 VDD VSS.t3161 VSS.t3160 sg13_lv_nmos ad=79.8f pd=0.8u as=0 ps=0 w=0.42u l=1u
X2635 VDD VSS.t573 VDD VDD sg13_lv_pmos ad=0.34p pd=2.68u as=0 ps=0 w=1u l=1u
X2636 VDD VSS.t981 VDD VDD sg13_lv_pmos ad=0.19p pd=1.38u as=0 ps=0 w=1u l=1u
X2637 VDD VSS.t1477 VDD VDD sg13_lv_pmos ad=0.34p pd=2.68u as=0 ps=0 w=1u l=1u
X2638 VSS.t2677 VDD VSS.t2677 VSS.t206 sg13_lv_nmos ad=0.1428p pd=1.52u as=0 ps=0 w=0.42u l=1u
X2639 VDD VSS.t2386 VDD VDD sg13_lv_pmos ad=0.34p pd=2.68u as=0 ps=0 w=1u l=1u
X2640 VDD VSS.t1650 VDD VDD sg13_lv_pmos ad=0.19p pd=1.38u as=0 ps=0 w=1u l=1u
X2641 VSS.t407 VDD VSS.t406 VSS.t4 sg13_lv_nmos ad=0.1428p pd=1.52u as=0 ps=0 w=0.42u l=1u
X2642 VDD VSS.t793 VDD VDD sg13_lv_pmos ad=0.34p pd=2.68u as=0 ps=0 w=1u l=1u
X2643 VSS.t294 VDD VSS.t289 VSS.t293 sg13_lv_nmos ad=0.1428p pd=1.52u as=0 ps=0 w=0.42u l=1u
X2644 sg13cmos5l_xor2_1_0.X a_2490_14447# VSS.t136 VSS.t135 sg13_lv_nmos ad=0.1628p pd=1.18u as=0.3108p ps=2.32u w=0.74u l=0.13u
X2645 VSS.t561 VDD VSS.t563 VSS.t562 sg13_lv_nmos ad=79.8f pd=0.8u as=0 ps=0 w=0.42u l=1u
X2646 sg13cmos5l_dfrbpq_1_2.Q a_17994_14020# VSS.t93 VSS.t3263 sg13_lv_nmos ad=0.2516p pd=2.16u as=0.1406p ps=1.12u w=0.74u l=0.13u
X2647 VDD VSS.t2334 VDD VDD sg13_lv_pmos ad=0.19p pd=1.38u as=0 ps=0 w=1u l=1u
X2648 VDD VSS.t1992 VDD VDD sg13_lv_pmos ad=0.19p pd=1.38u as=0 ps=0 w=1u l=1u
X2649 VSS.t1995 VDD VSS.t1994 VSS.t1993 sg13_lv_nmos ad=0.1428p pd=1.52u as=0 ps=0 w=0.42u l=1u
X2650 VDD VSS.t908 VDD VDD sg13_lv_pmos ad=0.34p pd=2.68u as=0 ps=0 w=1u l=1u
X2651 VSS.t1177 VDD VSS.t1178 VSS.t1154 sg13_lv_nmos ad=79.8f pd=0.8u as=0 ps=0 w=0.42u l=1u
X2652 VSS.t1215 VDD VSS.t1213 VSS.t1154 sg13_lv_nmos ad=0.1428p pd=1.52u as=0 ps=0 w=0.42u l=1u
X2653 VDD VSS.t1308 VDD VDD sg13_lv_pmos ad=0.34p pd=2.68u as=0 ps=0 w=1u l=1u
X2654 VDD VSS.t66 VDD VDD sg13_lv_pmos ad=0.34p pd=2.68u as=0 ps=0 w=1u l=1u
X2655 a_9444_15552# a_9963_15356# a_10703_15311# VSS.t129 sg13_lv_nmos ad=0.3473p pd=2.71u as=0.12665p ps=1.145u w=0.74u l=0.13u
X2656 a_7888_14726# sg13cmos5l_dfrbpq_1_1.RESET_B VDD VDD sg13_lv_pmos ad=79.8f pd=0.8u as=2.42015p ps=15.68u w=0.42u l=0.13u
X2657 VSS.t635 VDD VSS.t632 VSS.t634 sg13_lv_nmos ad=0.1428p pd=1.52u as=0 ps=0 w=0.42u l=1u
X2658 VSS.t66 VDD VSS.t66 VSS.t503 sg13_lv_nmos ad=79.8f pd=0.8u as=0 ps=0 w=0.42u l=1u
X2659 VDD a_27215_14845# a_27472_14726# VDD sg13_lv_pmos ad=2.42015p pd=15.68u as=79.8f ps=0.8u w=0.42u l=0.13u
X2660 VSS.t899 VDD VSS.t898 VSS.t897 sg13_lv_nmos ad=0.1428p pd=1.52u as=0 ps=0 w=0.42u l=1u
X2661 VSS.t1182 VDD VSS.t1183 VSS.t1154 sg13_lv_nmos ad=79.8f pd=0.8u as=0 ps=0 w=0.42u l=1u
X2662 VDD VSS.t2624 VDD VDD sg13_lv_pmos ad=0.19p pd=1.38u as=0 ps=0 w=1u l=1u
X2663 VDD VSS.t436 VDD VDD sg13_lv_pmos ad=0.34p pd=2.68u as=0 ps=0 w=1u l=1u
X2664 VSS.t1508 VDD VSS.t1507 VSS.t1506 sg13_lv_nmos ad=0.1428p pd=1.52u as=0 ps=0 w=0.42u l=1u
X2665 VSS.t3029 VDD VSS.t3028 VSS.t3027 sg13_lv_nmos ad=0.1428p pd=1.52u as=0 ps=0 w=0.42u l=1u
X2666 VSS.t2242 VDD VSS.t2241 VSS.t2240 sg13_lv_nmos ad=0.1428p pd=1.52u as=0 ps=0 w=0.42u l=1u
X2667 VDD a_7631_14845# a_8298_14484# VDD sg13_lv_pmos ad=0.2128p pd=1.5u as=0.3864p ps=2.93u w=1.12u l=0.13u
X2668 VSS.t944 VDD VSS.t943 VSS.t942 sg13_lv_nmos ad=0.1428p pd=1.52u as=0 ps=0 w=0.42u l=1u
X2669 VDD VSS.t808 VDD VDD sg13_lv_pmos ad=0.34p pd=2.68u as=0 ps=0 w=1u l=1u
X2670 VSS.t1251 VDD VSS.t1252 VSS.t1154 sg13_lv_nmos ad=79.8f pd=0.8u as=0 ps=0 w=0.42u l=1u
X2671 VDD VSS.t3141 VDD VDD sg13_lv_pmos ad=0.19p pd=1.38u as=0 ps=0 w=1u l=1u
X2672 VDD VSS.t1630 VDD VDD sg13_lv_pmos ad=0.19p pd=1.38u as=0 ps=0 w=1u l=1u
X2673 VDD VSS.t3093 VDD VDD sg13_lv_pmos ad=0.34p pd=2.68u as=0 ps=0 w=1u l=1u
X2674 VSS.t2692 VDD VSS.t2693 VSS.t206 sg13_lv_nmos ad=79.8f pd=0.8u as=0 ps=0 w=0.42u l=1u
X2675 VSS.t774 VDD VSS.t773 VSS.t772 sg13_lv_nmos ad=0.1428p pd=1.52u as=0 ps=0 w=0.42u l=1u
X2676 VSS.t341 VDD VSS.t343 VSS.t342 sg13_lv_nmos ad=79.8f pd=0.8u as=0 ps=0 w=0.42u l=1u
X2677 VSS.t2030 VDD VSS.t2029 VSS.t2028 sg13_lv_nmos ad=0.1428p pd=1.52u as=0 ps=0 w=0.42u l=1u
X2678 a_19054_15423# a_19169_15424# VSS.t171 VSS.t107 sg13_lv_nmos ad=0.1428p pd=1.52u as=0.1426p ps=1.16u w=0.42u l=0.5u
X2679 VSS.t509 VDD VSS.t509 VSS.t511 sg13_lv_nmos ad=79.8f pd=0.8u as=0 ps=0 w=0.42u l=1u
X2680 VSS.t1004 VDD VSS.t1006 VSS.t1005 sg13_lv_nmos ad=79.8f pd=0.8u as=0 ps=0 w=0.42u l=1u
X2681 VDD VSS.t1196 VDD VDD sg13_lv_pmos ad=0.19p pd=1.38u as=0 ps=0 w=1u l=1u
X2682 VDD VSS.t1196 VDD VDD sg13_lv_pmos ad=0.34p pd=2.68u as=0 ps=0 w=1u l=1u
X2683 VDD VSS.t2693 VDD VDD sg13_lv_pmos ad=0.34p pd=2.68u as=0 ps=0 w=1u l=1u
X2684 VDD VSS.t2728 VDD VDD sg13_lv_pmos ad=0.19p pd=1.38u as=0 ps=0 w=1u l=1u
X2685 VSS.t1270 VDD VSS.t1271 VSS.t1154 sg13_lv_nmos ad=79.8f pd=0.8u as=0 ps=0 w=0.42u l=1u
X2686 VSS.t1191 VDD VSS.t1192 VSS.t1154 sg13_lv_nmos ad=79.8f pd=0.8u as=0 ps=0 w=0.42u l=1u
X2687 VDD VSS.t2319 VDD VDD sg13_lv_pmos ad=0.19p pd=1.38u as=0 ps=0 w=1u l=1u
X2688 VDD VSS.t871 VDD VDD sg13_lv_pmos ad=0.19p pd=1.38u as=0 ps=0 w=1u l=1u
X2689 VSS.t2631 VDD VSS.t2633 VSS.t206 sg13_lv_nmos ad=79.8f pd=0.8u as=0 ps=0 w=0.42u l=1u
X2690 VDD sg13cmos5l_nand4_1_0.Y a_14261_15238# VDD sg13_lv_pmos ad=0.203p pd=1.5u as=0.1596p ps=1.22u w=0.84u l=0.13u
X2691 VDD VSS.t580 VDD VDD sg13_lv_pmos ad=0.34p pd=2.68u as=0 ps=0 w=1u l=1u
X2692 sg13cmos5l_dfrbpq_1_1.RESET_B a_5886_15486# VDD VDD sg13_lv_pmos ad=0.3927p pd=2.99u as=2.8961p ps=18.25u w=1.155u l=0.13u
X2693 VSS.t425 VDD VSS.t424 VSS.t4 sg13_lv_nmos ad=0.1428p pd=1.52u as=0 ps=0 w=0.42u l=1u
X2694 VSS.t372 VDD VSS.t372 VSS.t375 sg13_lv_nmos ad=79.8f pd=0.8u as=0 ps=0 w=0.42u l=1u
X2695 VSS.t76 sg13cmos5l_dlygate4sd3_1_0.X a_5707_14832# VSS.t75 sg13_lv_nmos ad=0.1331p pd=1.12u as=0.1216p ps=1.02u w=0.64u l=0.13u
X2696 VSS.t789 VDD VSS.t788 VSS.t787 sg13_lv_nmos ad=0.1428p pd=1.52u as=0 ps=0 w=0.42u l=1u
X2697 VSS.t2737 VDD VSS.t2739 VSS.t206 sg13_lv_nmos ad=79.8f pd=0.8u as=0 ps=0 w=0.42u l=1u
X2698 VDD a_25390_16263# sg13cmos5l_a21oi_1_2.A1 VDD sg13_lv_pmos ad=0.2254p pd=1.53u as=0.4256p ps=3u w=1.12u l=0.13u
X2699 VSS.t974 VDD VSS.t976 VSS.t975 sg13_lv_nmos ad=79.8f pd=0.8u as=0 ps=0 w=0.42u l=1u
X2700 VDD VSS.t963 VDD VDD sg13_lv_pmos ad=0.34p pd=2.68u as=0 ps=0 w=1u l=1u
X2701 VDD VSS.t2004 VDD VDD sg13_lv_pmos ad=0.34p pd=2.68u as=0 ps=0 w=1u l=1u
X2702 VDD VSS.t273 VDD VDD sg13_lv_pmos ad=0.34p pd=2.68u as=0 ps=0 w=1u l=1u
X2703 VSS.t546 VDD VSS.t545 VSS.t544 sg13_lv_nmos ad=0.1428p pd=1.52u as=0 ps=0 w=0.42u l=1u
X2704 VDD VSS.t3126 VDD VDD sg13_lv_pmos ad=0.19p pd=1.38u as=0 ps=0 w=1u l=1u
X2705 VSS.t9 a_25094_15238# a_25206_15302# VSS.t57 sg13_lv_nmos ad=0.1426p pd=1.16u as=0.1428p ps=1.52u w=0.42u l=0.5u
X2706 VDD VSS.t389 VDD VDD sg13_lv_pmos ad=0.19p pd=1.38u as=0 ps=0 w=1u l=1u
X2707 a_9861_14521# a_9861_14521# VSS.t4 VSS.t3216 sg13_lv_nmos ad=0.111p pd=1.34u as=4.11262p ps=27.15u w=0.3u l=0.13u
X2708 VDD VSS.t525 VDD VDD sg13_lv_pmos ad=0.34p pd=2.68u as=0 ps=0 w=1u l=1u
X2709 VDD VSS.t2656 VDD VDD sg13_lv_pmos ad=0.34p pd=2.68u as=0 ps=0 w=1u l=1u
X2710 a_10703_15311# a_9861_15213# a_10609_15311# VSS.t99 sg13_lv_nmos ad=0.12665p pd=1.145u as=0.1428p ps=1.52u w=0.42u l=0.13u
X2711 VDD VSS.t187 VDD VDD sg13_lv_pmos ad=0.34p pd=2.68u as=0 ps=0 w=1u l=1u
X2712 VSS.t1453 VDD VSS.t1452 VSS.t1451 sg13_lv_nmos ad=0.1428p pd=1.52u as=0 ps=0 w=0.42u l=1u
X2713 VSS.t361 VDD VSS.t361 VSS.t364 sg13_lv_nmos ad=79.8f pd=0.8u as=0 ps=0 w=0.42u l=1u
X2714 VSS.t1623 VDD VSS.t1625 VSS.t1624 sg13_lv_nmos ad=79.8f pd=0.8u as=0 ps=0 w=0.42u l=1u
X2715 VSS.t3144 VDD VSS.t3146 VSS.t3145 sg13_lv_nmos ad=79.8f pd=0.8u as=0 ps=0 w=0.42u l=1u
X2716 sg13cmos5l_buf_8_2.X a_19323_13726# VDD VDD sg13_lv_pmos ad=0.2128p pd=1.5u as=0.2128p ps=1.5u w=1.12u l=0.13u
X2717 VDD VSS.t1167 VDD VDD sg13_lv_pmos ad=0.34p pd=2.68u as=0 ps=0 w=1u l=1u
X2718 VDD VSS.t1462 VDD VDD sg13_lv_pmos ad=0.34p pd=2.68u as=0 ps=0 w=1u l=1u
X2719 VDD VSS.t2371 VDD VDD sg13_lv_pmos ad=0.34p pd=2.68u as=0 ps=0 w=1u l=1u
X2720 VSS.t434 VDD VSS.t433 VSS.t4 sg13_lv_nmos ad=0.1428p pd=1.52u as=0 ps=0 w=0.42u l=1u
X2721 VDD VSS.t838 VDD VDD sg13_lv_pmos ad=0.34p pd=2.68u as=0 ps=0 w=1u l=1u
X2722 VDD VSS.t1026 VDD VDD sg13_lv_pmos ad=0.19p pd=1.38u as=0 ps=0 w=1u l=1u
X2723 VSS.t2262 VDD VSS.t2261 VSS.t2260 sg13_lv_nmos ad=0.1428p pd=1.52u as=0 ps=0 w=0.42u l=1u
X2724 VDD VSS.t1969 VDD VDD sg13_lv_pmos ad=0.34p pd=2.68u as=0 ps=0 w=1u l=1u
X2725 VSS.t278 VDD VSS.t278 VSS.t279 sg13_lv_nmos ad=79.8f pd=0.8u as=0 ps=0 w=0.42u l=1u
X2726 a_15579_14854# clock_i VDD VDD sg13_lv_pmos ad=0.2128p pd=1.5u as=0.2128p ps=1.5u w=1.12u l=0.13u
X2727 VSS.t2432 VDD VSS.t2434 VSS.t2433 sg13_lv_nmos ad=79.8f pd=0.8u as=0 ps=0 w=0.42u l=1u
X2728 VDD VSS.t2496 VDD VDD sg13_lv_pmos ad=0.34p pd=2.68u as=0 ps=0 w=1u l=1u
X2729 VSS.t1980 VDD VSS.t1979 VSS.t1978 sg13_lv_nmos ad=0.1428p pd=1.52u as=0 ps=0 w=0.42u l=1u
X2730 VSS.t333 VDD VSS.t89 VSS.t334 sg13_lv_nmos ad=79.8f pd=0.8u as=0 ps=0 w=0.42u l=1u
X2731 VSS.t4 a_18021_14495# a_18123_14495# VSS.t46 sg13_lv_nmos ad=4.11262p pd=27.15u as=0.2516p ps=2.16u w=0.74u l=0.13u
X2732 VDD VSS.t629 VDD VDD sg13_lv_pmos ad=0.19p pd=1.38u as=0 ps=0 w=1u l=1u
X2733 VSS.t1930 VDD VSS.t1932 VSS.t1931 sg13_lv_nmos ad=79.8f pd=0.8u as=0 ps=0 w=0.42u l=1u
X2734 VDD VSS.t1652 VDD VDD sg13_lv_pmos ad=0.34p pd=2.68u as=0 ps=0 w=1u l=1u
X2735 VSS.t3014 VDD VSS.t3016 VSS.t3015 sg13_lv_nmos ad=79.8f pd=0.8u as=0 ps=0 w=0.42u l=1u
X2736 VDD sg13cmos5l_dfrbpq_1_6.RESET_B a_21034_14452# VDD sg13_lv_pmos ad=0.1563p pd=1.22u as=0.147p ps=1.54u w=0.42u l=0.13u
X2737 VDD sg13cmos5l_dlygate4sd3_1_8.X sg13cmos5l_nand4_1_0.Y VDD sg13_lv_pmos ad=0.3808p pd=2.92u as=0.2128p ps=1.5u w=1.12u l=0.13u
X2738 a_6680_15242# sg13cmos5l_dlygate4sd3_1_1.A a_6578_15242# VSS.t3287 sg13_lv_nmos ad=0.1406p pd=1.12u as=0.1406p ps=1.12u w=0.74u l=0.13u
X2739 VDD VSS.t596 VDD VDD sg13_lv_pmos ad=0.19p pd=1.38u as=0 ps=0 w=1u l=1u
X2740 VSS.t944 VDD VSS.t943 VSS.t942 sg13_lv_nmos ad=0.1428p pd=1.52u as=0 ps=0 w=0.42u l=1u
X2741 VSS.t1288 VDD VSS.t1289 VSS.t1154 sg13_lv_nmos ad=79.8f pd=0.8u as=0 ps=0 w=0.42u l=1u
X2742 VSS.t1713 VDD VSS.t1715 VSS.t1714 sg13_lv_nmos ad=79.8f pd=0.8u as=0 ps=0 w=0.42u l=1u
X2743 VDD VSS.t2616 VDD VDD sg13_lv_pmos ad=0.19p pd=1.38u as=0 ps=0 w=1u l=1u
X2744 VSS.t2227 VDD VSS.t2226 VSS.t2225 sg13_lv_nmos ad=0.1428p pd=1.52u as=0 ps=0 w=0.42u l=1u
X2745 sg13cmos5l_dfrbpq_1_2.RESET_B a_15870_15486# VDD VDD sg13_lv_pmos ad=0.3927p pd=2.99u as=2.8961p ps=18.25u w=1.155u l=0.13u
X2746 VSS.t34 a_7631_14845# a_8298_14484# VSS.t156 sg13_lv_nmos ad=0.1406p pd=1.12u as=0.2516p ps=2.16u w=0.74u l=0.13u
X2747 VSS.t2712 VDD VSS.t2712 VSS.t206 sg13_lv_nmos ad=0.1428p pd=1.52u as=0 ps=0 w=0.42u l=1u
X2748 VDD VSS.t427 VDD VDD sg13_lv_pmos ad=0.34p pd=2.68u as=0 ps=0 w=1u l=1u
X2749 a_26638_15423# a_26753_15424# VSS.t4 VSS.t14 sg13_lv_nmos ad=0.1428p pd=1.52u as=0.1426p ps=1.16u w=0.42u l=0.5u
X2750 a_16068_14040# a_16587_13844# a_17327_13799# VSS.t49 sg13_lv_nmos ad=0.3473p pd=2.71u as=0.12665p ps=1.145u w=0.74u l=0.13u
X2751 VDD VSS.t3078 VDD VDD sg13_lv_pmos ad=0.34p pd=2.68u as=0 ps=0 w=1u l=1u
X2752 VSS.t2080 VDD VSS.t2082 VSS.t2081 sg13_lv_nmos ad=79.8f pd=0.8u as=0 ps=0 w=0.42u l=1u
X2753 VDD VSS.t309 VDD VDD sg13_lv_pmos ad=0.34p pd=2.68u as=0 ps=0 w=1u l=1u
X2754 VSS.t1004 VDD VSS.t1006 VSS.t1005 sg13_lv_nmos ad=79.8f pd=0.8u as=0 ps=0 w=0.42u l=1u
X2755 VDD VSS.t1260 VDD VDD sg13_lv_pmos ad=0.34p pd=2.68u as=0 ps=0 w=1u l=1u
X2756 VSS.t1643 VDD VSS.t1645 VSS.t1644 sg13_lv_nmos ad=79.8f pd=0.8u as=0 ps=0 w=0.42u l=1u
X2757 VDD VSS.t801 VDD VDD sg13_lv_pmos ad=0.19p pd=1.38u as=0 ps=0 w=1u l=1u
X2758 VDD VSS.t993 VDD VDD sg13_lv_pmos ad=0.34p pd=2.68u as=0 ps=0 w=1u l=1u
X2759 VDD VSS.t1447 VDD VDD sg13_lv_pmos ad=0.34p pd=2.68u as=0 ps=0 w=1u l=1u
X2760 VSS.t1297 VDD VSS.t1297 VSS.t1154 sg13_lv_nmos ad=79.8f pd=0.8u as=0 ps=0 w=0.42u l=1u
X2761 VDD VSS.t1710 VDD VDD sg13_lv_pmos ad=0.19p pd=1.38u as=0 ps=0 w=1u l=1u
X2762 VDD VSS.t608 VDD VDD sg13_lv_pmos ad=0.34p pd=2.68u as=0 ps=0 w=1u l=1u
X2763 VSS.t864 VDD VSS.t863 VSS.t862 sg13_lv_nmos ad=0.1428p pd=1.52u as=0 ps=0 w=0.42u l=1u
X2764 VSS.t1583 VDD VSS.t1582 VSS.t1581 sg13_lv_nmos ad=0.1428p pd=1.52u as=0 ps=0 w=0.42u l=1u
X2765 VDD VSS.t2481 VDD VDD sg13_lv_pmos ad=0.34p pd=2.68u as=0 ps=0 w=1u l=1u
X2766 VDD VSS.t2304 VDD VDD sg13_lv_pmos ad=0.19p pd=1.38u as=0 ps=0 w=1u l=1u
X2767 VSS.t1203 VDD VSS.t1204 VSS.t1154 sg13_lv_nmos ad=79.8f pd=0.8u as=0 ps=0 w=0.42u l=1u
X2768 VDD VSS.t294 VDD VDD sg13_lv_pmos ad=0.34p pd=2.68u as=0 ps=0 w=1u l=1u
X2769 VDD a_6286_13911# sg13cmos5l_dlygate4sd3_1_0.X VDD sg13_lv_pmos ad=0.2254p pd=1.53u as=0.4256p ps=3u w=1.12u l=0.13u
X2770 a_26505_14113# a_26148_14040# VDD VDD sg13_lv_pmos ad=63f pd=0.72u as=0.1563p ps=1.22u w=0.42u l=0.13u
X2771 VSS.t1301 VDD VSS.t1303 VSS.t1154 sg13_lv_nmos ad=79.8f pd=0.8u as=0 ps=0 w=0.42u l=1u
X2772 VDD VSS.t2057 VDD VDD sg13_lv_pmos ad=0.19p pd=1.38u as=0 ps=0 w=1u l=1u
X2773 VDD VSS.t523 VDD VDD sg13_lv_pmos ad=0.19p pd=1.38u as=0 ps=0 w=1u l=1u
X2774 VSS.t113 sg13cmos5l_o21ai_1_2.Y a_24824_15238# VSS.t57 sg13_lv_nmos ad=79.8f pd=0.8u as=0.1428p ps=1.52u w=0.42u l=0.13u
X2775 VDD VSS.t1832 VDD VDD sg13_lv_pmos ad=0.19p pd=1.38u as=0 ps=0 w=1u l=1u
X2776 VSS.t1875 VDD VSS.t1877 VSS.t1876 sg13_lv_nmos ad=79.8f pd=0.8u as=0 ps=0 w=0.42u l=1u
X2777 VSS.t16 sg13cmos5l_inv_1_0.Y a_16596_15280# VSS.t3225 sg13_lv_nmos ad=0.2272p pd=1.99u as=78.39999f ps=0.885u w=0.64u l=0.13u
X2778 VSS.t2417 VDD VSS.t2419 VSS.t2418 sg13_lv_nmos ad=79.8f pd=0.8u as=0 ps=0 w=0.42u l=1u
X2779 VDD VSS.t66 VDD VDD sg13_lv_pmos ad=0.34p pd=2.68u as=0 ps=0 w=1u l=1u
X2780 VDD VSS.t2359 VDD VDD sg13_lv_pmos ad=0.19p pd=1.38u as=0 ps=0 w=1u l=1u
X2781 a_15782_13722# sg13cmos5l_dfrbpq_1_2.D VDD VDD sg13_lv_pmos ad=79.8f pd=0.8u as=0.1428p ps=1.52u w=0.42u l=0.13u
X2782 VSS.t2695 VDD VSS.t2696 VSS.t206 sg13_lv_nmos ad=79.8f pd=0.8u as=0 ps=0 w=0.42u l=1u
X2783 a_4474_14448# sg13cmos5l_dlygate4sd3_1_3.A VDD VDD sg13_lv_pmos ad=0.1428p pd=1.52u as=0.1523p ps=1.38u w=0.42u l=0.13u
X2784 VDD VSS.t956 VDD VDD sg13_lv_pmos ad=0.19p pd=1.38u as=0 ps=0 w=1u l=1u
X2785 VSS.t1438 VDD VSS.t1437 VSS.t1436 sg13_lv_nmos ad=0.1428p pd=1.52u as=0 ps=0 w=0.42u l=1u
X2786 VSS.t1965 VDD VSS.t1967 VSS.t1966 sg13_lv_nmos ad=79.8f pd=0.8u as=0 ps=0 w=0.42u l=1u
X2787 VSS.t824 VDD VSS.t826 VSS.t825 sg13_lv_nmos ad=79.8f pd=0.8u as=0 ps=0 w=0.42u l=1u
X2788 VDD VSS.t1199 VDD VDD sg13_lv_pmos ad=0.34p pd=2.68u as=0 ps=0 w=1u l=1u
X2789 VDD VSS.t2696 VDD VDD sg13_lv_pmos ad=0.34p pd=2.68u as=0 ps=0 w=1u l=1u
X2790 a_27500_15960# sg13cmos5l_dfrbpq_1_6.Q VDD VDD sg13_lv_pmos ad=0.2856p pd=2.36u as=0.2114p ps=1.54u w=0.84u l=0.13u
X2791 VSS.t2247 VDD VSS.t2246 VSS.t2245 sg13_lv_nmos ad=0.1428p pd=1.52u as=0 ps=0 w=0.42u l=1u
X2792 VDD VSS.t435 VDD VDD sg13_lv_pmos ad=0.19p pd=1.38u as=0 ps=0 w=1u l=1u
X2793 VDD VSS.t883 VDD VDD sg13_lv_pmos ad=0.34p pd=2.68u as=0 ps=0 w=1u l=1u
X2794 VSS.t2634 VDD VSS.t2636 VSS.t206 sg13_lv_nmos ad=79.8f pd=0.8u as=0 ps=0 w=0.42u l=1u
X2795 VSS.t2095 VDD VSS.t2094 VSS.t2093 sg13_lv_nmos ad=0.1428p pd=1.52u as=0 ps=0 w=0.42u l=1u
X2796 VSS.t1915 VDD VSS.t1917 VSS.t1916 sg13_lv_nmos ad=79.8f pd=0.8u as=0 ps=0 w=0.42u l=1u
X2797 VDD VSS.t509 VDD VDD sg13_lv_pmos ad=0.34p pd=2.68u as=0 ps=0 w=1u l=1u
X2798 VDD VSS.t623 VDD VDD sg13_lv_pmos ad=0.19p pd=1.38u as=0 ps=0 w=1u l=1u
X2799 VSS.t2999 VDD VSS.t3001 VSS.t3000 sg13_lv_nmos ad=79.8f pd=0.8u as=0 ps=0 w=0.42u l=1u
X2800 VDD sg13cmos5l_dfrbpq_1_6.RESET_B a_20774_14922# VDD sg13_lv_pmos ad=0.36237p pd=2.605u as=79.8f ps=0.8u w=0.42u l=0.13u
X2801 VSS.t617 VDD VSS.t617 VSS.t748 sg13_lv_nmos ad=0.1428p pd=1.52u as=0 ps=0 w=0.42u l=1u
X2802 VDD VSS.t2941 VDD VDD sg13_lv_pmos ad=0.19p pd=1.38u as=0 ps=0 w=1u l=1u
X2803 a_2516_14484# sg13cmos5l_buf_1_0.X VDD VDD sg13_lv_pmos ad=0.3808p pd=2.92u as=0.2128p ps=1.5u w=1.12u l=0.13u
X2804 VSS.t2437 VDD VSS.t2436 VSS.t2435 sg13_lv_nmos ad=0.1428p pd=1.52u as=0 ps=0 w=0.42u l=1u
X2805 VSS.t1698 VDD VSS.t1700 VSS.t1699 sg13_lv_nmos ad=79.8f pd=0.8u as=0 ps=0 w=0.42u l=1u
X2806 VSS.t561 VDD VSS.t563 VSS.t562 sg13_lv_nmos ad=79.8f pd=0.8u as=0 ps=0 w=0.42u l=1u
X2807 VDD VSS.t2351 VDD VDD sg13_lv_pmos ad=0.34p pd=2.68u as=0 ps=0 w=1u l=1u
X2808 a_26313_14531# a_25956_14488# VDD VDD sg13_lv_pmos ad=63f pd=0.72u as=0.1563p ps=1.22u w=0.42u l=0.13u
X2809 VSS.t1236 VDD VSS.t1237 VSS.t1154 sg13_lv_nmos ad=79.8f pd=0.8u as=0 ps=0 w=0.42u l=1u
X2810 VDD VSS.t2009 VDD VDD sg13_lv_pmos ad=0.34p pd=2.68u as=0 ps=0 w=1u l=1u
X2811 VDD VSS.t3131 VDD VDD sg13_lv_pmos ad=0.19p pd=1.38u as=0 ps=0 w=1u l=1u
X2812 VDD VSS.t2658 VDD VDD sg13_lv_pmos ad=0.34p pd=2.68u as=0 ps=0 w=1u l=1u
X2813 VSS.t4 a_9737_14822# a_9658_14725# VSS.t205 sg13_lv_nmos ad=4.11262p pd=27.15u as=0.27427p ps=2.28u w=0.795u l=0.13u
X2814 VDD VSS.t1287 VDD VDD sg13_lv_pmos ad=0.34p pd=2.68u as=0 ps=0 w=1u l=1u
X2815 VSS.t1168 VDD VSS.t1167 VSS.t1154 sg13_lv_nmos ad=0.1428p pd=1.52u as=0 ps=0 w=0.42u l=1u
X2816 VSS.t1568 VDD VSS.t1570 VSS.t1569 sg13_lv_nmos ad=79.8f pd=0.8u as=0 ps=0 w=0.42u l=1u
X2817 VSS.t1628 VDD VSS.t1630 VSS.t1629 sg13_lv_nmos ad=79.8f pd=0.8u as=0 ps=0 w=0.42u l=1u
X2818 VSS.t3149 VDD VSS.t3151 VSS.t3150 sg13_lv_nmos ad=79.8f pd=0.8u as=0 ps=0 w=0.42u l=1u
X2819 VSS.t2065 VDD VSS.t2067 VSS.t2066 sg13_lv_nmos ad=79.8f pd=0.8u as=0 ps=0 w=0.42u l=1u
X2820 VSS.t794 VDD VSS.t793 VSS.t792 sg13_lv_nmos ad=0.1428p pd=1.52u as=0 ps=0 w=0.42u l=1u
X2821 VSS.t2759 VDD VSS.t2758 VSS.t206 sg13_lv_nmos ad=0.1428p pd=1.52u as=0 ps=0 w=0.42u l=1u
X2822 VDD VSS.t415 VDD VDD sg13_lv_pmos ad=0.34p pd=2.68u as=0 ps=0 w=1u l=1u
X2823 VSS.t864 VDD VSS.t863 VSS.t862 sg13_lv_nmos ad=0.1428p pd=1.52u as=0 ps=0 w=0.42u l=1u
X2824 VSS.t1161 VDD VSS.t1162 VSS.t1154 sg13_lv_nmos ad=79.8f pd=0.8u as=0 ps=0 w=0.42u l=1u
X2825 a_21549_14020# sg13cmos5l_or3_1_2.B a_21460_14020# VDD sg13_lv_pmos ad=0.19p pd=1.38u as=0.1575p ps=1.315u w=1u l=0.13u
X2826 VDD VSS.t1695 VDD VDD sg13_lv_pmos ad=0.19p pd=1.38u as=0 ps=0 w=1u l=1u
X2827 VSS.t2232 VDD VSS.t2231 VSS.t2230 sg13_lv_nmos ad=0.1428p pd=1.52u as=0 ps=0 w=0.42u l=1u
X2828 VSS.t681 VDD VSS.t683 VSS.t682 sg13_lv_nmos ad=79.8f pd=0.8u as=0 ps=0 w=0.42u l=1u
X2829 VDD VSS.t150 VDD VDD sg13_lv_pmos ad=0.34p pd=2.68u as=0 ps=0 w=1u l=1u
X2830 VDD VSS.t602 VDD VDD sg13_lv_pmos ad=0.34p pd=2.68u as=0 ps=0 w=1u l=1u
X2831 VDD VSS.t986 VDD VDD sg13_lv_pmos ad=0.19p pd=1.38u as=0 ps=0 w=1u l=1u
X2832 VDD VSS.t1647 VDD VDD sg13_lv_pmos ad=0.34p pd=2.68u as=0 ps=0 w=1u l=1u
X2833 VSS.t2625 VDD VSS.t2627 VSS.t206 sg13_lv_nmos ad=79.8f pd=0.8u as=0 ps=0 w=0.42u l=1u
X2834 VSS.t2702 VDD VSS.t2702 VSS.t206 sg13_lv_nmos ad=0.1428p pd=1.52u as=0 ps=0 w=0.42u l=1u
X2835 VDD VSS.t2466 VDD VDD sg13_lv_pmos ad=0.34p pd=2.68u as=0 ps=0 w=1u l=1u
X2836 VSS.t1935 VDD VSS.t1937 VSS.t1936 sg13_lv_nmos ad=79.8f pd=0.8u as=0 ps=0 w=0.42u l=1u
X2837 VDD VSS.t273 VDD VDD sg13_lv_pmos ad=0.19p pd=1.38u as=0 ps=0 w=1u l=1u
X2838 VDD a_21251_13690# sg13cmos5l_or3_1_2.X VDD sg13_lv_pmos ad=0.3822p pd=1.84u as=0.3808p ps=2.92u w=1.12u l=0.13u
X2839 VDD VSS.t523 VDD VDD sg13_lv_pmos ad=0.19p pd=1.38u as=0 ps=0 w=1u l=1u
X2840 VSS.t655 VDD VSS.t216 VSS.t654 sg13_lv_nmos ad=0.1428p pd=1.52u as=0 ps=0 w=0.42u l=1u
X2841 VSS.t1218 VDD VSS.t1217 VSS.t1154 sg13_lv_nmos ad=0.1428p pd=1.52u as=0 ps=0 w=0.42u l=1u
X2842 sg13cmos5l_xnor2_1_2.B sg13cmos5l_buf_1_0.X a_6202_15238# VSS.t3196 sg13_lv_nmos ad=0.2516p pd=2.16u as=0.1406p ps=1.12u w=0.74u l=0.13u
X2843 sg13cmos5l_xnor2_1_0.Y a_7680_15549# a_7829_15238# VSS.t3190 sg13_lv_nmos ad=0.2516p pd=2.16u as=0.1406p ps=1.12u w=0.74u l=0.13u
X2844 VDD VSS.t1311 VDD VDD sg13_lv_pmos ad=0.34p pd=2.68u as=0 ps=0 w=1u l=1u
X2845 VSS.t2944 VDD VSS.t2946 VSS.t2945 sg13_lv_nmos ad=79.8f pd=0.8u as=0 ps=0 w=0.42u l=1u
X2846 VDD VSS.t66 VDD VDD sg13_lv_pmos ad=0.34p pd=2.68u as=0 ps=0 w=1u l=1u
X2847 VDD VSS.t424 VDD VDD sg13_lv_pmos ad=0.34p pd=2.68u as=0 ps=0 w=1u l=1u
X2848 sg13cmos5l_a21oi_1_3.B1 sg13cmos5l_buf_1_10.X VDD VDD sg13_lv_pmos ad=0.3808p pd=2.92u as=0.3808p ps=2.92u w=1.12u l=0.13u
X2849 VDD VSS.t2690 VDD VDD sg13_lv_pmos ad=0.19p pd=1.38u as=0 ps=0 w=1u l=1u
X2850 VSS.t599 VDD VSS.t599 VSS.t600 sg13_lv_nmos ad=79.8f pd=0.8u as=0 ps=0 w=0.42u l=1u
X2851 VDD VSS.t1001 VDD VDD sg13_lv_pmos ad=0.19p pd=1.38u as=0 ps=0 w=1u l=1u
X2852 VDD VSS.t3083 VDD VDD sg13_lv_pmos ad=0.34p pd=2.68u as=0 ps=0 w=1u l=1u
X2853 VSS.t2357 VDD VSS.t2356 VSS.t2355 sg13_lv_nmos ad=0.1428p pd=1.52u as=0 ps=0 w=0.42u l=1u
X2854 VSS.t2050 VDD VSS.t2052 VSS.t2051 sg13_lv_nmos ad=79.8f pd=0.8u as=0 ps=0 w=0.42u l=1u
X2855 VDD VSS.t571 VDD VDD sg13_lv_pmos ad=0.34p pd=2.68u as=0 ps=0 w=1u l=1u
X2856 VSS.t824 VDD VSS.t826 VSS.t825 sg13_lv_nmos ad=79.8f pd=0.8u as=0 ps=0 w=0.42u l=1u
X2857 VDD VSS.t1452 VDD VDD sg13_lv_pmos ad=0.34p pd=2.68u as=0 ps=0 w=1u l=1u
X2858 VDD VSS.t2361 VDD VDD sg13_lv_pmos ad=0.34p pd=2.68u as=0 ps=0 w=1u l=1u
X2859 VSS.t546 VDD VSS.t545 VSS.t544 sg13_lv_nmos ad=0.1428p pd=1.52u as=0 ps=0 w=0.42u l=1u
X2860 VDD VSS.t1625 VDD VDD sg13_lv_pmos ad=0.19p pd=1.38u as=0 ps=0 w=1u l=1u
X2861 VDD VSS.t1680 VDD VDD sg13_lv_pmos ad=0.19p pd=1.38u as=0 ps=0 w=1u l=1u
X2862 VDD VSS.t1872 VDD VDD sg13_lv_pmos ad=0.19p pd=1.38u as=0 ps=0 w=1u l=1u
X2863 a_27034_15202# sg13cmos5l_dfrbpq_1_7.Q VSS.t4 VSS.t4 sg13_lv_nmos ad=0.1428p pd=1.52u as=79.8f ps=0.8u w=0.42u l=0.13u
X2864 VSS.t1970 VDD VSS.t1969 VSS.t1968 sg13_lv_nmos ad=0.1428p pd=1.52u as=0 ps=0 w=0.42u l=1u
X2865 VDD VSS.t1320 VDD VDD sg13_lv_pmos ad=0.34p pd=2.68u as=0 ps=0 w=1u l=1u
X2866 VSS.t521 VDD VSS.t523 VSS.t522 sg13_lv_nmos ad=79.8f pd=0.8u as=0 ps=0 w=0.42u l=1u
X2867 VDD VSS.t509 VDD VDD sg13_lv_pmos ad=0.34p pd=2.68u as=0 ps=0 w=1u l=1u
X2868 VSS.t2080 VDD VSS.t2079 VSS.t2078 sg13_lv_nmos ad=0.1428p pd=1.52u as=0 ps=0 w=0.42u l=1u
X2869 VSS.t699 VDD VSS.t576 VSS.t700 sg13_lv_nmos ad=79.8f pd=0.8u as=0 ps=0 w=0.42u l=1u
X2870 VSS.t964 VDD VSS.t963 VSS.t962 sg13_lv_nmos ad=0.1428p pd=1.52u as=0 ps=0 w=0.42u l=1u
X2871 VSS.t1880 VDD VSS.t1882 VSS.t1881 sg13_lv_nmos ad=79.8f pd=0.8u as=0 ps=0 w=0.42u l=1u
X2872 VSS.t1263 VDD VSS.t1264 VSS.t1154 sg13_lv_nmos ad=79.8f pd=0.8u as=0 ps=0 w=0.42u l=1u
X2873 VSS.t2731 VDD VSS.t2733 VSS.t206 sg13_lv_nmos ad=79.8f pd=0.8u as=0 ps=0 w=0.42u l=1u
X2874 VSS.t2422 VDD VSS.t2424 VSS.t2423 sg13_lv_nmos ad=79.8f pd=0.8u as=0 ps=0 w=0.42u l=1u
X2875 VDD VSS.t3116 VDD VDD sg13_lv_pmos ad=0.19p pd=1.38u as=0 ps=0 w=1u l=1u
X2876 a_20705_15260# sg13cmos5l_dlygate4sd3_1_9.X sg13cmos5l_a21oi_1_1.Y VSS.t107 sg13_lv_nmos ad=0.1406p pd=1.12u as=0.1406p ps=1.12u w=0.74u l=0.13u
X2877 VSS.t794 VDD VSS.t793 VSS.t792 sg13_lv_nmos ad=0.1428p pd=1.52u as=0 ps=0 w=0.42u l=1u
X2878 VSS.t2292 VDD VSS.t2291 VSS.t2290 sg13_lv_nmos ad=0.1428p pd=1.52u as=0 ps=0 w=0.42u l=1u
X2879 VSS.t1553 VDD VSS.t1555 VSS.t1554 sg13_lv_nmos ad=79.8f pd=0.8u as=0 ps=0 w=0.42u l=1u
X2880 VSS.t1024 VDD VSS.t1026 VSS.t1025 sg13_lv_nmos ad=79.8f pd=0.8u as=0 ps=0 w=0.42u l=1u
X2881 VDD VSS.t593 VDD VDD sg13_lv_pmos ad=0.34p pd=2.68u as=0 ps=0 w=1u l=1u
X2882 VDD VSS.t2986 VDD VDD sg13_lv_pmos ad=0.19p pd=1.38u as=0 ps=0 w=1u l=1u
X2883 VDD VSS.t1857 VDD VDD sg13_lv_pmos ad=0.19p pd=1.38u as=0 ps=0 w=1u l=1u
X2884 VDD VSS.t332 VDD VDD sg13_lv_pmos ad=0.34p pd=2.68u as=0 ps=0 w=1u l=1u
X2885 VDD sg13cmos5l_dfrbpq_1_3.RESET_B a_17578_14452# VDD sg13_lv_pmos ad=0.1563p pd=1.22u as=0.147p ps=1.54u w=0.42u l=0.13u
X2886 a_26122_13945# a_26565_13701# a_25862_13722# VSS.t64 sg13_lv_nmos ad=79.8f pd=0.8u as=0.1296p ps=1.52u w=0.42u l=0.13u
X2887 VSS.t1708 VDD VSS.t1710 VSS.t1709 sg13_lv_nmos ad=79.8f pd=0.8u as=0 ps=0 w=0.42u l=1u
X2888 VDD VSS.t1632 VDD VDD sg13_lv_pmos ad=0.34p pd=2.68u as=0 ps=0 w=1u l=1u
X2889 VSS.t2617 VDD VSS.t2618 VSS.t206 sg13_lv_nmos ad=79.8f pd=0.8u as=0 ps=0 w=0.42u l=1u
X2890 VSS.t2100 VDD VSS.t2099 VSS.t2098 sg13_lv_nmos ad=0.1428p pd=1.52u as=0 ps=0 w=0.42u l=1u
X2891 VSS.t1920 VDD VSS.t1922 VSS.t1921 sg13_lv_nmos ad=79.8f pd=0.8u as=0 ps=0 w=0.42u l=1u
X2892 VSS.t437 VDD VSS.t436 VSS.t4 sg13_lv_nmos ad=0.1428p pd=1.52u as=0 ps=0 w=0.42u l=1u
X2893 VSS.t3004 VDD VSS.t3006 VSS.t3005 sg13_lv_nmos ad=79.8f pd=0.8u as=0 ps=0 w=0.42u l=1u
X2894 VDD VSS.t2770 VDD VDD sg13_lv_pmos ad=0.19p pd=1.38u as=0 ps=0 w=1u l=1u
X2895 VSS.t34 sg13cmos5l_xnor2_1_0.Y a_8312_15238# VSS.t3226 sg13_lv_nmos ad=79.8f pd=0.8u as=0.1428p ps=1.52u w=0.42u l=0.13u
X2896 VDD sg13cmos5l_buf_8_2.A a_19323_13726# VDD sg13_lv_pmos ad=0.2128p pd=1.5u as=0.2128p ps=1.5u w=1.12u l=0.13u
X2897 sg13cmos5l_a21oi_1_3.A2 a_24169_14508# VDD VDD sg13_lv_pmos ad=0.3808p pd=2.92u as=0.3822p ps=1.84u w=1.12u l=0.13u
X2898 VSS.t1245 VDD VSS.t1244 VSS.t1154 sg13_lv_nmos ad=0.1428p pd=1.52u as=0 ps=0 w=0.42u l=1u
X2899 VSS.t1703 VDD VSS.t1705 VSS.t1704 sg13_lv_nmos ad=79.8f pd=0.8u as=0 ps=0 w=0.42u l=1u
X2900 VDD VSS.t2224 VDD VDD sg13_lv_pmos ad=0.19p pd=1.38u as=0 ps=0 w=1u l=1u
X2901 VDD VSS.t2321 VDD VDD sg13_lv_pmos ad=0.34p pd=2.68u as=0 ps=0 w=1u l=1u
X2902 VDD VSS.t2014 VDD VDD sg13_lv_pmos ad=0.34p pd=2.68u as=0 ps=0 w=1u l=1u
X2903 VDD VSS.t3136 VDD VDD sg13_lv_pmos ad=0.19p pd=1.38u as=0 ps=0 w=1u l=1u
X2904 VSS.t1830 VDD VSS.t1832 VSS.t1831 sg13_lv_nmos ad=79.8f pd=0.8u as=0 ps=0 w=0.42u l=1u
X2905 VSS.t179 a_22030_15423# sg13cmos5l_or3_1_2.A VSS.t3204 sg13_lv_nmos ad=0.1426p pd=1.16u as=0.2516p ps=2.16u w=0.74u l=0.13u
X2906 VSS.t1288 VDD VSS.t1287 VSS.t1154 sg13_lv_nmos ad=0.1428p pd=1.52u as=0 ps=0 w=0.42u l=1u
X2907 VDD VSS.t565 VDD VDD sg13_lv_pmos ad=0.34p pd=2.68u as=0 ps=0 w=1u l=1u
X2908 VSS.t66 a_16485_13701# a_16587_13844# VSS.t3181 sg13_lv_nmos ad=15.38618p pd=0.10091m as=0.2516p ps=2.16u w=0.74u l=0.13u
X2909 VSS.t38 VDD VSS.t516 VSS.t651 sg13_lv_nmos ad=0.1428p pd=1.52u as=0 ps=0 w=0.42u l=1u
X2910 VDD VSS.t1962 VDD VDD sg13_lv_pmos ad=0.19p pd=1.38u as=0 ps=0 w=1u l=1u
X2911 VSS.t994 VDD VSS.t993 VSS.t992 sg13_lv_nmos ad=0.1428p pd=1.52u as=0 ps=0 w=0.42u l=1u
X2912 VSS.t302 VDD VSS.t302 VSS.t301 sg13_lv_nmos ad=0.1428p pd=1.52u as=0 ps=0 w=0.42u l=1u
X2913 VSS.t30 a_12010_15202# sg13cmos5l_dfrbpq_1_2.CLK VSS.t29 sg13_lv_nmos ad=0.1406p pd=1.12u as=0.1406p ps=1.12u w=0.74u l=0.13u
X2914 VSS.t1895 VDD VSS.t1894 VSS.t1893 sg13_lv_nmos ad=0.1428p pd=1.52u as=0 ps=0 w=0.42u l=1u
X2915 VDD VSS.t858 VDD VDD sg13_lv_pmos ad=0.34p pd=2.68u as=0 ps=0 w=1u l=1u
X2916 VDD VSS.t1437 VDD VDD sg13_lv_pmos ad=0.34p pd=2.68u as=0 ps=0 w=1u l=1u
X2917 VSS.t2741 VDD VSS.t2740 VSS.t206 sg13_lv_nmos ad=0.1428p pd=1.52u as=0 ps=0 w=0.42u l=1u
X2918 VDD VSS.t836 VDD VDD sg13_lv_pmos ad=0.19p pd=1.38u as=0 ps=0 w=1u l=1u
X2919 a_11122_15234# sg13cmos5l_tiehi_1.L_HI VSS.t144 VSS.t200 sg13_lv_nmos ad=37.8f pd=0.6u as=79.8f ps=0.8u w=0.42u l=0.13u
X2920 VSS.t2237 VDD VSS.t2236 VSS.t2235 sg13_lv_nmos ad=0.1428p pd=1.52u as=0 ps=0 w=0.42u l=1u
X2921 sg13cmos5l_or3_1_2.C sg13cmos5l_dfrbpq_1_3.Q a_20218_15238# VSS.t107 sg13_lv_nmos ad=0.2516p pd=2.16u as=0.1406p ps=1.12u w=0.74u l=0.13u
X2922 VSS.t1693 VDD VSS.t1695 VSS.t1694 sg13_lv_nmos ad=79.8f pd=0.8u as=0 ps=0 w=0.42u l=1u
X2923 VSS.t1498 VDD VSS.t1500 VSS.t1499 sg13_lv_nmos ad=79.8f pd=0.8u as=0 ps=0 w=0.42u l=1u
X2924 VSS.t2407 VDD VSS.t2409 VSS.t2408 sg13_lv_nmos ad=79.8f pd=0.8u as=0 ps=0 w=0.42u l=1u
X2925 VSS.t2705 VDD VSS.t2704 VSS.t206 sg13_lv_nmos ad=0.1428p pd=1.52u as=0 ps=0 w=0.42u l=1u
X2926 a_16175_15238# sg13cmos5l_inv_1_0.Y VSS.t16 VSS.t3223 sg13_lv_nmos ad=0.2516p pd=2.16u as=0.1898p ps=1.36u w=0.74u l=0.13u
X2927 VSS.t964 VDD VSS.t963 VSS.t962 sg13_lv_nmos ad=0.1428p pd=1.52u as=0 ps=0 w=0.42u l=1u
X2928 VDD VSS.t2931 VDD VDD sg13_lv_pmos ad=0.19p pd=1.38u as=0 ps=0 w=1u l=1u
X2929 VSS.t404 VDD VSS.t403 VSS.t4 sg13_lv_nmos ad=0.1428p pd=1.52u as=0 ps=0 w=0.42u l=1u
X2930 VDD VSS.t921 VDD VDD sg13_lv_pmos ad=0.19p pd=1.38u as=0 ps=0 w=1u l=1u
X2931 VSS.t869 VDD VSS.t871 VSS.t870 sg13_lv_nmos ad=79.8f pd=0.8u as=0 ps=0 w=0.42u l=1u
X2932 VDD VSS.t2389 VDD VDD sg13_lv_pmos ad=0.19p pd=1.38u as=0 ps=0 w=1u l=1u
X2933 VSS.t2050 VDD VSS.t2049 VSS.t2048 sg13_lv_nmos ad=0.1428p pd=1.52u as=0 ps=0 w=0.42u l=1u
X2934 VDD VSS.t2047 VDD VDD sg13_lv_pmos ad=0.19p pd=1.38u as=0 ps=0 w=1u l=1u
X2935 VSS.t387 VDD VSS.t389 VSS.t388 sg13_lv_nmos ad=79.8f pd=0.8u as=0 ps=0 w=0.42u l=1u
X2936 VSS.t1865 VDD VSS.t1867 VSS.t1866 sg13_lv_nmos ad=79.8f pd=0.8u as=0 ps=0 w=0.42u l=1u
X2937 VSS.t83 a_21251_13690# sg13cmos5l_or3_1_2.X VSS.t3184 sg13_lv_nmos ad=0.13395p pd=1.12u as=0.2516p ps=2.16u w=0.74u l=0.13u
X2938 VDD VSS.t439 VDD VDD sg13_lv_pmos ad=0.34p pd=2.68u as=0 ps=0 w=1u l=1u
X2939 VDD VSS.t528 VDD VDD sg13_lv_pmos ad=0.19p pd=1.38u as=0 ps=0 w=1u l=1u
X2940 VDD a_4175_15311# a_4842_15532# VDD sg13_lv_pmos ad=0.2128p pd=1.5u as=0.3864p ps=2.93u w=1.12u l=0.13u
X2941 VDD a_10222_14751# sg13cmos5l_dlygate4sd3_1_8.X VDD sg13_lv_pmos ad=0.2254p pd=1.53u as=0.4256p ps=3u w=1.12u l=0.13u
X2942 VDD VSS.t1272 VDD VDD sg13_lv_pmos ad=0.34p pd=2.68u as=0 ps=0 w=1u l=1u
X2943 VDD VSS.t1495 VDD VDD sg13_lv_pmos ad=0.19p pd=1.38u as=0 ps=0 w=1u l=1u
X2944 VSS.t1024 VDD VSS.t1026 VSS.t1025 sg13_lv_nmos ad=79.8f pd=0.8u as=0 ps=0 w=0.42u l=1u
X2945 VSS.t25 a_12010_15202# sg13cmos5l_dfrbpq_1_2.CLK VSS.t24 sg13_lv_nmos ad=0.1406p pd=1.12u as=0.1406p ps=1.12u w=0.74u l=0.13u
X2946 VSS.t2652 VDD VSS.t2654 VSS.t206 sg13_lv_nmos ad=79.8f pd=0.8u as=0 ps=0 w=0.42u l=1u
X2947 VDD VSS.t620 VDD VDD sg13_lv_pmos ad=0.34p pd=2.68u as=0 ps=0 w=1u l=1u
X2948 VDD VSS.t1630 VDD VDD sg13_lv_pmos ad=0.19p pd=1.38u as=0 ps=0 w=1u l=1u
X2949 sg13cmos5l_dfrbpq_1_5.Q a_28074_14020# VDD VDD sg13_lv_pmos ad=0.3808p pd=2.92u as=0.2128p ps=1.5u w=1.12u l=0.13u
X2950 VDD VSS.t1685 VDD VDD sg13_lv_pmos ad=0.19p pd=1.38u as=0 ps=0 w=1u l=1u
X2951 VDD VSS.t2971 VDD VDD sg13_lv_pmos ad=0.19p pd=1.38u as=0 ps=0 w=1u l=1u
X2952 VDD VSS.t3148 VDD VDD sg13_lv_pmos ad=0.34p pd=2.68u as=0 ps=0 w=1u l=1u
X2953 VDD VSS.t1842 VDD VDD sg13_lv_pmos ad=0.19p pd=1.38u as=0 ps=0 w=1u l=1u
X2954 VSS.t2427 VDD VSS.t2429 VSS.t2428 sg13_lv_nmos ad=79.8f pd=0.8u as=0 ps=0 w=0.42u l=1u
X2955 VDD VSS.t2761 VDD VDD sg13_lv_pmos ad=0.19p pd=1.38u as=0 ps=0 w=1u l=1u
X2956 VSS.t2085 VDD VSS.t2084 VSS.t2083 sg13_lv_nmos ad=0.1428p pd=1.52u as=0 ps=0 w=0.42u l=1u
X2957 VDD VSS.t891 VDD VDD sg13_lv_pmos ad=0.19p pd=1.38u as=0 ps=0 w=1u l=1u
X2958 VSS.t1648 VDD VSS.t1647 VSS.t1646 sg13_lv_nmos ad=0.1428p pd=1.52u as=0 ps=0 w=0.42u l=1u
X2959 VDD VSS.t2374 VDD VDD sg13_lv_pmos ad=0.19p pd=1.38u as=0 ps=0 w=1u l=1u
X2960 VDD VSS.t377 VDD VDD sg13_lv_pmos ad=0.19p pd=1.38u as=0 ps=0 w=1u l=1u
X2961 VDD VSS.t509 VDD VDD sg13_lv_pmos ad=0.34p pd=2.68u as=0 ps=0 w=1u l=1u
X2962 VSS.t620 VDD VSS.t623 VSS.t751 sg13_lv_nmos ad=79.8f pd=0.8u as=0 ps=0 w=0.42u l=1u
X2963 VDD VSS.t1999 VDD VDD sg13_lv_pmos ad=0.34p pd=2.68u as=0 ps=0 w=1u l=1u
X2964 VSS.t994 VDD VSS.t993 VSS.t992 sg13_lv_nmos ad=0.1428p pd=1.52u as=0 ps=0 w=0.42u l=1u
X2965 VDD VSS.t828 VDD VDD sg13_lv_pmos ad=0.34p pd=2.68u as=0 ps=0 w=1u l=1u
X2966 VDD VSS.t3121 VDD VDD sg13_lv_pmos ad=0.19p pd=1.38u as=0 ps=0 w=1u l=1u
X2967 VSS.t2392 VDD VSS.t2394 VSS.t2393 sg13_lv_nmos ad=79.8f pd=0.8u as=0 ps=0 w=0.42u l=1u
X2968 VDD VSS.t565 VDD VDD sg13_lv_pmos ad=0.34p pd=2.68u as=0 ps=0 w=1u l=1u
X2969 VDD VSS.t136 VDD VDD sg13_lv_pmos ad=0.19p pd=1.38u as=0 ps=0 w=1u l=1u
X2970 VDD VSS.t766 VDD VDD sg13_lv_pmos ad=0.19p pd=1.38u as=0 ps=0 w=1u l=1u
X2971 VSS.t1558 VDD VSS.t1560 VSS.t1559 sg13_lv_nmos ad=79.8f pd=0.8u as=0 ps=0 w=0.42u l=1u
X2972 sg13cmos5l_buf_8_2.X a_19323_13726# VDD VDD sg13_lv_pmos ad=0.2128p pd=1.5u as=0.2128p ps=1.5u w=1.12u l=0.13u
X2973 VSS.t1880 VDD VSS.t1879 VSS.t1878 sg13_lv_nmos ad=0.1428p pd=1.52u as=0 ps=0 w=0.42u l=1u
X2974 VDD VSS.t372 VDD VDD sg13_lv_pmos ad=0.19p pd=1.38u as=0 ps=0 w=1u l=1u
X2975 VSS.t1197 VDD VSS.t1196 VSS.t1154 sg13_lv_nmos ad=0.1428p pd=1.52u as=0 ps=0 w=0.42u l=1u
X2976 VDD VSS.t1834 VDD VDD sg13_lv_pmos ad=0.34p pd=2.68u as=0 ps=0 w=1u l=1u
X2977 sg13cmos5l_dlygate4sd3_1_0.A a_6540_13238# VDD VDD sg13_lv_pmos ad=0.2408p pd=1.55u as=0.3808p ps=2.92u w=1.12u l=0.13u
X2978 VDD VSS.t69 VDD VDD sg13_lv_pmos ad=0.19p pd=1.38u as=0 ps=0 w=1u l=1u
X2979 a_8685_14832# sg13cmos5l_buf_1_10.X VDD VDD sg13_lv_pmos ad=0.1596p pd=1.22u as=0.2856p ps=2.36u w=0.84u l=0.13u
X2980 a_21060_14488# a_21579_14495# a_22319_14845# VSS.t8 sg13_lv_nmos ad=0.3473p pd=2.71u as=0.12665p ps=1.145u w=0.74u l=0.13u
X2981 VDD VSS.t1290 VDD VDD sg13_lv_pmos ad=0.34p pd=2.68u as=0 ps=0 w=1u l=1u
X2982 VSS.t2222 VDD VSS.t2221 VSS.t2220 sg13_lv_nmos ad=0.1428p pd=1.52u as=0 ps=0 w=0.42u l=1u
X2983 VSS.t617 VDD VSS.t614 VSS.t616 sg13_lv_nmos ad=0.1428p pd=1.52u as=0 ps=0 w=0.42u l=1u
X2984 VDD VSS.t1637 VDD VDD sg13_lv_pmos ad=0.34p pd=2.68u as=0 ps=0 w=1u l=1u
X2985 VSS.t1678 VDD VSS.t1680 VSS.t1679 sg13_lv_nmos ad=79.8f pd=0.8u as=0 ps=0 w=0.42u l=1u
X2986 VSS.t2620 VDD VSS.t2621 VSS.t206 sg13_lv_nmos ad=79.8f pd=0.8u as=0 ps=0 w=0.42u l=1u
X2987 VSS.t2697 VDD VSS.t2697 VSS.t206 sg13_lv_nmos ad=0.1428p pd=1.52u as=0 ps=0 w=0.42u l=1u
X2988 VSS.t869 VDD VSS.t871 VSS.t870 sg13_lv_nmos ad=79.8f pd=0.8u as=0 ps=0 w=0.42u l=1u
X2989 VSS.t3009 VDD VSS.t3011 VSS.t3010 sg13_lv_nmos ad=79.8f pd=0.8u as=0 ps=0 w=0.42u l=1u
X2990 VDD VSS.t2916 VDD VDD sg13_lv_pmos ad=0.19p pd=1.38u as=0 ps=0 w=1u l=1u
X2991 a_21166_16263# a_21281_16262# VDD VDD sg13_lv_pmos ad=0.34p pd=2.68u as=0.2254p ps=1.53u w=1u l=0.5u
X2992 VDD a_5687_15315# a_5687_15549# VDD sg13_lv_pmos ad=2.8961p pd=18.25u as=0.2442p ps=2.06u w=0.66u l=0.13u
X2993 VDD VSS.t2326 VDD VDD sg13_lv_pmos ad=0.34p pd=2.68u as=0 ps=0 w=1u l=1u
X2994 VDD VSS.t1984 VDD VDD sg13_lv_pmos ad=0.34p pd=2.68u as=0 ps=0 w=1u l=1u
X2995 VDD a_22508_15960# counter_value_o[4] VDD sg13_lv_pmos ad=0.2114p pd=1.54u as=0.42p ps=2.99u w=1.12u l=0.13u
X2996 VDD VSS.t593 VDD VDD sg13_lv_pmos ad=0.19p pd=1.38u as=0 ps=0 w=1u l=1u
X2997 VSS.t521 VDD VSS.t523 VSS.t522 sg13_lv_nmos ad=79.8f pd=0.8u as=0 ps=0 w=0.42u l=1u
X2998 VDD VSS.t528 VDD VDD sg13_lv_pmos ad=0.19p pd=1.38u as=0 ps=0 w=1u l=1u
X2999 VDD VSS.t1321 VDD VDD sg13_lv_pmos ad=0.19p pd=1.38u as=0 ps=0 w=1u l=1u
X3000 VDD VSS.t1217 VDD VDD sg13_lv_pmos ad=0.19p pd=1.38u as=0 ps=0 w=1u l=1u
X3001 VSS.t1180 VDD VSS.t1179 VSS.t1154 sg13_lv_nmos ad=0.1428p pd=1.52u as=0 ps=0 w=0.42u l=1u
X3002 VDD VSS.t3106 VDD VDD sg13_lv_pmos ad=0.19p pd=1.38u as=0 ps=0 w=1u l=1u
X3003 VDD VSS.t2685 VDD VDD sg13_lv_pmos ad=0.19p pd=1.38u as=0 ps=0 w=1u l=1u
X3004 VDD VSS.t1902 VDD VDD sg13_lv_pmos ad=0.19p pd=1.38u as=0 ps=0 w=1u l=1u
X3005 VSS.t2347 VDD VSS.t2346 VSS.t2345 sg13_lv_nmos ad=0.1428p pd=1.52u as=0 ps=0 w=0.42u l=1u
X3006 a_27664_13942# sg13cmos5l_dfrbpq_1_5.RESET_B VDD VDD sg13_lv_pmos ad=79.8f pd=0.8u as=2.42015p ps=15.68u w=0.42u l=0.13u
X3007 VSS.t1173 VDD VSS.t1174 VSS.t1154 sg13_lv_nmos ad=79.8f pd=0.8u as=0 ps=0 w=0.42u l=1u
X3008 sg13cmos5l_nand4_1_0.Y sg13cmos5l_xor2_1_0.B VDD VDD sg13_lv_pmos ad=0.2128p pd=1.5u as=0.3808p ps=2.92u w=1.12u l=0.13u
X3009 VSS.t434 VDD VSS.t435 VSS.t4 sg13_lv_nmos ad=79.8f pd=0.8u as=0 ps=0 w=0.42u l=1u
X3010 VDD VSS.t427 VDD VDD sg13_lv_pmos ad=0.34p pd=2.68u as=0 ps=0 w=1u l=1u
X3011 a_15782_13722# a_16587_13844# a_16042_13945# VDD sg13_lv_pmos ad=0.1428p pd=1.52u as=79.8f ps=0.8u w=0.42u l=0.13u
X3012 VSS.t2744 VDD VSS.t2743 VSS.t206 sg13_lv_nmos ad=0.1428p pd=1.52u as=0 ps=0 w=0.42u l=1u
X3013 VDD VSS.t2027 VDD VDD sg13_lv_pmos ad=0.19p pd=1.38u as=0 ps=0 w=1u l=1u
X3014 VDD VSS.t3133 VDD VDD sg13_lv_pmos ad=0.34p pd=2.68u as=0 ps=0 w=1u l=1u
X3015 VDD VSS.t283 VDD VDD sg13_lv_pmos ad=0.19p pd=1.38u as=0 ps=0 w=1u l=1u
X3016 VDD VSS.t1670 VDD VDD sg13_lv_pmos ad=0.19p pd=1.38u as=0 ps=0 w=1u l=1u
X3017 VSS.t2412 VDD VSS.t2414 VSS.t2413 sg13_lv_nmos ad=79.8f pd=0.8u as=0 ps=0 w=0.42u l=1u
X3018 a_10222_14751# a_10337_14750# VDD VDD sg13_lv_pmos ad=0.34p pd=2.68u as=0.2254p ps=1.53u w=1u l=0.5u
X3019 VDD VSS.t1710 VDD VDD sg13_lv_pmos ad=0.19p pd=1.38u as=0 ps=0 w=1u l=1u
X3020 VSS.t1910 VDD VSS.t1912 VSS.t1911 sg13_lv_nmos ad=79.8f pd=0.8u as=0 ps=0 w=0.42u l=1u
X3021 VDD VSS.t2936 VDD VDD sg13_lv_pmos ad=0.19p pd=1.38u as=0 ps=0 w=1u l=1u
X3022 VDD VSS.t1540 VDD VDD sg13_lv_pmos ad=0.19p pd=1.38u as=0 ps=0 w=1u l=1u
X3023 VDD a_26565_13701# a_26667_13844# VDD sg13_lv_pmos ad=2.42015p pd=15.68u as=0.3864p ps=2.93u w=1.12u l=0.13u
X3024 VDD VSS.t509 VDD VDD sg13_lv_pmos ad=0.34p pd=2.68u as=0 ps=0 w=1u l=1u
X3025 VSS.t4 a_21477_14495# a_21579_14495# VSS.t3281 sg13_lv_nmos ad=4.11262p pd=27.15u as=0.2516p ps=2.16u w=0.74u l=0.13u
X3026 VDD VSS.t79 VDD VDD sg13_lv_pmos ad=0.34p pd=2.68u as=0 ps=0 w=1u l=1u
X3027 VSS.t1273 VDD VSS.t1272 VSS.t1154 sg13_lv_nmos ad=0.1428p pd=1.52u as=0 ps=0 w=0.42u l=1u
X3028 VDD VSS.t1312 VDD VDD sg13_lv_pmos ad=0.19p pd=1.38u as=0 ps=0 w=1u l=1u
X3029 VSS.t2629 VDD VSS.t2628 VSS.t206 sg13_lv_nmos ad=0.1428p pd=1.52u as=0 ps=0 w=0.42u l=1u
X3030 VDD VSS.t576 VDD VDD sg13_lv_pmos ad=0.34p pd=2.68u as=0 ps=0 w=1u l=1u
X3031 VDD VSS.t2681 VDD VDD sg13_lv_pmos ad=0.19p pd=1.38u as=0 ps=0 w=1u l=1u
X3032 VDD VSS.t2354 VDD VDD sg13_lv_pmos ad=0.19p pd=1.38u as=0 ps=0 w=1u l=1u
X3033 VSS.t416 VDD VSS.t415 VSS.t4 sg13_lv_nmos ad=0.1428p pd=1.52u as=0 ps=0 w=0.42u l=1u
X3034 a_4474_14448# sg13cmos5l_dlygate4sd3_1_3.A VSS.t41 VSS.t3230 sg13_lv_nmos ad=0.1428p pd=1.52u as=79.8f ps=0.8u w=0.42u l=0.13u
X3035 VSS.t231 VDD VSS.t231 VSS.t367 sg13_lv_nmos ad=79.8f pd=0.8u as=0 ps=0 w=0.42u l=1u
X3036 VSS.t583 VDD VSS.t586 VSS.t585 sg13_lv_nmos ad=79.8f pd=0.8u as=0 ps=0 w=0.42u l=1u
X3037 VSS.t2656 VDD VSS.t2657 VSS.t206 sg13_lv_nmos ad=79.8f pd=0.8u as=0 ps=0 w=0.42u l=1u
X3038 VSS.t2690 VDD VSS.t2691 VSS.t206 sg13_lv_nmos ad=79.8f pd=0.8u as=0 ps=0 w=0.42u l=1u
X3039 VSS.t1309 VDD VSS.t1309 VSS.t1154 sg13_lv_nmos ad=79.8f pd=0.8u as=0 ps=0 w=0.42u l=1u
X3040 VDD VSS.t1690 VDD VDD sg13_lv_pmos ad=0.19p pd=1.38u as=0 ps=0 w=1u l=1u
X3041 VDD VSS.t2976 VDD VDD sg13_lv_pmos ad=0.19p pd=1.38u as=0 ps=0 w=1u l=1u
X3042 VDD VSS.t1847 VDD VDD sg13_lv_pmos ad=0.19p pd=1.38u as=0 ps=0 w=1u l=1u
X3043 VSS.t1850 VDD VSS.t1849 VSS.t1848 sg13_lv_nmos ad=0.1428p pd=1.52u as=0 ps=0 w=0.42u l=1u
X3044 VSS.t289 VDD VSS.t289 VSS.t291 sg13_lv_nmos ad=0.1428p pd=1.52u as=0 ps=0 w=0.42u l=1u
X3045 VDD VSS.t30 VDD VDD sg13_lv_pmos ad=0.19p pd=1.38u as=0 ps=0 w=1u l=1u
X3046 VDD VSS.t103 VDD VDD sg13_lv_pmos ad=0.34p pd=2.68u as=0 ps=0 w=1u l=1u
X3047 VDD VSS.t2691 VDD VDD sg13_lv_pmos ad=0.34p pd=2.68u as=0 ps=0 w=1u l=1u
X3048 a_27215_14845# a_26373_14495# a_25956_14488# VDD sg13_lv_pmos ad=0.2048p pd=1.63u as=0.34p ps=2.68u w=1u l=0.13u
X3049 VSS.t2994 VDD VSS.t2996 VSS.t2995 sg13_lv_nmos ad=79.8f pd=0.8u as=0 ps=0 w=0.42u l=1u
X3050 VDD VSS.t2764 VDD VDD sg13_lv_pmos ad=0.19p pd=1.38u as=0 ps=0 w=1u l=1u
X3051 VSS.t2055 VDD VSS.t2054 VSS.t2053 sg13_lv_nmos ad=0.1428p pd=1.52u as=0 ps=0 w=0.42u l=1u
X3052 VSS.t583 VDD VSS.t583 VSS.t709 sg13_lv_nmos ad=79.8f pd=0.8u as=0 ps=0 w=0.42u l=1u
X3053 VDD VSS.t411 VDD VDD sg13_lv_pmos ad=0.19p pd=1.38u as=0 ps=0 w=1u l=1u
X3054 VDD VSS.t1028 VDD VDD sg13_lv_pmos ad=0.34p pd=2.68u as=0 ps=0 w=1u l=1u
X3055 VDD VSS.t620 VDD VDD sg13_lv_pmos ad=0.19p pd=1.38u as=0 ps=0 w=1u l=1u
X3056 VSS.t1318 VDD VSS.t1319 VSS.t1154 sg13_lv_nmos ad=79.8f pd=0.8u as=0 ps=0 w=0.42u l=1u
X3057 VSS.t2397 VDD VSS.t2399 VSS.t2398 sg13_lv_nmos ad=79.8f pd=0.8u as=0 ps=0 w=0.42u l=1u
X3058 VDD VSS.t1485 VDD VDD sg13_lv_pmos ad=0.19p pd=1.38u as=0 ps=0 w=1u l=1u
X3059 VDD VSS.t2948 VDD VDD sg13_lv_pmos ad=0.34p pd=2.68u as=0 ps=0 w=1u l=1u
X3060 VDD VSS.t596 VDD VDD sg13_lv_pmos ad=0.34p pd=2.68u as=0 ps=0 w=1u l=1u
X3061 VSS.t1563 VDD VSS.t1565 VSS.t1564 sg13_lv_nmos ad=79.8f pd=0.8u as=0 ps=0 w=0.42u l=1u
X3062 VDD VSS.t2064 VDD VDD sg13_lv_pmos ad=0.34p pd=2.68u as=0 ps=0 w=1u l=1u
X3063 VSS.t834 VDD VSS.t836 VSS.t835 sg13_lv_nmos ad=79.8f pd=0.8u as=0 ps=0 w=0.42u l=1u
X3064 VSS.t1885 VDD VSS.t1884 VSS.t1883 sg13_lv_nmos ad=0.1428p pd=1.52u as=0 ps=0 w=0.42u l=1u
X3065 a_4078_14751# a_4193_14750# VSS.t32 VSS.t95 sg13_lv_nmos ad=0.1428p pd=1.52u as=0.1426p ps=1.16u w=0.42u l=0.5u
X3066 VSS.t2734 VDD VSS.t2734 VSS.t206 sg13_lv_nmos ad=0.1428p pd=1.52u as=0 ps=0 w=0.42u l=1u
X3067 VDD VSS.t2649 VDD VDD sg13_lv_pmos ad=0.19p pd=1.38u as=0 ps=0 w=1u l=1u
X3068 a_21286_14909# sg13cmos5l_dfrbpq_1_6.RESET_B VSS.t157 VSS.t3272 sg13_lv_nmos ad=37.8f pd=0.6u as=0.1701p ps=1.65u w=0.42u l=0.13u
X3069 VDD VSS.t1234 VDD VDD sg13_lv_pmos ad=0.19p pd=1.38u as=0 ps=0 w=1u l=1u
X3070 VDD VSS.t2012 VDD VDD sg13_lv_pmos ad=0.19p pd=1.38u as=0 ps=0 w=1u l=1u
X3071 VSS.t2427 VDD VSS.t2426 VSS.t2425 sg13_lv_nmos ad=0.1428p pd=1.52u as=0 ps=0 w=0.42u l=1u
X3072 VDD VSS.t1964 VDD VDD sg13_lv_pmos ad=0.34p pd=2.68u as=0 ps=0 w=1u l=1u
X3073 VSS.t1683 VDD VSS.t1685 VSS.t1684 sg13_lv_nmos ad=79.8f pd=0.8u as=0 ps=0 w=0.42u l=1u
X3074 VDD VSS.t1695 VDD VDD sg13_lv_pmos ad=0.19p pd=1.38u as=0 ps=0 w=1u l=1u
X3075 VSS.t2075 VDD VSS.t2074 VSS.t2073 sg13_lv_nmos ad=0.1428p pd=1.52u as=0 ps=0 w=0.42u l=1u
X3076 VSS.t1895 VDD VSS.t1897 VSS.t1896 sg13_lv_nmos ad=79.8f pd=0.8u as=0 ps=0 w=0.42u l=1u
X3077 a_16955_14484# sg13cmos5l_a21oi_1_0.A2 VDD VDD sg13_lv_pmos ad=0.3808p pd=2.92u as=0.2128p ps=1.5u w=1.12u l=0.13u
X3078 VDD VSS.t2921 VDD VDD sg13_lv_pmos ad=0.19p pd=1.38u as=0 ps=0 w=1u l=1u
X3079 VSS.t2979 VDD VSS.t2981 VSS.t2980 sg13_lv_nmos ad=79.8f pd=0.8u as=0 ps=0 w=0.42u l=1u
X3080 VDD VSS.t1647 VDD VDD sg13_lv_pmos ad=0.34p pd=2.68u as=0 ps=0 w=1u l=1u
X3081 VSS.t2492 VDD VSS.t2494 VSS.t2493 sg13_lv_nmos ad=79.8f pd=0.8u as=0 ps=0 w=0.42u l=1u
X3082 a_2942_14484# sg13cmos5l_xor2_1_0.B a_2490_14447# VDD sg13_lv_pmos ad=0.1225p pd=1.245u as=0.34p ps=2.68u w=1u l=0.13u
X3083 VSS.t16 a_15579_14854# sg13cmos5l_buf_8_2.A VSS.t3246 sg13_lv_nmos ad=0.2516p pd=2.16u as=0.1406p ps=1.12u w=0.74u l=0.13u
X3084 VDD VSS.t803 VDD VDD sg13_lv_pmos ad=0.34p pd=2.68u as=0 ps=0 w=1u l=1u
X3085 VDD VSS.t1525 VDD VDD sg13_lv_pmos ad=0.19p pd=1.38u as=0 ps=0 w=1u l=1u
X3086 VDD VSS.t1702 VDD VDD sg13_lv_pmos ad=0.34p pd=2.68u as=0 ps=0 w=1u l=1u
X3087 VDD VSS.t599 VDD VDD sg13_lv_pmos ad=0.34p pd=2.68u as=0 ps=0 w=1u l=1u
X3088 a_5613_14832# sg13cmos5l_buf_1_10.X VDD VDD sg13_lv_pmos ad=0.1596p pd=1.22u as=0.2856p ps=2.36u w=0.84u l=0.13u
X3089 VSS.t1300 VDD VSS.t1299 VSS.t1154 sg13_lv_nmos ad=0.1428p pd=1.52u as=0 ps=0 w=0.42u l=1u
X3090 VDD VSS.t2331 VDD VDD sg13_lv_pmos ad=0.34p pd=2.68u as=0 ps=0 w=1u l=1u
X3091 a_18665_15180# a_18789_15277# VDD VDD sg13_lv_pmos ad=0.2442p pd=2.06u as=2.8961p ps=18.25u w=0.66u l=0.13u
X3092 VDD sg13cmos5l_buf_1_0.X sg13cmos5l_xnor2_1_2.B VDD sg13_lv_pmos ad=0.3808p pd=2.92u as=0.2128p ps=1.5u w=1.12u l=0.13u
X3093 VSS.t134 VDD VSS.t136 VSS.t391 sg13_lv_nmos ad=79.8f pd=0.8u as=0 ps=0 w=0.42u l=1u
X3094 VDD VSS.t635 VDD VDD sg13_lv_pmos ad=0.34p pd=2.68u as=0 ps=0 w=1u l=1u
X3095 VSS.t1293 VDD VSS.t1294 VSS.t1154 sg13_lv_nmos ad=79.8f pd=0.8u as=0 ps=0 w=0.42u l=1u
X3096 VDD VSS.t1907 VDD VDD sg13_lv_pmos ad=0.19p pd=1.38u as=0 ps=0 w=1u l=1u
X3097 VSS.t320 VDD VSS.t319 VSS.t318 sg13_lv_nmos ad=0.1428p pd=1.52u as=0 ps=0 w=0.42u l=1u
X3098 a_5886_15486# a_5687_15549# VSS.t4 VSS.t3169 sg13_lv_nmos ad=0.27427p pd=2.28u as=4.11262p ps=27.15u w=0.795u l=0.13u
X3099 VDD VSS.t444 VDD VDD sg13_lv_pmos ad=0.19p pd=1.38u as=0 ps=0 w=1u l=1u
X3100 VDD VSS.t856 VDD VDD sg13_lv_pmos ad=0.19p pd=1.38u as=0 ps=0 w=1u l=1u
X3101 VDD VSS.t2226 VDD VDD sg13_lv_pmos ad=0.34p pd=2.68u as=0 ps=0 w=1u l=1u
X3102 VSS.t2746 VDD VSS.t2746 VSS.t206 sg13_lv_nmos ad=0.1428p pd=1.52u as=0 ps=0 w=0.42u l=1u
X3103 VSS.t157 a_21070_15423# sg13cmos5l_dlygate4sd3_1_9.X VSS.t221 sg13_lv_nmos ad=0.1426p pd=1.16u as=0.2516p ps=2.16u w=0.74u l=0.13u
X3104 VDD VSS.t1276 VDD VDD sg13_lv_pmos ad=0.19p pd=1.38u as=0 ps=0 w=1u l=1u
X3105 VDD VSS.t1225 VDD VDD sg13_lv_pmos ad=0.19p pd=1.38u as=0 ps=0 w=1u l=1u
X3106 VDD VSS.t2718 VDD VDD sg13_lv_pmos ad=0.19p pd=1.38u as=0 ps=0 w=1u l=1u
X3107 VDD VSS.t2032 VDD VDD sg13_lv_pmos ad=0.19p pd=1.38u as=0 ps=0 w=1u l=1u
X3108 VDD VSS.t3138 VDD VDD sg13_lv_pmos ad=0.34p pd=2.68u as=0 ps=0 w=1u l=1u
X3109 VSS.t2412 VDD VSS.t2411 VSS.t2410 sg13_lv_nmos ad=0.1428p pd=1.52u as=0 ps=0 w=0.42u l=1u
X3110 VSS.t1835 VDD VSS.t1834 VSS.t1833 sg13_lv_nmos ad=0.1428p pd=1.52u as=0 ps=0 w=0.42u l=1u
X3111 VDD a_7822_13911# sg13cmos5l_xnor2_1_2.A VDD sg13_lv_pmos ad=0.2254p pd=1.53u as=0.4256p ps=3u w=1.12u l=0.13u
X3112 VSS.t573 VDD VSS.t150 VSS.t695 sg13_lv_nmos ad=79.8f pd=0.8u as=0 ps=0 w=0.42u l=1u
X3113 VSS.t599 VDD VSS.t602 VSS.t737 sg13_lv_nmos ad=79.8f pd=0.8u as=0 ps=0 w=0.42u l=1u
X3114 VDD VSS.t1675 VDD VDD sg13_lv_pmos ad=0.19p pd=1.38u as=0 ps=0 w=1u l=1u
X3115 VSS.t2692 VDD VSS.t2692 VSS.t206 sg13_lv_nmos ad=0.1428p pd=1.52u as=0 ps=0 w=0.42u l=1u
X3116 VSS.t157 sg13cmos5l_or3_1_2.X a_20705_15260# VSS.t107 sg13_lv_nmos ad=0.2516p pd=2.16u as=0.1406p ps=1.12u w=0.74u l=0.13u
X3117 VDD VSS.t1680 VDD VDD sg13_lv_pmos ad=0.19p pd=1.38u as=0 ps=0 w=1u l=1u
X3118 VSS.t889 VDD VSS.t891 VSS.t890 sg13_lv_nmos ad=79.8f pd=0.8u as=0 ps=0 w=0.42u l=1u
X3119 VSS.t1638 VDD VSS.t1637 VSS.t1636 sg13_lv_nmos ad=0.1428p pd=1.52u as=0 ps=0 w=0.42u l=1u
X3120 VSS.t3159 VDD VSS.t3158 VSS.t3157 sg13_lv_nmos ad=0.1428p pd=1.52u as=0 ps=0 w=0.42u l=1u
X3121 VSS.t2477 VDD VSS.t2479 VSS.t2478 sg13_lv_nmos ad=79.8f pd=0.8u as=0 ps=0 w=0.42u l=1u
X3122 VDD VSS.t2364 VDD VDD sg13_lv_pmos ad=0.19p pd=1.38u as=0 ps=0 w=1u l=1u
X3123 a_22508_15960# sg13cmos5l_dfrbpq_1_3.Q VSS.t123 VSS.t122 sg13_lv_nmos ad=0.187p pd=1.78u as=0.14875p ps=1.16u w=0.55u l=0.13u
X3124 a_7631_14845# a_6789_14495# a_7537_14845# VSS.t55 sg13_lv_nmos ad=0.12665p pd=1.145u as=0.1428p ps=1.52u w=0.42u l=0.13u
X3125 VSS.t829 VDD VSS.t828 VSS.t827 sg13_lv_nmos ad=0.1428p pd=1.52u as=0 ps=0 w=0.42u l=1u
X3126 VSS.t2631 VDD VSS.t2631 VSS.t206 sg13_lv_nmos ad=0.1428p pd=1.52u as=0 ps=0 w=0.42u l=1u
X3127 VSS.t764 VDD VSS.t766 VSS.t765 sg13_lv_nmos ad=79.8f pd=0.8u as=0 ps=0 w=0.42u l=1u
X3128 VSS.t2725 VDD VSS.t2727 VSS.t206 sg13_lv_nmos ad=79.8f pd=0.8u as=0 ps=0 w=0.42u l=1u
X3129 VDD VSS.t2683 VDD VDD sg13_lv_pmos ad=0.19p pd=1.38u as=0 ps=0 w=1u l=1u
X3130 VSS.t2382 VDD VSS.t2384 VSS.t2383 sg13_lv_nmos ad=79.8f pd=0.8u as=0 ps=0 w=0.42u l=1u
X3131 VSS.t1945 VDD VSS.t1944 VSS.t1943 sg13_lv_nmos ad=0.1428p pd=1.52u as=0 ps=0 w=0.42u l=1u
X3132 VDD VSS.t1470 VDD VDD sg13_lv_pmos ad=0.19p pd=1.38u as=0 ps=0 w=1u l=1u
X3133 VDD VSS.t2933 VDD VDD sg13_lv_pmos ad=0.34p pd=2.68u as=0 ps=0 w=1u l=1u
X3134 VDD VSS.t623 VDD VDD sg13_lv_pmos ad=0.34p pd=2.68u as=0 ps=0 w=1u l=1u
X3135 VSS.t834 VDD VSS.t836 VSS.t835 sg13_lv_nmos ad=79.8f pd=0.8u as=0 ps=0 w=0.42u l=1u
X3136 VSS.t1234 VDD VSS.t1233 VSS.t1154 sg13_lv_nmos ad=0.1428p pd=1.52u as=0 ps=0 w=0.42u l=1u
X3137 a_21562_15960# sg13cmos5l_a21oi_1_1.Y VDD VDD sg13_lv_pmos ad=0.1428p pd=1.52u as=0.1523p ps=1.38u w=0.42u l=0.13u
X3138 VSS.t1548 VDD VSS.t1550 VSS.t1549 sg13_lv_nmos ad=79.8f pd=0.8u as=0 ps=0 w=0.42u l=1u
X3139 VDD VSS.t2049 VDD VDD sg13_lv_pmos ad=0.34p pd=2.68u as=0 ps=0 w=1u l=1u
X3140 VSS.t163 sg13cmos5l_or3_1_1.X a_25025_16344# VSS.t210 sg13_lv_nmos ad=0.2516p pd=2.16u as=0.1406p ps=1.12u w=0.74u l=0.13u
X3141 VDD VSS.t356 VDD VDD sg13_lv_pmos ad=0.19p pd=1.38u as=0 ps=0 w=1u l=1u
X3142 a_17604_14488# a_18123_14495# a_18863_14845# VSS.t13 sg13_lv_nmos ad=0.3473p pd=2.71u as=0.12665p ps=1.145u w=0.74u l=0.13u
X3143 VDD VSS.t2419 VDD VDD sg13_lv_pmos ad=0.19p pd=1.38u as=0 ps=0 w=1u l=1u
X3144 VDD VSS.t1852 VDD VDD sg13_lv_pmos ad=0.19p pd=1.38u as=0 ps=0 w=1u l=1u
X3145 VSS.t1239 VDD VSS.t1238 VSS.t1154 sg13_lv_nmos ad=0.1428p pd=1.52u as=0 ps=0 w=0.42u l=1u
X3146 VDD VSS.t1660 VDD VDD sg13_lv_pmos ad=0.19p pd=1.38u as=0 ps=0 w=1u l=1u
X3147 VSS.t2025 VDD VSS.t2027 VSS.t2026 sg13_lv_nmos ad=79.8f pd=0.8u as=0 ps=0 w=0.42u l=1u
X3148 VSS.t859 VDD VSS.t858 VSS.t857 sg13_lv_nmos ad=0.1428p pd=1.52u as=0 ps=0 w=0.42u l=1u
X3149 VDD VSS.t1949 VDD VDD sg13_lv_pmos ad=0.34p pd=2.68u as=0 ps=0 w=1u l=1u
X3150 VSS.t1159 VDD VSS.t1158 VSS.t1154 sg13_lv_nmos ad=0.1428p pd=1.52u as=0 ps=0 w=0.42u l=1u
X3151 VSS.t1200 VDD VSS.t1201 VSS.t1154 sg13_lv_nmos ad=79.8f pd=0.8u as=0 ps=0 w=0.42u l=1u
X3152 VSS.t2060 VDD VSS.t2059 VSS.t2058 sg13_lv_nmos ad=0.1428p pd=1.52u as=0 ps=0 w=0.42u l=1u
X3153 VSS.t3144 VDD VSS.t3143 VSS.t3142 sg13_lv_nmos ad=0.1428p pd=1.52u as=0 ps=0 w=0.42u l=1u
X3154 VDD VSS.t1036 VDD VDD sg13_lv_pmos ad=0.19p pd=1.38u as=0 ps=0 w=1u l=1u
X3155 sg13cmos5l_buf_1_10.X a_1192_9948# VDD VDD sg13_lv_pmos ad=0.42p pd=2.99u as=0.2114p ps=1.54u w=1.12u l=0.13u
X3156 VSS.t620 VDD VSS.t620 VSS.t621 sg13_lv_nmos ad=79.8f pd=0.8u as=0 ps=0 w=0.42u l=1u
X3157 VSS.t632 VDD VSS.t635 VSS.t759 sg13_lv_nmos ad=79.8f pd=0.8u as=0 ps=0 w=0.42u l=1u
X3158 VDD VSS.t1632 VDD VDD sg13_lv_pmos ad=0.34p pd=2.68u as=0 ps=0 w=1u l=1u
X3159 VSS.t1164 VDD VSS.t1163 VSS.t1154 sg13_lv_nmos ad=0.1428p pd=1.52u as=0 ps=0 w=0.42u l=1u
X3160 VDD VSS.t1687 VDD VDD sg13_lv_pmos ad=0.34p pd=2.68u as=0 ps=0 w=1u l=1u
X3161 VSS.t1538 VDD VSS.t1540 VSS.t1539 sg13_lv_nmos ad=79.8f pd=0.8u as=0 ps=0 w=0.42u l=1u
X3162 VSS.t2432 VDD VSS.t2431 VSS.t2430 sg13_lv_nmos ad=0.1428p pd=1.52u as=0 ps=0 w=0.42u l=1u
X3163 a_27417_14607# a_26475_14495# a_27215_14845# VDD sg13_lv_pmos ad=93.45f pd=0.865u as=0.2048p ps=1.63u w=0.42u l=0.13u
X3164 VDD VSS.t689 VDD VDD sg13_lv_pmos ad=0.34p pd=2.68u as=0 ps=0 w=1u l=1u
X3165 VSS.t919 VDD VSS.t921 VSS.t920 sg13_lv_nmos ad=79.8f pd=0.8u as=0 ps=0 w=0.42u l=1u
X3166 VDD VSS.t2316 VDD VDD sg13_lv_pmos ad=0.34p pd=2.68u as=0 ps=0 w=1u l=1u
X3167 VSS.t686 VDD VSS.t685 VSS.t684 sg13_lv_nmos ad=0.1428p pd=1.52u as=0 ps=0 w=0.42u l=1u
X3168 VDD VSS.t786 VDD VDD sg13_lv_pmos ad=0.19p pd=1.38u as=0 ps=0 w=1u l=1u
X3169 VDD VSS.t1490 VDD VDD sg13_lv_pmos ad=0.19p pd=1.38u as=0 ps=0 w=1u l=1u
X3170 VSS.t2613 VDD VSS.t2614 VSS.t206 sg13_lv_nmos ad=79.8f pd=0.8u as=0 ps=0 w=0.42u l=1u
X3171 VSS.t289 VDD VSS.t289 VSS.t290 sg13_lv_nmos ad=79.8f pd=0.8u as=0 ps=0 w=0.42u l=1u
X3172 VSS.t1533 VDD VSS.t1535 VSS.t1534 sg13_lv_nmos ad=79.8f pd=0.8u as=0 ps=0 w=0.42u l=1u
X3173 VDD VSS.t2069 VDD VDD sg13_lv_pmos ad=0.34p pd=2.68u as=0 ps=0 w=1u l=1u
X3174 VSS.t1890 VDD VSS.t1889 VSS.t1888 sg13_lv_nmos ad=0.1428p pd=1.52u as=0 ps=0 w=0.42u l=1u
X3175 VDD a_12010_15202# sg13cmos5l_dfrbpq_1_2.CLK VDD sg13_lv_pmos ad=0.2128p pd=1.5u as=0.2128p ps=1.5u w=1.12u l=0.13u
X3176 VDD VSS.t1302 VDD VDD sg13_lv_pmos ad=0.34p pd=2.68u as=0 ps=0 w=1u l=1u
X3177 VSS.t1183 VDD VSS.t1182 VSS.t1154 sg13_lv_nmos ad=0.1428p pd=1.52u as=0 ps=0 w=0.42u l=1u
X3178 VSS.t2737 VDD VSS.t2737 VSS.t206 sg13_lv_nmos ad=0.1428p pd=1.52u as=0 ps=0 w=0.42u l=1u
X3179 VDD VSS.t2614 VDD VDD sg13_lv_pmos ad=0.34p pd=2.68u as=0 ps=0 w=1u l=1u
X3180 VSS.t509 VDD VSS.t509 VSS.t513 sg13_lv_nmos ad=79.8f pd=0.8u as=0 ps=0 w=0.42u l=1u
X3181 VDD VSS.t1216 VDD VDD sg13_lv_pmos ad=0.19p pd=1.38u as=0 ps=0 w=1u l=1u
X3182 VDD VSS.t2711 VDD VDD sg13_lv_pmos ad=0.19p pd=1.38u as=0 ps=0 w=1u l=1u
X3183 VSS.t2397 VDD VSS.t2396 VSS.t2395 sg13_lv_nmos ad=0.1428p pd=1.52u as=0 ps=0 w=0.42u l=1u
X3184 VSS.t889 VDD VSS.t891 VSS.t890 sg13_lv_nmos ad=79.8f pd=0.8u as=0 ps=0 w=0.42u l=1u
X3185 VSS.t1252 VDD VSS.t1251 VSS.t1154 sg13_lv_nmos ad=0.1428p pd=1.52u as=0 ps=0 w=0.42u l=1u
X3186 VSS.t443 VDD VSS.t442 VSS.t4 sg13_lv_nmos ad=0.1428p pd=1.52u as=0 ps=0 w=0.42u l=1u
X3187 VSS.t1688 VDD VSS.t1690 VSS.t1689 sg13_lv_nmos ad=79.8f pd=0.8u as=0 ps=0 w=0.42u l=1u
X3188 VDD sg13cmos5l_dfrbpq_1_3.Q sg13cmos5l_or3_1_2.C VDD sg13_lv_pmos ad=0.3808p pd=2.92u as=0.2128p ps=1.5u w=1.12u l=0.13u
X3189 VDD sg13cmos5l_inv_1_0.Y a_16314_15532# VDD sg13_lv_pmos ad=0.2891p pd=1.695u as=0.1428p ps=1.375u w=1.12u l=0.13u
X3190 VDD VSS.t1003 VDD VDD sg13_lv_pmos ad=0.34p pd=2.68u as=0 ps=0 w=1u l=1u
X3191 VSS.t2462 VDD VSS.t2464 VSS.t2463 sg13_lv_nmos ad=79.8f pd=0.8u as=0 ps=0 w=0.42u l=1u
X3192 VSS.t829 VDD VSS.t828 VSS.t827 sg13_lv_nmos ad=0.1428p pd=1.52u as=0 ps=0 w=0.42u l=1u
X3193 VDD VSS.t1530 VDD VDD sg13_lv_pmos ad=0.19p pd=1.38u as=0 ps=0 w=1u l=1u
X3194 VSS.t2736 VDD VSS.t2735 VSS.t206 sg13_lv_nmos ad=0.1428p pd=1.52u as=0 ps=0 w=0.42u l=1u
X3195 VDD VSS.t1864 VDD VDD sg13_lv_pmos ad=0.34p pd=2.68u as=0 ps=0 w=1u l=1u
X3196 a_24841_13726# sg13cmos5l_or3_1_1.B VSS.t60 VSS.t166 sg13_lv_nmos ad=0.198p pd=1.27u as=0.1045p ps=0.93u w=0.55u l=0.13u
X3197 VSS.t764 VDD VSS.t766 VSS.t765 sg13_lv_nmos ad=79.8f pd=0.8u as=0 ps=0 w=0.42u l=1u
X3198 VDD VSS.t1228 VDD VDD sg13_lv_pmos ad=0.19p pd=1.38u as=0 ps=0 w=1u l=1u
X3199 VSS.t1192 VDD VSS.t1191 VSS.t1154 sg13_lv_nmos ad=0.1428p pd=1.52u as=0 ps=0 w=0.42u l=1u
X3200 sg13cmos5l_or3_1_1.C sg13cmos5l_dfrbpq_1_6.Q VDD VDD sg13_lv_pmos ad=0.2128p pd=1.5u as=0.2128p ps=1.5u w=1.12u l=0.13u
X3201 a_23378_15242# sg13cmos5l_dfrbpq_1_2.Q VSS.t3261 VSS.t57 sg13_lv_nmos ad=0.1406p pd=1.12u as=0.2886p ps=2.26u w=0.74u l=0.13u
X3202 VDD a_19120_14726# a_19065_14607# VDD sg13_lv_pmos ad=2.42015p pd=15.68u as=93.45f ps=0.865u w=0.42u l=0.13u
X3203 VDD VSS.t941 VDD VDD sg13_lv_pmos ad=0.19p pd=1.38u as=0 ps=0 w=1u l=1u
X3204 VSS.t2778 VDD VSS.t2777 VSS.t206 sg13_lv_nmos ad=0.1428p pd=1.52u as=0 ps=0 w=0.42u l=1u
X3205 VDD VSS.t2676 VDD VDD sg13_lv_pmos ad=0.19p pd=1.38u as=0 ps=0 w=1u l=1u
X3206 VDD sg13cmos5l_dfrbpq_1_0.RESET_B a_2630_15234# VDD sg13_lv_pmos ad=0.36237p pd=2.605u as=79.8f ps=0.8u w=0.42u l=0.13u
X3207 VSS.t3014 VDD VSS.t3013 VSS.t3012 sg13_lv_nmos ad=0.1428p pd=1.52u as=0 ps=0 w=0.42u l=1u
X3208 VDD VSS.t439 VDD VDD sg13_lv_pmos ad=0.34p pd=2.68u as=0 ps=0 w=1u l=1u
X3209 VSS.t1483 VDD VSS.t1485 VSS.t1484 sg13_lv_nmos ad=79.8f pd=0.8u as=0 ps=0 w=0.42u l=1u
X3210 VDD VSS.t340 VDD VDD sg13_lv_pmos ad=0.34p pd=2.68u as=0 ps=0 w=1u l=1u
X3211 VSS.t1713 VDD VSS.t1712 VSS.t1711 sg13_lv_nmos ad=0.1428p pd=1.52u as=0 ps=0 w=0.42u l=1u
X3212 VDD VSS.t1495 VDD VDD sg13_lv_pmos ad=0.19p pd=1.38u as=0 ps=0 w=1u l=1u
X3213 VDD VSS.t2404 VDD VDD sg13_lv_pmos ad=0.19p pd=1.38u as=0 ps=0 w=1u l=1u
X3214 VSS.t1875 VDD VSS.t1874 VSS.t1873 sg13_lv_nmos ad=0.1428p pd=1.52u as=0 ps=0 w=0.42u l=1u
X3215 VSS.t576 VDD VSS.t576 VSS.t701 sg13_lv_nmos ad=0.1428p pd=1.52u as=0 ps=0 w=0.42u l=1u
X3216 VDD VSS.t1228 VDD VDD sg13_lv_pmos ad=0.19p pd=1.38u as=0 ps=0 w=1u l=1u
X3217 VDD VSS.t2721 VDD VDD sg13_lv_pmos ad=0.19p pd=1.38u as=0 ps=0 w=1u l=1u
X3218 VDD VSS.t2002 VDD VDD sg13_lv_pmos ad=0.19p pd=1.38u as=0 ps=0 w=1u l=1u
X3219 VDD a_12010_15202# sg13cmos5l_dfrbpq_1_2.CLK VDD sg13_lv_pmos ad=0.2128p pd=1.5u as=0.2128p ps=1.5u w=1.12u l=0.13u
X3220 VSS.t859 VDD VSS.t858 VSS.t857 sg13_lv_nmos ad=0.1428p pd=1.52u as=0 ps=0 w=0.42u l=1u
X3221 VSS.t1266 VDD VSS.t1265 VSS.t1154 sg13_lv_nmos ad=0.1428p pd=1.52u as=0 ps=0 w=0.42u l=1u
X3222 VDD VSS.t2356 VDD VDD sg13_lv_pmos ad=0.34p pd=2.68u as=0 ps=0 w=1u l=1u
X3223 VSS.t2417 VDD VSS.t2416 VSS.t2415 sg13_lv_nmos ad=0.1428p pd=1.52u as=0 ps=0 w=0.42u l=1u
X3224 VSS.t588 VDD VSS.t590 VSS.t589 sg13_lv_nmos ad=79.8f pd=0.8u as=0 ps=0 w=0.42u l=1u
X3225 VDD VSS.t1502 VDD VDD sg13_lv_pmos ad=0.34p pd=2.68u as=0 ps=0 w=1u l=1u
X3226 VDD VSS.t3108 VDD VDD sg13_lv_pmos ad=0.34p pd=2.68u as=0 ps=0 w=1u l=1u
X3227 VDD VSS.t1837 VDD VDD sg13_lv_pmos ad=0.19p pd=1.38u as=0 ps=0 w=1u l=1u
X3228 VSS.t346 VDD VSS.t106 VSS.t347 sg13_lv_nmos ad=79.8f pd=0.8u as=0 ps=0 w=0.42u l=1u
X3229 VDD VSS.t1685 VDD VDD sg13_lv_pmos ad=0.19p pd=1.38u as=0 ps=0 w=1u l=1u
X3230 VSS.t1965 VDD VSS.t1964 VSS.t1963 sg13_lv_nmos ad=0.1428p pd=1.52u as=0 ps=0 w=0.42u l=1u
X3231 a_21060_14488# a_21034_14452# VSS.t157 VSS.t180 sg13_lv_nmos ad=0.2516p pd=2.16u as=0.1626p ps=1.415u w=0.74u l=0.13u
X3232 sg13cmos5l_buf_8_2.A a_15579_14854# VDD VDD sg13_lv_pmos ad=0.2128p pd=1.5u as=0.2128p ps=1.5u w=1.12u l=0.13u
X3233 sg13cmos5l_dfrbpq_1_2.CLK a_12010_15202# VSS.t20 VSS.t19 sg13_lv_nmos ad=0.1406p pd=1.12u as=0.2516p ps=2.16u w=0.74u l=0.13u
X3234 VSS.t1029 VDD VSS.t1028 VSS.t1027 sg13_lv_nmos ad=0.1428p pd=1.52u as=0 ps=0 w=0.42u l=1u
X3235 VDD VSS.t2369 VDD VDD sg13_lv_pmos ad=0.19p pd=1.38u as=0 ps=0 w=1u l=1u
X3236 VSS.t919 VDD VSS.t921 VSS.t920 sg13_lv_nmos ad=79.8f pd=0.8u as=0 ps=0 w=0.42u l=1u
X3237 VDD VSS.t1209 VDD VDD sg13_lv_pmos ad=0.34p pd=2.68u as=0 ps=0 w=1u l=1u
X3238 VDD VSS.t538 VDD VDD sg13_lv_pmos ad=0.19p pd=1.38u as=0 ps=0 w=1u l=1u
X3239 VDD VSS.t893 VDD VDD sg13_lv_pmos ad=0.34p pd=2.68u as=0 ps=0 w=1u l=1u
X3240 a_6682_13690# sg13cmos5l_dlygate4sd3_1_0.A VSS.t38 VSS.t37 sg13_lv_nmos ad=0.1428p pd=1.52u as=79.8f ps=0.8u w=0.42u l=0.13u
X3241 VSS.t1523 VDD VSS.t1525 VSS.t1524 sg13_lv_nmos ad=79.8f pd=0.8u as=0 ps=0 w=0.42u l=1u
X3242 VSS.t1703 VDD VSS.t1702 VSS.t1701 sg13_lv_nmos ad=0.1428p pd=1.52u as=0 ps=0 w=0.42u l=1u
X3243 VSS.t2634 VDD VSS.t2634 VSS.t206 sg13_lv_nmos ad=0.1428p pd=1.52u as=0 ps=0 w=0.42u l=1u
X3244 VSS.t2728 VDD VSS.t2730 VSS.t206 sg13_lv_nmos ad=79.8f pd=0.8u as=0 ps=0 w=0.42u l=1u
X3245 VDD VSS.t2686 VDD VDD sg13_lv_pmos ad=0.19p pd=1.38u as=0 ps=0 w=1u l=1u
X3246 VSS.t1915 VDD VSS.t1914 VSS.t1913 sg13_lv_nmos ad=0.1428p pd=1.52u as=0 ps=0 w=0.42u l=1u
X3247 VSS.t428 VDD VSS.t427 VSS.t4 sg13_lv_nmos ad=0.1428p pd=1.52u as=0 ps=0 w=0.42u l=1u
X3248 VDD VSS.t1475 VDD VDD sg13_lv_pmos ad=0.19p pd=1.38u as=0 ps=0 w=1u l=1u
X3249 VDD VSS.t2938 VDD VDD sg13_lv_pmos ad=0.34p pd=2.68u as=0 ps=0 w=1u l=1u
X3250 VDD VSS.t361 VDD VDD sg13_lv_pmos ad=0.34p pd=2.68u as=0 ps=0 w=1u l=1u
X3251 VDD VSS.t414 VDD VDD sg13_lv_pmos ad=0.19p pd=1.38u as=0 ps=0 w=1u l=1u
X3252 VDD VSS.t1247 VDD VDD sg13_lv_pmos ad=0.19p pd=1.38u as=0 ps=0 w=1u l=1u
X3253 VSS.t1321 VDD VSS.t1322 VSS.t1154 sg13_lv_nmos ad=79.8f pd=0.8u as=0 ps=0 w=0.42u l=1u
X3254 VSS.t1698 VDD VSS.t1697 VSS.t1696 sg13_lv_nmos ad=0.1428p pd=1.52u as=0 ps=0 w=0.42u l=1u
X3255 VDD VSS.t2424 VDD VDD sg13_lv_pmos ad=0.19p pd=1.38u as=0 ps=0 w=1u l=1u
X3256 VSS.t2447 VDD VSS.t2449 VSS.t2448 sg13_lv_nmos ad=79.8f pd=0.8u as=0 ps=0 w=0.42u l=1u
X3257 VDD VSS.t768 VDD VDD sg13_lv_pmos ad=0.34p pd=2.68u as=0 ps=0 w=1u l=1u
X3258 VSS.t724 VDD VSS.t726 VSS.t725 sg13_lv_nmos ad=79.8f pd=0.8u as=0 ps=0 w=0.42u l=1u
X3259 VDD VSS.t1312 VDD VDD sg13_lv_pmos ad=0.34p pd=2.68u as=0 ps=0 w=1u l=1u
X3260 VDD VSS.t2951 VDD VDD sg13_lv_pmos ad=0.19p pd=1.38u as=0 ps=0 w=1u l=1u
X3261 VSS.t2030 VDD VSS.t2032 VSS.t2031 sg13_lv_nmos ad=79.8f pd=0.8u as=0 ps=0 w=0.42u l=1u
X3262 VDD VSS.t1954 VDD VDD sg13_lv_pmos ad=0.34p pd=2.68u as=0 ps=0 w=1u l=1u
X3263 VSS.t191 a_27664_13942# a_27313_13799# VSS.t190 sg13_lv_nmos ad=79.8f pd=0.8u as=0.1428p ps=1.52u w=0.42u l=0.13u
X3264 VSS.t1673 VDD VSS.t1675 VSS.t1674 sg13_lv_nmos ad=79.8f pd=0.8u as=0 ps=0 w=0.42u l=1u
X3265 VSS.t20 VDD VSS.t459 VSS.t458 sg13_lv_nmos ad=0.1428p pd=1.52u as=0 ps=0 w=0.42u l=1u
X3266 VDD VSS.t267 VDD VDD sg13_lv_pmos ad=0.34p pd=2.68u as=0 ps=0 w=1u l=1u
X3267 VDD VSS.t1187 VDD VDD sg13_lv_pmos ad=0.19p pd=1.38u as=0 ps=0 w=1u l=1u
X3268 VSS.t2658 VDD VSS.t2658 VSS.t206 sg13_lv_nmos ad=0.1428p pd=1.52u as=0 ps=0 w=0.42u l=1u
X3269 VDD VSS.t423 VDD VDD sg13_lv_pmos ad=0.19p pd=1.38u as=0 ps=0 w=1u l=1u
X3270 sg13cmos5l_buf_8_2.A a_15579_14854# VDD VDD sg13_lv_pmos ad=0.2128p pd=1.5u as=0.2128p ps=1.5u w=1.12u l=0.13u
X3271 a_6714_12972# sg13cmos5l_xnor2_1_2.B sg13cmos5l_dlygate4sd3_1_0.A VDD sg13_lv_pmos ad=0.1428p pd=1.375u as=0.2408p ps=1.55u w=1.12u l=0.13u
X3272 VDD VSS.t1637 VDD VDD sg13_lv_pmos ad=0.34p pd=2.68u as=0 ps=0 w=1u l=1u
X3273 a_25094_15238# a_24824_15238# VDD VDD sg13_lv_pmos ad=0.34p pd=2.68u as=0.1523p ps=1.38u w=1u l=0.5u
X3274 VDD VSS.t1256 VDD VDD sg13_lv_pmos ad=0.19p pd=1.38u as=0 ps=0 w=1u l=1u
X3275 VDD VSS.t1692 VDD VDD sg13_lv_pmos ad=0.34p pd=2.68u as=0 ps=0 w=1u l=1u
X3276 VSS.t1543 VDD VSS.t1545 VSS.t1544 sg13_lv_nmos ad=79.8f pd=0.8u as=0 ps=0 w=0.42u l=1u
X3277 VSS.t3064 VDD VSS.t3066 VSS.t3065 sg13_lv_nmos ad=79.8f pd=0.8u as=0 ps=0 w=0.42u l=1u
X3278 VSS.t2277 VDD VSS.t2279 VSS.t2278 sg13_lv_nmos ad=79.8f pd=0.8u as=0 ps=0 w=0.42u l=1u
X3279 VDD VSS.t1849 VDD VDD sg13_lv_pmos ad=0.34p pd=2.68u as=0 ps=0 w=1u l=1u
X3280 a_6575_13342# sg13cmos5l_xnor2_1_2.A VSS.t38 VSS.t104 sg13_lv_nmos ad=0.2516p pd=2.16u as=0.1898p ps=1.36u w=0.74u l=0.13u
X3281 a_26244_14909# a_26475_14495# a_25930_14452# VSS.t137 sg13_lv_nmos ad=0.2373p pd=1.97u as=79.8f ps=0.8u w=0.42u l=0.13u
X3282 VDD VSS.t2765 VDD VDD sg13_lv_pmos ad=0.34p pd=2.68u as=0 ps=0 w=1u l=1u
X3283 VSS.t854 VDD VSS.t856 VSS.t855 sg13_lv_nmos ad=79.8f pd=0.8u as=0 ps=0 w=0.42u l=1u
X3284 a_25670_14922# sg13cmos5l_dfrbpq_1_7.D VDD VDD sg13_lv_pmos ad=79.8f pd=0.8u as=0.1428p ps=1.52u w=0.42u l=0.13u
X3285 VSS.t1303 VDD VSS.t1302 VSS.t1154 sg13_lv_nmos ad=0.1428p pd=1.52u as=0 ps=0 w=0.42u l=1u
X3286 VDD VSS.t2381 VDD VDD sg13_lv_pmos ad=0.34p pd=2.68u as=0 ps=0 w=1u l=1u
X3287 VDD VSS.t144 VDD VDD sg13_lv_pmos ad=0.34p pd=2.68u as=0 ps=0 w=1u l=1u
X3288 VDD VSS.t578 VDD VDD sg13_lv_pmos ad=0.34p pd=2.68u as=0 ps=0 w=1u l=1u
X3289 VDD VSS.t923 VDD VDD sg13_lv_pmos ad=0.34p pd=2.68u as=0 ps=0 w=1u l=1u
X3290 VDD VSS.t2617 VDD VDD sg13_lv_pmos ad=0.34p pd=2.68u as=0 ps=0 w=1u l=1u
X3291 VSS.t1860 VDD VSS.t1859 VSS.t1858 sg13_lv_nmos ad=0.1428p pd=1.52u as=0 ps=0 w=0.42u l=1u
X3292 VDD VSS.t1219 VDD VDD sg13_lv_pmos ad=0.19p pd=1.38u as=0 ps=0 w=1u l=1u
X3293 VDD VSS.t2713 VDD VDD sg13_lv_pmos ad=0.19p pd=1.38u as=0 ps=0 w=1u l=1u
X3294 VDD VSS.t1987 VDD VDD sg13_lv_pmos ad=0.19p pd=1.38u as=0 ps=0 w=1u l=1u
X3295 a_24169_14508# sg13cmos5l_or3_1_2.B VSS.t58 VSS.t8 sg13_lv_nmos ad=0.198p pd=1.27u as=0.1045p ps=0.93u w=0.55u l=0.13u
X3296 VSS.t60 VDD VSS.t60 VSS.t715 sg13_lv_nmos ad=0.1428p pd=1.52u as=0 ps=0 w=0.42u l=1u
X3297 VSS.t2402 VDD VSS.t2401 VSS.t2400 sg13_lv_nmos ad=0.1428p pd=1.52u as=0 ps=0 w=0.42u l=1u
X3298 VDD VSS.t861 VDD VDD sg13_lv_pmos ad=0.19p pd=1.38u as=0 ps=0 w=1u l=1u
X3299 VDD VSS.t1487 VDD VDD sg13_lv_pmos ad=0.34p pd=2.68u as=0 ps=0 w=1u l=1u
X3300 VDD VSS.t2341 VDD VDD sg13_lv_pmos ad=0.34p pd=2.68u as=0 ps=0 w=1u l=1u
X3301 VDD VSS.t530 VDD VDD sg13_lv_pmos ad=0.34p pd=2.68u as=0 ps=0 w=1u l=1u
X3302 VSS.t1658 VDD VSS.t1660 VSS.t1659 sg13_lv_nmos ad=79.8f pd=0.8u as=0 ps=0 w=0.42u l=1u
X3303 VSS.t1568 VDD VSS.t1567 VSS.t1566 sg13_lv_nmos ad=0.1428p pd=1.52u as=0 ps=0 w=0.42u l=1u
X3304 a_18106_15960# sg13cmos5l_dlygate4sd3_1_5.A VSS.t11 VSS.t3236 sg13_lv_nmos ad=0.1428p pd=1.52u as=79.8f ps=0.8u w=0.42u l=0.13u
X3305 VDD VSS.t66 VDD VDD sg13_lv_pmos ad=0.19p pd=1.38u as=0 ps=0 w=1u l=1u
X3306 a_6996_13320# sg13cmos5l_xnor2_1_2.B a_6540_13238# VSS.t3189 sg13_lv_nmos ad=78.39999f pd=0.885u as=0.2176p ps=1.96u w=0.64u l=0.13u
X3307 VDD VSS.t823 VDD VDD sg13_lv_pmos ad=0.34p pd=2.68u as=0 ps=0 w=1u l=1u
X3308 VSS.t1029 VDD VSS.t1028 VSS.t1027 sg13_lv_nmos ad=0.1428p pd=1.52u as=0 ps=0 w=0.42u l=1u
X3309 VDD VSS.t1670 VDD VDD sg13_lv_pmos ad=0.19p pd=1.38u as=0 ps=0 w=1u l=1u
X3310 VDD VSS.t611 VDD VDD sg13_lv_pmos ad=0.34p pd=2.68u as=0 ps=0 w=1u l=1u
X3311 VSS.t602 VDD VSS.t605 VSS.t739 sg13_lv_nmos ad=79.8f pd=0.8u as=0 ps=0 w=0.42u l=1u
X3312 sg13cmos5l_buf_1_0.X a_1192_3900# VSS.t207 VSS.t206 sg13_lv_nmos ad=0.2886p pd=2.26u as=0.14875p ps=1.16u w=0.74u l=0.13u
X3313 VSS.t2467 VDD VSS.t2469 VSS.t2468 sg13_lv_nmos ad=79.8f pd=0.8u as=0 ps=0 w=0.42u l=1u
X3314 VDD VSS.t2998 VDD VDD sg13_lv_pmos ad=0.34p pd=2.68u as=0 ps=0 w=1u l=1u
X3315 VDD VSS.t1869 VDD VDD sg13_lv_pmos ad=0.34p pd=2.68u as=0 ps=0 w=1u l=1u
X3316 VDD VSS.t538 VDD VDD sg13_lv_pmos ad=0.19p pd=1.38u as=0 ps=0 w=1u l=1u
X3317 VDD VSS.t2042 VDD VDD sg13_lv_pmos ad=0.19p pd=1.38u as=0 ps=0 w=1u l=1u
X3318 VSS.t1688 VDD VSS.t1687 VSS.t1686 sg13_lv_nmos ad=0.1428p pd=1.52u as=0 ps=0 w=0.42u l=1u
X3319 VDD VSS.t1540 VDD VDD sg13_lv_pmos ad=0.19p pd=1.38u as=0 ps=0 w=1u l=1u
X3320 VSS.t2625 VDD VSS.t2625 VSS.t206 sg13_lv_nmos ad=0.1428p pd=1.52u as=0 ps=0 w=0.42u l=1u
X3321 VDD VSS.t2678 VDD VDD sg13_lv_pmos ad=0.19p pd=1.38u as=0 ps=0 w=1u l=1u
X3322 VSS.t1 a_8582_15238# a_8694_15302# VSS.t116 sg13_lv_nmos ad=0.1426p pd=1.16u as=0.1428p ps=1.52u w=0.42u l=0.5u
X3323 VDD VSS.t876 VDD VDD sg13_lv_pmos ad=0.19p pd=1.38u as=0 ps=0 w=1u l=1u
X3324 VSS.t2984 VDD VSS.t2983 VSS.t2982 sg13_lv_nmos ad=0.1428p pd=1.52u as=0 ps=0 w=0.42u l=1u
X3325 VSS.t1488 VDD VSS.t1490 VSS.t1489 sg13_lv_nmos ad=79.8f pd=0.8u as=0 ps=0 w=0.42u l=1u
X3326 VSS.t611 VDD VSS.t614 VSS.t745 sg13_lv_nmos ad=79.8f pd=0.8u as=0 ps=0 w=0.42u l=1u
X3327 VSS.t769 VDD VSS.t771 VSS.t770 sg13_lv_nmos ad=79.8f pd=0.8u as=0 ps=0 w=0.42u l=1u
X3328 VDD VSS.t2007 VDD VDD sg13_lv_pmos ad=0.19p pd=1.38u as=0 ps=0 w=1u l=1u
X3329 VDD VSS.t813 VDD VDD sg13_lv_pmos ad=0.34p pd=2.68u as=0 ps=0 w=1u l=1u
X3330 VSS.t1237 VDD VSS.t1236 VSS.t1154 sg13_lv_nmos ad=0.1428p pd=1.52u as=0 ps=0 w=0.42u l=1u
X3331 VDD VSS.t626 VDD VDD sg13_lv_pmos ad=0.34p pd=2.68u as=0 ps=0 w=1u l=1u
X3332 VDD VSS.t3113 VDD VDD sg13_lv_pmos ad=0.34p pd=2.68u as=0 ps=0 w=1u l=1u
X3333 VSS.t2624 VDD VSS.t2623 VSS.t206 sg13_lv_nmos ad=0.1428p pd=1.52u as=0 ps=0 w=0.42u l=1u
X3334 a_9158_15234# a_9963_15356# a_9418_15457# VDD sg13_lv_pmos ad=0.1428p pd=1.52u as=79.8f ps=0.8u w=0.42u l=0.13u
X3335 VSS.t76 sg13cmos5l_dfrbpq_1_1.RESET_B a_6180_14922# VSS.t218 sg13_lv_nmos ad=0.1626p pd=1.415u as=60.89999f ps=0.71u w=0.42u l=0.13u
X3336 sg13cmos5l_o21ai_1_2.Y sg13cmos5l_o21ai_1_2.A2 a_23736_14464# VDD sg13_lv_pmos ad=0.2128p pd=1.5u as=0.2128p ps=1.5u w=1.12u l=0.15u
X3337 VDD VSS.t1690 VDD VDD sg13_lv_pmos ad=0.19p pd=1.38u as=0 ps=0 w=1u l=1u
X3338 VDD a_17327_13799# a_17994_14020# VDD sg13_lv_pmos ad=0.2128p pd=1.5u as=0.3864p ps=2.93u w=1.12u l=0.13u
X3339 VSS.t509 VDD VSS.t509 VSS.t513 sg13_lv_nmos ad=79.8f pd=0.8u as=0 ps=0 w=0.42u l=1u
X3340 VDD VSS.t2034 VDD VDD sg13_lv_pmos ad=0.34p pd=2.68u as=0 ps=0 w=1u l=1u
X3341 VSS.t1162 VDD VSS.t1161 VSS.t1154 sg13_lv_nmos ad=0.1428p pd=1.52u as=0 ps=0 w=0.42u l=1u
X3342 VSS.t1194 VDD VSS.t1195 VSS.t1154 sg13_lv_nmos ad=79.8f pd=0.8u as=0 ps=0 w=0.42u l=1u
X3343 a_23858_15242# sg13cmos5l_dfrbpq_1_2.Q VSS.t81 VSS.t57 sg13_lv_nmos ad=0.1406p pd=1.12u as=0.2516p ps=2.16u w=0.74u l=0.13u
X3344 VSS.t2422 VDD VSS.t2421 VSS.t2420 sg13_lv_nmos ad=0.1428p pd=1.52u as=0 ps=0 w=0.42u l=1u
X3345 VSS.t2262 VDD VSS.t2264 VSS.t2263 sg13_lv_nmos ad=79.8f pd=0.8u as=0 ps=0 w=0.42u l=1u
X3346 VDD VSS.t69 VDD VDD sg13_lv_pmos ad=0.34p pd=2.68u as=0 ps=0 w=1u l=1u
X3347 a_7643_15280# sg13cmos5l_dlygate4sd3_1_8.X VSS.t193 VSS.t3186 sg13_lv_nmos ad=78.39999f pd=0.885u as=0.2272p ps=1.99u w=0.64u l=0.13u
X3348 VSS.t784 VDD VSS.t786 VSS.t785 sg13_lv_nmos ad=79.8f pd=0.8u as=0 ps=0 w=0.42u l=1u
X3349 VSS.t1528 VDD VSS.t1530 VSS.t1529 sg13_lv_nmos ad=79.8f pd=0.8u as=0 ps=0 w=0.42u l=1u
X3350 VSS.t1708 VDD VSS.t1707 VSS.t1706 sg13_lv_nmos ad=0.1428p pd=1.52u as=0 ps=0 w=0.42u l=1u
X3351 VSS.t3049 VDD VSS.t3051 VSS.t3050 sg13_lv_nmos ad=79.8f pd=0.8u as=0 ps=0 w=0.42u l=1u
X3352 VDD VSS.t411 VDD VDD sg13_lv_pmos ad=0.19p pd=1.38u as=0 ps=0 w=1u l=1u
X3353 VDD VSS.t1041 VDD VDD sg13_lv_pmos ad=0.19p pd=1.38u as=0 ps=0 w=1u l=1u
X3354 VSS.t854 VDD VSS.t856 VSS.t855 sg13_lv_nmos ad=79.8f pd=0.8u as=0 ps=0 w=0.42u l=1u
X3355 VDD VSS.t843 VDD VDD sg13_lv_pmos ad=0.34p pd=2.68u as=0 ps=0 w=1u l=1u
X3356 VDD VSS.t2670 VDD VDD sg13_lv_pmos ad=0.19p pd=1.38u as=0 ps=0 w=1u l=1u
X3357 VSS.t1920 VDD VSS.t1919 VSS.t1918 sg13_lv_nmos ad=0.1428p pd=1.52u as=0 ps=0 w=0.42u l=1u
X3358 VSS.t246 a_27898_15202# a_27617_15424# VSS.t4 sg13_lv_nmos ad=79.8f pd=0.8u as=0.1428p ps=1.52u w=0.42u l=0.5u
X3359 VDD VSS.t2943 VDD VDD sg13_lv_pmos ad=0.34p pd=2.68u as=0 ps=0 w=1u l=1u
X3360 VSS.t3004 VDD VSS.t3003 VSS.t3002 sg13_lv_nmos ad=0.1428p pd=1.52u as=0 ps=0 w=0.42u l=1u
X3361 VSS.t16 sg13cmos5l_inv_1_0.A sg13cmos5l_inv_1_0.Y VSS.t35 sg13_lv_nmos ad=0.2516p pd=2.16u as=0.2516p ps=2.16u w=0.74u l=0.13u
X3362 VSS.t377 VDD VSS.t377 VSS.t378 sg13_lv_nmos ad=79.8f pd=0.8u as=0 ps=0 w=0.42u l=1u
X3363 VDD VSS.t573 VDD VDD sg13_lv_pmos ad=0.19p pd=1.38u as=0 ps=0 w=1u l=1u
X3364 VDD VSS.t2366 VDD VDD sg13_lv_pmos ad=0.34p pd=2.68u as=0 ps=0 w=1u l=1u
X3365 VSS.t690 VDD VSS.t689 VSS.t688 sg13_lv_nmos ad=0.1428p pd=1.52u as=0 ps=0 w=0.42u l=1u
X3366 VDD VSS.t1485 VDD VDD sg13_lv_pmos ad=0.19p pd=1.38u as=0 ps=0 w=1u l=1u
X3367 VDD VSS.t2394 VDD VDD sg13_lv_pmos ad=0.19p pd=1.38u as=0 ps=0 w=1u l=1u
X3368 VSS.t2452 VDD VSS.t2454 VSS.t2453 sg13_lv_nmos ad=79.8f pd=0.8u as=0 ps=0 w=0.42u l=1u
X3369 VDD a_17806_15423# sg13cmos5l_inv_1_0.A VDD sg13_lv_pmos ad=0.2254p pd=1.53u as=0.4256p ps=3u w=1.12u l=0.13u
X3370 VSS.t289 VDD VSS.t289 VSS.t292 sg13_lv_nmos ad=79.8f pd=0.8u as=0 ps=0 w=0.42u l=1u
X3371 VSS.t551 VDD VSS.t550 VSS.t549 sg13_lv_nmos ad=0.1428p pd=1.52u as=0 ps=0 w=0.42u l=1u
X3372 a_25956_14488# a_26475_14495# a_27215_14845# VSS.t4 sg13_lv_nmos ad=0.3473p pd=2.71u as=0.12665p ps=1.145u w=0.74u l=0.13u
X3373 VDD VSS.t530 VDD VDD sg13_lv_pmos ad=0.34p pd=2.68u as=0 ps=0 w=1u l=1u
X3374 VDD VSS.t906 VDD VDD sg13_lv_pmos ad=0.19p pd=1.38u as=0 ps=0 w=1u l=1u
X3375 VDD VSS.t1208 VDD VDD sg13_lv_pmos ad=0.19p pd=1.38u as=0 ps=0 w=1u l=1u
X3376 VSS.t1171 VDD VSS.t1170 VSS.t1154 sg13_lv_nmos ad=0.1428p pd=1.52u as=0 ps=0 w=0.42u l=1u
X3377 VSS.t1282 VDD VSS.t1282 VSS.t1154 sg13_lv_nmos ad=79.8f pd=0.8u as=0 ps=0 w=0.42u l=1u
X3378 VDD VSS.t1316 VDD VDD sg13_lv_pmos ad=0.34p pd=2.68u as=0 ps=0 w=1u l=1u
X3379 VSS.t1618 VDD VSS.t1620 VSS.t1619 sg13_lv_nmos ad=79.8f pd=0.8u as=0 ps=0 w=0.42u l=1u
X3380 VSS.t2000 VDD VSS.t2002 VSS.t2001 sg13_lv_nmos ad=79.8f pd=0.8u as=0 ps=0 w=0.42u l=1u
X3381 sg13cmos5l_nand3_1_0.Y sg13cmos5l_dlygate4sd3_1_3.A VDD VDD sg13_lv_pmos ad=0.2128p pd=1.5u as=0.3808p ps=2.92u w=1.12u l=0.13u
X3382 VSS.t1212 VDD VSS.t1213 VSS.t1154 sg13_lv_nmos ad=79.8f pd=0.8u as=0 ps=0 w=0.42u l=1u
X3383 VDD VSS.t1306 VDD VDD sg13_lv_pmos ad=0.19p pd=1.38u as=0 ps=0 w=1u l=1u
X3384 VSS.t1503 VDD VSS.t1502 VSS.t1501 sg13_lv_nmos ad=0.1428p pd=1.52u as=0 ps=0 w=0.42u l=1u
X3385 VDD VSS.t2681 VDD VDD sg13_lv_pmos ad=0.34p pd=2.68u as=0 ps=0 w=1u l=1u
X3386 VDD VSS.t66 VDD VDD sg13_lv_pmos ad=0.19p pd=1.38u as=0 ps=0 w=1u l=1u
X3387 a_15876_13722# sg13cmos5l_dfrbpq_1_2.D a_15782_13722# VSS.t3265 sg13_lv_nmos ad=60.89999f pd=0.71u as=0.1428p ps=1.52u w=0.42u l=0.13u
X3388 VSS.t632 VDD VSS.t632 VSS.t633 sg13_lv_nmos ad=79.8f pd=0.8u as=0 ps=0 w=0.42u l=1u
X3389 VSS.t1176 VDD VSS.t1175 VSS.t1154 sg13_lv_nmos ad=0.1428p pd=1.52u as=0 ps=0 w=0.42u l=1u
X3390 VDD VSS.t2019 VDD VDD sg13_lv_pmos ad=0.34p pd=2.68u as=0 ps=0 w=1u l=1u
X3391 VSS.t939 VDD VSS.t941 VSS.t940 sg13_lv_nmos ad=79.8f pd=0.8u as=0 ps=0 w=0.42u l=1u
X3392 VDD VSS.t1662 VDD VDD sg13_lv_pmos ad=0.34p pd=2.68u as=0 ps=0 w=1u l=1u
X3393 VDD VSS.t1854 VDD VDD sg13_lv_pmos ad=0.34p pd=2.68u as=0 ps=0 w=1u l=1u
X3394 VSS.t41 VDD VSS.t76 VSS.t453 sg13_lv_nmos ad=79.8f pd=0.8u as=0 ps=0 w=0.42u l=1u
X3395 VSS.t3034 VDD VSS.t3036 VSS.t3035 sg13_lv_nmos ad=79.8f pd=0.8u as=0 ps=0 w=0.42u l=1u
X3396 VSS.t2247 VDD VSS.t2249 VSS.t2248 sg13_lv_nmos ad=79.8f pd=0.8u as=0 ps=0 w=0.42u l=1u
X3397 VDD VSS.t1525 VDD VDD sg13_lv_pmos ad=0.19p pd=1.38u as=0 ps=0 w=1u l=1u
X3398 VDD VSS.t1702 VDD VDD sg13_lv_pmos ad=0.34p pd=2.68u as=0 ps=0 w=1u l=1u
X3399 VDD VSS.t2768 VDD VDD sg13_lv_pmos ad=0.34p pd=2.68u as=0 ps=0 w=1u l=1u
X3400 VSS.t2322 VDD VSS.t2324 VSS.t2323 sg13_lv_nmos ad=79.8f pd=0.8u as=0 ps=0 w=0.42u l=1u
X3401 VSS.t769 VDD VSS.t771 VSS.t770 sg13_lv_nmos ad=79.8f pd=0.8u as=0 ps=0 w=0.42u l=1u
X3402 VDD VSS.t2386 VDD VDD sg13_lv_pmos ad=0.34p pd=2.68u as=0 ps=0 w=1u l=1u
X3403 VDD VSS.t2044 VDD VDD sg13_lv_pmos ad=0.34p pd=2.68u as=0 ps=0 w=1u l=1u
X3404 VSS.t1473 VDD VSS.t1475 VSS.t1474 sg13_lv_nmos ad=79.8f pd=0.8u as=0 ps=0 w=0.42u l=1u
X3405 a_9732_15247# a_9444_15552# a_9670_15247# VSS.t97 sg13_lv_nmos ad=0.1428p pd=1.52u as=37.8f ps=0.6u w=0.42u l=0.13u
X3406 sg13cmos5l_buf_8_2.A a_15579_14854# VSS.t16 VSS.t3243 sg13_lv_nmos ad=0.1406p pd=1.12u as=0.1406p ps=1.12u w=0.74u l=0.13u
X3407 VSS.t1264 VDD VSS.t1263 VSS.t1154 sg13_lv_nmos ad=0.1428p pd=1.52u as=0 ps=0 w=0.42u l=1u
X3408 VDD VSS.t1222 VDD VDD sg13_lv_pmos ad=0.19p pd=1.38u as=0 ps=0 w=1u l=1u
X3409 VDD VSS.t2716 VDD VDD sg13_lv_pmos ad=0.19p pd=1.38u as=0 ps=0 w=1u l=1u
X3410 VDD VSS.t1992 VDD VDD sg13_lv_pmos ad=0.19p pd=1.38u as=0 ps=0 w=1u l=1u
X3411 a_17604_14488# a_17578_14452# VSS.t16 VSS.t100 sg13_lv_nmos ad=0.2516p pd=2.16u as=0.1626p ps=1.415u w=0.74u l=0.13u
X3412 VDD VSS.t444 VDD VDD sg13_lv_pmos ad=0.19p pd=1.38u as=0 ps=0 w=1u l=1u
X3413 VSS.t2407 VDD VSS.t2406 VSS.t2405 sg13_lv_nmos ad=0.1428p pd=1.52u as=0 ps=0 w=0.42u l=1u
X3414 VDD VSS.t345 VDD VDD sg13_lv_pmos ad=0.34p pd=2.68u as=0 ps=0 w=1u l=1u
X3415 VDD VSS.t1492 VDD VDD sg13_lv_pmos ad=0.34p pd=2.68u as=0 ps=0 w=1u l=1u
X3416 VSS.t2616 VDD VSS.t2615 VSS.t206 sg13_lv_nmos ad=0.1428p pd=1.52u as=0 ps=0 w=0.42u l=1u
X3417 VDD VSS.t2346 VDD VDD sg13_lv_pmos ad=0.34p pd=2.68u as=0 ps=0 w=1u l=1u
X3418 a_16140_15424# sg13cmos5l_or3_1_2.B VDD VDD sg13_lv_pmos ad=0.1596p pd=1.22u as=0.2891p ps=1.695u w=0.84u l=0.13u
X3419 VDD VSS.t314 VDD VDD sg13_lv_pmos ad=0.34p pd=2.68u as=0 ps=0 w=1u l=1u
X3420 VSS.t614 VDD VSS.t611 VSS.t613 sg13_lv_nmos ad=0.1428p pd=1.52u as=0 ps=0 w=0.42u l=1u
X3421 VSS.t1955 VDD VSS.t1954 VSS.t1953 sg13_lv_nmos ad=0.1428p pd=1.52u as=0 ps=0 w=0.42u l=1u
X3422 a_22319_14845# a_21477_14495# a_22225_14845# VSS.t8 sg13_lv_nmos ad=0.12665p pd=1.145u as=0.1428p ps=1.52u w=0.42u l=0.13u
X3423 VSS.t1269 VDD VSS.t1268 VSS.t1154 sg13_lv_nmos ad=0.1428p pd=1.52u as=0 ps=0 w=0.42u l=1u
X3424 VSS.t1538 VDD VSS.t1537 VSS.t1536 sg13_lv_nmos ad=0.1428p pd=1.52u as=0 ps=0 w=0.42u l=1u
X3425 VDD VSS.t1675 VDD VDD sg13_lv_pmos ad=0.19p pd=1.38u as=0 ps=0 w=1u l=1u
X3426 VSS.t369 VDD VSS.t231 VSS.t368 sg13_lv_nmos ad=0.1428p pd=1.52u as=0 ps=0 w=0.42u l=1u
X3427 a_25774_15423# a_25889_15424# VSS.t3 VSS.t36 sg13_lv_nmos ad=0.1428p pd=1.52u as=0.1426p ps=1.16u w=0.42u l=0.5u
X3428 a_19282_14922# sg13cmos5l_dfrbpq_1_3.RESET_B VSS.t171 VSS.t13 sg13_lv_nmos ad=37.8f pd=0.6u as=79.8f ps=0.8u w=0.42u l=0.13u
X3429 VSS.t588 VDD VSS.t588 VSS.t587 sg13_lv_nmos ad=0.1428p pd=1.52u as=0 ps=0 w=0.42u l=1u
X3430 VSS.t2472 VDD VSS.t2474 VSS.t2473 sg13_lv_nmos ad=79.8f pd=0.8u as=0 ps=0 w=0.42u l=1u
X3431 a_8582_15238# a_8312_15238# VDD VDD sg13_lv_pmos ad=0.34p pd=2.68u as=0.1523p ps=1.38u w=1u l=0.5u
X3432 VSS.t784 VDD VSS.t786 VSS.t785 sg13_lv_nmos ad=79.8f pd=0.8u as=0 ps=0 w=0.42u l=1u
X3433 VSS.t1300 VDD VSS.t1301 VSS.t1154 sg13_lv_nmos ad=79.8f pd=0.8u as=0 ps=0 w=0.42u l=1u
X3434 VDD VSS.t1505 VDD VDD sg13_lv_pmos ad=0.19p pd=1.38u as=0 ps=0 w=1u l=1u
X3435 VDD VSS.t2968 VDD VDD sg13_lv_pmos ad=0.34p pd=2.68u as=0 ps=0 w=1u l=1u
X3436 VDD VSS.t1839 VDD VDD sg13_lv_pmos ad=0.34p pd=2.68u as=0 ps=0 w=1u l=1u
X3437 VDD a_4078_14751# sg13cmos5l_xor2_1_0.B VDD sg13_lv_pmos ad=0.2254p pd=1.53u as=0.4256p ps=3u w=1.12u l=0.13u
X3438 VSS.t1693 VDD VSS.t1692 VSS.t1691 sg13_lv_nmos ad=0.1428p pd=1.52u as=0 ps=0 w=0.42u l=1u
X3439 VSS.t450 VDD VSS.t32 VSS.t451 sg13_lv_nmos ad=79.8f pd=0.8u as=0 ps=0 w=0.42u l=1u
X3440 VDD VSS.t2759 VDD VDD sg13_lv_pmos ad=0.34p pd=2.68u as=0 ps=0 w=1u l=1u
X3441 VDD VSS.t2661 VDD VDD sg13_lv_pmos ad=0.19p pd=1.38u as=0 ps=0 w=1u l=1u
X3442 VSS.t1905 VDD VSS.t1904 VSS.t1903 sg13_lv_nmos ad=0.1428p pd=1.52u as=0 ps=0 w=0.42u l=1u
X3443 VDD VSS.t2928 VDD VDD sg13_lv_pmos ad=0.34p pd=2.68u as=0 ps=0 w=1u l=1u
X3444 VSS.t2989 VDD VSS.t2988 VSS.t2987 sg13_lv_nmos ad=0.1428p pd=1.52u as=0 ps=0 w=0.42u l=1u
X3445 VDD a_18586_15455# sg13cmos5l_dfrbpq_1_3.RESET_B VDD sg13_lv_pmos ad=2.8961p pd=18.25u as=0.3927p ps=2.99u w=1.155u l=0.13u
X3446 VSS.t506 VDD VSS.t506 VSS.t507 sg13_lv_nmos ad=0.1428p pd=1.52u as=0 ps=0 w=0.42u l=1u
X3447 VDD VSS.t898 VDD VDD sg13_lv_pmos ad=0.34p pd=2.68u as=0 ps=0 w=1u l=1u
X3448 sg13cmos5l_o21ai_1_3.Y sg13cmos5l_or3_1_1.A a_24310_15230# VSS.t57 sg13_lv_nmos ad=0.2516p pd=2.16u as=0.1406p ps=1.12u w=0.74u l=0.15u
X3449 VSS.t586 VDD VSS.t583 VSS.t710 sg13_lv_nmos ad=0.1428p pd=1.52u as=0 ps=0 w=0.42u l=1u
X3450 VDD VSS.t1166 VDD VDD sg13_lv_pmos ad=0.19p pd=1.38u as=0 ps=0 w=1u l=1u
X3451 VSS.t431 VDD VSS.t432 VSS.t4 sg13_lv_nmos ad=79.8f pd=0.8u as=0 ps=0 w=0.42u l=1u
X3452 VDD VSS.t821 VDD VDD sg13_lv_pmos ad=0.19p pd=1.38u as=0 ps=0 w=1u l=1u
X3453 VDD VSS.t1013 VDD VDD sg13_lv_pmos ad=0.34p pd=2.68u as=0 ps=0 w=1u l=1u
X3454 VSS.t1278 VDD VSS.t1276 VSS.t1154 sg13_lv_nmos ad=0.1428p pd=1.52u as=0 ps=0 w=0.42u l=1u
X3455 VDD VSS.t1470 VDD VDD sg13_lv_pmos ad=0.19p pd=1.38u as=0 ps=0 w=1u l=1u
X3456 VSS.t2437 VDD VSS.t2439 VSS.t2438 sg13_lv_nmos ad=79.8f pd=0.8u as=0 ps=0 w=0.42u l=1u
X3457 VSS.t273 VDD VSS.t273 VSS.t272 sg13_lv_nmos ad=0.1428p pd=1.52u as=0 ps=0 w=0.42u l=1u
X3458 VDD sg13cmos5l_dfrbpq_1_5.RESET_B a_26122_13945# VDD sg13_lv_pmos ad=0.1563p pd=1.22u as=0.147p ps=1.54u w=0.42u l=0.13u
X3459 VSS.t103 sg13cmos5l_xnor2_1_2.A a_6996_13320# VSS.t102 sg13_lv_nmos ad=0.2272p pd=1.99u as=78.39999f ps=0.885u w=0.64u l=0.13u
X3460 VDD VSS.t2379 VDD VDD sg13_lv_pmos ad=0.19p pd=1.38u as=0 ps=0 w=1u l=1u
X3461 VDD VSS.t2708 VDD VDD sg13_lv_pmos ad=0.19p pd=1.38u as=0 ps=0 w=1u l=1u
X3462 VSS.t2267 VDD VSS.t2269 VSS.t2268 sg13_lv_nmos ad=79.8f pd=0.8u as=0 ps=0 w=0.42u l=1u
X3463 VSS.t2392 VDD VSS.t2391 VSS.t2390 sg13_lv_nmos ad=0.1428p pd=1.52u as=0 ps=0 w=0.42u l=1u
X3464 VSS.t1603 VDD VSS.t1605 VSS.t1604 sg13_lv_nmos ad=79.8f pd=0.8u as=0 ps=0 w=0.42u l=1u
X3465 VSS.t2721 VDD VSS.t2722 VSS.t206 sg13_lv_nmos ad=79.8f pd=0.8u as=0 ps=0 w=0.42u l=1u
X3466 VSS.t60 sg13cmos5l_or3_1_1.C a_24841_13726# VSS.t59 sg13_lv_nmos ad=0.1045p pd=0.93u as=0.187p ps=1.78u w=0.55u l=0.13u
X3467 VDD VSS.t191 VDD VDD sg13_lv_pmos ad=0.34p pd=2.68u as=0 ps=0 w=1u l=1u
X3468 VDD VSS.t773 VDD VDD sg13_lv_pmos ad=0.34p pd=2.68u as=0 ps=0 w=1u l=1u
X3469 VSS.t1558 VDD VSS.t1557 VSS.t1556 sg13_lv_nmos ad=0.1428p pd=1.52u as=0 ps=0 w=0.42u l=1u
X3470 VSS.t1488 VDD VSS.t1487 VSS.t1486 sg13_lv_nmos ad=0.1428p pd=1.52u as=0 ps=0 w=0.42u l=1u
X3471 VDD VSS.t1660 VDD VDD sg13_lv_pmos ad=0.19p pd=1.38u as=0 ps=0 w=1u l=1u
X3472 a_37484_15960# sg13cmos5l_dfrbpq_1_5.Q VDD VDD sg13_lv_pmos ad=0.2856p pd=2.36u as=0.2114p ps=1.54u w=0.84u l=0.13u
X3473 VSS.t939 VDD VSS.t941 VSS.t940 sg13_lv_nmos ad=79.8f pd=0.8u as=0 ps=0 w=0.42u l=1u
X3474 VDD VSS.t1221 VDD VDD sg13_lv_pmos ad=0.34p pd=2.68u as=0 ps=0 w=1u l=1u
X3475 VSS.t1314 VDD VSS.t1315 VSS.t1154 sg13_lv_nmos ad=79.8f pd=0.8u as=0 ps=0 w=0.42u l=1u
X3476 VDD VSS.t558 VDD VDD sg13_lv_pmos ad=0.19p pd=1.38u as=0 ps=0 w=1u l=1u
X3477 VDD VSS.t1228 VDD VDD sg13_lv_pmos ad=0.34p pd=2.68u as=0 ps=0 w=1u l=1u
X3478 VDD VSS.t2722 VDD VDD sg13_lv_pmos ad=0.34p pd=2.68u as=0 ps=0 w=1u l=1u
X3479 VDD VSS.t2004 VDD VDD sg13_lv_pmos ad=0.34p pd=2.68u as=0 ps=0 w=1u l=1u
X3480 VSS.t573 VDD VSS.t573 VSS.t572 sg13_lv_nmos ad=0.1428p pd=1.52u as=0 ps=0 w=0.42u l=1u
X3481 VSS.t121 a_14261_15238# sg13cmos5l_or3_1_1.B VSS.t214 sg13_lv_nmos ad=0.2516p pd=2.16u as=0.1406p ps=1.12u w=0.74u l=0.13u
X3482 VSS.t25 VDD VSS.t25 VSS.t461 sg13_lv_nmos ad=0.1428p pd=1.52u as=0 ps=0 w=0.42u l=1u
X3483 VSS.t2232 VDD VSS.t2234 VSS.t2233 sg13_lv_nmos ad=79.8f pd=0.8u as=0 ps=0 w=0.42u l=1u
X3484 VSS.t1925 VDD VSS.t1924 VSS.t1923 sg13_lv_nmos ad=0.1428p pd=1.52u as=0 ps=0 w=0.42u l=1u
X3485 VDD VSS.t626 VDD VDD sg13_lv_pmos ad=0.19p pd=1.38u as=0 ps=0 w=1u l=1u
X3486 VDD VSS.t1687 VDD VDD sg13_lv_pmos ad=0.34p pd=2.68u as=0 ps=0 w=1u l=1u
X3487 VDD VSS.t1258 VDD VDD sg13_lv_pmos ad=0.19p pd=1.38u as=0 ps=0 w=1u l=1u
X3488 VDD VSS.t2913 VDD VDD sg13_lv_pmos ad=0.34p pd=2.68u as=0 ps=0 w=1u l=1u
X3489 VSS.t2487 VDD VSS.t2486 VSS.t2485 sg13_lv_nmos ad=0.1428p pd=1.52u as=0 ps=0 w=0.42u l=1u
X3490 VSS.t2307 VDD VSS.t2309 VSS.t2308 sg13_lv_nmos ad=79.8f pd=0.8u as=0 ps=0 w=0.42u l=1u
X3491 VDD sg13cmos5l_a21oi_1_2.A1 a_24923_15996# VDD sg13_lv_pmos ad=0.2128p pd=1.5u as=0.2128p ps=1.5u w=1.12u l=0.13u
X3492 VDD VSS.t788 VDD VDD sg13_lv_pmos ad=0.34p pd=2.68u as=0 ps=0 w=1u l=1u
X3493 VDD VSS.t976 VDD VDD sg13_lv_pmos ad=0.19p pd=1.38u as=0 ps=0 w=1u l=1u
X3494 VDD VSS.t1552 VDD VDD sg13_lv_pmos ad=0.34p pd=2.68u as=0 ps=0 w=1u l=1u
X3495 VDD VSS.t2371 VDD VDD sg13_lv_pmos ad=0.34p pd=2.68u as=0 ps=0 w=1u l=1u
X3496 VDD VSS.t1490 VDD VDD sg13_lv_pmos ad=0.19p pd=1.38u as=0 ps=0 w=1u l=1u
X3497 VDD VSS.t2399 VDD VDD sg13_lv_pmos ad=0.19p pd=1.38u as=0 ps=0 w=1u l=1u
X3498 VSS.t859 VDD VSS.t861 VSS.t860 sg13_lv_nmos ad=79.8f pd=0.8u as=0 ps=0 w=0.42u l=1u
X3499 VSS.t1588 VDD VSS.t1590 VSS.t1589 sg13_lv_nmos ad=79.8f pd=0.8u as=0 ps=0 w=0.42u l=1u
X3500 VDD VSS.t2687 VDD VDD sg13_lv_pmos ad=0.34p pd=2.68u as=0 ps=0 w=1u l=1u
X3501 VSS.t2005 VDD VSS.t2007 VSS.t2006 sg13_lv_nmos ad=79.8f pd=0.8u as=0 ps=0 w=0.42u l=1u
X3502 a_6372_14488# a_6346_14452# VDD VDD sg13_lv_pmos ad=0.34p pd=2.68u as=0.36237p ps=2.605u w=1u l=0.13u
X3503 VDD VSS.t294 VDD VDD sg13_lv_pmos ad=0.19p pd=1.38u as=0 ps=0 w=1u l=1u
X3504 VDD sg13cmos5l_dfrbpq_1_7.RESET_B a_25930_14452# VDD sg13_lv_pmos ad=0.1563p pd=1.22u as=0.147p ps=1.54u w=0.42u l=0.13u
X3505 VSS.t1296 VDD VSS.t1295 VSS.t1154 sg13_lv_nmos ad=0.1428p pd=1.52u as=0 ps=0 w=0.42u l=1u
X3506 a_4432_15454# sg13cmos5l_dfrbpq_1_0.RESET_B VDD VDD sg13_lv_pmos ad=79.8f pd=0.8u as=2.8961p ps=18.25u w=0.42u l=0.13u
X3507 VDD VSS.t2426 VDD VDD sg13_lv_pmos ad=0.34p pd=2.68u as=0 ps=0 w=1u l=1u
X3508 VSS.t2457 VDD VSS.t2459 VSS.t2458 sg13_lv_nmos ad=79.8f pd=0.8u as=0 ps=0 w=0.42u l=1u
X3509 VSS.t686 VDD VSS.t687 VSS.t684 sg13_lv_nmos ad=79.8f pd=0.8u as=0 ps=0 w=0.42u l=1u
X3510 VDD VSS.t1667 VDD VDD sg13_lv_pmos ad=0.34p pd=2.68u as=0 ps=0 w=1u l=1u
X3511 VDD VSS.t2953 VDD VDD sg13_lv_pmos ad=0.34p pd=2.68u as=0 ps=0 w=1u l=1u
X3512 VSS.t2035 VDD VSS.t2034 VSS.t2033 sg13_lv_nmos ad=0.1428p pd=1.52u as=0 ps=0 w=0.42u l=1u
X3513 VDD VSS.t605 VDD VDD sg13_lv_pmos ad=0.34p pd=2.68u as=0 ps=0 w=1u l=1u
X3514 VSS.t1216 VDD VSS.t1215 VSS.t1154 sg13_lv_nmos ad=0.1428p pd=1.52u as=0 ps=0 w=0.42u l=1u
X3515 VSS.t1518 VDD VSS.t1520 VSS.t1519 sg13_lv_nmos ad=79.8f pd=0.8u as=0 ps=0 w=0.42u l=1u
X3516 VSS.t3039 VDD VSS.t3041 VSS.t3040 sg13_lv_nmos ad=79.8f pd=0.8u as=0 ps=0 w=0.42u l=1u
X3517 VSS.t2252 VDD VSS.t2254 VSS.t2253 sg13_lv_nmos ad=79.8f pd=0.8u as=0 ps=0 w=0.42u l=1u
X3518 a_22576_14726# a_22319_14845# a_22738_14922# VSS.t8 sg13_lv_nmos ad=0.1428p pd=1.52u as=37.8f ps=0.6u w=0.42u l=0.13u
X3519 VDD VSS.t1530 VDD VDD sg13_lv_pmos ad=0.19p pd=1.38u as=0 ps=0 w=1u l=1u
X3520 VSS.t874 VDD VSS.t876 VSS.t875 sg13_lv_nmos ad=79.8f pd=0.8u as=0 ps=0 w=0.42u l=1u
X3521 VDD VSS.t1239 VDD VDD sg13_lv_pmos ad=0.34p pd=2.68u as=0 ps=0 w=1u l=1u
X3522 VDD VSS.t2750 VDD VDD sg13_lv_pmos ad=0.34p pd=2.68u as=0 ps=0 w=1u l=1u
X3523 VDD VSS.t943 VDD VDD sg13_lv_pmos ad=0.34p pd=2.68u as=0 ps=0 w=1u l=1u
X3524 VSS.t2327 VDD VSS.t2329 VSS.t2328 sg13_lv_nmos ad=79.8f pd=0.8u as=0 ps=0 w=0.42u l=1u
X3525 VSS.t814 VDD VSS.t813 VSS.t812 sg13_lv_nmos ad=0.1428p pd=1.52u as=0 ps=0 w=0.42u l=1u
X3526 VDD VSS.t2700 VDD VDD sg13_lv_pmos ad=0.19p pd=1.38u as=0 ps=0 w=1u l=1u
X3527 VSS.t2377 VDD VSS.t2376 VSS.t2375 sg13_lv_nmos ad=0.1428p pd=1.52u as=0 ps=0 w=0.42u l=1u
X3528 VDD VSS.t1497 VDD VDD sg13_lv_pmos ad=0.34p pd=2.68u as=0 ps=0 w=1u l=1u
X3529 VDD VSS.t509 VDD VDD sg13_lv_pmos ad=0.19p pd=1.38u as=0 ps=0 w=1u l=1u
X3530 VDD VSS.t614 VDD VDD sg13_lv_pmos ad=0.34p pd=2.68u as=0 ps=0 w=1u l=1u
X3531 VDD VSS.t1006 VDD VDD sg13_lv_pmos ad=0.19p pd=1.38u as=0 ps=0 w=1u l=1u
X3532 VDD VSS.t2057 VDD VDD sg13_lv_pmos ad=0.19p pd=1.38u as=0 ps=0 w=1u l=1u
X3533 VSS.t1543 VDD VSS.t1542 VSS.t1541 sg13_lv_nmos ad=0.1428p pd=1.52u as=0 ps=0 w=0.42u l=1u
X3534 VDD VSS.t1502 VDD VDD sg13_lv_pmos ad=0.34p pd=2.68u as=0 ps=0 w=1u l=1u
X3535 VSS.t2690 VDD VSS.t2689 VSS.t206 sg13_lv_nmos ad=0.1428p pd=1.52u as=0 ps=0 w=0.42u l=1u
X3536 VDD VSS.t2411 VDD VDD sg13_lv_pmos ad=0.34p pd=2.68u as=0 ps=0 w=1u l=1u
X3537 VSS.t2292 VDD VSS.t2294 VSS.t2293 sg13_lv_nmos ad=79.8f pd=0.8u as=0 ps=0 w=0.42u l=1u
X3538 VSS.t416 VDD VSS.t417 VSS.t4 sg13_lv_nmos ad=79.8f pd=0.8u as=0 ps=0 w=0.42u l=1u
X3539 VDD VSS.t558 VDD VDD sg13_lv_pmos ad=0.19p pd=1.38u as=0 ps=0 w=1u l=1u
X3540 VSS.t551 VDD VSS.t550 VSS.t549 sg13_lv_nmos ad=0.1428p pd=1.52u as=0 ps=0 w=0.42u l=1u
X3541 VSS.t2442 VDD VSS.t2444 VSS.t2443 sg13_lv_nmos ad=79.8f pd=0.8u as=0 ps=0 w=0.42u l=1u
X3542 VSS.t1192 VDD VSS.t1193 VSS.t1154 sg13_lv_nmos ad=79.8f pd=0.8u as=0 ps=0 w=0.42u l=1u
X3543 VSS.t1230 VDD VSS.t1228 VSS.t1154 sg13_lv_nmos ad=0.1428p pd=1.52u as=0 ps=0 w=0.42u l=1u
X3544 VDD VSS.t2973 VDD VDD sg13_lv_pmos ad=0.34p pd=2.68u as=0 ps=0 w=1u l=1u
X3545 VDD VSS.t1844 VDD VDD sg13_lv_pmos ad=0.34p pd=2.68u as=0 ps=0 w=1u l=1u
X3546 VSS.t2020 VDD VSS.t2019 VSS.t2018 sg13_lv_nmos ad=0.1428p pd=1.52u as=0 ps=0 w=0.42u l=1u
X3547 sg13cmos5l_dfrbpq_1_2.CLK a_12010_15202# VDD VDD sg13_lv_pmos ad=0.2128p pd=1.5u as=0.3864p ps=2.93u w=1.12u l=0.13u
X3548 VSS.t844 VDD VSS.t843 VSS.t842 sg13_lv_nmos ad=0.1428p pd=1.52u as=0 ps=0 w=0.42u l=1u
X3549 VDD VSS.t2359 VDD VDD sg13_lv_pmos ad=0.19p pd=1.38u as=0 ps=0 w=1u l=1u
X3550 VDD VSS.t2017 VDD VDD sg13_lv_pmos ad=0.19p pd=1.38u as=0 ps=0 w=1u l=1u
X3551 VSS.t1663 VDD VSS.t1662 VSS.t1661 sg13_lv_nmos ad=0.1428p pd=1.52u as=0 ps=0 w=0.42u l=1u
X3552 VDD VSS.t896 VDD VDD sg13_lv_pmos ad=0.19p pd=1.38u as=0 ps=0 w=1u l=1u
X3553 VSS.t1910 VDD VSS.t1909 VSS.t1908 sg13_lv_nmos ad=0.1428p pd=1.52u as=0 ps=0 w=0.42u l=1u
X3554 VDD VSS.t1286 VDD VDD sg13_lv_pmos ad=0.19p pd=1.38u as=0 ps=0 w=1u l=1u
X3555 VSS.t2994 VDD VSS.t2993 VSS.t2992 sg13_lv_nmos ad=0.1428p pd=1.52u as=0 ps=0 w=0.42u l=1u
X3556 a_9861_15213# sg13cmos5l_dfrbpq_1_2.CLK VSS.t4 VSS.t98 sg13_lv_nmos ad=0.2516p pd=2.16u as=3.8707p ps=25.555u w=0.74u l=0.13u
X3557 VDD VSS.t1021 VDD VDD sg13_lv_pmos ad=0.19p pd=1.38u as=0 ps=0 w=1u l=1u
X3558 VSS.t2472 VDD VSS.t2471 VSS.t2470 sg13_lv_nmos ad=0.1428p pd=1.52u as=0 ps=0 w=0.42u l=1u
X3559 VDD a_15579_14854# sg13cmos5l_buf_8_2.A VDD sg13_lv_pmos ad=0.2128p pd=1.5u as=0.2128p ps=1.5u w=1.12u l=0.13u
X3560 VSS.t611 VDD VSS.t611 VSS.t612 sg13_lv_nmos ad=79.8f pd=0.8u as=0 ps=0 w=0.42u l=1u
X3561 VDD a_22576_14726# a_22521_14607# VDD sg13_lv_pmos ad=2.42015p pd=15.68u as=93.45f ps=0.865u w=0.42u l=0.13u
X3562 VSS.t859 VDD VSS.t861 VSS.t860 sg13_lv_nmos ad=79.8f pd=0.8u as=0 ps=0 w=0.42u l=1u
X3563 VDD VSS.t1475 VDD VDD sg13_lv_pmos ad=0.19p pd=1.38u as=0 ps=0 w=1u l=1u
X3564 VSS.t2762 VDD VSS.t2763 VSS.t206 sg13_lv_nmos ad=79.8f pd=0.8u as=0 ps=0 w=0.42u l=1u
X3565 VDD VSS.t414 VDD VDD sg13_lv_pmos ad=0.19p pd=1.38u as=0 ps=0 w=1u l=1u
X3566 VSS.t904 VDD VSS.t906 VSS.t905 sg13_lv_nmos ad=79.8f pd=0.8u as=0 ps=0 w=0.42u l=1u
X3567 VDD VSS.t2384 VDD VDD sg13_lv_pmos ad=0.19p pd=1.38u as=0 ps=0 w=1u l=1u
X3568 VDD sg13cmos5l_a21oi_1_0.Y a_16856_15238# VDD sg13_lv_pmos ad=0.1523p pd=1.38u as=0.1428p ps=1.52u w=0.42u l=0.13u
X3569 VSS.t2272 VDD VSS.t2274 VSS.t2273 sg13_lv_nmos ad=79.8f pd=0.8u as=0 ps=0 w=0.42u l=1u
X3570 VSS.t468 VDD VSS.t468 VSS.t13 sg13_lv_nmos ad=0.1428p pd=1.52u as=0 ps=0 w=0.42u l=1u
X3571 VDD VSS.t771 VDD VDD sg13_lv_pmos ad=0.19p pd=1.38u as=0 ps=0 w=1u l=1u
X3572 VSS.t1990 VDD VSS.t1992 VSS.t1991 sg13_lv_nmos ad=79.8f pd=0.8u as=0 ps=0 w=0.42u l=1u
X3573 VDD VSS.t445 VDD VDD sg13_lv_pmos ad=0.34p pd=2.68u as=0 ps=0 w=1u l=1u
X3574 VSS.t2724 VDD VSS.t2725 VSS.t206 sg13_lv_nmos ad=79.8f pd=0.8u as=0 ps=0 w=0.42u l=1u
X3575 sg13cmos5l_a21oi_1_3.A1 a_25206_15302# VDD VDD sg13_lv_pmos ad=0.4256p pd=3u as=0.2254p ps=1.53u w=1.12u l=0.13u
X3576 a_6086_14922# sg13cmos5l_and2_1_1.X VDD VDD sg13_lv_pmos ad=79.8f pd=0.8u as=0.1428p ps=1.52u w=0.42u l=0.13u
X3577 a_21034_14452# a_21477_14495# a_21417_14531# VDD sg13_lv_pmos ad=79.8f pd=0.8u as=63f ps=0.72u w=0.42u l=0.13u
X3578 VSS.t216 VDD VSS.t216 VSS.t653 sg13_lv_nmos ad=79.8f pd=0.8u as=0 ps=0 w=0.42u l=1u
X3579 VSS.t1493 VDD VSS.t1492 VSS.t1491 sg13_lv_nmos ad=0.1428p pd=1.52u as=0 ps=0 w=0.42u l=1u
X3580 VDD sg13cmos5l_dfrbpq_1_7.RESET_B a_25670_14922# VDD sg13_lv_pmos ad=0.36237p pd=2.605u as=79.8f ps=0.8u w=0.42u l=0.13u
X3581 VSS.t1174 VDD VSS.t1173 VSS.t1154 sg13_lv_nmos ad=0.1428p pd=1.52u as=0 ps=0 w=0.42u l=1u
X3582 VSS.t66 VDD VSS.t506 VSS.t505 sg13_lv_nmos ad=79.8f pd=0.8u as=0 ps=0 w=0.42u l=1u
X3583 VDD VSS.t1231 VDD VDD sg13_lv_pmos ad=0.34p pd=2.68u as=0 ps=0 w=1u l=1u
X3584 VDD VSS.t2725 VDD VDD sg13_lv_pmos ad=0.34p pd=2.68u as=0 ps=0 w=1u l=1u
X3585 VDD VSS.t2009 VDD VDD sg13_lv_pmos ad=0.34p pd=2.68u as=0 ps=0 w=1u l=1u
X3586 VSS.t699 a_19323_13726# sg13cmos5l_buf_8_2.X VSS.t3252 sg13_lv_nmos ad=0.1406p pd=1.12u as=0.1406p ps=1.12u w=0.74u l=0.13u
X3587 VSS.t874 VDD VSS.t876 VSS.t875 sg13_lv_nmos ad=79.8f pd=0.8u as=0 ps=0 w=0.42u l=1u
X3588 VDD VSS.t423 VDD VDD sg13_lv_pmos ad=0.19p pd=1.38u as=0 ps=0 w=1u l=1u
X3589 VSS.t635 VDD VSS.t635 VSS.t636 sg13_lv_nmos ad=79.8f pd=0.8u as=0 ps=0 w=0.42u l=1u
X3590 VSS.t1503 VDD VSS.t1505 VSS.t1504 sg13_lv_nmos ad=79.8f pd=0.8u as=0 ps=0 w=0.42u l=1u
X3591 VSS.t1683 VDD VSS.t1682 VSS.t1681 sg13_lv_nmos ad=0.1428p pd=1.52u as=0 ps=0 w=0.42u l=1u
X3592 VSS.t3024 VDD VSS.t3026 VSS.t3025 sg13_lv_nmos ad=79.8f pd=0.8u as=0 ps=0 w=0.42u l=1u
X3593 VSS.t2237 VDD VSS.t2239 VSS.t2238 sg13_lv_nmos ad=79.8f pd=0.8u as=0 ps=0 w=0.42u l=1u
X3594 VDD VSS.t361 VDD VDD sg13_lv_pmos ad=0.19p pd=1.38u as=0 ps=0 w=1u l=1u
X3595 a_19065_14607# a_18123_14495# a_18863_14845# VDD sg13_lv_pmos ad=93.45f pd=0.865u as=0.2048p ps=1.63u w=0.42u l=0.13u
X3596 VDD VSS.t1692 VDD VDD sg13_lv_pmos ad=0.34p pd=2.68u as=0 ps=0 w=1u l=1u
X3597 VSS.t2492 VDD VSS.t2491 VSS.t2490 sg13_lv_nmos ad=0.1428p pd=1.52u as=0 ps=0 w=0.42u l=1u
X3598 VSS.t2312 VDD VSS.t2314 VSS.t2313 sg13_lv_nmos ad=79.8f pd=0.8u as=0 ps=0 w=0.42u l=1u
X3599 VSS.t11 sg13cmos5l_dlygate4sd3_1_4.X a_16969_16020# VSS.t3268 sg13_lv_nmos ad=0.13395p pd=1.12u as=0.198p ps=1.27u w=0.55u l=0.13u
X3600 a_2916_15552# a_2890_15457# VSS.t196 VSS.t245 sg13_lv_nmos ad=0.2516p pd=2.16u as=0.1626p ps=1.415u w=0.74u l=0.13u
X3601 VDD VSS.t147 VDD VDD sg13_lv_pmos ad=0.34p pd=2.68u as=0 ps=0 w=1u l=1u
X3602 sg13cmos5l_o21ai_1_2.A2 sg13cmos5l_dfrbpq_1_6.Q VDD VDD sg13_lv_pmos ad=0.3808p pd=2.92u as=0.2128p ps=1.5u w=1.12u l=0.13u
X3603 VSS.t814 VDD VSS.t813 VSS.t812 sg13_lv_nmos ad=0.1428p pd=1.52u as=0 ps=0 w=0.42u l=1u
X3604 VSS.t1248 VDD VSS.t1247 VSS.t1154 sg13_lv_nmos ad=0.1428p pd=1.52u as=0 ps=0 w=0.42u l=1u
X3605 VDD VSS.t3091 VDD VDD sg13_lv_pmos ad=0.19p pd=1.38u as=0 ps=0 w=1u l=1u
X3606 VDD VSS.t1522 VDD VDD sg13_lv_pmos ad=0.34p pd=2.68u as=0 ps=0 w=1u l=1u
X3607 VDD VSS.t1220 VDD VDD sg13_lv_pmos ad=0.19p pd=1.38u as=0 ps=0 w=1u l=1u
X3608 VDD VSS.t926 VDD VDD sg13_lv_pmos ad=0.19p pd=1.38u as=0 ps=0 w=1u l=1u
X3609 VSS.t1593 VDD VSS.t1595 VSS.t1594 sg13_lv_nmos ad=79.8f pd=0.8u as=0 ps=0 w=0.42u l=1u
X3610 VDD VSS.t2670 VDD VDD sg13_lv_pmos ad=0.34p pd=2.68u as=0 ps=0 w=1u l=1u
X3611 VSS.t20 VDD VSS.t22 VSS.t460 sg13_lv_nmos ad=79.8f pd=0.8u as=0 ps=0 w=0.42u l=1u
X3612 VDD VSS.t509 VDD VDD sg13_lv_pmos ad=0.19p pd=1.38u as=0 ps=0 w=1u l=1u
X3613 VSS.t506 VDD VSS.t506 VSS.t507 sg13_lv_nmos ad=0.1428p pd=1.52u as=0 ps=0 w=0.42u l=1u
X3614 VDD VSS.t1482 VDD VDD sg13_lv_pmos ad=0.34p pd=2.68u as=0 ps=0 w=1u l=1u
X3615 VSS.t1188 VDD VSS.t1187 VSS.t1154 sg13_lv_nmos ad=0.1428p pd=1.52u as=0 ps=0 w=0.42u l=1u
X3616 VDD VSS.t1252 VDD VDD sg13_lv_pmos ad=0.19p pd=1.38u as=0 ps=0 w=1u l=1u
X3617 VDD VSS.t2745 VDD VDD sg13_lv_pmos ad=0.19p pd=1.38u as=0 ps=0 w=1u l=1u
X3618 VSS.t352 VDD VSS.t352 VSS.t353 sg13_lv_nmos ad=0.1428p pd=1.52u as=0 ps=0 w=0.42u l=1u
X3619 VDD VSS.t863 VDD VDD sg13_lv_pmos ad=0.34p pd=2.68u as=0 ps=0 w=1u l=1u
X3620 VDD VSS.t1487 VDD VDD sg13_lv_pmos ad=0.34p pd=2.68u as=0 ps=0 w=1u l=1u
X3621 VSS.t2457 VDD VSS.t2456 VSS.t2455 sg13_lv_nmos ad=0.1428p pd=1.52u as=0 ps=0 w=0.42u l=1u
X3622 a_2646_14842# sg13cmos5l_xor2_1_0.B sg13cmos5l_xor2_1_0.X VSS.t194 sg13_lv_nmos ad=88.8f pd=0.98u as=0.1628p ps=1.18u w=0.74u l=0.13u
X3623 VDD VSS.t2396 VDD VDD sg13_lv_pmos ad=0.34p pd=2.68u as=0 ps=0 w=1u l=1u
X3624 VSS.t410 VDD VSS.t411 VSS.t4 sg13_lv_nmos ad=79.8f pd=0.8u as=0 ps=0 w=0.42u l=1u
X3625 VSS.t844 VDD VSS.t843 VSS.t842 sg13_lv_nmos ad=0.1428p pd=1.52u as=0 ps=0 w=0.42u l=1u
X3626 VSS.t1257 VDD VSS.t1256 VSS.t1154 sg13_lv_nmos ad=0.1428p pd=1.52u as=0 ps=0 w=0.42u l=1u
X3627 VSS.t2287 VDD VSS.t2286 VSS.t2285 sg13_lv_nmos ad=0.1428p pd=1.52u as=0 ps=0 w=0.42u l=1u
X3628 VDD VSS.t2958 VDD VDD sg13_lv_pmos ad=0.34p pd=2.68u as=0 ps=0 w=1u l=1u
X3629 VDD VSS.t1829 VDD VDD sg13_lv_pmos ad=0.34p pd=2.68u as=0 ps=0 w=1u l=1u
X3630 VSS.t2005 VDD VSS.t2004 VSS.t2003 sg13_lv_nmos ad=0.1428p pd=1.52u as=0 ps=0 w=0.42u l=1u
X3631 VSS.t372 VDD VSS.t369 VSS.t371 sg13_lv_nmos ad=0.1428p pd=1.52u as=0 ps=0 w=0.42u l=1u
X3632 a_23638_14862# sg13cmos5l_o21ai_1_2.A2 VSS.t81 VSS.t8 sg13_lv_nmos ad=0.1406p pd=1.12u as=0.1406p ps=1.12u w=0.74u l=0.15u
X3633 VSS.t571 VDD VSS.t570 VSS.t569 sg13_lv_nmos ad=0.1428p pd=1.52u as=0 ps=0 w=0.42u l=1u
X3634 a_3273_15625# a_2916_15552# VDD VDD sg13_lv_pmos ad=63f pd=0.72u as=0.1563p ps=1.22u w=0.42u l=0.13u
X3635 VSS.t1014 VDD VSS.t1013 VSS.t1012 sg13_lv_nmos ad=0.1428p pd=1.52u as=0 ps=0 w=0.42u l=1u
X3636 VDD VSS.t2361 VDD VDD sg13_lv_pmos ad=0.34p pd=2.68u as=0 ps=0 w=1u l=1u
X3637 VSS.t904 VDD VSS.t906 VSS.t905 sg13_lv_nmos ad=79.8f pd=0.8u as=0 ps=0 w=0.42u l=1u
X3638 VDD VSS.t1200 VDD VDD sg13_lv_pmos ad=0.34p pd=2.68u as=0 ps=0 w=1u l=1u
X3639 VSS.t1276 VDD VSS.t1275 VSS.t1154 sg13_lv_nmos ad=0.1428p pd=1.52u as=0 ps=0 w=0.42u l=1u
X3640 VDD VSS.t1872 VDD VDD sg13_lv_pmos ad=0.19p pd=1.38u as=0 ps=0 w=1u l=1u
X3641 VDD VSS.t2706 VDD VDD sg13_lv_pmos ad=0.19p pd=1.38u as=0 ps=0 w=1u l=1u
X3642 a_17578_14452# a_18021_14495# a_17961_14531# VDD sg13_lv_pmos ad=79.8f pd=0.8u as=63f ps=0.72u w=0.42u l=0.13u
X3643 VSS.t1553 VDD VSS.t1552 VSS.t1551 sg13_lv_nmos ad=0.1428p pd=1.52u as=0 ps=0 w=0.42u l=1u
X3644 a_9861_15213# sg13cmos5l_dfrbpq_1_2.CLK VDD VDD sg13_lv_pmos ad=0.4088p pd=2.97u as=2.77542p ps=17.49u w=1.12u l=0.13u
X3645 VSS.t2257 VDD VSS.t2259 VSS.t2258 sg13_lv_nmos ad=79.8f pd=0.8u as=0 ps=0 w=0.42u l=1u
X3646 VSS.t713 VDD VSS.t588 VSS.t712 sg13_lv_nmos ad=0.1428p pd=1.52u as=0 ps=0 w=0.42u l=1u
X3647 VSS.t1281 VDD VSS.t1279 VSS.t1154 sg13_lv_nmos ad=0.1428p pd=1.52u as=0 ps=0 w=0.42u l=1u
X3648 VDD VSS.t1467 VDD VDD sg13_lv_pmos ad=0.34p pd=2.68u as=0 ps=0 w=1u l=1u
X3649 VDD VSS.t826 VDD VDD sg13_lv_pmos ad=0.19p pd=1.38u as=0 ps=0 w=1u l=1u
X3650 VSS.t2105 VDD VSS.t2107 VSS.t2106 sg13_lv_nmos ad=79.8f pd=0.8u as=0 ps=0 w=0.42u l=1u
X3651 VDD a_26554_16237# sg13cmos5l_dfrbpq_1_5.RESET_B VDD sg13_lv_pmos ad=2.8961p pd=18.25u as=0.3927p ps=2.99u w=1.155u l=0.13u
X3652 VSS.t1312 VDD VSS.t1312 VSS.t1154 sg13_lv_nmos ad=79.8f pd=0.8u as=0 ps=0 w=0.42u l=1u
X3653 VSS.t1548 VDD VSS.t1547 VSS.t1546 sg13_lv_nmos ad=0.1428p pd=1.52u as=0 ps=0 w=0.42u l=1u
X3654 VSS.t2297 VDD VSS.t2299 VSS.t2298 sg13_lv_nmos ad=79.8f pd=0.8u as=0 ps=0 w=0.42u l=1u
X3655 VDD VSS.t1223 VDD VDD sg13_lv_pmos ad=0.34p pd=2.68u as=0 ps=0 w=1u l=1u
X3656 VDD VSS.t2717 VDD VDD sg13_lv_pmos ad=0.34p pd=2.68u as=0 ps=0 w=1u l=1u
X3657 VSS.t2025 VDD VSS.t2024 VSS.t2023 sg13_lv_nmos ad=0.1428p pd=1.52u as=0 ps=0 w=0.42u l=1u
X3658 VDD VSS.t2022 VDD VDD sg13_lv_pmos ad=0.19p pd=1.38u as=0 ps=0 w=1u l=1u
X3659 VSS.t69 a_7532_15960# counter_value_o[1] VSS.t68 sg13_lv_nmos ad=0.14875p pd=1.16u as=0.2886p ps=2.26u w=0.74u l=0.13u
X3660 VSS.t1668 VDD VSS.t1667 VSS.t1666 sg13_lv_nmos ad=0.1428p pd=1.52u as=0 ps=0 w=0.42u l=1u
X3661 VDD VSS.t563 VDD VDD sg13_lv_pmos ad=0.19p pd=1.38u as=0 ps=0 w=1u l=1u
X3662 VDD VSS.t1178 VDD VDD sg13_lv_pmos ad=0.19p pd=1.38u as=0 ps=0 w=1u l=1u
X3663 VDD VSS.t1033 VDD VDD sg13_lv_pmos ad=0.34p pd=2.68u as=0 ps=0 w=1u l=1u
X3664 VSS.t2477 VDD VSS.t2476 VSS.t2475 sg13_lv_nmos ad=0.1428p pd=1.52u as=0 ps=0 w=0.42u l=1u
X3665 VSS.t283 VDD VSS.t278 VSS.t282 sg13_lv_nmos ad=0.1428p pd=1.52u as=0 ps=0 w=0.42u l=1u
X3666 VSS.t443 VDD VSS.t444 VSS.t4 sg13_lv_nmos ad=79.8f pd=0.8u as=0 ps=0 w=0.42u l=1u
X3667 VDD VSS.t1507 VDD VDD sg13_lv_pmos ad=0.34p pd=2.68u as=0 ps=0 w=1u l=1u
X3668 VDD VSS.t1857 VDD VDD sg13_lv_pmos ad=0.19p pd=1.38u as=0 ps=0 w=1u l=1u
X3669 VSS.t2765 VDD VSS.t2766 VSS.t206 sg13_lv_nmos ad=79.8f pd=0.8u as=0 ps=0 w=0.42u l=1u
X3670 VDD VSS.t2698 VDD VDD sg13_lv_pmos ad=0.19p pd=1.38u as=0 ps=0 w=1u l=1u
X3671 VSS.t1975 VDD VSS.t1974 VSS.t1973 sg13_lv_nmos ad=0.1428p pd=1.52u as=0 ps=0 w=0.42u l=1u
X3672 VDD VSS.t632 VDD VDD sg13_lv_pmos ad=0.34p pd=2.68u as=0 ps=0 w=1u l=1u
X3673 VDD VSS.t793 VDD VDD sg13_lv_pmos ad=0.34p pd=2.68u as=0 ps=0 w=1u l=1u
X3674 VSS.t1578 VDD VSS.t1580 VSS.t1579 sg13_lv_nmos ad=79.8f pd=0.8u as=0 ps=0 w=0.42u l=1u
X3675 VSS.t2708 VDD VSS.t2709 VSS.t206 sg13_lv_nmos ad=79.8f pd=0.8u as=0 ps=0 w=0.42u l=1u
X3676 VSS.t1294 VDD VSS.t1293 VSS.t1154 sg13_lv_nmos ad=0.1428p pd=1.52u as=0 ps=0 w=0.42u l=1u
X3677 VDD VSS.t2449 VDD VDD sg13_lv_pmos ad=0.19p pd=1.38u as=0 ps=0 w=1u l=1u
X3678 VDD a_19054_15423# sg13cmos5l_dlygate4sd3_1_4.X VDD sg13_lv_pmos ad=0.2254p pd=1.53u as=0.4256p ps=3u w=1.12u l=0.13u
X3679 VSS.t401 VDD VSS.t402 VSS.t4 sg13_lv_nmos ad=79.8f pd=0.8u as=0 ps=0 w=0.42u l=1u
X3680 VDD VSS.t908 VDD VDD sg13_lv_pmos ad=0.34p pd=2.68u as=0 ps=0 w=1u l=1u
X3681 VSS.t1498 VDD VSS.t1497 VSS.t1496 sg13_lv_nmos ad=0.1428p pd=1.52u as=0 ps=0 w=0.42u l=1u
X3682 VDD VSS.t2224 VDD VDD sg13_lv_pmos ad=0.19p pd=1.38u as=0 ps=0 w=1u l=1u
X3683 VSS.t2055 VDD VSS.t2057 VSS.t2056 sg13_lv_nmos ad=79.8f pd=0.8u as=0 ps=0 w=0.42u l=1u
X3684 VDD VSS.t1234 VDD VDD sg13_lv_pmos ad=0.34p pd=2.68u as=0 ps=0 w=1u l=1u
X3685 VDD VSS.t2014 VDD VDD sg13_lv_pmos ad=0.34p pd=2.68u as=0 ps=0 w=1u l=1u
X3686 VDD VSS.t2709 VDD VDD sg13_lv_pmos ad=0.34p pd=2.68u as=0 ps=0 w=1u l=1u
X3687 VSS.t2272 VDD VSS.t2271 VSS.t2270 sg13_lv_nmos ad=0.1428p pd=1.52u as=0 ps=0 w=0.42u l=1u
X3688 VSS.t4 a_5687_15315# a_5687_15315# VSS.t3173 sg13_lv_nmos ad=4.11262p pd=27.15u as=0.111p ps=1.34u w=0.3u l=0.13u
X3689 VDD VSS.t846 VDD VDD sg13_lv_pmos ad=0.19p pd=1.38u as=0 ps=0 w=1u l=1u
X3690 VSS.t3029 VDD VSS.t3031 VSS.t3030 sg13_lv_nmos ad=79.8f pd=0.8u as=0 ps=0 w=0.42u l=1u
X3691 VSS.t2650 VDD VSS.t2651 VSS.t206 sg13_lv_nmos ad=79.8f pd=0.8u as=0 ps=0 w=0.42u l=1u
X3692 VSS.t2242 VDD VSS.t2244 VSS.t2243 sg13_lv_nmos ad=79.8f pd=0.8u as=0 ps=0 w=0.42u l=1u
X3693 a_21251_13690# sg13cmos5l_or3_1_2.C VSS.t83 VSS.t3174 sg13_lv_nmos ad=0.187p pd=1.78u as=0.1045p ps=0.93u w=0.55u l=0.13u
X3694 VDD VSS.t1271 VDD VDD sg13_lv_pmos ad=0.19p pd=1.38u as=0 ps=0 w=1u l=1u
X3695 VDD VSS.t808 VDD VDD sg13_lv_pmos ad=0.34p pd=2.68u as=0 ps=0 w=1u l=1u
X3696 VSS.t1014 VDD VSS.t1013 VSS.t1012 sg13_lv_nmos ad=0.1428p pd=1.52u as=0 ps=0 w=0.42u l=1u
X3697 VDD VSS.t1662 VDD VDD sg13_lv_pmos ad=0.34p pd=2.68u as=0 ps=0 w=1u l=1u
X3698 VSS.t596 VDD VSS.t596 VSS.t597 sg13_lv_nmos ad=79.8f pd=0.8u as=0 ps=0 w=0.42u l=1u
X3699 VSS.t1219 VDD VSS.t1220 VSS.t1154 sg13_lv_nmos ad=79.8f pd=0.8u as=0 ps=0 w=0.42u l=1u
X3700 VSS.t294 VDD VSS.t294 VSS.t297 sg13_lv_nmos ad=79.8f pd=0.8u as=0 ps=0 w=0.42u l=1u
X3701 VDD VSS.t1527 VDD VDD sg13_lv_pmos ad=0.34p pd=2.68u as=0 ps=0 w=1u l=1u
X3702 VSS.t1885 VDD VSS.t1887 VSS.t1886 sg13_lv_nmos ad=79.8f pd=0.8u as=0 ps=0 w=0.42u l=1u
X3703 VDD VSS.t2674 VDD VDD sg13_lv_pmos ad=0.34p pd=2.68u as=0 ps=0 w=1u l=1u
X3704 VSS.t1425 VDD VSS.t1306 VSS.t1154 sg13_lv_nmos ad=0.1428p pd=1.52u as=0 ps=0 w=0.42u l=1u
X3705 VDD VSS.t545 VDD VDD sg13_lv_pmos ad=0.34p pd=2.68u as=0 ps=0 w=1u l=1u
X3706 VSS.t819 VDD VSS.t821 VSS.t820 sg13_lv_nmos ad=79.8f pd=0.8u as=0 ps=0 w=0.42u l=1u
X3707 a_9158_15234# sg13cmos5l_and2_1_2.X VDD VDD sg13_lv_pmos ad=79.8f pd=0.8u as=0.1428p ps=1.52u w=0.42u l=0.13u
X3708 VSS.t134 sg13cmos5l_xor2_1_0.X a_2059_14832# VSS.t133 sg13_lv_nmos ad=0.1331p pd=1.12u as=0.1216p ps=1.02u w=0.64u l=0.13u
X3709 VDD VSS.t878 VDD VDD sg13_lv_pmos ad=0.34p pd=2.68u as=0 ps=0 w=1u l=1u
X3710 VDD VSS.t1255 VDD VDD sg13_lv_pmos ad=0.19p pd=1.38u as=0 ps=0 w=1u l=1u
X3711 VSS.t1483 VDD VSS.t1482 VSS.t1481 sg13_lv_nmos ad=0.1428p pd=1.52u as=0 ps=0 w=0.42u l=1u
X3712 VSS.t2090 VDD VSS.t2092 VSS.t2091 sg13_lv_nmos ad=79.8f pd=0.8u as=0 ps=0 w=0.42u l=1u
X3713 VDD VSS.t2047 VDD VDD sg13_lv_pmos ad=0.19p pd=1.38u as=0 ps=0 w=1u l=1u
X3714 VDD VSS.t1492 VDD VDD sg13_lv_pmos ad=0.34p pd=2.68u as=0 ps=0 w=1u l=1u
X3715 VSS.t2462 VDD VSS.t2461 VSS.t2460 sg13_lv_nmos ad=0.1428p pd=1.52u as=0 ps=0 w=0.42u l=1u
X3716 VSS.t153 VDD VSS.t153 VSS.t697 sg13_lv_nmos ad=79.8f pd=0.8u as=0 ps=0 w=0.42u l=1u
X3717 VSS.t2685 VDD VSS.t2684 VSS.t206 sg13_lv_nmos ad=0.1428p pd=1.52u as=0 ps=0 w=0.42u l=1u
X3718 VDD VSS.t2401 VDD VDD sg13_lv_pmos ad=0.34p pd=2.68u as=0 ps=0 w=1u l=1u
X3719 VDD VSS.t617 VDD VDD sg13_lv_pmos ad=0.34p pd=2.68u as=0 ps=0 w=1u l=1u
X3720 VDD VSS.t2963 VDD VDD sg13_lv_pmos ad=0.34p pd=2.68u as=0 ps=0 w=1u l=1u
X3721 a_10222_14751# a_10337_14750# VSS.t144 VSS.t168 sg13_lv_nmos ad=0.1428p pd=1.52u as=0.1426p ps=1.16u w=0.42u l=0.5u
X3722 VSS.t2227 VDD VSS.t2229 VSS.t2228 sg13_lv_nmos ad=79.8f pd=0.8u as=0 ps=0 w=0.42u l=1u
X3723 VSS.t2010 VDD VSS.t2009 VSS.t2008 sg13_lv_nmos ad=0.1428p pd=1.52u as=0 ps=0 w=0.42u l=1u
X3724 VDD VSS.t563 VDD VDD sg13_lv_pmos ad=0.19p pd=1.38u as=0 ps=0 w=1u l=1u
X3725 VDD VSS.t963 VDD VDD sg13_lv_pmos ad=0.34p pd=2.68u as=0 ps=0 w=1u l=1u
X3726 VSS.t1960 VDD VSS.t1962 VSS.t1961 sg13_lv_nmos ad=79.8f pd=0.8u as=0 ps=0 w=0.42u l=1u
X3727 VDD VSS.t1505 VDD VDD sg13_lv_pmos ad=0.19p pd=1.38u as=0 ps=0 w=1u l=1u
X3728 VSS.t2302 VDD VSS.t2304 VSS.t2303 sg13_lv_nmos ad=79.8f pd=0.8u as=0 ps=0 w=0.42u l=1u
X3729 VSS.t66 VDD VSS.t506 VSS.t505 sg13_lv_nmos ad=79.8f pd=0.8u as=0 ps=0 w=0.42u l=1u
X3730 VDD VSS.t2102 VDD VDD sg13_lv_pmos ad=0.19p pd=1.38u as=0 ps=0 w=1u l=1u
X3731 VDD VSS.t231 VDD VDD sg13_lv_pmos ad=0.34p pd=2.68u as=0 ps=0 w=1u l=1u
X3732 a_25037_14020# sg13cmos5l_or3_1_1.B a_24935_14020# VDD sg13_lv_pmos ad=0.1575p pd=1.315u as=0.19p ps=1.38u w=1u l=0.13u
X3733 VDD VSS.t1842 VDD VDD sg13_lv_pmos ad=0.19p pd=1.38u as=0 ps=0 w=1u l=1u
X3734 VSS.t2756 VDD VSS.t2757 VSS.t206 sg13_lv_nmos ad=79.8f pd=0.8u as=0 ps=0 w=0.42u l=1u
X3735 VDD VSS.t2633 VDD VDD sg13_lv_pmos ad=0.19p pd=1.38u as=0 ps=0 w=1u l=1u
X3736 VDD VSS.t327 VDD VDD sg13_lv_pmos ad=0.34p pd=2.68u as=0 ps=0 w=1u l=1u
X3737 VDD VSS.t1289 VDD VDD sg13_lv_pmos ad=0.19p pd=1.38u as=0 ps=0 w=1u l=1u
X3738 VSS.t1523 VDD VSS.t1522 VSS.t1521 sg13_lv_nmos ad=0.1428p pd=1.52u as=0 ps=0 w=0.42u l=1u
X3739 VSS.t3044 VDD VSS.t3043 VSS.t3042 sg13_lv_nmos ad=0.1428p pd=1.52u as=0 ps=0 w=0.42u l=1u
X3740 VSS.t2257 VDD VSS.t2256 VSS.t2255 sg13_lv_nmos ad=0.1428p pd=1.52u as=0 ps=0 w=0.42u l=1u
X3741 a_7262_15242# sg13cmos5l_buf_1_0.X a_7160_15242# VSS.t3198 sg13_lv_nmos ad=0.1406p pd=1.12u as=0.1406p ps=1.12u w=0.74u l=0.13u
X3742 VDD a_26638_15423# sg13cmos5l_o21ai_1_2.B1 VDD sg13_lv_pmos ad=0.2254p pd=1.53u as=0.4256p ps=3u w=1.12u l=0.13u
X3743 VDD a_6682_13690# a_6401_13912# VDD sg13_lv_pmos ad=0.1523p pd=1.38u as=0.34p ps=2.68u w=1u l=0.5u
X3744 VSS.t2728 VDD VSS.t2728 VSS.t206 sg13_lv_nmos ad=0.1428p pd=1.52u as=0 ps=0 w=0.42u l=1u
X3745 VSS.t614 VDD VSS.t614 VSS.t615 sg13_lv_nmos ad=79.8f pd=0.8u as=0 ps=0 w=0.42u l=1u
X3746 VDD VSS.t1026 VDD VDD sg13_lv_pmos ad=0.19p pd=1.38u as=0 ps=0 w=1u l=1u
X3747 VDD sg13cmos5l_inv_1_0.A sg13cmos5l_inv_1_0.Y VDD sg13_lv_pmos ad=0.3808p pd=2.92u as=0.3808p ps=2.92u w=1.12u l=0.13u
X3748 VSS.t369 VDD VSS.t369 VSS.t370 sg13_lv_nmos ad=79.8f pd=0.8u as=0 ps=0 w=0.42u l=1u
X3749 VSS.t428 VDD VSS.t429 VSS.t4 sg13_lv_nmos ad=79.8f pd=0.8u as=0 ps=0 w=0.42u l=1u
X3750 VDD VSS.t683 VDD VDD sg13_lv_pmos ad=0.19p pd=1.38u as=0 ps=0 w=1u l=1u
X3751 VDD VSS.t1645 VDD VDD sg13_lv_pmos ad=0.19p pd=1.38u as=0 ps=0 w=1u l=1u
X3752 VSS.t570 VDD VSS.t571 VSS.t677 sg13_lv_nmos ad=0.1428p pd=1.52u as=0 ps=0 w=0.42u l=1u
X3753 VDD VSS.t1999 VDD VDD sg13_lv_pmos ad=0.34p pd=2.68u as=0 ps=0 w=1u l=1u
X3754 VDD VSS.t216 VDD VDD sg13_lv_pmos ad=0.34p pd=2.68u as=0 ps=0 w=1u l=1u
X3755 VDD VSS.t1297 VDD VDD sg13_lv_pmos ad=0.19p pd=1.38u as=0 ps=0 w=1u l=1u
X3756 VDD a_14261_15238# sg13cmos5l_or3_1_1.B VDD sg13_lv_pmos ad=0.3808p pd=2.92u as=0.2128p ps=1.5u w=1.12u l=0.13u
X3757 a_22738_14922# sg13cmos5l_dfrbpq_1_6.RESET_B VSS.t176 VSS.t8 sg13_lv_nmos ad=37.8f pd=0.6u as=79.8f ps=0.8u w=0.42u l=0.13u
X3758 VSS.t623 VDD VSS.t623 VSS.t624 sg13_lv_nmos ad=79.8f pd=0.8u as=0 ps=0 w=0.42u l=1u
X3759 VDD a_4175_15311# a_4432_15454# VDD sg13_lv_pmos ad=2.8961p pd=18.25u as=79.8f ps=0.8u w=0.42u l=0.13u
X3760 VSS.t1167 VDD VSS.t1329 VSS.t1154 sg13_lv_nmos ad=0.1428p pd=1.52u as=0 ps=0 w=0.42u l=1u
X3761 VSS.t1278 VDD VSS.t1279 VSS.t1154 sg13_lv_nmos ad=79.8f pd=0.8u as=0 ps=0 w=0.42u l=1u
X3762 VDD VSS.t2264 VDD VDD sg13_lv_pmos ad=0.19p pd=1.38u as=0 ps=0 w=1u l=1u
X3763 VSS.t2447 VDD VSS.t2446 VSS.t2445 sg13_lv_nmos ad=0.1428p pd=1.52u as=0 ps=0 w=0.42u l=1u
X3764 a_26565_13701# sg13cmos5l_buf_8_2.X VDD VDD sg13_lv_pmos ad=0.4088p pd=2.97u as=2.3367p ps=15.135u w=1.12u l=0.13u
X3765 VSS.t924 VDD VSS.t926 VSS.t925 sg13_lv_nmos ad=79.8f pd=0.8u as=0 ps=0 w=0.42u l=1u
X3766 VDD VSS.t1512 VDD VDD sg13_lv_pmos ad=0.34p pd=2.68u as=0 ps=0 w=1u l=1u
X3767 sg13cmos5l_buf_8_2.X a_19323_13726# VSS.t153 VSS.t3247 sg13_lv_nmos ad=0.1406p pd=1.12u as=0.1406p ps=1.12u w=0.74u l=0.13u
X3768 VDD VSS.t993 VDD VDD sg13_lv_pmos ad=0.34p pd=2.68u as=0 ps=0 w=1u l=1u
X3769 VSS.t2746 VDD VSS.t2748 VSS.t206 sg13_lv_nmos ad=79.8f pd=0.8u as=0 ps=0 w=0.42u l=1u
X3770 VDD VSS.t273 VDD VDD sg13_lv_pmos ad=0.34p pd=2.68u as=0 ps=0 w=1u l=1u
X3771 sg13cmos5l_or3_1_1.B a_14261_15238# VSS.t121 VSS.t211 sg13_lv_nmos ad=0.1406p pd=1.12u as=0.3293p ps=1.63u w=0.74u l=0.13u
X3772 VSS.t1870 VDD VSS.t1872 VSS.t1871 sg13_lv_nmos ad=79.8f pd=0.8u as=0 ps=0 w=0.42u l=1u
X3773 VSS.t410 VDD VSS.t409 VSS.t4 sg13_lv_nmos ad=0.1428p pd=1.52u as=0 ps=0 w=0.42u l=1u
X3774 VSS.t819 VDD VSS.t821 VSS.t820 sg13_lv_nmos ad=79.8f pd=0.8u as=0 ps=0 w=0.42u l=1u
X3775 VDD VSS.t1552 VDD VDD sg13_lv_pmos ad=0.34p pd=2.68u as=0 ps=0 w=1u l=1u
X3776 VDD VSS.t545 VDD VDD sg13_lv_pmos ad=0.34p pd=2.68u as=0 ps=0 w=1u l=1u
X3777 VSS.t1583 VDD VSS.t1585 VSS.t1584 sg13_lv_nmos ad=79.8f pd=0.8u as=0 ps=0 w=0.42u l=1u
X3778 VSS.t2711 VDD VSS.t2712 VSS.t206 sg13_lv_nmos ad=79.8f pd=0.8u as=0 ps=0 w=0.42u l=1u
X3779 VSS.t1468 VDD VSS.t1467 VSS.t1466 sg13_lv_nmos ad=0.1428p pd=1.52u as=0 ps=0 w=0.42u l=1u
X3780 a_12524_15960# sg13cmos5l_dlygate4sd3_1_8.A VDD VDD sg13_lv_pmos ad=0.2856p pd=2.36u as=0.2114p ps=1.54u w=0.84u l=0.13u
X3781 VDD VSS.t1246 VDD VDD sg13_lv_pmos ad=0.19p pd=1.38u as=0 ps=0 w=1u l=1u
X3782 VSS.t2060 VDD VSS.t2062 VSS.t2061 sg13_lv_nmos ad=79.8f pd=0.8u as=0 ps=0 w=0.42u l=1u
X3783 a_17529_14037# a_16587_13844# a_17327_13799# VDD sg13_lv_pmos ad=93.45f pd=0.865u as=0.2048p ps=1.63u w=0.42u l=0.13u
X3784 VDD VSS.t1217 VDD VDD sg13_lv_pmos ad=0.34p pd=2.68u as=0 ps=0 w=1u l=1u
X3785 VDD VSS.t2712 VDD VDD sg13_lv_pmos ad=0.34p pd=2.68u as=0 ps=0 w=1u l=1u
X3786 VSS.t2277 VDD VSS.t2276 VSS.t2275 sg13_lv_nmos ad=0.1428p pd=1.52u as=0 ps=0 w=0.42u l=1u
X3787 VDD VSS.t1984 VDD VDD sg13_lv_pmos ad=0.34p pd=2.68u as=0 ps=0 w=1u l=1u
X3788 VSS.t356 VDD VSS.t352 VSS.t355 sg13_lv_nmos ad=0.1428p pd=1.52u as=0 ps=0 w=0.42u l=1u
X3789 VDD VSS.t576 VDD VDD sg13_lv_pmos ad=0.19p pd=1.38u as=0 ps=0 w=1u l=1u
X3790 VSS.t2727 VDD VSS.t2725 VSS.t206 sg13_lv_nmos ad=0.1428p pd=1.52u as=0 ps=0 w=0.42u l=1u
X3791 VSS.t51 a_10703_15311# a_11370_15532# VSS.t3238 sg13_lv_nmos ad=0.1406p pd=1.12u as=0.2516p ps=2.16u w=0.74u l=0.13u
X3792 a_18789_15277# a_18789_15277# VSS.t4 VSS.t107 sg13_lv_nmos ad=0.111p pd=1.34u as=4.11262p ps=27.15u w=0.3u l=0.13u
X3793 VSS.t605 VDD VSS.t602 VSS.t604 sg13_lv_nmos ad=0.1428p pd=1.52u as=0 ps=0 w=0.42u l=1u
X3794 VDD VSS.t1902 VDD VDD sg13_lv_pmos ad=0.19p pd=1.38u as=0 ps=0 w=1u l=1u
X3795 VSS.t1945 VDD VSS.t1947 VSS.t1946 sg13_lv_nmos ad=79.8f pd=0.8u as=0 ps=0 w=0.42u l=1u
X3796 VSS.t413 VDD VSS.t414 VSS.t4 sg13_lv_nmos ad=79.8f pd=0.8u as=0 ps=0 w=0.42u l=1u
X3797 VSS.t1260 VDD VSS.t1258 VSS.t1154 sg13_lv_nmos ad=0.1428p pd=1.52u as=0 ps=0 w=0.42u l=1u
X3798 VDD VSS.t1667 VDD VDD sg13_lv_pmos ad=0.34p pd=2.68u as=0 ps=0 w=1u l=1u
X3799 a_6346_14452# a_6789_14495# a_6086_14922# VSS.t53 sg13_lv_nmos ad=79.8f pd=0.8u as=0.1296p ps=1.52u w=0.42u l=0.13u
X3800 VDD VSS.t2249 VDD VDD sg13_lv_pmos ad=0.19p pd=1.38u as=0 ps=0 w=1u l=1u
X3801 VSS.t2467 VDD VSS.t2466 VSS.t2465 sg13_lv_nmos ad=0.1428p pd=1.52u as=0 ps=0 w=0.42u l=1u
X3802 VSS.t2287 VDD VSS.t2289 VSS.t2288 sg13_lv_nmos ad=79.8f pd=0.8u as=0 ps=0 w=0.42u l=1u
X3803 VDD VSS.t2087 VDD VDD sg13_lv_pmos ad=0.19p pd=1.38u as=0 ps=0 w=1u l=1u
X3804 VDD VSS.t2039 VDD VDD sg13_lv_pmos ad=0.34p pd=2.68u as=0 ps=0 w=1u l=1u
X3805 VSS.t1855 VDD VSS.t1857 VSS.t1856 sg13_lv_nmos ad=79.8f pd=0.8u as=0 ps=0 w=0.42u l=1u
X3806 VDD VSS.t3161 VDD VDD sg13_lv_pmos ad=0.19p pd=1.38u as=0 ps=0 w=1u l=1u
X3807 VDD VSS.t2677 VDD VDD sg13_lv_pmos ad=0.34p pd=2.68u as=0 ps=0 w=1u l=1u
X3808 VSS.t2720 VDD VSS.t2719 VSS.t206 sg13_lv_nmos ad=0.1428p pd=1.52u as=0 ps=0 w=0.42u l=1u
X3809 VSS.t66 VDD VSS.t66 VSS.t500 sg13_lv_nmos ad=0.1428p pd=1.52u as=0 ps=0 w=0.42u l=1u
X3810 VDD VSS.t883 VDD VDD sg13_lv_pmos ad=0.34p pd=2.68u as=0 ps=0 w=1u l=1u
X3811 VSS.t704 VDD VSS.t83 VSS.t703 sg13_lv_nmos ad=0.1428p pd=1.52u as=0 ps=0 w=0.42u l=1u
X3812 VSS.t2095 VDD VSS.t2097 VSS.t2096 sg13_lv_nmos ad=79.8f pd=0.8u as=0 ps=0 w=0.42u l=1u
X3813 VSS.t422 VDD VSS.t423 VSS.t4 sg13_lv_nmos ad=79.8f pd=0.8u as=0 ps=0 w=0.42u l=1u
X3814 VDD VSS.t1497 VDD VDD sg13_lv_pmos ad=0.34p pd=2.68u as=0 ps=0 w=1u l=1u
X3815 VDD VSS.t2406 VDD VDD sg13_lv_pmos ad=0.34p pd=2.68u as=0 ps=0 w=1u l=1u
X3816 VDD a_17126_15238# a_17238_15302# VDD sg13_lv_pmos ad=0.2254p pd=1.53u as=0.34p ps=2.68u w=1u l=0.5u
X3817 sg13cmos5l_dlygate4sd3_1_3.A a_4842_15532# VDD VDD sg13_lv_pmos ad=0.3808p pd=2.92u as=0.2128p ps=1.5u w=1.12u l=0.13u
X3818 VSS.t1598 VDD VSS.t1597 VSS.t1596 sg13_lv_nmos ad=0.1428p pd=1.52u as=0 ps=0 w=0.42u l=1u
X3819 VDD VSS.t2354 VDD VDD sg13_lv_pmos ad=0.19p pd=1.38u as=0 ps=0 w=1u l=1u
X3820 VSS.t2015 VDD VSS.t2014 VSS.t2013 sg13_lv_nmos ad=0.1428p pd=1.52u as=0 ps=0 w=0.42u l=1u
X3821 VSS.t2718 VDD VSS.t2718 VSS.t206 sg13_lv_nmos ad=0.1428p pd=1.52u as=0 ps=0 w=0.42u l=1u
X3822 VSS.t894 VDD VSS.t896 VSS.t895 sg13_lv_nmos ad=79.8f pd=0.8u as=0 ps=0 w=0.42u l=1u
X3823 VSS.t924 VDD VSS.t926 VSS.t925 sg13_lv_nmos ad=79.8f pd=0.8u as=0 ps=0 w=0.42u l=1u
X3824 VDD VSS.t1212 VDD VDD sg13_lv_pmos ad=0.34p pd=2.68u as=0 ps=0 w=1u l=1u
X3825 VDD VSS.t196 VDD VDD sg13_lv_pmos ad=0.34p pd=2.68u as=0 ps=0 w=1u l=1u
X3826 a_7631_14845# a_6789_14495# a_6372_14488# VDD sg13_lv_pmos ad=0.2048p pd=1.63u as=0.34p ps=2.68u w=1u l=0.13u
X3827 VDD VSS.t2072 VDD VDD sg13_lv_pmos ad=0.19p pd=1.38u as=0 ps=0 w=1u l=1u
X3828 sg13cmos5l_buf_8_2.X a_19323_13726# VSS.t699 VSS.t3253 sg13_lv_nmos ad=0.1406p pd=1.12u as=0.1406p ps=1.12u w=0.74u l=0.13u
X3829 VDD VSS.t1847 VDD VDD sg13_lv_pmos ad=0.19p pd=1.38u as=0 ps=0 w=1u l=1u
X3830 VDD VSS.t2636 VDD VDD sg13_lv_pmos ad=0.19p pd=1.38u as=0 ps=0 w=1u l=1u
X3831 VDD VSS.t2693 VDD VDD sg13_lv_pmos ad=0.19p pd=1.38u as=0 ps=0 w=1u l=1u
X3832 VSS.t1890 VDD VSS.t1892 VSS.t1891 sg13_lv_nmos ad=79.8f pd=0.8u as=0 ps=0 w=0.42u l=1u
X3833 VSS.t1528 VDD VSS.t1527 VSS.t1526 sg13_lv_nmos ad=0.1428p pd=1.52u as=0 ps=0 w=0.42u l=1u
X3834 VSS.t3049 VDD VSS.t3048 VSS.t3047 sg13_lv_nmos ad=0.1428p pd=1.52u as=0 ps=0 w=0.42u l=1u
X3835 VSS.t2262 VDD VSS.t2261 VSS.t2260 sg13_lv_nmos ad=0.1428p pd=1.52u as=0 ps=0 w=0.42u l=1u
X3836 VSS.t2432 VDD VSS.t2434 VSS.t2433 sg13_lv_nmos ad=79.8f pd=0.8u as=0 ps=0 w=0.42u l=1u
X3837 VDD VSS.t110 VDD VDD sg13_lv_pmos ad=0.34p pd=2.68u as=0 ps=0 w=1u l=1u
X3838 VDD VSS.t1250 VDD VDD sg13_lv_pmos ad=0.19p pd=1.38u as=0 ps=0 w=1u l=1u
X3839 VSS.t2337 VDD VSS.t2336 VSS.t2335 sg13_lv_nmos ad=0.1428p pd=1.52u as=0 ps=0 w=0.42u l=1u
X3840 VSS.t2702 VDD VSS.t2703 VSS.t206 sg13_lv_nmos ad=79.8f pd=0.8u as=0 ps=0 w=0.42u l=1u
X3841 VDD VSS.t2439 VDD VDD sg13_lv_pmos ad=0.19p pd=1.38u as=0 ps=0 w=1u l=1u
X3842 VSS.t89 a_21166_16263# sg13cmos5l_dfrbpq_1_6.D VSS.t88 sg13_lv_nmos ad=0.1426p pd=1.16u as=0.2516p ps=2.16u w=0.74u l=0.13u
X3843 VSS.t1198 VDD VSS.t1199 VSS.t1154 sg13_lv_nmos ad=79.8f pd=0.8u as=0 ps=0 w=0.42u l=1u
X3844 counter_value_o[3] a_16552_15996# VDD VDD sg13_lv_pmos ad=0.42p pd=2.99u as=0.2114p ps=1.54u w=1.12u l=0.13u
X3845 a_25786_15960# sg13cmos5l_o21ai_1_3.Y VSS.t163 VSS.t226 sg13_lv_nmos ad=0.1428p pd=1.52u as=79.8f ps=0.8u w=0.42u l=0.13u
X3846 VDD VSS.t599 VDD VDD sg13_lv_pmos ad=0.19p pd=1.38u as=0 ps=0 w=1u l=1u
X3847 VSS.t2045 VDD VSS.t2047 VSS.t2046 sg13_lv_nmos ad=79.8f pd=0.8u as=0 ps=0 w=0.42u l=1u
X3848 VDD sg13cmos5l_o21ai_1_2.B1 sg13cmos5l_o21ai_1_2.Y VDD sg13_lv_pmos ad=0.3808p pd=2.92u as=0.2128p ps=1.5u w=1.12u l=0.15u
X3849 VDD VSS.t1208 VDD VDD sg13_lv_pmos ad=0.34p pd=2.68u as=0 ps=0 w=1u l=1u
X3850 VDD VSS.t2703 VDD VDD sg13_lv_pmos ad=0.34p pd=2.68u as=0 ps=0 w=1u l=1u
X3851 VSS.t2000 VDD VSS.t1999 VSS.t1998 sg13_lv_nmos ad=0.1428p pd=1.52u as=0 ps=0 w=0.42u l=1u
X3852 VSS.t2643 VDD VSS.t2645 VSS.t206 sg13_lv_nmos ad=79.8f pd=0.8u as=0 ps=0 w=0.42u l=1u
X3853 VDD a_18202_15202# a_17921_15424# VDD sg13_lv_pmos ad=0.1523p pd=1.38u as=0.34p ps=2.68u w=1u l=0.5u
X3854 VSS.t1287 VDD VSS.t1286 VSS.t1154 sg13_lv_nmos ad=0.1428p pd=1.52u as=0 ps=0 w=0.42u l=1u
X3855 VDD VSS.t2064 VDD VDD sg13_lv_pmos ad=0.34p pd=2.68u as=0 ps=0 w=1u l=1u
X3856 VSS.t315 VDD VSS.t317 VSS.t316 sg13_lv_nmos ad=79.8f pd=0.8u as=0 ps=0 w=0.42u l=1u
X3857 VDD VSS.t1265 VDD VDD sg13_lv_pmos ad=0.34p pd=2.68u as=0 ps=0 w=1u l=1u
X3858 VDD VSS.t2758 VDD VDD sg13_lv_pmos ad=0.34p pd=2.68u as=0 ps=0 w=1u l=1u
X3859 VSS.t2452 VDD VSS.t2451 VSS.t2450 sg13_lv_nmos ad=0.1428p pd=1.52u as=0 ps=0 w=0.42u l=1u
X3860 VDD VSS.t1517 VDD VDD sg13_lv_pmos ad=0.34p pd=2.68u as=0 ps=0 w=1u l=1u
X3861 VDD VSS.t2234 VDD VDD sg13_lv_pmos ad=0.19p pd=1.38u as=0 ps=0 w=1u l=1u
X3862 VSS.t2750 VDD VSS.t2751 VSS.t206 sg13_lv_nmos ad=79.8f pd=0.8u as=0 ps=0 w=0.42u l=1u
X3863 VDD VSS.t2024 VDD VDD sg13_lv_pmos ad=0.34p pd=2.68u as=0 ps=0 w=1u l=1u
X3864 VSS.t1840 VDD VSS.t1842 VSS.t1841 sg13_lv_nmos ad=79.8f pd=0.8u as=0 ps=0 w=0.42u l=1u
X3865 VDD VSS.t791 VDD VDD sg13_lv_pmos ad=0.19p pd=1.38u as=0 ps=0 w=1u l=1u
X3866 VDD VSS.t1522 VDD VDD sg13_lv_pmos ad=0.34p pd=2.68u as=0 ps=0 w=1u l=1u
X3867 VDD VSS.t3146 VDD VDD sg13_lv_pmos ad=0.19p pd=1.38u as=0 ps=0 w=1u l=1u
X3868 VDD VSS.t2668 VDD VDD sg13_lv_pmos ad=0.34p pd=2.68u as=0 ps=0 w=1u l=1u
X3869 VSS.t879 VDD VSS.t878 VSS.t877 sg13_lv_nmos ad=0.1428p pd=1.52u as=0 ps=0 w=0.42u l=1u
X3870 a_26148_14040# a_26667_13844# a_27407_13799# VSS.t62 sg13_lv_nmos ad=0.3473p pd=2.71u as=0.12665p ps=1.145u w=0.74u l=0.13u
X3871 VSS.t2768 VDD VSS.t2767 VSS.t206 sg13_lv_nmos ad=0.1428p pd=1.52u as=0 ps=0 w=0.42u l=1u
X3872 VDD VSS.t1482 VDD VDD sg13_lv_pmos ad=0.34p pd=2.68u as=0 ps=0 w=1u l=1u
X3873 VDD VSS.t2391 VDD VDD sg13_lv_pmos ad=0.34p pd=2.68u as=0 ps=0 w=1u l=1u
X3874 VSS.t2282 VDD VSS.t2281 VSS.t2280 sg13_lv_nmos ad=0.1428p pd=1.52u as=0 ps=0 w=0.42u l=1u
X3875 VSS.t894 VDD VSS.t896 VSS.t895 sg13_lv_nmos ad=79.8f pd=0.8u as=0 ps=0 w=0.42u l=1u
X3876 VDD VSS.t66 VDD VDD sg13_lv_pmos ad=0.19p pd=1.38u as=0 ps=0 w=1u l=1u
X3877 VDD VSS.t1907 VDD VDD sg13_lv_pmos ad=0.19p pd=1.38u as=0 ps=0 w=1u l=1u
X3878 VSS.t2711 VDD VSS.t2710 VSS.t206 sg13_lv_nmos ad=0.1428p pd=1.52u as=0 ps=0 w=0.42u l=1u
X3879 VSS.t1950 VDD VSS.t1952 VSS.t1951 sg13_lv_nmos ad=79.8f pd=0.8u as=0 ps=0 w=0.42u l=1u
X3880 VDD VSS.t806 VDD VDD sg13_lv_pmos ad=0.19p pd=1.38u as=0 ps=0 w=1u l=1u
X3881 VSS.t1231 VDD VSS.t1231 VSS.t1154 sg13_lv_nmos ad=79.8f pd=0.8u as=0 ps=0 w=0.42u l=1u
X3882 VDD VSS.t2226 VDD VDD sg13_lv_pmos ad=0.34p pd=2.68u as=0 ps=0 w=1u l=1u
X3883 VDD VSS.t349 VDD VDD sg13_lv_pmos ad=0.34p pd=2.68u as=0 ps=0 w=1u l=1u
X3884 VSS.t1195 VDD VSS.t1194 VSS.t1154 sg13_lv_nmos ad=0.1428p pd=1.52u as=0 ps=0 w=0.42u l=1u
X3885 VDD VSS.t2627 VDD VDD sg13_lv_pmos ad=0.19p pd=1.38u as=0 ps=0 w=1u l=1u
X3886 VDD VSS.t386 VDD VDD sg13_lv_pmos ad=0.34p pd=2.68u as=0 ps=0 w=1u l=1u
X3887 VSS.t1513 VDD VSS.t1512 VSS.t1511 sg13_lv_nmos ad=0.1428p pd=1.52u as=0 ps=0 w=0.42u l=1u
X3888 VSS.t3034 VDD VSS.t3033 VSS.t3032 sg13_lv_nmos ad=0.1428p pd=1.52u as=0 ps=0 w=0.42u l=1u
X3889 VSS.t2247 VDD VSS.t2246 VSS.t2245 sg13_lv_nmos ad=0.1428p pd=1.52u as=0 ps=0 w=0.42u l=1u
X3890 VSS.t1860 VDD VSS.t1862 VSS.t1861 sg13_lv_nmos ad=79.8f pd=0.8u as=0 ps=0 w=0.42u l=1u
X3891 VSS.t187 a_27407_13799# a_28074_14020# VSS.t203 sg13_lv_nmos ad=0.1406p pd=1.12u as=0.2516p ps=2.16u w=0.74u l=0.13u
X3892 VSS.t1156 VDD VSS.t1157 VSS.t1154 sg13_lv_nmos ad=79.8f pd=0.8u as=0 ps=0 w=0.42u l=1u
X3893 VSS.t352 VDD VSS.t352 VSS.t354 sg13_lv_nmos ad=79.8f pd=0.8u as=0 ps=0 w=0.42u l=1u
X3894 VSS.t193 sg13cmos5l_dlygate4sd3_1_8.X a_7829_15238# VSS.t3187 sg13_lv_nmos ad=0.1898p pd=1.36u as=0.2516p ps=2.16u w=0.74u l=0.13u
X3895 VDD VSS.t1240 VDD VDD sg13_lv_pmos ad=0.19p pd=1.38u as=0 ps=0 w=1u l=1u
X3896 VDD VSS.t2733 VDD VDD sg13_lv_pmos ad=0.19p pd=1.38u as=0 ps=0 w=1u l=1u
X3897 VDD VSS.t629 VDD VDD sg13_lv_pmos ad=0.34p pd=2.68u as=0 ps=0 w=1u l=1u
X3898 VDD VSS.t1467 VDD VDD sg13_lv_pmos ad=0.34p pd=2.68u as=0 ps=0 w=1u l=1u
X3899 VSS.t2658 VDD VSS.t2660 VSS.t206 sg13_lv_nmos ad=79.8f pd=0.8u as=0 ps=0 w=0.42u l=1u
X3900 VDD VSS.t2376 VDD VDD sg13_lv_pmos ad=0.34p pd=2.68u as=0 ps=0 w=1u l=1u
X3901 VSS.t2437 VDD VSS.t2436 VSS.t2435 sg13_lv_nmos ad=0.1428p pd=1.52u as=0 ps=0 w=0.42u l=1u
X3902 VDD VSS.t408 VDD VDD sg13_lv_pmos ad=0.19p pd=1.38u as=0 ps=0 w=1u l=1u
X3903 VSS.t2267 VDD VSS.t2266 VSS.t2265 sg13_lv_nmos ad=0.1428p pd=1.52u as=0 ps=0 w=0.42u l=1u
X3904 VSS.t909 VDD VSS.t908 VSS.t907 sg13_lv_nmos ad=0.1428p pd=1.52u as=0 ps=0 w=0.42u l=1u
X3905 VDD VSS.t1887 VDD VDD sg13_lv_pmos ad=0.19p pd=1.38u as=0 ps=0 w=1u l=1u
X3906 VSS.t1603 VDD VSS.t1602 VSS.t1601 sg13_lv_nmos ad=0.1428p pd=1.52u as=0 ps=0 w=0.42u l=1u
X3907 VSS.t1985 VDD VSS.t1984 VSS.t1983 sg13_lv_nmos ad=0.1428p pd=1.52u as=0 ps=0 w=0.42u l=1u
X3908 VDD VSS.t961 VDD VDD sg13_lv_pmos ad=0.19p pd=1.38u as=0 ps=0 w=1u l=1u
X3909 VSS.t1213 VDD VSS.t1212 VSS.t1154 sg13_lv_nmos ad=0.1428p pd=1.52u as=0 ps=0 w=0.42u l=1u
X3910 VSS.t2721 VDD VSS.t2720 VSS.t206 sg13_lv_nmos ad=0.1428p pd=1.52u as=0 ps=0 w=0.42u l=1u
X3911 VDD VSS.t2294 VDD VDD sg13_lv_pmos ad=0.19p pd=1.38u as=0 ps=0 w=1u l=1u
X3912 VSS.t541 VDD VSS.t543 VSS.t542 sg13_lv_nmos ad=79.8f pd=0.8u as=0 ps=0 w=0.42u l=1u
X3913 VDD VSS.t372 VDD VDD sg13_lv_pmos ad=0.34p pd=2.68u as=0 ps=0 w=1u l=1u
X3914 VDD VSS.t1256 VDD VDD sg13_lv_pmos ad=0.34p pd=2.68u as=0 ps=0 w=1u l=1u
X3915 VDD VSS.t2049 VDD VDD sg13_lv_pmos ad=0.34p pd=2.68u as=0 ps=0 w=1u l=1u
X3916 VDD VSS.t2419 VDD VDD sg13_lv_pmos ad=0.19p pd=1.38u as=0 ps=0 w=1u l=1u
X3917 VDD VSS.t2077 VDD VDD sg13_lv_pmos ad=0.19p pd=1.38u as=0 ps=0 w=1u l=1u
X3918 VSS.t1900 VDD VSS.t1902 VSS.t1901 sg13_lv_nmos ad=79.8f pd=0.8u as=0 ps=0 w=0.42u l=1u
X3919 VDD VSS.t289 VDD VDD sg13_lv_pmos ad=0.34p pd=2.68u as=0 ps=0 w=1u l=1u
X3920 sg13cmos5l_and2_1_2.X a_8685_14832# VSS.t1 VSS.t232 sg13_lv_nmos ad=0.2516p pd=2.16u as=0.1331p ps=1.12u w=0.74u l=0.13u
X3921 VDD VSS.t1852 VDD VDD sg13_lv_pmos ad=0.19p pd=1.38u as=0 ps=0 w=1u l=1u
X3922 VDD VSS.t2696 VDD VDD sg13_lv_pmos ad=0.19p pd=1.38u as=0 ps=0 w=1u l=1u
X3923 VSS.t626 VDD VSS.t626 VSS.t627 sg13_lv_nmos ad=79.8f pd=0.8u as=0 ps=0 w=0.42u l=1u
X3924 VSS.t1533 VDD VSS.t1532 VSS.t1531 sg13_lv_nmos ad=0.1428p pd=1.52u as=0 ps=0 w=0.42u l=1u
X3925 VSS.t2741 VDD VSS.t2742 VSS.t206 sg13_lv_nmos ad=79.8f pd=0.8u as=0 ps=0 w=0.42u l=1u
X3926 VDD VSS.t2618 VDD VDD sg13_lv_pmos ad=0.19p pd=1.38u as=0 ps=0 w=1u l=1u
X3927 VSS.t2232 VDD VSS.t2231 VSS.t2230 sg13_lv_nmos ad=0.1428p pd=1.52u as=0 ps=0 w=0.42u l=1u
X3928 sg13cmos5l_a21oi_1_3.Y sg13cmos5l_a21oi_1_3.A1 a_25203_13320# VSS.t141 sg13_lv_nmos ad=0.1406p pd=1.12u as=0.1406p ps=1.12u w=0.74u l=0.13u
X3929 VSS.t879 VDD VSS.t878 VSS.t877 sg13_lv_nmos ad=0.1428p pd=1.52u as=0 ps=0 w=0.42u l=1u
X3930 VSS.t1249 VDD VSS.t1250 VSS.t1154 sg13_lv_nmos ad=79.8f pd=0.8u as=0 ps=0 w=0.42u l=1u
X3931 VSS.t377 VDD VSS.t377 VSS.t380 sg13_lv_nmos ad=79.8f pd=0.8u as=0 ps=0 w=0.42u l=1u
X3932 VSS.t440 VDD VSS.t441 VSS.t4 sg13_lv_nmos ad=79.8f pd=0.8u as=0 ps=0 w=0.42u l=1u
X3933 VDD VSS.t150 VDD VDD sg13_lv_pmos ad=0.19p pd=1.38u as=0 ps=0 w=1u l=1u
X3934 VDD VSS.t836 VDD VDD sg13_lv_pmos ad=0.19p pd=1.38u as=0 ps=0 w=1u l=1u
X3935 VDD VSS.t1507 VDD VDD sg13_lv_pmos ad=0.34p pd=2.68u as=0 ps=0 w=1u l=1u
X3936 a_18202_15202# sg13cmos5l_dfrbpq_1_2.Q VDD VDD sg13_lv_pmos ad=0.1428p pd=1.52u as=0.1523p ps=1.38u w=0.42u l=0.13u
X3937 sg13cmos5l_buf_8_2.A a_15579_14854# VSS.t16 VSS.t3239 sg13_lv_nmos ad=0.1406p pd=1.12u as=0.1406p ps=1.12u w=0.74u l=0.13u
X3938 VSS.t573 VDD VSS.t93 VSS.t692 sg13_lv_nmos ad=0.1428p pd=1.52u as=0 ps=0 w=0.42u l=1u
X3939 VSS.t2307 VDD VSS.t2306 VSS.t2305 sg13_lv_nmos ad=0.1428p pd=1.52u as=0 ps=0 w=0.42u l=1u
X3940 VSS.t2670 VDD VSS.t2672 VSS.t206 sg13_lv_nmos ad=79.8f pd=0.8u as=0 ps=0 w=0.42u l=1u
X3941 VDD VSS.t278 VDD VDD sg13_lv_pmos ad=0.34p pd=2.68u as=0 ps=0 w=1u l=1u
X3942 VSS.t160 sg13cmos5l_or3_1_1.B a_16168_15996# VSS.t165 sg13_lv_nmos ad=0.14875p pd=1.16u as=0.187p ps=1.78u w=0.55u l=0.13u
X3943 a_23736_14464# sg13cmos5l_or3_1_2.B VDD VDD sg13_lv_pmos ad=0.2128p pd=1.5u as=0.3808p ps=2.92u w=1.12u l=0.15u
X3944 VDD VSS.t596 VDD VDD sg13_lv_pmos ad=0.34p pd=2.68u as=0 ps=0 w=1u l=1u
X3945 VDD VSS.t1715 VDD VDD sg13_lv_pmos ad=0.19p pd=1.38u as=0 ps=0 w=1u l=1u
X3946 VDD VSS.t3001 VDD VDD sg13_lv_pmos ad=0.19p pd=1.38u as=0 ps=0 w=1u l=1u
X3947 VSS.t2739 VDD VSS.t2740 VSS.t206 sg13_lv_nmos ad=79.8f pd=0.8u as=0 ps=0 w=0.42u l=1u
X3948 VDD VSS.t66 VDD VDD sg13_lv_pmos ad=0.19p pd=1.38u as=0 ps=0 w=1u l=1u
X3949 VDD VSS.t928 VDD VDD sg13_lv_pmos ad=0.34p pd=2.68u as=0 ps=0 w=1u l=1u
X3950 a_24935_14020# sg13cmos5l_or3_1_1.C a_24841_13726# VDD sg13_lv_pmos ad=0.19p pd=1.38u as=0.34p ps=2.68u w=1u l=0.13u
X3951 VSS.t66 VDD VSS.t66 VSS.t500 sg13_lv_nmos ad=0.1428p pd=1.52u as=0 ps=0 w=0.42u l=1u
X3952 VSS.t2646 VDD VSS.t2648 VSS.t206 sg13_lv_nmos ad=79.8f pd=0.8u as=0 ps=0 w=0.42u l=1u
X3953 VDD VSS.t2069 VDD VDD sg13_lv_pmos ad=0.34p pd=2.68u as=0 ps=0 w=1u l=1u
X3954 VDD VSS.t1247 VDD VDD sg13_lv_pmos ad=0.34p pd=2.68u as=0 ps=0 w=1u l=1u
X3955 VDD VSS.t2740 VDD VDD sg13_lv_pmos ad=0.34p pd=2.68u as=0 ps=0 w=1u l=1u
X3956 VSS.t3019 VDD VSS.t3021 VSS.t3020 sg13_lv_nmos ad=79.8f pd=0.8u as=0 ps=0 w=0.42u l=1u
X3957 VDD VSS.t338 VDD VDD sg13_lv_pmos ad=0.19p pd=1.38u as=0 ps=0 w=1u l=1u
X3958 a_2890_15457# a_3333_15213# a_2630_15234# VSS.t259 sg13_lv_nmos ad=79.8f pd=0.8u as=0.1296p ps=1.52u w=0.42u l=0.13u
X3959 VDD VSS.t426 VDD VDD sg13_lv_pmos ad=0.19p pd=1.38u as=0 ps=0 w=1u l=1u
X3960 a_22030_15423# a_22145_15424# VSS.t179 VSS.t208 sg13_lv_nmos ad=0.1428p pd=1.52u as=0.1426p ps=1.16u w=0.42u l=0.5u
X3961 VDD VSS.t307 VDD VDD sg13_lv_pmos ad=0.19p pd=1.38u as=0 ps=0 w=1u l=1u
X3962 VSS.t635 VDD VSS.t761 VSS.t760 sg13_lv_nmos ad=0.1428p pd=1.52u as=0 ps=0 w=0.42u l=1u
X3963 VDD VSS.t2239 VDD VDD sg13_lv_pmos ad=0.19p pd=1.38u as=0 ps=0 w=1u l=1u
X3964 VDD VSS.t991 VDD VDD sg13_lv_pmos ad=0.19p pd=1.38u as=0 ps=0 w=1u l=1u
X3965 VDD VSS.t2029 VDD VDD sg13_lv_pmos ad=0.34p pd=2.68u as=0 ps=0 w=1u l=1u
X3966 VSS.t422 VDD VSS.t421 VSS.t4 sg13_lv_nmos ad=0.1428p pd=1.52u as=0 ps=0 w=0.42u l=1u
X3967 VSS.t580 VDD VSS.t580 VSS.t581 sg13_lv_nmos ad=0.1428p pd=1.52u as=0 ps=0 w=0.42u l=1u
X3968 VSS.t1845 VDD VSS.t1847 VSS.t1846 sg13_lv_nmos ad=79.8f pd=0.8u as=0 ps=0 w=0.42u l=1u
X3969 VSS.t596 VDD VSS.t599 VSS.t735 sg13_lv_nmos ad=79.8f pd=0.8u as=0 ps=0 w=0.42u l=1u
X3970 VDD VSS.t1527 VDD VDD sg13_lv_pmos ad=0.34p pd=2.68u as=0 ps=0 w=1u l=1u
X3971 VDD VSS.t3151 VDD VDD sg13_lv_pmos ad=0.19p pd=1.38u as=0 ps=0 w=1u l=1u
X3972 VSS.t2645 VDD VSS.t2646 VSS.t206 sg13_lv_nmos ad=79.8f pd=0.8u as=0 ps=0 w=0.42u l=1u
X3973 VSS.t336 VDD VSS.t123 VSS.t335 sg13_lv_nmos ad=0.1428p pd=1.52u as=0 ps=0 w=0.42u l=1u
X3974 a_21477_14495# sg13cmos5l_buf_8_2.X VDD VDD sg13_lv_pmos ad=0.4088p pd=2.97u as=2.3367p ps=15.135u w=1.12u l=0.13u
X3975 VDD VSS.t468 VDD VDD sg13_lv_pmos ad=0.34p pd=2.68u as=0 ps=0 w=1u l=1u
X3976 VDD VSS.t1864 VDD VDD sg13_lv_pmos ad=0.34p pd=2.68u as=0 ps=0 w=1u l=1u
X3977 VDD VSS.t2702 VDD VDD sg13_lv_pmos ad=0.34p pd=2.68u as=0 ps=0 w=1u l=1u
X3978 VSS.t909 VDD VSS.t908 VSS.t907 sg13_lv_nmos ad=0.1428p pd=1.52u as=0 ps=0 w=0.42u l=1u
X3979 VSS.t2750 VDD VSS.t2748 VSS.t206 sg13_lv_nmos ad=0.1428p pd=1.52u as=0 ps=0 w=0.42u l=1u
X3980 VDD VSS.t583 VDD VDD sg13_lv_pmos ad=0.19p pd=1.38u as=0 ps=0 w=1u l=1u
X3981 VDD VSS.t891 VDD VDD sg13_lv_pmos ad=0.19p pd=1.38u as=0 ps=0 w=1u l=1u
X3982 VSS.t580 VDD VSS.t578 VSS.t706 sg13_lv_nmos ad=0.1428p pd=1.52u as=0 ps=0 w=0.42u l=1u
X3983 VSS.t2252 VDD VSS.t2251 VSS.t2250 sg13_lv_nmos ad=0.1428p pd=1.52u as=0 ps=0 w=0.42u l=1u
X3984 VSS.t1272 VDD VSS.t1271 VSS.t1154 sg13_lv_nmos ad=0.1428p pd=1.52u as=0 ps=0 w=0.42u l=1u
X3985 VDD VSS.t1288 VDD VDD sg13_lv_pmos ad=0.19p pd=1.38u as=0 ps=0 w=1u l=1u
X3986 VSS.t1588 VDD VSS.t1587 VSS.t1586 sg13_lv_nmos ad=0.1428p pd=1.52u as=0 ps=0 w=0.42u l=1u
X3987 VSS.t2637 VDD VSS.t2639 VSS.t206 sg13_lv_nmos ad=79.8f pd=0.8u as=0 ps=0 w=0.42u l=1u
X3988 VSS.t2713 VDD VSS.t2713 VSS.t206 sg13_lv_nmos ad=0.1428p pd=1.52u as=0 ps=0 w=0.42u l=1u
X3989 VDD VSS.t2456 VDD VDD sg13_lv_pmos ad=0.34p pd=2.68u as=0 ps=0 w=1u l=1u
X3990 VSS.t1955 VDD VSS.t1957 VSS.t1956 sg13_lv_nmos ad=79.8f pd=0.8u as=0 ps=0 w=0.42u l=1u
X3991 VDD VSS.t2654 VDD VDD sg13_lv_pmos ad=0.19p pd=1.38u as=0 ps=0 w=1u l=1u
X3992 VSS.t2292 VDD VSS.t2291 VSS.t2290 sg13_lv_nmos ad=0.1428p pd=1.52u as=0 ps=0 w=0.42u l=1u
X3993 a_6682_13690# sg13cmos5l_dlygate4sd3_1_0.A VDD VDD sg13_lv_pmos ad=0.1428p pd=1.52u as=0.1523p ps=1.38u w=0.42u l=0.13u
X3994 VDD VSS.t614 VDD VDD sg13_lv_pmos ad=0.34p pd=2.68u as=0 ps=0 w=1u l=1u
X3995 VDD VSS.t828 VDD VDD sg13_lv_pmos ad=0.34p pd=2.68u as=0 ps=0 w=1u l=1u
X3996 VDD VSS.t2946 VDD VDD sg13_lv_pmos ad=0.19p pd=1.38u as=0 ps=0 w=1u l=1u
X3997 VSS.t1315 VDD VSS.t1314 VSS.t1154 sg13_lv_nmos ad=0.1428p pd=1.52u as=0 ps=0 w=0.42u l=1u
X3998 VDD VSS.t2404 VDD VDD sg13_lv_pmos ad=0.19p pd=1.38u as=0 ps=0 w=1u l=1u
X3999 VDD VSS.t2062 VDD VDD sg13_lv_pmos ad=0.19p pd=1.38u as=0 ps=0 w=1u l=1u
X4000 VSS.t2065 VDD VSS.t2064 VSS.t2063 sg13_lv_nmos ad=0.1428p pd=1.52u as=0 ps=0 w=0.42u l=1u
X4001 VDD VSS.t766 VDD VDD sg13_lv_pmos ad=0.19p pd=1.38u as=0 ps=0 w=1u l=1u
X4002 VDD VSS.t147 VDD VDD sg13_lv_pmos ad=0.34p pd=2.68u as=0 ps=0 w=1u l=1u
X4003 VSS.t112 VDD VSS.t112 VSS.t716 sg13_lv_nmos ad=0.1428p pd=1.52u as=0 ps=0 w=0.42u l=1u
X4004 VDD VSS.t1837 VDD VDD sg13_lv_pmos ad=0.19p pd=1.38u as=0 ps=0 w=1u l=1u
X4005 VDD VSS.t2356 VDD VDD sg13_lv_pmos ad=0.34p pd=2.68u as=0 ps=0 w=1u l=1u
X4006 VSS.t1518 VDD VSS.t1517 VSS.t1516 sg13_lv_nmos ad=0.1428p pd=1.52u as=0 ps=0 w=0.42u l=1u
X4007 VSS.t361 VDD VSS.t356 VSS.t360 sg13_lv_nmos ad=0.1428p pd=1.52u as=0 ps=0 w=0.42u l=1u
X4008 VDD VSS.t548 VDD VDD sg13_lv_pmos ad=0.19p pd=1.38u as=0 ps=0 w=1u l=1u
X4009 VDD VSS.t396 VDD VDD sg13_lv_pmos ad=0.34p pd=2.68u as=0 ps=0 w=1u l=1u
X4010 VSS.t456 VDD VSS.t51 VSS.t457 sg13_lv_nmos ad=79.8f pd=0.8u as=0 ps=0 w=0.42u l=1u
X4011 VDD VSS.t881 VDD VDD sg13_lv_pmos ad=0.19p pd=1.38u as=0 ps=0 w=1u l=1u
X4012 VDD VSS.t1932 VDD VDD sg13_lv_pmos ad=0.19p pd=1.38u as=0 ps=0 w=1u l=1u
X4013 VDD VSS.t1179 VDD VDD sg13_lv_pmos ad=0.34p pd=2.68u as=0 ps=0 w=1u l=1u
X4014 VDD a_7631_14845# a_7888_14726# VDD sg13_lv_pmos ad=2.42015p pd=15.68u as=79.8f ps=0.8u w=0.42u l=0.13u
X4015 VSS.t614 VDD VSS.t617 VSS.t747 sg13_lv_nmos ad=79.8f pd=0.8u as=0 ps=0 w=0.42u l=1u
X4016 VSS.t2762 VDD VSS.t2761 VSS.t206 sg13_lv_nmos ad=0.1428p pd=1.52u as=0 ps=0 w=0.42u l=1u
X4017 VSS.t2662 VDD VSS.t2663 VSS.t206 sg13_lv_nmos ad=79.8f pd=0.8u as=0 ps=0 w=0.42u l=1u
X4018 VDD VSS.t1645 VDD VDD sg13_lv_pmos ad=0.19p pd=1.38u as=0 ps=0 w=1u l=1u
X4019 sg13cmos5l_dlygate4sd3_1_1.A a_8298_14484# VDD VDD sg13_lv_pmos ad=0.3808p pd=2.92u as=0.2128p ps=1.5u w=1.12u l=0.13u
X4020 VDD VSS.t1700 VDD VDD sg13_lv_pmos ad=0.19p pd=1.38u as=0 ps=0 w=1u l=1u
X4021 VDD VSS.t2299 VDD VDD sg13_lv_pmos ad=0.19p pd=1.38u as=0 ps=0 w=1u l=1u
X4022 a_17710_16263# a_17825_16262# VSS.t11 VSS.t127 sg13_lv_nmos ad=0.1428p pd=1.52u as=0.1426p ps=1.16u w=0.42u l=0.5u
X4023 VDD VSS.t2424 VDD VDD sg13_lv_pmos ad=0.19p pd=1.38u as=0 ps=0 w=1u l=1u
X4024 VDD VSS.t2082 VDD VDD sg13_lv_pmos ad=0.19p pd=1.38u as=0 ps=0 w=1u l=1u
X4025 VSS.t1905 VDD VSS.t1907 VSS.t1906 sg13_lv_nmos ad=79.8f pd=0.8u as=0 ps=0 w=0.42u l=1u
X4026 VSS.t789 VDD VSS.t791 VSS.t790 sg13_lv_nmos ad=79.8f pd=0.8u as=0 ps=0 w=0.42u l=1u
X4027 VDD VSS.t2621 VDD VDD sg13_lv_pmos ad=0.19p pd=1.38u as=0 ps=0 w=1u l=1u
X4028 VSS.t2237 VDD VSS.t2236 VSS.t2235 sg13_lv_nmos ad=0.1428p pd=1.52u as=0 ps=0 w=0.42u l=1u
X4029 VSS.t163 a_25390_16263# sg13cmos5l_a21oi_1_2.A1 VSS.t162 sg13_lv_nmos ad=0.1426p pd=1.16u as=0.2516p ps=2.16u w=0.74u l=0.13u
X4030 a_24310_15230# sg13cmos5l_or3_1_1.C VSS.t58 VSS.t57 sg13_lv_nmos ad=0.1406p pd=1.12u as=0.1406p ps=1.12u w=0.74u l=0.15u
X4031 VDD VSS.t848 VDD VDD sg13_lv_pmos ad=0.34p pd=2.68u as=0 ps=0 w=1u l=1u
X4032 VSS.t3024 VDD VSS.t3023 VSS.t3022 sg13_lv_nmos ad=0.1428p pd=1.52u as=0 ps=0 w=0.42u l=1u
X4033 VSS.t2407 VDD VSS.t2409 VSS.t2408 sg13_lv_nmos ad=79.8f pd=0.8u as=0 ps=0 w=0.42u l=1u
X4034 sg13cmos5l_dlygate4sd3_1_8.A a_11370_15532# VSS.t51 VSS.t50 sg13_lv_nmos ad=0.2516p pd=2.16u as=0.1406p ps=1.12u w=0.74u l=0.13u
X4035 VDD VSS.t1512 VDD VDD sg13_lv_pmos ad=0.34p pd=2.68u as=0 ps=0 w=1u l=1u
X4036 VSS.t2636 VDD VSS.t2637 VSS.t206 sg13_lv_nmos ad=79.8f pd=0.8u as=0 ps=0 w=0.42u l=1u
X4037 sg13cmos5l_or3_1_1.B a_14261_15238# VDD VDD sg13_lv_pmos ad=0.2128p pd=1.5u as=0.203p ps=1.5u w=1.12u l=0.13u
X4038 VSS.t196 sg13cmos5l_buf_1_0.X a_2646_14842# VSS.t3199 sg13_lv_nmos ad=0.15245p pd=1.17u as=88.8f ps=0.98u w=0.74u l=0.13u
X4039 a_6660_14909# a_6891_14495# a_6346_14452# VSS.t53 sg13_lv_nmos ad=0.2373p pd=1.97u as=79.8f ps=0.8u w=0.42u l=0.13u
X4040 VDD VSS.t602 VDD VDD sg13_lv_pmos ad=0.19p pd=1.38u as=0 ps=0 w=1u l=1u
X4041 VSS.t1210 VDD VSS.t1211 VSS.t1154 sg13_lv_nmos ad=79.8f pd=0.8u as=0 ps=0 w=0.42u l=1u
X4042 VSS.t2312 VDD VSS.t2311 VSS.t2310 sg13_lv_nmos ad=0.1428p pd=1.52u as=0 ps=0 w=0.42u l=1u
X4043 VSS.t66 a_26565_13701# a_26667_13844# VSS.t65 sg13_lv_nmos ad=15.38618p pd=0.10091m as=0.2516p ps=2.16u w=0.74u l=0.13u
X4044 VSS.t599 VDD VSS.t596 VSS.t598 sg13_lv_nmos ad=0.1428p pd=1.52u as=0 ps=0 w=0.42u l=1u
X4045 VSS.t1573 VDD VSS.t1575 VSS.t1574 sg13_lv_nmos ad=79.8f pd=0.8u as=0 ps=0 w=0.42u l=1u
X4046 VDD VSS.t1849 VDD VDD sg13_lv_pmos ad=0.34p pd=2.68u as=0 ps=0 w=1u l=1u
X4047 sg13cmos5l_and2_1_1.X a_5613_14832# VSS.t76 VSS.t3169 sg13_lv_nmos ad=0.2516p pd=2.16u as=0.1331p ps=1.12u w=0.74u l=0.13u
X4048 VDD VSS.t586 VDD VDD sg13_lv_pmos ad=0.19p pd=1.38u as=0 ps=0 w=1u l=1u
X4049 VDD VSS.t2694 VDD VDD sg13_lv_pmos ad=0.34p pd=2.68u as=0 ps=0 w=1u l=1u
X4050 VSS.t150 sg13cmos5l_buf_8_2.A a_19323_13726# VSS.t149 sg13_lv_nmos ad=0.1406p pd=1.12u as=0.2553p ps=2.17u w=0.74u l=0.13u
X4051 VSS.t884 VDD VSS.t883 VSS.t882 sg13_lv_nmos ad=0.1428p pd=1.52u as=0 ps=0 w=0.42u l=1u
X4052 VDD VSS.t3006 VDD VDD sg13_lv_pmos ad=0.19p pd=1.38u as=0 ps=0 w=1u l=1u
X4053 VSS.t2742 VDD VSS.t2743 VSS.t206 sg13_lv_nmos ad=79.8f pd=0.8u as=0 ps=0 w=0.42u l=1u
X4054 VDD VSS.t1877 VDD VDD sg13_lv_pmos ad=0.19p pd=1.38u as=0 ps=0 w=1u l=1u
X4055 VSS.t1215 VDD VSS.t1216 VSS.t1154 sg13_lv_nmos ad=79.8f pd=0.8u as=0 ps=0 w=0.42u l=1u
X4056 VSS.t804 VDD VSS.t806 VSS.t805 sg13_lv_nmos ad=79.8f pd=0.8u as=0 ps=0 w=0.42u l=1u
X4057 a_25390_16263# a_25505_16262# VSS.t163 VSS.t241 sg13_lv_nmos ad=0.1428p pd=1.52u as=0.1426p ps=1.16u w=0.42u l=0.5u
X4058 VSS.t2629 VDD VSS.t2630 VSS.t206 sg13_lv_nmos ad=79.8f pd=0.8u as=0 ps=0 w=0.42u l=1u
X4059 VDD VSS.t2441 VDD VDD sg13_lv_pmos ad=0.34p pd=2.68u as=0 ps=0 w=1u l=1u
X4060 VSS.t1940 VDD VSS.t1942 VSS.t1941 sg13_lv_nmos ad=79.8f pd=0.8u as=0 ps=0 w=0.42u l=1u
X4061 VDD VSS.t1250 VDD VDD sg13_lv_pmos ad=0.34p pd=2.68u as=0 ps=0 w=1u l=1u
X4062 VDD VSS.t2743 VDD VDD sg13_lv_pmos ad=0.34p pd=2.68u as=0 ps=0 w=1u l=1u
X4063 VDD a_19323_13726# sg13cmos5l_buf_8_2.X VDD sg13_lv_pmos ad=0.2128p pd=1.5u as=0.2128p ps=1.5u w=1.12u l=0.13u
X4064 VDD VSS.t2244 VDD VDD sg13_lv_pmos ad=0.19p pd=1.38u as=0 ps=0 w=1u l=1u
X4065 VDD VSS.t811 VDD VDD sg13_lv_pmos ad=0.19p pd=1.38u as=0 ps=0 w=1u l=1u
X4066 VDD VSS.t2341 VDD VDD sg13_lv_pmos ad=0.34p pd=2.68u as=0 ps=0 w=1u l=1u
X4067 VDD clock_i a_15579_14854# VDD sg13_lv_pmos ad=0.2128p pd=1.5u as=0.2128p ps=1.5u w=1.12u l=0.13u
X4068 VDD VSS.t548 VDD VDD sg13_lv_pmos ad=0.19p pd=1.38u as=0 ps=0 w=1u l=1u
X4069 VSS.t2427 VDD VSS.t2429 VSS.t2428 sg13_lv_nmos ad=79.8f pd=0.8u as=0 ps=0 w=0.42u l=1u
X4070 VSS.t1850 VDD VSS.t1852 VSS.t1851 sg13_lv_nmos ad=79.8f pd=0.8u as=0 ps=0 w=0.42u l=1u
X4071 a_7822_13911# a_7937_13912# VSS.t216 VSS.t220 sg13_lv_nmos ad=0.1428p pd=1.52u as=0.1426p ps=1.16u w=0.42u l=0.5u
X4072 VSS.t541 VDD VSS.t543 VSS.t542 sg13_lv_nmos ad=79.8f pd=0.8u as=0 ps=0 w=0.42u l=1u
X4073 VSS.t2627 VDD VSS.t2628 VSS.t206 sg13_lv_nmos ad=79.8f pd=0.8u as=0 ps=0 w=0.42u l=1u
X4074 VDD VSS.t1319 VDD VDD sg13_lv_pmos ad=0.19p pd=1.38u as=0 ps=0 w=1u l=1u
X4075 VDD VSS.t2094 VDD VDD sg13_lv_pmos ad=0.34p pd=2.68u as=0 ps=0 w=1u l=1u
X4076 VDD VSS.t1917 VDD VDD sg13_lv_pmos ad=0.19p pd=1.38u as=0 ps=0 w=1u l=1u
X4077 a_6286_13911# a_6401_13912# VSS.t38 VSS.t3215 sg13_lv_nmos ad=0.1428p pd=1.52u as=0.1426p ps=1.16u w=0.42u l=0.5u
X4078 VSS.t377 VDD VSS.t377 VSS.t382 sg13_lv_nmos ad=0.1428p pd=1.52u as=0 ps=0 w=0.42u l=1u
X4079 sg13cmos5l_nand3_1_0.Y sg13cmos5l_buf_1_0.X a_6680_15242# VSS.t3197 sg13_lv_nmos ad=0.2516p pd=2.16u as=0.1406p ps=1.12u w=0.74u l=0.13u
X4080 VDD VSS.t1869 VDD VDD sg13_lv_pmos ad=0.34p pd=2.68u as=0 ps=0 w=1u l=1u
X4081 VDD VSS.t2704 VDD VDD sg13_lv_pmos ad=0.34p pd=2.68u as=0 ps=0 w=1u l=1u
X4082 VSS.t1159 VDD VSS.t1160 VSS.t1154 sg13_lv_nmos ad=79.8f pd=0.8u as=0 ps=0 w=0.42u l=1u
X4083 VSS.t2753 VDD VSS.t2752 VSS.t206 sg13_lv_nmos ad=0.1428p pd=1.52u as=0 ps=0 w=0.42u l=1u
X4084 VDD VSS.t2628 VDD VDD sg13_lv_pmos ad=0.34p pd=2.68u as=0 ps=0 w=1u l=1u
X4085 VDD VSS.t2042 VDD VDD sg13_lv_pmos ad=0.19p pd=1.38u as=0 ps=0 w=1u l=1u
X4086 VDD a_2540_15960# counter_value_o[0] VDD sg13_lv_pmos ad=0.2114p pd=1.54u as=0.42p ps=2.99u w=1.12u l=0.13u
X4087 VSS.t959 VDD VSS.t961 VSS.t960 sg13_lv_nmos ad=79.8f pd=0.8u as=0 ps=0 w=0.42u l=1u
X4088 VSS.t2884 VDD VSS.t2886 VSS.t2885 sg13_lv_nmos ad=79.8f pd=0.8u as=0 ps=0 w=0.42u l=1u
X4089 sg13cmos5l_dlygate4sd3_1_1.A a_8298_14484# VSS.t34 VSS.t33 sg13_lv_nmos ad=0.2516p pd=2.16u as=0.1406p ps=1.12u w=0.74u l=0.13u
X4090 VDD VSS.t1028 VDD VDD sg13_lv_pmos ad=0.34p pd=2.68u as=0 ps=0 w=1u l=1u
X4091 VSS.t1713 VDD VSS.t1715 VSS.t1714 sg13_lv_nmos ad=79.8f pd=0.8u as=0 ps=0 w=0.42u l=1u
X4092 VSS.t419 VDD VSS.t420 VSS.t4 sg13_lv_nmos ad=79.8f pd=0.8u as=0 ps=0 w=0.42u l=1u
X4093 VDD VSS.t635 VDD VDD sg13_lv_pmos ad=0.19p pd=1.38u as=0 ps=0 w=1u l=1u
X4094 VSS.t2716 VDD VSS.t2715 VSS.t206 sg13_lv_nmos ad=0.1428p pd=1.52u as=0 ps=0 w=0.42u l=1u
X4095 VDD VSS.t2461 VDD VDD sg13_lv_pmos ad=0.34p pd=2.68u as=0 ps=0 w=1u l=1u
X4096 VSS.t1925 VDD VSS.t1927 VSS.t1926 sg13_lv_nmos ad=79.8f pd=0.8u as=0 ps=0 w=0.42u l=1u
X4097 VSS.t629 VDD VSS.t629 VSS.t756 sg13_lv_nmos ad=0.1428p pd=1.52u as=0 ps=0 w=0.42u l=1u
X4098 VSS.t147 VDD VSS.t147 VSS.t393 sg13_lv_nmos ad=0.1428p pd=1.52u as=0 ps=0 w=0.42u l=1u
X4099 VDD VSS.t685 VDD VDD sg13_lv_pmos ad=0.34p pd=2.68u as=0 ps=0 w=1u l=1u
X4100 VDD VSS.t2067 VDD VDD sg13_lv_pmos ad=0.19p pd=1.38u as=0 ps=0 w=1u l=1u
X4101 VSS.t2070 VDD VSS.t2069 VSS.t2068 sg13_lv_nmos ad=0.1428p pd=1.52u as=0 ps=0 w=0.42u l=1u
X4102 sg13cmos5l_o21ai_1_2.Y sg13cmos5l_o21ai_1_2.B1 a_23638_14862# VSS.t8 sg13_lv_nmos ad=0.2516p pd=2.16u as=0.1406p ps=1.12u w=0.74u l=0.15u
X4103 VSS.t789 VDD VSS.t791 VSS.t790 sg13_lv_nmos ad=79.8f pd=0.8u as=0 ps=0 w=0.42u l=1u
X4104 VDD VSS.t778 VDD VDD sg13_lv_pmos ad=0.34p pd=2.68u as=0 ps=0 w=1u l=1u
X4105 VDD VSS.t1555 VDD VDD sg13_lv_pmos ad=0.19p pd=1.38u as=0 ps=0 w=1u l=1u
X4106 VSS.t69 VDD VSS.t69 VSS.t286 sg13_lv_nmos ad=0.1428p pd=1.52u as=0 ps=0 w=0.42u l=1u
X4107 VSS.t546 VDD VSS.t548 VSS.t547 sg13_lv_nmos ad=79.8f pd=0.8u as=0 ps=0 w=0.42u l=1u
X4108 VDD VSS.t377 VDD VDD sg13_lv_pmos ad=0.34p pd=2.68u as=0 ps=0 w=1u l=1u
X4109 VSS.t1168 VDD VSS.t1169 VSS.t1154 sg13_lv_nmos ad=79.8f pd=0.8u as=0 ps=0 w=0.42u l=1u
X4110 VSS.t2222 VDD VSS.t2221 VSS.t2220 sg13_lv_nmos ad=0.1428p pd=1.52u as=0 ps=0 w=0.42u l=1u
X4111 VSS.t1835 VDD VSS.t1837 VSS.t1836 sg13_lv_nmos ad=79.8f pd=0.8u as=0 ps=0 w=0.42u l=1u
X4112 VDD VSS.t1299 VDD VDD sg13_lv_pmos ad=0.34p pd=2.68u as=0 ps=0 w=1u l=1u
X4113 VDD VSS.t1168 VDD VDD sg13_lv_pmos ad=0.19p pd=1.38u as=0 ps=0 w=1u l=1u
X4114 VSS.t626 VDD VSS.t623 VSS.t625 sg13_lv_nmos ad=0.1428p pd=1.52u as=0 ps=0 w=0.42u l=1u
X4115 VSS.t1583 VDD VSS.t1582 VSS.t1581 sg13_lv_nmos ad=0.1428p pd=1.52u as=0 ps=0 w=0.42u l=1u
X4116 VSS.t3104 VDD VSS.t3103 VSS.t3102 sg13_lv_nmos ad=0.1428p pd=1.52u as=0 ps=0 w=0.42u l=1u
X4117 VSS.t2297 VDD VSS.t2296 VSS.t2295 sg13_lv_nmos ad=0.1428p pd=1.52u as=0 ps=0 w=0.42u l=1u
X4118 a_1965_14832# sg13cmos5l_buf_1_10.X VDD VDD sg13_lv_pmos ad=0.1596p pd=1.22u as=0.2856p ps=2.36u w=0.84u l=0.13u
X4119 VSS.t884 VDD VSS.t883 VSS.t882 sg13_lv_nmos ad=0.1428p pd=1.52u as=0 ps=0 w=0.42u l=1u
X4120 VDD VSS.t2256 VDD VDD sg13_lv_pmos ad=0.34p pd=2.68u as=0 ps=0 w=1u l=1u
X4121 a_25094_15238# a_24824_15238# VSS.t113 VSS.t57 sg13_lv_nmos ad=0.1428p pd=1.52u as=79.8f ps=0.8u w=0.42u l=0.5u
X4122 VSS.t2664 VDD VSS.t2666 VSS.t206 sg13_lv_nmos ad=79.8f pd=0.8u as=0 ps=0 w=0.42u l=1u
X4123 VSS.t929 VDD VSS.t928 VSS.t927 sg13_lv_nmos ad=0.1428p pd=1.52u as=0 ps=0 w=0.42u l=1u
X4124 VSS.t804 VDD VSS.t806 VSS.t805 sg13_lv_nmos ad=79.8f pd=0.8u as=0 ps=0 w=0.42u l=1u
X4125 VSS.t1242 VDD VSS.t1243 VSS.t1154 sg13_lv_nmos ad=79.8f pd=0.8u as=0 ps=0 w=0.42u l=1u
X4126 VDD VSS.t1705 VDD VDD sg13_lv_pmos ad=0.19p pd=1.38u as=0 ps=0 w=1u l=1u
X4127 VDD VSS.t2991 VDD VDD sg13_lv_pmos ad=0.19p pd=1.38u as=0 ps=0 w=1u l=1u
X4128 VSS.t2733 VDD VSS.t2734 VSS.t206 sg13_lv_nmos ad=79.8f pd=0.8u as=0 ps=0 w=0.42u l=1u
X4129 VDD VSS.t1862 VDD VDD sg13_lv_pmos ad=0.19p pd=1.38u as=0 ps=0 w=1u l=1u
X4130 VSS.t1865 VDD VSS.t1864 VSS.t1863 sg13_lv_nmos ad=0.1428p pd=1.52u as=0 ps=0 w=0.42u l=1u
X4131 VSS.t1578 VDD VSS.t1577 VSS.t1576 sg13_lv_nmos ad=0.1428p pd=1.52u as=0 ps=0 w=0.42u l=1u
X4132 VDD sg13cmos5l_dfrbpq_1_2.RESET_B a_15782_13722# VDD sg13_lv_pmos ad=0.36237p pd=2.605u as=79.8f ps=0.8u w=0.42u l=0.13u
X4133 VSS.t60 sg13cmos5l_or3_1_1.A a_24841_13726# VSS.t3171 sg13_lv_nmos ad=0.13395p pd=1.12u as=0.198p ps=1.27u w=0.55u l=0.13u
X4134 VSS.t2708 VDD VSS.t2707 VSS.t206 sg13_lv_nmos ad=0.1428p pd=1.52u as=0 ps=0 w=0.42u l=1u
X4135 VSS.t2105 VDD VSS.t2104 VSS.t2103 sg13_lv_nmos ad=0.1428p pd=1.52u as=0 ps=0 w=0.42u l=1u
X4136 VDD VSS.t1241 VDD VDD sg13_lv_pmos ad=0.34p pd=2.68u as=0 ps=0 w=1u l=1u
X4137 VDD VSS.t2734 VDD VDD sg13_lv_pmos ad=0.34p pd=2.68u as=0 ps=0 w=1u l=1u
X4138 VDD VSS.t2394 VDD VDD sg13_lv_pmos ad=0.19p pd=1.38u as=0 ps=0 w=1u l=1u
X4139 VDD sg13cmos5l_a21oi_1_3.A2 a_25109_12972# VDD sg13_lv_pmos ad=0.2128p pd=1.5u as=0.3808p ps=2.92u w=1.12u l=0.13u
X4140 VSS.t989 VDD VSS.t991 VSS.t990 sg13_lv_nmos ad=79.8f pd=0.8u as=0 ps=0 w=0.42u l=1u
X4141 VDD VSS.t2052 VDD VDD sg13_lv_pmos ad=0.19p pd=1.38u as=0 ps=0 w=1u l=1u
X4142 a_18021_14495# sg13cmos5l_buf_8_2.X VDD VDD sg13_lv_pmos ad=0.4088p pd=2.97u as=2.3367p ps=15.135u w=1.12u l=0.13u
X4143 VSS.t1261 VDD VSS.t1262 VSS.t1154 sg13_lv_nmos ad=79.8f pd=0.8u as=0 ps=0 w=0.42u l=1u
X4144 VDD VSS.t2229 VDD VDD sg13_lv_pmos ad=0.19p pd=1.38u as=0 ps=0 w=1u l=1u
X4145 VDD VSS.t856 VDD VDD sg13_lv_pmos ad=0.19p pd=1.38u as=0 ps=0 w=1u l=1u
X4146 VSS.t2650 VDD VSS.t2649 VSS.t206 sg13_lv_nmos ad=0.1428p pd=1.52u as=0 ps=0 w=0.42u l=1u
X4147 VSS.t2412 VDD VSS.t2414 VSS.t2413 sg13_lv_nmos ad=79.8f pd=0.8u as=0 ps=0 w=0.42u l=1u
X4148 VDD VSS.t1517 VDD VDD sg13_lv_pmos ad=0.34p pd=2.68u as=0 ps=0 w=1u l=1u
X4149 VDD a_17710_16263# sg13cmos5l_a21oi_1_0.A1 VDD sg13_lv_pmos ad=0.2254p pd=1.53u as=0.4256p ps=3u w=1.12u l=0.13u
X4150 a_10703_15311# a_9861_15213# a_9444_15552# VDD sg13_lv_pmos ad=0.2048p pd=1.63u as=0.34p ps=2.68u w=1u l=0.13u
X4151 VDD VSS.t1500 VDD VDD sg13_lv_pmos ad=0.19p pd=1.38u as=0 ps=0 w=1u l=1u
X4152 VSS.t2618 VDD VSS.t2619 VSS.t206 sg13_lv_nmos ad=79.8f pd=0.8u as=0 ps=0 w=0.42u l=1u
X4153 VDD VSS.t312 VDD VDD sg13_lv_pmos ad=0.19p pd=1.38u as=0 ps=0 w=1u l=1u
X4154 VDD a_15671_15315# a_15671_15549# VDD sg13_lv_pmos ad=2.8961p pd=18.25u as=0.2442p ps=2.06u w=0.66u l=0.13u
X4155 VDD VSS.t246 VDD VDD sg13_lv_pmos ad=0.34p pd=2.68u as=0 ps=0 w=1u l=1u
X4156 VSS.t2317 VDD VSS.t2316 VSS.t2315 sg13_lv_nmos ad=0.1428p pd=1.52u as=0 ps=0 w=0.42u l=1u
X4157 VDD VSS.t2079 VDD VDD sg13_lv_pmos ad=0.34p pd=2.68u as=0 ps=0 w=1u l=1u
X4158 a_16068_14040# a_16042_13945# VSS.t44 VSS.t43 sg13_lv_nmos ad=0.2516p pd=2.16u as=0.1626p ps=1.415u w=0.74u l=0.13u
X4159 VDD VSS.t1233 VDD VDD sg13_lv_pmos ad=0.34p pd=2.68u as=0 ps=0 w=1u l=1u
X4160 VDD VSS.t1854 VDD VDD sg13_lv_pmos ad=0.34p pd=2.68u as=0 ps=0 w=1u l=1u
X4161 VSS.t959 VDD VSS.t961 VSS.t960 sg13_lv_nmos ad=79.8f pd=0.8u as=0 ps=0 w=0.42u l=1u
X4162 VDD VSS.t948 VDD VDD sg13_lv_pmos ad=0.34p pd=2.68u as=0 ps=0 w=1u l=1u
X4163 VDD VSS.t2619 VDD VDD sg13_lv_pmos ad=0.34p pd=2.68u as=0 ps=0 w=1u l=1u
X4164 VDD VSS.t2697 VDD VDD sg13_lv_pmos ad=0.34p pd=2.68u as=0 ps=0 w=1u l=1u
X4165 a_10960_15454# a_10703_15311# a_11122_15234# VSS.t3237 sg13_lv_nmos ad=0.1428p pd=1.52u as=37.8f ps=0.6u w=0.42u l=0.13u
X4166 VDD VSS.t3011 VDD VDD sg13_lv_pmos ad=0.19p pd=1.38u as=0 ps=0 w=1u l=1u
X4167 VDD VSS.t1882 VDD VDD sg13_lv_pmos ad=0.19p pd=1.38u as=0 ps=0 w=1u l=1u
X4168 VSS.t1698 VDD VSS.t1700 VSS.t1699 sg13_lv_nmos ad=79.8f pd=0.8u as=0 ps=0 w=0.42u l=1u
X4169 VDD VSS.t438 VDD VDD sg13_lv_pmos ad=0.19p pd=1.38u as=0 ps=0 w=1u l=1u
X4170 VSS.t2090 VDD VSS.t2089 VSS.t2088 sg13_lv_nmos ad=0.1428p pd=1.52u as=0 ps=0 w=0.42u l=1u
X4171 VDD VSS.t2044 VDD VDD sg13_lv_pmos ad=0.34p pd=2.68u as=0 ps=0 w=1u l=1u
X4172 VDD VSS.t1158 VDD VDD sg13_lv_pmos ad=0.34p pd=2.68u as=0 ps=0 w=1u l=1u
X4173 VDD sg13cmos5l_or3_1_1.A sg13cmos5l_o21ai_1_3.Y VDD sg13_lv_pmos ad=0.3808p pd=2.92u as=0.2128p ps=1.5u w=1.12u l=0.15u
X4174 VDD VSS.t1011 VDD VDD sg13_lv_pmos ad=0.19p pd=1.38u as=0 ps=0 w=1u l=1u
X4175 VSS.t1275 VDD VSS.t1276 VSS.t1154 sg13_lv_nmos ad=79.8f pd=0.8u as=0 ps=0 w=0.42u l=1u
X4176 VSS.t16 sg13cmos5l_dfrbpq_1_3.RESET_B a_17412_14922# VSS.t3211 sg13_lv_nmos ad=0.1626p pd=1.415u as=60.89999f ps=0.71u w=0.42u l=0.13u
X4177 VSS.t1568 VDD VSS.t1570 VSS.t1569 sg13_lv_nmos ad=79.8f pd=0.8u as=0 ps=0 w=0.42u l=1u
X4178 VDD VSS.t2346 VDD VDD sg13_lv_pmos ad=0.34p pd=2.68u as=0 ps=0 w=1u l=1u
X4179 a_21251_13690# sg13cmos5l_or3_1_2.C a_21549_14020# VDD sg13_lv_pmos ad=0.34p pd=2.68u as=0.19p ps=1.38u w=1u l=0.13u
X4180 VSS.t231 a_32492_15960# counter_value_o[6] VSS.t230 sg13_lv_nmos ad=0.14875p pd=1.16u as=0.2886p ps=2.26u w=0.74u l=0.13u
X4181 VSS.t879 VDD VSS.t881 VSS.t880 sg13_lv_nmos ad=79.8f pd=0.8u as=0 ps=0 w=0.42u l=1u
X4182 VSS.t1438 VDD VSS.t1440 VSS.t1439 sg13_lv_nmos ad=79.8f pd=0.8u as=0 ps=0 w=0.42u l=1u
X4183 VSS.t2630 VDD VSS.t2631 VSS.t206 sg13_lv_nmos ad=79.8f pd=0.8u as=0 ps=0 w=0.42u l=1u
X4184 a_21070_15423# a_21185_15424# VSS.t157 VSS.t3208 sg13_lv_nmos ad=0.1428p pd=1.52u as=0.1426p ps=1.16u w=0.42u l=0.5u
X4185 VDD VSS.t386 VDD VDD sg13_lv_pmos ad=0.34p pd=2.68u as=0 ps=0 w=1u l=1u
X4186 VDD VSS.t726 VDD VDD sg13_lv_pmos ad=0.19p pd=1.38u as=0 ps=0 w=1u l=1u
X4187 VDD VSS.t1922 VDD VDD sg13_lv_pmos ad=0.19p pd=1.38u as=0 ps=0 w=1u l=1u
X4188 sg13cmos5l_and2_1_2.B a_8694_15302# VDD VDD sg13_lv_pmos ad=0.4256p pd=3u as=0.2254p ps=1.53u w=1.12u l=0.13u
X4189 VSS.t929 VDD VSS.t928 VSS.t927 sg13_lv_nmos ad=0.1428p pd=1.52u as=0 ps=0 w=0.42u l=1u
X4190 VDD VSS.t1159 VDD VDD sg13_lv_pmos ad=0.19p pd=1.38u as=0 ps=0 w=1u l=1u
X4191 VDD VSS.t2241 VDD VDD sg13_lv_pmos ad=0.34p pd=2.68u as=0 ps=0 w=1u l=1u
X4192 a_7923_15532# sg13cmos5l_dlygate4sd3_1_8.X VDD VDD sg13_lv_pmos ad=0.1428p pd=1.375u as=0.2891p ps=1.695u w=1.12u l=0.13u
X4193 VDD VSS.t1839 VDD VDD sg13_lv_pmos ad=0.34p pd=2.68u as=0 ps=0 w=1u l=1u
X4194 VSS.t2756 VDD VSS.t2755 VSS.t206 sg13_lv_nmos ad=0.1428p pd=1.52u as=0 ps=0 w=0.42u l=1u
X4195 VDD VSS.t2631 VDD VDD sg13_lv_pmos ad=0.34p pd=2.68u as=0 ps=0 w=1u l=1u
X4196 VDD VSS.t2727 VDD VDD sg13_lv_pmos ad=0.19p pd=1.38u as=0 ps=0 w=1u l=1u
X4197 VDD sg13cmos5l_o21ai_1_2.B1 a_24365_14508# VDD sg13_lv_pmos ad=0.3822p pd=1.84u as=0.1575p ps=1.315u w=1u l=0.13u
X4198 VSS.t112 sg13cmos5l_a21oi_1_3.B1 sg13cmos5l_a21oi_1_3.Y VSS.t111 sg13_lv_nmos ad=0.2516p pd=2.16u as=0.1406p ps=1.12u w=0.74u l=0.13u
X4199 VDD VSS.t3153 VDD VDD sg13_lv_pmos ad=0.34p pd=2.68u as=0 ps=0 w=1u l=1u
X4200 a_27502_15423# a_27617_15424# VDD VDD sg13_lv_pmos ad=0.34p pd=2.68u as=0.2254p ps=1.53u w=1u l=0.5u
X4201 VDD VSS.t418 VDD VDD sg13_lv_pmos ad=0.34p pd=2.68u as=0 ps=0 w=1u l=1u
X4202 VSS.t11 sg13cmos5l_or3_1_2.B a_16969_16020# VSS.t84 sg13_lv_nmos ad=0.1045p pd=0.93u as=0.187p ps=1.78u w=0.55u l=0.13u
X4203 VDD VSS.t408 VDD VDD sg13_lv_pmos ad=0.19p pd=1.38u as=0 ps=0 w=1u l=1u
X4204 VDD VSS.t509 VDD VDD sg13_lv_pmos ad=0.19p pd=1.38u as=0 ps=0 w=1u l=1u
X4205 VDD VSS.t626 VDD VDD sg13_lv_pmos ad=0.34p pd=2.68u as=0 ps=0 w=1u l=1u
X4206 VSS.t2700 VDD VSS.t2699 VSS.t206 sg13_lv_nmos ad=0.1428p pd=1.52u as=0 ps=0 w=0.42u l=1u
X4207 VSS.t989 VDD VSS.t991 VSS.t990 sg13_lv_nmos ad=79.8f pd=0.8u as=0 ps=0 w=0.42u l=1u
X4208 VDD VSS.t1251 VDD VDD sg13_lv_pmos ad=0.34p pd=2.68u as=0 ps=0 w=1u l=1u
X4209 a_32492_15960# sg13cmos5l_dfrbpq_1_7.Q VSS.t231 VSS.t3228 sg13_lv_nmos ad=0.187p pd=1.78u as=0.14875p ps=1.16u w=0.55u l=0.13u
X4210 VDD a_27034_15202# a_26753_15424# VDD sg13_lv_pmos ad=0.1523p pd=1.38u as=0.34p ps=2.68u w=1u l=0.5u
X4211 VDD VSS.t786 VDD VDD sg13_lv_pmos ad=0.19p pd=1.38u as=0 ps=0 w=1u l=1u
X4212 VDD VSS.t978 VDD VDD sg13_lv_pmos ad=0.34p pd=2.68u as=0 ps=0 w=1u l=1u
X4213 VSS.t81 sg13cmos5l_or3_1_2.B a_23638_14862# VSS.t8 sg13_lv_nmos ad=0.1406p pd=1.12u as=0.2516p ps=2.16u w=0.74u l=0.15u
X4214 VSS.t1658 VDD VSS.t1657 VSS.t1656 sg13_lv_nmos ad=0.1428p pd=1.52u as=0 ps=0 w=0.42u l=1u
X4215 VDD VSS.t2379 VDD VDD sg13_lv_pmos ad=0.19p pd=1.38u as=0 ps=0 w=1u l=1u
X4216 VSS.t187 VDD VSS.t187 VSS.t730 sg13_lv_nmos ad=0.1428p pd=1.52u as=0 ps=0 w=0.42u l=1u
X4217 VDD VSS.t1560 VDD VDD sg13_lv_pmos ad=0.19p pd=1.38u as=0 ps=0 w=1u l=1u
X4218 VSS.t2654 VDD VSS.t2655 VSS.t206 sg13_lv_nmos ad=79.8f pd=0.8u as=0 ps=0 w=0.42u l=1u
X4219 VDD VSS.t1894 VDD VDD sg13_lv_pmos ad=0.34p pd=2.68u as=0 ps=0 w=1u l=1u
X4220 VSS.t268 VDD VSS.t270 VSS.t269 sg13_lv_nmos ad=79.8f pd=0.8u as=0 ps=0 w=0.42u l=1u
X4221 VSS.t849 VDD VSS.t848 VSS.t847 sg13_lv_nmos ad=0.1428p pd=1.52u as=0 ps=0 w=0.42u l=1u
X4222 VDD a_10960_15454# a_10905_15549# VDD sg13_lv_pmos ad=2.8961p pd=18.25u as=93.45f ps=0.865u w=0.42u l=0.13u
X4223 VDD VSS.t901 VDD VDD sg13_lv_pmos ad=0.19p pd=1.38u as=0 ps=0 w=1u l=1u
X4224 VSS.t2640 VDD VSS.t2640 VSS.t206 sg13_lv_nmos ad=0.1428p pd=1.52u as=0 ps=0 w=0.42u l=1u
X4225 VDD VSS.t2691 VDD VDD sg13_lv_pmos ad=0.19p pd=1.38u as=0 ps=0 w=1u l=1u
X4226 VSS.t1960 VDD VSS.t1959 VSS.t1958 sg13_lv_nmos ad=0.1428p pd=1.52u as=0 ps=0 w=0.42u l=1u
X4227 VSS.t302 VDD VSS.t302 VSS.t303 sg13_lv_nmos ad=79.8f pd=0.8u as=0 ps=0 w=0.42u l=1u
X4228 VSS.t396 VDD VSS.t396 VSS.t466 sg13_lv_nmos ad=79.8f pd=0.8u as=0 ps=0 w=0.42u l=1u
X4229 VDD VSS.t1191 VDD VDD sg13_lv_pmos ad=0.34p pd=2.68u as=0 ps=0 w=1u l=1u
X4230 VSS.t2302 VDD VSS.t2301 VSS.t2300 sg13_lv_nmos ad=0.1428p pd=1.52u as=0 ps=0 w=0.42u l=1u
X4231 a_2540_15960# sg13cmos5l_dlygate4sd3_1_3.A VSS.t131 VSS.t3231 sg13_lv_nmos ad=0.187p pd=1.78u as=0.14875p ps=1.16u w=0.55u l=0.13u
X4232 VSS.t626 VDD VSS.t629 VSS.t755 sg13_lv_nmos ad=79.8f pd=0.8u as=0 ps=0 w=0.42u l=1u
X4233 VDD VSS.t2261 VDD VDD sg13_lv_pmos ad=0.34p pd=2.68u as=0 ps=0 w=1u l=1u
X4234 VSS.t2492 VDD VSS.t2494 VSS.t2493 sg13_lv_nmos ad=79.8f pd=0.8u as=0 ps=0 w=0.42u l=1u
X4235 VSS.t2668 VDD VSS.t2669 VSS.t206 sg13_lv_nmos ad=79.8f pd=0.8u as=0 ps=0 w=0.42u l=1u
X4236 VDD VSS.t2434 VDD VDD sg13_lv_pmos ad=0.19p pd=1.38u as=0 ps=0 w=1u l=1u
X4237 VDD VSS.t605 VDD VDD sg13_lv_pmos ad=0.19p pd=1.38u as=0 ps=0 w=1u l=1u
X4238 VDD VSS.t776 VDD VDD sg13_lv_pmos ad=0.19p pd=1.38u as=0 ps=0 w=1u l=1u
X4239 VSS.t1213 VDD VSS.t1213 VSS.t1154 sg13_lv_nmos ad=79.8f pd=0.8u as=0 ps=0 w=0.42u l=1u
X4240 VDD VSS.t2996 VDD VDD sg13_lv_pmos ad=0.19p pd=1.38u as=0 ps=0 w=1u l=1u
X4241 VDD VSS.t1867 VDD VDD sg13_lv_pmos ad=0.19p pd=1.38u as=0 ps=0 w=1u l=1u
X4242 VSS.t1870 VDD VSS.t1869 VSS.t1868 sg13_lv_nmos ad=0.1428p pd=1.52u as=0 ps=0 w=0.42u l=1u
X4243 VSS.t404 VDD VSS.t405 VSS.t4 sg13_lv_nmos ad=79.8f pd=0.8u as=0 ps=0 w=0.42u l=1u
X4244 VSS.t2040 VDD VSS.t2042 VSS.t2041 sg13_lv_nmos ad=79.8f pd=0.8u as=0 ps=0 w=0.42u l=1u
X4245 VDD VSS.t941 VDD VDD sg13_lv_pmos ad=0.19p pd=1.38u as=0 ps=0 w=1u l=1u
X4246 VDD VSS.t1715 VDD VDD sg13_lv_pmos ad=0.19p pd=1.38u as=0 ps=0 w=1u l=1u
X4247 VDD VSS.t590 VDD VDD sg13_lv_pmos ad=0.19p pd=1.38u as=0 ps=0 w=1u l=1u
X4248 VDD VSS.t1244 VDD VDD sg13_lv_pmos ad=0.34p pd=2.68u as=0 ps=0 w=1u l=1u
X4249 VDD VSS.t2737 VDD VDD sg13_lv_pmos ad=0.34p pd=2.68u as=0 ps=0 w=1u l=1u
X4250 VDD VSS.t2399 VDD VDD sg13_lv_pmos ad=0.19p pd=1.38u as=0 ps=0 w=1u l=1u
X4251 VSS.t809 VDD VSS.t811 VSS.t810 sg13_lv_nmos ad=79.8f pd=0.8u as=0 ps=0 w=0.42u l=1u
X4252 VDD a_27500_15960# counter_value_o[5] VDD sg13_lv_pmos ad=0.2114p pd=1.54u as=0.42p ps=2.99u w=1.12u l=0.13u
X4253 VSS.t879 VDD VSS.t881 VSS.t880 sg13_lv_nmos ad=79.8f pd=0.8u as=0 ps=0 w=0.42u l=1u
X4254 VSS.t2904 VDD VSS.t2903 VSS.t2902 sg13_lv_nmos ad=0.1428p pd=1.52u as=0 ps=0 w=0.42u l=1u
X4255 VDD VSS.t426 VDD VDD sg13_lv_pmos ad=0.19p pd=1.38u as=0 ps=0 w=1u l=1u
X4256 a_26436_13735# a_26667_13844# a_26122_13945# VSS.t61 sg13_lv_nmos ad=0.2373p pd=1.97u as=79.8f ps=0.8u w=0.42u l=0.13u
X4257 a_26374_13735# sg13cmos5l_dfrbpq_1_5.RESET_B VSS.t243 VSS.t249 sg13_lv_nmos ad=37.8f pd=0.6u as=0.1701p ps=1.65u w=0.42u l=0.13u
X4258 VDD VSS.t868 VDD VDD sg13_lv_pmos ad=0.34p pd=2.68u as=0 ps=0 w=1u l=1u
X4259 VSS.t1553 VDD VSS.t1555 VSS.t1554 sg13_lv_nmos ad=79.8f pd=0.8u as=0 ps=0 w=0.42u l=1u
X4260 VSS.t1222 VDD VSS.t1223 VSS.t1154 sg13_lv_nmos ad=79.8f pd=0.8u as=0 ps=0 w=0.42u l=1u
X4261 VSS.t294 VDD VSS.t294 VSS.t299 sg13_lv_nmos ad=79.8f pd=0.8u as=0 ps=0 w=0.42u l=1u
X4262 VSS.t44 sg13cmos5l_dfrbpq_1_2.RESET_B a_15876_13722# VSS.t252 sg13_lv_nmos ad=0.1626p pd=1.415u as=60.89999f ps=0.71u w=0.42u l=0.13u
X4263 VSS.t608 VDD VSS.t608 VSS.t742 sg13_lv_nmos ad=0.1428p pd=1.52u as=0 ps=0 w=0.42u l=1u
X4264 VDD VSS.t614 VDD VDD sg13_lv_pmos ad=0.19p pd=1.38u as=0 ps=0 w=1u l=1u
X4265 VSS.t2621 VDD VSS.t2622 VSS.t206 sg13_lv_nmos ad=79.8f pd=0.8u as=0 ps=0 w=0.42u l=1u
X4266 VSS.t4 a_27472_14726# a_27121_14845# VSS.t4 sg13_lv_nmos ad=79.8f pd=0.8u as=0.1428p ps=1.52u w=0.42u l=0.13u
X4267 VDD VSS.t2426 VDD VDD sg13_lv_pmos ad=0.34p pd=2.68u as=0 ps=0 w=1u l=1u
X4268 VDD VSS.t2084 VDD VDD sg13_lv_pmos ad=0.34p pd=2.68u as=0 ps=0 w=1u l=1u
X4269 VSS.t2477 VDD VSS.t2479 VSS.t2478 sg13_lv_nmos ad=79.8f pd=0.8u as=0 ps=0 w=0.42u l=1u
X4270 a_8582_15238# a_8312_15238# VSS.t34 VSS.t3194 sg13_lv_nmos ad=0.1428p pd=1.52u as=79.8f ps=0.8u w=0.42u l=0.5u
X4271 sg13cmos5l_buf_8_2.X a_19323_13726# VDD VDD sg13_lv_pmos ad=0.2128p pd=1.5u as=0.2128p ps=1.5u w=1.12u l=0.13u
X4272 VSS.t546 VDD VSS.t548 VSS.t547 sg13_lv_nmos ad=79.8f pd=0.8u as=0 ps=0 w=0.42u l=1u
X4273 VSS.t1186 VDD VSS.t1185 VSS.t1154 sg13_lv_nmos ad=0.1428p pd=1.52u as=0 ps=0 w=0.42u l=1u
X4274 VSS.t1227 VDD VSS.t1228 VSS.t1154 sg13_lv_nmos ad=79.8f pd=0.8u as=0 ps=0 w=0.42u l=1u
X4275 VDD VSS.t2777 VDD VDD sg13_lv_pmos ad=0.34p pd=2.68u as=0 ps=0 w=1u l=1u
X4276 a_15870_15486# a_15671_15549# VSS.t4 VSS.t167 sg13_lv_nmos ad=0.27427p pd=2.28u as=4.11262p ps=27.15u w=0.795u l=0.13u
X4277 VDD VSS.t2981 VDD VDD sg13_lv_pmos ad=0.19p pd=1.38u as=0 ps=0 w=1u l=1u
X4278 VDD VSS.t509 VDD VDD sg13_lv_pmos ad=0.19p pd=1.38u as=0 ps=0 w=1u l=1u
X4279 VDD VSS.t1322 VDD VDD sg13_lv_pmos ad=0.19p pd=1.38u as=0 ps=0 w=1u l=1u
X4280 a_27472_14726# a_27215_14845# a_27634_14922# VSS.t4 sg13_lv_nmos ad=0.1428p pd=1.52u as=37.8f ps=0.6u w=0.42u l=0.13u
X4281 VSS.t1703 VDD VSS.t1705 VSS.t1704 sg13_lv_nmos ad=79.8f pd=0.8u as=0 ps=0 w=0.42u l=1u
X4282 a_12010_15202# sg13cmos5l_buf_8_2.A VSS.t30 VSS.t145 sg13_lv_nmos ad=0.1406p pd=1.12u as=0.1406p ps=1.12u w=0.74u l=0.13u
X4283 VSS.t779 VDD VSS.t778 VSS.t777 sg13_lv_nmos ad=0.1428p pd=1.52u as=0 ps=0 w=0.42u l=1u
X4284 VSS.t2676 VDD VSS.t2676 VSS.t206 sg13_lv_nmos ad=0.1428p pd=1.52u as=0 ps=0 w=0.42u l=1u
X4285 VSS.t849 VDD VSS.t848 VSS.t847 sg13_lv_nmos ad=0.1428p pd=1.52u as=0 ps=0 w=0.42u l=1u
X4286 VDD VSS.t1545 VDD VDD sg13_lv_pmos ad=0.19p pd=1.38u as=0 ps=0 w=1u l=1u
X4287 VSS.t2745 VDD VSS.t2744 VSS.t206 sg13_lv_nmos ad=0.1428p pd=1.52u as=0 ps=0 w=0.42u l=1u
X4288 VDD VSS.t1879 VDD VDD sg13_lv_pmos ad=0.34p pd=2.68u as=0 ps=0 w=1u l=1u
X4289 VSS.t2010 VDD VSS.t2012 VSS.t2011 sg13_lv_nmos ad=79.8f pd=0.8u as=0 ps=0 w=0.42u l=1u
X4290 a_26122_13945# a_26565_13701# a_26505_14113# VDD sg13_lv_pmos ad=79.8f pd=0.8u as=63f ps=0.72u w=0.42u l=0.13u
X4291 VDD VSS.t946 VDD VDD sg13_lv_pmos ad=0.19p pd=1.38u as=0 ps=0 w=1u l=1u
X4292 VSS.t1204 VDD VSS.t1203 VSS.t1154 sg13_lv_nmos ad=0.1428p pd=1.52u as=0 ps=0 w=0.42u l=1u
X4293 VDD VSS.t2411 VDD VDD sg13_lv_pmos ad=0.34p pd=2.68u as=0 ps=0 w=1u l=1u
X4294 VSS.t1498 VDD VSS.t1500 VSS.t1499 sg13_lv_nmos ad=79.8f pd=0.8u as=0 ps=0 w=0.42u l=1u
X4295 VSS.t1209 VDD VSS.t1208 VSS.t1154 sg13_lv_nmos ad=0.1428p pd=1.52u as=0 ps=0 w=0.42u l=1u
X4296 VDD VSS.t2246 VDD VDD sg13_lv_pmos ad=0.34p pd=2.68u as=0 ps=0 w=1u l=1u
X4297 VDD VSS.t1844 VDD VDD sg13_lv_pmos ad=0.34p pd=2.68u as=0 ps=0 w=1u l=1u
X4298 VDD VSS.t2692 VDD VDD sg13_lv_pmos ad=0.34p pd=2.68u as=0 ps=0 w=1u l=1u
X4299 VDD sg13cmos5l_dfrbpq_1_0.RESET_B a_2890_15457# VDD sg13_lv_pmos ad=0.1563p pd=1.22u as=0.147p ps=1.54u w=0.42u l=0.13u
X4300 a_21251_13690# sg13cmos5l_or3_1_2.A VSS.t83 VSS.t3266 sg13_lv_nmos ad=0.198p pd=1.27u as=0.13395p ps=1.12u w=0.55u l=0.13u
X4301 VSS.t1240 VDD VSS.t1241 VSS.t1154 sg13_lv_nmos ad=79.8f pd=0.8u as=0 ps=0 w=0.42u l=1u
X4302 VDD VSS.t1237 VDD VDD sg13_lv_pmos ad=0.19p pd=1.38u as=0 ps=0 w=1u l=1u
X4303 VDD VSS.t2730 VDD VDD sg13_lv_pmos ad=0.19p pd=1.38u as=0 ps=0 w=1u l=1u
X4304 VDD VSS.t2017 VDD VDD sg13_lv_pmos ad=0.19p pd=1.38u as=0 ps=0 w=1u l=1u
X4305 VSS.t1 sg13cmos5l_tiehi_1.L_HI a_9252_15234# VSS.t97 sg13_lv_nmos ad=0.1626p pd=1.415u as=60.89999f ps=0.71u w=0.42u l=0.13u
X4306 a_16068_14040# a_16042_13945# VDD VDD sg13_lv_pmos ad=0.34p pd=2.68u as=0.36237p ps=2.605u w=1u l=0.13u
X4307 VSS.t629 VDD VSS.t626 VSS.t628 sg13_lv_nmos ad=0.1428p pd=1.52u as=0 ps=0 w=0.42u l=1u
X4308 VDD VSS.t3158 VDD VDD sg13_lv_pmos ad=0.34p pd=2.68u as=0 ps=0 w=1u l=1u
X4309 VSS.t2432 VDD VSS.t2431 VSS.t2430 sg13_lv_nmos ad=0.1428p pd=1.52u as=0 ps=0 w=0.42u l=1u
X4310 VSS.t1855 VDD VSS.t1854 VSS.t1853 sg13_lv_nmos ad=0.1428p pd=1.52u as=0 ps=0 w=0.42u l=1u
X4311 VDD VSS.t2436 VDD VDD sg13_lv_pmos ad=0.34p pd=2.68u as=0 ps=0 w=1u l=1u
X4312 VSS.t934 VDD VSS.t933 VSS.t932 sg13_lv_nmos ad=0.1428p pd=1.52u as=0 ps=0 w=0.42u l=1u
X4313 VDD VSS.t1700 VDD VDD sg13_lv_pmos ad=0.19p pd=1.38u as=0 ps=0 w=1u l=1u
X4314 VSS.t809 VDD VSS.t811 VSS.t810 sg13_lv_nmos ad=79.8f pd=0.8u as=0 ps=0 w=0.42u l=1u
X4315 VSS.t1245 VDD VSS.t1246 VSS.t1154 sg13_lv_nmos ad=79.8f pd=0.8u as=0 ps=0 w=0.42u l=1u
X4316 sg13cmos5l_dfrbpq_1_2.CLK a_12010_15202# VSS.t25 VSS.t26 sg13_lv_nmos ad=0.1406p pd=1.12u as=0.1406p ps=1.12u w=0.74u l=0.13u
X4317 VSS.t2497 VDD VSS.t2499 VSS.t2498 sg13_lv_nmos ad=79.8f pd=0.8u as=0 ps=0 w=0.42u l=1u
X4318 VDD VSS.t2384 VDD VDD sg13_lv_pmos ad=0.19p pd=1.38u as=0 ps=0 w=1u l=1u
X4319 VSS.t2045 VDD VSS.t2044 VSS.t2043 sg13_lv_nmos ad=0.1428p pd=1.52u as=0 ps=0 w=0.42u l=1u
X4320 VDD VSS.t1565 VDD VDD sg13_lv_pmos ad=0.19p pd=1.38u as=0 ps=0 w=1u l=1u
X4321 VSS.t2657 VDD VSS.t2658 VSS.t206 sg13_lv_nmos ad=79.8f pd=0.8u as=0 ps=0 w=0.42u l=1u
X4322 VDD VSS.t913 VDD VDD sg13_lv_pmos ad=0.34p pd=2.68u as=0 ps=0 w=1u l=1u
X4323 VSS.t2889 VDD VSS.t2888 VSS.t2887 sg13_lv_nmos ad=0.1428p pd=1.52u as=0 ps=0 w=0.42u l=1u
X4324 VSS.t2643 VDD VSS.t2643 VSS.t206 sg13_lv_nmos ad=0.1428p pd=1.52u as=0 ps=0 w=0.42u l=1u
X4325 VDD VSS.t2658 VDD VDD sg13_lv_pmos ad=0.34p pd=2.68u as=0 ps=0 w=1u l=1u
X4326 VSS.t1930 VDD VSS.t1929 VSS.t1928 sg13_lv_nmos ad=0.1428p pd=1.52u as=0 ps=0 w=0.42u l=1u
X4327 VDD VSS.t417 VDD VDD sg13_lv_pmos ad=0.19p pd=1.38u as=0 ps=0 w=1u l=1u
X4328 VSS.t349 VDD VSS.t352 VSS.t351 sg13_lv_nmos ad=79.8f pd=0.8u as=0 ps=0 w=0.42u l=1u
X4329 VDD VSS.t861 VDD VDD sg13_lv_pmos ad=0.19p pd=1.38u as=0 ps=0 w=1u l=1u
X4330 a_25930_14452# a_26373_14495# a_26313_14531# VDD sg13_lv_pmos ad=79.8f pd=0.8u as=63f ps=0.72u w=0.42u l=0.13u
X4331 sg13cmos5l_buf_8_2.X a_19323_13726# VDD VDD sg13_lv_pmos ad=0.2128p pd=1.5u as=0.2128p ps=1.5u w=1.12u l=0.13u
X4332 VSS.t949 VDD VSS.t948 VSS.t947 sg13_lv_nmos ad=0.1428p pd=1.52u as=0 ps=0 w=0.42u l=1u
X4333 VDD VSS.t2231 VDD VDD sg13_lv_pmos ad=0.34p pd=2.68u as=0 ps=0 w=1u l=1u
X4334 VSS.t1254 VDD VSS.t1255 VSS.t1154 sg13_lv_nmos ad=79.8f pd=0.8u as=0 ps=0 w=0.42u l=1u
X4335 VSS.t2462 VDD VSS.t2464 VSS.t2463 sg13_lv_nmos ad=79.8f pd=0.8u as=0 ps=0 w=0.42u l=1u
X4336 a_21348_14909# a_21060_14488# a_21286_14909# VSS.t154 sg13_lv_nmos ad=0.1428p pd=1.52u as=37.8f ps=0.6u w=0.42u l=0.13u
X4337 VSS.t413 VDD VSS.t412 VSS.t4 sg13_lv_nmos ad=0.1428p pd=1.52u as=0 ps=0 w=0.42u l=1u
X4338 VSS.t1458 VDD VSS.t1457 VSS.t1456 sg13_lv_nmos ad=0.1428p pd=1.52u as=0 ps=0 w=0.42u l=1u
X4339 VDD VSS.t2966 VDD VDD sg13_lv_pmos ad=0.19p pd=1.38u as=0 ps=0 w=1u l=1u
X4340 VDD VSS.t3143 VDD VDD sg13_lv_pmos ad=0.34p pd=2.68u as=0 ps=0 w=1u l=1u
X4341 VSS.t2367 VDD VSS.t2366 VSS.t2365 sg13_lv_nmos ad=0.1428p pd=1.52u as=0 ps=0 w=0.42u l=1u
X4342 VSS.t1840 VDD VSS.t1839 VSS.t1838 sg13_lv_nmos ad=0.1428p pd=1.52u as=0 ps=0 w=0.42u l=1u
X4343 VSS.t779 VDD VSS.t778 VSS.t777 sg13_lv_nmos ad=0.1428p pd=1.52u as=0 ps=0 w=0.42u l=1u
X4344 VDD VSS.t1236 VDD VDD sg13_lv_pmos ad=0.34p pd=2.68u as=0 ps=0 w=1u l=1u
X4345 a_17057_14832# sg13cmos5l_a21oi_1_0.A1 sg13cmos5l_a21oi_1_0.Y VSS.t125 sg13_lv_nmos ad=0.1406p pd=1.12u as=0.1406p ps=1.12u w=0.74u l=0.13u
X4346 VSS.t38 a_6682_13690# a_6401_13912# VSS.t3219 sg13_lv_nmos ad=79.8f pd=0.8u as=0.1428p ps=1.52u w=0.42u l=0.5u
X4347 VSS.t521 VDD VSS.t520 VSS.t519 sg13_lv_nmos ad=0.1428p pd=1.52u as=0 ps=0 w=0.42u l=1u
X4348 VSS.t1009 VDD VSS.t1011 VSS.t1010 sg13_lv_nmos ad=79.8f pd=0.8u as=0 ps=0 w=0.42u l=1u
X4349 VDD VSS.t1190 VDD VDD sg13_lv_pmos ad=0.19p pd=1.38u as=0 ps=0 w=1u l=1u
X4350 VSS.t2668 VDD VSS.t2808 VSS.t206 sg13_lv_nmos ad=0.1428p pd=1.52u as=0 ps=0 w=0.42u l=1u
R0 VSS.t53 VSS.n816 2.277e+06
R1 VSS.t3216 VSS.n827 1.34743e+06
R2 VSS.t206 VSS.n406 4108.7
R3 VSS.n406 VSS.n463 4108.7
R4 VSS.n463 VSS.n520 4108.7
R5 VSS.n520 VSS.t1154 4108.7
R6 VSS.t1154 VSS.n735 4108.7
R7 VSS.n890 VSS.n735 4108.7
R8 VSS.n722 VSS.n890 4108.7
R9 VSS.t2890 VSS.n127 183.805
R10 VSS.t2895 VSS.n127 183.805
R11 VSS.n127 VSS.t2915 183.805
R12 VSS.n127 VSS.t2925 183.805
R13 VSS.n127 VSS.t2935 183.805
R14 VSS.n127 VSS.t2940 183.806
R15 VSS.n127 VSS.t2955 183.806
R16 VSS.t2985 VSS.n127 183.806
R17 VSS.t2990 VSS.n127 183.805
R18 VSS.t3005 VSS.n127 183.805
R19 VSS.t3025 VSS.n127 183.806
R20 VSS.t3030 VSS.n127 183.805
R21 VSS.t3035 VSS.n127 183.806
R22 VSS.n127 VSS.t3055 183.805
R23 VSS.n127 VSS.t3085 183.805
R24 VSS.n127 VSS.t3105 183.806
R25 VSS.t3110 VSS.n127 183.805
R26 VSS.n127 VSS.t3125 183.805
R27 VSS.t3140 VSS.n127 183.806
R28 VSS.n127 VSS.t3145 183.805
R29 VSS.n127 VSS.t3155 183.805
R30 VSS.t206 VSS.n127 4435.04
R31 VSS.t168 VSS.t205 612.602
R32 VSS.n24 VSS.t2313 109.992
R33 VSS.t2263 VSS.n24 109.992
R34 VSS.n24 VSS.t2278 109.993
R35 VSS.t2293 VSS.n24 109.992
R36 VSS.t2343 VSS.n24 109.992
R37 VSS.t2363 VSS.n24 109.992
R38 VSS.n24 VSS.t2368 109.993
R39 VSS.n24 VSS.t2378 109.993
R40 VSS.t2383 VSS.n24 109.992
R41 VSS.t2403 VSS.n24 109.992
R42 VSS.n24 VSS.t2408 109.993
R43 VSS.n24 VSS.t2428 109.992
R44 VSS.n24 VSS.t2448 109.992
R45 VSS.n24 VSS.t2478 109.993
R46 VSS.t2483 VSS.n24 109.992
R47 VSS.t1861 VSS.n22 109.992
R48 VSS.t1881 VSS.n22 109.992
R49 VSS.n22 VSS.t1888 109.001
R50 VSS.n22 VSS.t1903 108.999
R51 VSS.t1911 VSS.n22 109.992
R52 VSS.n22 VSS.t1926 109.993
R53 VSS.t1971 VSS.n22 109.993
R54 VSS.n22 VSS.t1976 109.992
R55 VSS.t1981 VSS.n22 109.992
R56 VSS.t1991 VSS.n22 109.993
R57 VSS.t2001 VSS.n22 109.992
R58 VSS.t2026 VSS.n22 109.992
R59 VSS.t2031 VSS.n22 109.993
R60 VSS.t2041 VSS.n22 109.993
R61 VSS.t2046 VSS.n22 109.992
R62 VSS.t2051 VSS.n22 109.993
R63 VSS.t2061 VSS.n22 109.993
R64 VSS.t1439 VSS.n23 109.986
R65 VSS.n23 VSS.t1471 108.999
R66 VSS.t1489 VSS.n23 109.992
R67 VSS.n23 VSS.t1501 108.999
R68 VSS.t1519 VSS.n23 109.992
R69 VSS.t1579 VSS.n23 109.993
R70 VSS.t1584 VSS.n23 109.992
R71 VSS.t1604 VSS.n23 109.993
R72 VSS.t1614 VSS.n23 109.992
R73 VSS.t1634 VSS.n23 109.992
R74 VSS.n23 VSS.t1649 109.993
R75 VSS.t1654 VSS.n23 109.992
R76 VSS.n23 VSS.t1659 109.992
R77 VSS.n23 VSS.t1709 109.992
R78 VSS.n117 VSS.t787 109.001
R79 VSS.t825 VSS.n117 109.992
R80 VSS.t880 VSS.n117 109.992
R81 VSS.n117 VSS.t887 108.999
R82 VSS.n117 VSS.t927 108.999
R83 VSS.n117 VSS.t952 108.999
R84 VSS.n117 VSS.t962 108.999
R85 VSS.n117 VSS.t972 108.999
R86 VSS.t1022 VSS.n117 108.999
R87 VSS.t91 VSS.t66 72.0407
R88 VSS.n88 VSS.t714 109.644
R89 VSS.n148 VSS.t66 15.2046
R90 VSS.t66 VSS.t549 109.001
R91 VSS.t564 VSS.t66 108.999
R92 VSS.t50 VSS.n156 60.3116
R93 VSS.n45 VSS.t3197 424.017
R94 VSS.t636 VSS.n171 243.169
R95 VSS.n89 VSS.t111 418.56
R96 VSS.t66 VSS.n126 3.41984
R97 VSS.n24 VSS.n406 427.5
R98 VSS.n22 VSS.n463 427.5
R99 VSS.n23 VSS.n520 427.5
R100 VSS.n118 VSS.n735 427.885
R101 VSS.n191 VSS.t186 75.7034
R102 VSS.t597 VSS.n189 242.846
R103 VSS.t600 VSS.n188 242.846
R104 VSS.t603 VSS.n187 242.846
R105 VSS.t609 VSS.n184 242.846
R106 VSS.t615 VSS.n182 242.846
R107 VSS.t618 VSS.n181 242.846
R108 VSS.t627 VSS.n175 242.846
R109 VSS.t3184 VSS.n130 420.111
R110 VSS.t705 VSS.n212 242.846
R111 VSS.t707 VSS.n203 242.846
R112 VSS.t709 VSS.n201 242.846
R113 VSS.t4 VSS.n722 427.5
R114 VSS.t3198 VSS.n806 408.31
R115 VSS.n755 VSS.t3250 407.144
R116 VSS.n876 VSS.t26 407.144
R117 VSS.n849 VSS.t35 407.144
R118 VSS.n853 VSS.t3242 407.144
R119 VSS.t2907 VSS.n127 182.042
R120 VSS.t2917 VSS.n127 182.042
R121 VSS.t2942 VSS.n127 182.042
R122 VSS.t2962 VSS.n127 182.042
R123 VSS.t2967 VSS.n127 182.042
R124 VSS.n127 VSS.t2977 182.042
R125 VSS.n127 VSS.t2997 182.042
R126 VSS.n127 VSS.t3007 182.042
R127 VSS.n127 VSS.t3012 182.042
R128 VSS.n127 VSS.t3047 182.042
R129 VSS.n127 VSS.t3057 182.042
R130 VSS.t3062 VSS.n127 182.042
R131 VSS.n127 VSS.t3077 182.042
R132 VSS.t3092 VSS.n127 182.042
R133 VSS.n127 VSS.t3117 182.042
R134 VSS.n127 VSS.t3127 182.042
R135 VSS.t3132 VSS.n127 182.042
R136 VSS.n127 VSS.t3147 182.042
R137 VSS.n127 VSS.t3157 182.042
R138 VSS.t102 VSS.n888 402.858
R139 VSS.t67 VSS.n143 75.2357
R140 VSS.n931 VSS.t49 398.572
R141 VSS.t129 VSS.n829 398.572
R142 VSS.t120 VSS.t211 398.572
R143 VSS.n43 VSS.t3230 398.228
R144 VSS.n831 VSS.t3202 397.132
R145 VSS.t3168 VSS.n36 397.132
R146 VSS.n900 VSS.t141 394.286
R147 VSS.n127 VSS.t2885 183.804
R148 VSS.n820 VSS.t101 391.118
R149 VSS.n929 VSS.t3249 390
R150 VSS.t27 VSS.n870 390
R151 VSS.t3169 VSS.n159 36.5344
R152 VSS.t3264 VSS.n50 386.526
R153 VSS.n760 VSS.t3266 385.714
R154 VSS.n797 VSS.t3277 385.714
R155 VSS.n40 VSS.t3187 385.334
R156 VSS.t175 VSS.n34 384.274
R157 VSS.t37 VSS.n787 381.43
R158 VSS.t24 VSS.n834 381.43
R159 VSS.t194 VSS.n798 381.43
R160 VSS.n41 VSS.t3232 381.036
R161 VSS.t192 VSS.n45 381.036
R162 VSS.t3188 VSS.n790 377.144
R163 VSS.t212 VSS.n836 377.144
R164 VSS.n852 VSS.t80 377.144
R165 VSS.t65 VSS.n128 43.6455
R166 VSS.t3281 VSS.n50 376.724
R167 VSS.t3174 VSS.n754 368.572
R168 VSS.t59 VSS.n901 368.572
R169 VSS.n902 VSS.t235 368.572
R170 VSS.n883 VSS.t104 368.572
R171 VSS.t3223 VSS.n841 368.572
R172 VSS.t55 VSS.n46 368.142
R173 VSS.n47 VSS.t3190 368.142
R174 VSS.n872 VSS.t28 364.286
R175 VSS.n851 VSS.t3240 364.286
R176 VSS.n878 VSS.t260 361.033
R177 VSS.t54 VSS.n807 361.033
R178 VSS.t133 VSS.n796 360
R179 VSS.n757 VSS.t3252 355.714
R180 VSS.t23 VSS.n833 355.714
R181 VSS.n848 VSS.t109 355.714
R182 VSS.n854 VSS.t3244 355.714
R183 VSS.t67 VSS.n906 351.43
R184 VSS.t186 VSS.n911 351.43
R185 VSS.t3193 VSS.n749 351.43
R186 VSS.n881 VSS.t173 351.43
R187 VSS.t3238 VSS.n156 99.148
R188 VSS.t213 VSS.n835 351.43
R189 VSS.t17 VSS.n843 351.43
R190 VSS.t119 VSS.n48 350.95
R191 VSS.n823 VSS.t238 348.139
R192 VSS.t161 VSS.n750 347.144
R193 VSS.n832 VSS.t143 347.144
R194 VSS.n902 VSS.t166 342.858
R195 VSS.t40 VSS.n43 342.354
R196 VSS.t156 VSS.n47 342.354
R197 VSS.t66 VSS.n134 13.0749
R198 VSS.t3283 VSS.n801 339.543
R199 VSS.n753 VSS.t3247 338.572
R200 VSS.n886 VSS.t215 338.572
R201 VSS.t3239 VSS.n844 338.572
R202 VSS.t3209 VSS.n765 337.046
R203 VSS.t118 VSS.n817 335.245
R204 VSS.t2905 VSS.n127 183.806
R205 VSS.t2930 VSS.n127 183.806
R206 VSS.t2945 VSS.n127 183.806
R207 VSS.t2960 VSS.n127 183.806
R208 VSS.t2970 VSS.n127 183.806
R209 VSS.t3000 VSS.n127 183.806
R210 VSS.t3040 VSS.n127 183.806
R211 VSS.t3050 VSS.n127 183.806
R212 VSS.t3065 VSS.n127 183.806
R213 VSS.t3090 VSS.n127 183.806
R214 VSS.t3115 VSS.n127 183.806
R215 VSS.t3120 VSS.n127 183.806
R216 VSS.t3160 VSS.n127 183.806
R217 VSS.t46 VSS.t3258 330.947
R218 VSS.n758 VSS.t3253 330
R219 VSS.t3276 VSS.n846 330
R220 VSS.n126 VSS.t242 66.199
R221 VSS.n935 VSS.t43 329.168
R222 VSS.t180 VSS.n861 329.168
R223 VSS.t221 VSS.n860 329.168
R224 VSS.t15 VSS.n152 83.7485
R225 VSS.n800 VSS.t245 329.168
R226 VSS.t3196 VSS.t184 326.649
R227 VSS.t203 VSS.n910 325.714
R228 VSS.n847 VSS.t214 325.714
R229 VSS.t4 VSS.t142 321.486
R230 VSS.t128 VSS.n158 77.4642
R231 VSS.n91 VSS.t170 319.99
R232 VSS.n36 VSS.t3246 319.99
R233 VSS.t135 VSS.n29 319.99
R234 VSS.n127 VSS.t3152 182.042
R235 VSS.n127 VSS.t3150 183.806
R236 VSS.n127 VSS.t3142 182.042
R237 VSS.t3137 VSS.n127 182.042
R238 VSS.t3135 VSS.n127 183.805
R239 VSS.n127 VSS.t3130 183.806
R240 VSS.n127 VSS.t3122 182.042
R241 VSS.n127 VSS.t3112 182.042
R242 VSS.t3107 VSS.n127 182.042
R243 VSS.n127 VSS.t3102 182.042
R244 VSS.t3097 VSS.n127 182.042
R245 VSS.t3095 VSS.n127 183.806
R246 VSS.t3087 VSS.n127 182.042
R247 VSS.n127 VSS.t3082 182.042
R248 VSS.n127 VSS.t3080 183.806
R249 VSS.n127 VSS.t3072 182.042
R250 VSS.t3067 VSS.n127 182.042
R251 VSS.n127 VSS.t3060 183.806
R252 VSS.n127 VSS.t3052 182.042
R253 VSS.t3042 VSS.n127 182.042
R254 VSS.t3037 VSS.n127 182.042
R255 VSS.t3032 VSS.n127 182.042
R256 VSS.t3027 VSS.n127 182.042
R257 VSS.t3022 VSS.n127 182.042
R258 VSS.t3017 VSS.n127 182.042
R259 VSS.n127 VSS.t3015 183.806
R260 VSS.n127 VSS.t3010 183.806
R261 VSS.t3002 VSS.n127 182.042
R262 VSS.t2992 VSS.n127 182.042
R263 VSS.t2987 VSS.n127 182.042
R264 VSS.t2982 VSS.n127 182.042
R265 VSS.n127 VSS.t2980 183.806
R266 VSS.n127 VSS.t2972 182.042
R267 VSS.t2965 VSS.n127 183.805
R268 VSS.n127 VSS.t2957 182.042
R269 VSS.n127 VSS.t2952 182.042
R270 VSS.n127 VSS.t2947 182.042
R271 VSS.n127 VSS.t2937 182.042
R272 VSS.n127 VSS.t2932 182.042
R273 VSS.n127 VSS.t2927 182.042
R274 VSS.n127 VSS.t2922 182.042
R275 VSS.t2920 VSS.n127 183.806
R276 VSS.n127 VSS.t2912 182.042
R277 VSS.t2910 VSS.n127 183.805
R278 VSS.n127 VSS.t2902 182.042
R279 VSS.t2897 VSS.n127 182.042
R280 VSS.n127 VSS.t2892 182.042
R281 VSS.t2887 VSS.n127 182.042
R282 VSS.n127 VSS.t2882 181.875
R283 VSS.n822 VSS.t3176 313.755
R284 VSS.n827 VSS.t33 313.755
R285 VSS.t152 VSS.n752 312.858
R286 VSS.n889 VSS.t3189 312.858
R287 VSS.n873 VSS.t145 312.858
R288 VSS.n850 VSS.t3235 312.858
R289 VSS.t85 VSS.n840 312.858
R290 VSS.t725 VSS.n905 305.159
R291 VSS.n816 VSS.n812 305.159
R292 VSS.n146 VSS.t3265 312.969
R293 VSS.t14 VSS.n765 292.264
R294 VSS.n865 VSS.t208 292.264
R295 VSS.n813 VSS.t95 292.264
R296 VSS.t3215 VSS.n151 304.37
R297 VSS.t220 VSS.n886 291.43
R298 VSS.n46 VSS.t3178 290.779
R299 VSS.t146 VSS.n868 287.144
R300 VSS.n799 VSS.t3199 287.144
R301 VSS.n893 VSS.t36 283.334
R302 VSS.t3208 VSS.n860 283.334
R303 VSS.n856 VSS.t264 283.334
R304 VSS.t107 VSS.t258 279.37
R305 VSS.t261 VSS.t31 279.37
R306 VSS.n138 VSS.t66 10.6179
R307 VSS.n905 VSS.t71 275.072
R308 VSS.n122 VSS.t72 288.68
R309 VSS.n865 VSS.t73 275.072
R310 VSS.t70 VSS.n858 275.072
R311 VSS.n812 VSS.t3180 275.072
R312 VSS.n48 VSS.t3194 273.587
R313 VSS.n108 VSS.t256 272.846
R314 VSS.t3165 VSS.t39 266.476
R315 VSS.n818 VSS.t3173 266.476
R316 VSS.t169 VSS.t219 266.476
R317 VSS.t217 VSS.t155 266.476
R318 VSS.t202 VSS.t248 265.714
R319 VSS.t56 VSS.n845 265.714
R320 VSS.n874 VSS.t148 261.43
R321 VSS.n849 VSS.t3233 261.43
R322 VSS.n927 VSS.t64 258.334
R323 VSS.t253 VSS.t3213 258.334
R324 VSS.t3191 VSS.n932 258.334
R325 VSS.n766 VSS.t233 258.334
R326 VSS.t3272 VSS.t154 258.334
R327 VSS.n857 VSS.t45 258.334
R328 VSS.t222 VSS.t3164 258.334
R329 VSS.t90 VSS.n122 37.8459
R330 VSS.n878 VSS.t451 257.88
R331 VSS.n882 VSS.t3219 257.144
R332 VSS.t3195 VSS.n828 257.144
R333 VSS.n855 VSS.t183 257.144
R334 VSS.t218 VSS.n809 253.583
R335 VSS.t512 VSS.t66 108.999
R336 VSS.n93 VSS.t592 251.417
R337 VSS.n77 VSS.t595 251.417
R338 VSS.n95 VSS.t598 251.417
R339 VSS.n75 VSS.t601 251.417
R340 VSS.n97 VSS.t604 251.417
R341 VSS.n73 VSS.t607 251.417
R342 VSS.n99 VSS.t610 251.417
R343 VSS.n71 VSS.t613 251.417
R344 VSS.n101 VSS.t616 251.417
R345 VSS.n69 VSS.t619 251.417
R346 VSS.n103 VSS.t622 251.417
R347 VSS.n67 VSS.t625 251.417
R348 VSS.n105 VSS.t628 251.417
R349 VSS.n65 VSS.t631 251.417
R350 VSS.n107 VSS.t634 251.417
R351 VSS.n81 VSS.t706 251.417
R352 VSS.n86 VSS.t708 251.417
R353 VSS.n79 VSS.t710 251.417
R354 VSS.t712 VSS.n87 251.417
R355 VSS.n890 VSS.t66 427.5
R356 VSS.n62 VSS.t652 251.417
R357 VSS.n31 VSS.t393 251.417
R358 VSS.n33 VSS.t465 251.417
R359 VSS.n936 VSS.t252 250.952
R360 VSS.t3211 VSS.n839 250.952
R361 VSS.t3163 VSS.n794 250.952
R362 VSS.t132 VSS.n837 250
R363 VSS.t137 VSS.n27 249.002
R364 VSS.n49 VSS.t114 249.002
R365 VSS.t53 VSS.n42 243.5
R366 VSS.t66 VSS.t501 109.986
R367 VSS.t503 VSS.t66 109.993
R368 VSS.t508 VSS.t66 109.993
R369 VSS.t66 VSS.t515 109.992
R370 VSS.t66 VSS.t700 243.47
R371 VSS.n92 VSS.t731 242.846
R372 VSS.n78 VSS.t733 242.846
R373 VSS.n94 VSS.t735 242.846
R374 VSS.n76 VSS.t737 242.846
R375 VSS.n96 VSS.t739 242.846
R376 VSS.n74 VSS.t741 242.846
R377 VSS.n98 VSS.t743 242.846
R378 VSS.n72 VSS.t745 242.846
R379 VSS.n100 VSS.t747 242.846
R380 VSS.n70 VSS.t749 242.846
R381 VSS.n102 VSS.t751 242.846
R382 VSS.n68 VSS.t753 242.846
R383 VSS.n104 VSS.t755 242.846
R384 VSS.n66 VSS.t757 242.846
R385 VSS.n106 VSS.t759 242.846
R386 VSS.n82 VSS.t579 242.846
R387 VSS.n85 VSS.t582 242.846
R388 VSS.n80 VSS.t585 242.846
R389 VSS.n63 VSS.t518 242.846
R390 VSS.n32 VSS.t464 242.846
R391 VSS.n33 VSS.t394 242.846
R392 VSS.n149 VSS.t4 9.30614
R393 VSS.n29 VSS.t391 242.846
R394 VSS.t116 VSS.t0 240.689
R395 VSS.n128 VSS.t722 238.357
R396 VSS.n815 VSS.t452 236.391
R397 VSS.n24 VSS.t2220 108.722
R398 VSS.n24 VSS.t2230 108.999
R399 VSS.n24 VSS.t2235 108.999
R400 VSS.t2255 VSS.n24 108.999
R401 VSS.t2265 VSS.n24 108.999
R402 VSS.n24 VSS.t2270 109.001
R403 VSS.t2285 VSS.n24 108.999
R404 VSS.n24 VSS.t2300 109.001
R405 VSS.t2315 VSS.n24 108.999
R406 VSS.n24 VSS.t2330 109.001
R407 VSS.t2335 VSS.n24 108.999
R408 VSS.t2345 VSS.n24 108.999
R409 VSS.t2355 VSS.n24 108.999
R410 VSS.t2385 VSS.n24 108.999
R411 VSS.t2395 VSS.n24 108.999
R412 VSS.n24 VSS.t2410 108.999
R413 VSS.n24 VSS.t2430 108.999
R414 VSS.t2435 VSS.n24 109.001
R415 VSS.n24 VSS.t2450 108.999
R416 VSS.t2455 VSS.n24 108.999
R417 VSS.t2495 VSS.n24 108.999
R418 VSS.n22 VSS.t1828 108.722
R419 VSS.n22 VSS.t1833 109.001
R420 VSS.n22 VSS.t1838 108.999
R421 VSS.n22 VSS.t1853 108.999
R422 VSS.n22 VSS.t1863 108.999
R423 VSS.n22 VSS.t1868 109.001
R424 VSS.n22 VSS.t1883 108.999
R425 VSS.t1933 VSS.n22 108.999
R426 VSS.t1953 VSS.n22 108.999
R427 VSS.n22 VSS.t1958 109.001
R428 VSS.t1963 VSS.n22 108.999
R429 VSS.t1983 VSS.n22 108.999
R430 VSS.t1993 VSS.n22 109.001
R431 VSS.n22 VSS.t2003 108.999
R432 VSS.n22 VSS.t2013 109.001
R433 VSS.n22 VSS.t2018 108.999
R434 VSS.n22 VSS.t2033 108.999
R435 VSS.n22 VSS.t2053 109.001
R436 VSS.n22 VSS.t2063 108.999
R437 VSS.t2073 VSS.n22 108.999
R438 VSS.n22 VSS.t2078 109.001
R439 VSS.t2083 VSS.n22 108.999
R440 VSS.t2093 VSS.n22 108.999
R441 VSS.n22 VSS.t2098 109.001
R442 VSS.n23 VSS.t1441 109.001
R443 VSS.n23 VSS.t1446 108.999
R444 VSS.t1461 VSS.n23 108.999
R445 VSS.t1481 VSS.n23 108.999
R446 VSS.t1491 VSS.n23 108.999
R447 VSS.n23 VSS.t1496 109.001
R448 VSS.t1521 VSS.n23 108.999
R449 VSS.n23 VSS.t1531 109.001
R450 VSS.n23 VSS.t1541 108.999
R451 VSS.n23 VSS.t1556 109.001
R452 VSS.n23 VSS.t1566 109.001
R453 VSS.n23 VSS.t1571 108.999
R454 VSS.n23 VSS.t1586 108.999
R455 VSS.t1606 VSS.n23 108.999
R456 VSS.n23 VSS.t1621 108.999
R457 VSS.t1626 VSS.n23 108.999
R458 VSS.t1636 VSS.n23 109.001
R459 VSS.n23 VSS.t1641 108.999
R460 VSS.n23 VSS.t1661 108.999
R461 VSS.n23 VSS.t1681 108.999
R462 VSS.n23 VSS.t1701 108.999
R463 VSS.n117 VSS.t767 108.999
R464 VSS.n117 VSS.t777 108.999
R465 VSS.n117 VSS.t797 108.999
R466 VSS.n117 VSS.t807 108.999
R467 VSS.n117 VSS.t827 108.999
R468 VSS.n117 VSS.t832 108.999
R469 VSS.n117 VSS.t847 108.999
R470 VSS.n117 VSS.t852 108.999
R471 VSS.n117 VSS.t857 108.999
R472 VSS.n117 VSS.t862 109.001
R473 VSS.n117 VSS.t882 109.001
R474 VSS.n117 VSS.t967 109.001
R475 VSS.n117 VSS.t977 109.001
R476 VSS.n117 VSS.t1012 109.001
R477 VSS.t1037 VSS.n117 108.999
R478 VSS.n191 VSS.t730 251.417
R479 VSS.n190 VSS.t732 251.417
R480 VSS.n189 VSS.t734 251.417
R481 VSS.n188 VSS.t736 251.417
R482 VSS.n187 VSS.t738 251.417
R483 VSS.n185 VSS.t740 251.417
R484 VSS.n184 VSS.t742 251.417
R485 VSS.n183 VSS.t744 251.417
R486 VSS.n182 VSS.t746 251.417
R487 VSS.n181 VSS.t748 251.417
R488 VSS.n180 VSS.t750 251.417
R489 VSS.n177 VSS.t752 251.417
R490 VSS.n175 VSS.t754 251.417
R491 VSS.n174 VSS.t756 251.417
R492 VSS.n173 VSS.t758 251.417
R493 VSS.n930 VSS.t688 235.714
R494 VSS.t692 VSS.n134 238.992
R495 VSS.n136 VSS.t693 106.677
R496 VSS.n138 VSS.t696 241.448
R497 VSS.t701 VSS.n129 105.331
R498 VSS.n760 VSS.t703 235.714
R499 VSS.n212 VSS.t577 251.417
R500 VSS.n203 VSS.t581 251.417
R501 VSS.n201 VSS.t584 251.417
R502 VSS.n198 VSS.t587 251.417
R503 VSS.n903 VSS.t716 235.714
R504 VSS.n888 VSS.t517 235.714
R505 VSS.n887 VSS.t654 235.714
R506 VSS.t519 VSS.t66 108.993
R507 VSS.t66 VSS.t524 108.999
R508 VSS.t539 VSS.t66 108.999
R509 VSS.t66 VSS.t544 108.999
R510 VSS.t559 VSS.t66 109.001
R511 VSS.t458 VSS.t4 108.635
R512 VSS.n875 VSS.t461 235.714
R513 VSS.n874 VSS.t463 235.714
R514 VSS.t4 VSS.t390 252.065
R515 VSS.n168 VSS.t48 249.002
R516 VSS.n864 VSS.t181 233.333
R517 VSS.t12 VSS.n837 233.333
R518 VSS.n28 VSS.t3200 232.335
R519 VSS.n934 VSS.t680 229.167
R520 VSS.n160 VSS.t453 102.749
R521 VSS.n24 VSS.t2243 109.992
R522 VSS.n24 VSS.t2308 109.993
R523 VSS.n22 VSS.t1901 109.992
R524 VSS.n23 VSS.t1454 109.993
R525 VSS.n23 VSS.t1469 109.992
R526 VSS.n23 VSS.t1514 109.993
R527 VSS.n117 VSS.t775 109.992
R528 VSS.n117 VSS.t785 109.992
R529 VSS.n117 VSS.t805 109.992
R530 VSS.n117 VSS.t900 109.992
R531 VSS.n117 VSS.t905 109.992
R532 VSS.n117 VSS.t925 109.992
R533 VSS.n117 VSS.t940 109.992
R534 VSS.n117 VSS.t950 109.992
R535 VSS.n117 VSS.t990 109.992
R536 VSS.n117 VSS.t995 109.992
R537 VSS.n910 VSS.t729 227.143
R538 VSS.n190 VSS.t594 242.846
R539 VSS.n185 VSS.t606 242.846
R540 VSS.n183 VSS.t612 242.846
R541 VSS.n180 VSS.t621 242.846
R542 VSS.n177 VSS.t624 242.846
R543 VSS.n174 VSS.t630 242.846
R544 VSS.n173 VSS.t633 242.846
R545 VSS.n130 VSS.t702 102.457
R546 VSS.n198 VSS.t711 242.846
R547 VSS.n163 VSS.t653 242.846
R548 VSS.n148 VSS.t656 228.291
R549 VSS.t66 VSS.t522 109.986
R550 VSS.n146 VSS.t678 102.457
R551 VSS.t462 VSS.n869 227.143
R552 VSS.t74 VSS.t263 225
R553 VSS.t651 VSS.t66 111.022
R554 VSS.t575 VSS.n129 107.358
R555 VSS.t392 VSS.n42 222.011
R556 VSS.t591 VSS.n89 221.417
R557 VSS.n30 VSS.t395 221.417
R558 VSS.n35 VSS.t397 221.417
R559 VSS.t66 VSS.t720 237.142
R560 VSS.n933 VSS.t682 220.833
R561 VSS.t3279 VSS.t5 212.5
R562 VSS.n160 VSS.t392 214.988
R563 VSS.t698 VSS.t3251 205.714
R564 VSS.t715 VSS.n161 102.707
R565 VSS.n903 VSS.t591 205.714
R566 VSS.t569 VSS.n147 15.0018
R567 VSS.t395 VSS.n149 212.761
R568 VSS.n847 VSS.t467 205.714
R569 VSS.n243 VSS.t467 221.417
R570 VSS.t397 VSS.n243 221.417
R571 VSS.n160 VSS.t4 7.66894
R572 VSS.t695 VSS.t66 109.981
R573 VSS.t2223 VSS.n24 109.986
R574 VSS.t2238 VSS.n24 109.993
R575 VSS.t2248 VSS.n24 109.993
R576 VSS.t2258 VSS.n24 109.993
R577 VSS.t2298 VSS.n24 109.993
R578 VSS.t2328 VSS.n24 109.993
R579 VSS.t2338 VSS.n24 109.993
R580 VSS.t2413 VSS.n24 109.993
R581 VSS.t2423 VSS.n24 109.993
R582 VSS.t2443 VSS.n24 109.993
R583 VSS.t2453 VSS.n24 109.993
R584 VSS.t2463 VSS.n24 109.993
R585 VSS.t2488 VSS.n24 109.993
R586 VSS.t2498 VSS.n24 109.993
R587 VSS.t1831 VSS.n22 109.986
R588 VSS.t1846 VSS.n22 109.993
R589 VSS.t1866 VSS.n22 109.993
R590 VSS.t1876 VSS.n22 109.993
R591 VSS.t1896 VSS.n22 109.993
R592 VSS.t1906 VSS.n22 109.993
R593 VSS.t1916 VSS.n22 109.993
R594 VSS.t1921 VSS.n22 109.992
R595 VSS.t1946 VSS.n22 109.993
R596 VSS.t1966 VSS.n22 109.993
R597 VSS.t1986 VSS.n22 109.993
R598 VSS.t2011 VSS.n22 109.993
R599 VSS.t2021 VSS.n22 109.993
R600 VSS.t2036 VSS.n22 109.993
R601 VSS.n22 VSS.t2066 109.993
R602 VSS.t2086 VSS.n22 109.993
R603 VSS.t2106 VSS.n22 109.993
R604 VSS.t1474 VSS.n23 109.993
R605 VSS.t1504 VSS.n23 109.993
R606 VSS.t1524 VSS.n23 109.993
R607 VSS.t1529 VSS.n23 109.993
R608 VSS.t1539 VSS.n23 109.993
R609 VSS.t1544 VSS.n23 109.993
R610 VSS.t1554 VSS.n23 109.993
R611 VSS.t1564 VSS.n23 109.993
R612 VSS.t1574 VSS.n23 109.993
R613 VSS.t1609 VSS.n23 109.993
R614 VSS.t1619 VSS.n23 109.993
R615 VSS.t1644 VSS.n23 109.993
R616 VSS.t1664 VSS.n23 109.993
R617 VSS.t1674 VSS.n23 109.993
R618 VSS.t1684 VSS.n23 109.993
R619 VSS.t1694 VSS.n23 109.993
R620 VSS.t1714 VSS.n23 109.993
R621 VSS.t765 VSS.n117 109.986
R622 VSS.t780 VSS.n117 109.993
R623 VSS.t815 VSS.n117 109.993
R624 VSS.t820 VSS.n117 109.993
R625 VSS.t840 VSS.n117 109.993
R626 VSS.n117 VSS.t855 109.993
R627 VSS.t860 VSS.n117 109.993
R628 VSS.t870 VSS.n117 109.993
R629 VSS.t890 VSS.n117 109.993
R630 VSS.t910 VSS.n117 109.993
R631 VSS.t955 VSS.n117 109.993
R632 VSS.t960 VSS.n117 109.993
R633 VSS.t1030 VSS.n117 109.993
R634 VSS.t1040 VSS.n117 109.993
R635 VSS.t66 VSS.n135 86.7544
R636 VSS.n130 VSS.t66 7.66905
R637 VSS.t532 VSS.t66 109.993
R638 VSS.t537 VSS.t66 109.993
R639 VSS.t557 VSS.t66 109.992
R640 VSS.n146 VSS.t66 7.66905
R641 VSS.t457 VSS.t4 200.613
R642 VSS.t388 VSS.t4 109.986
R643 VSS.t729 VSS.n909 199.989
R644 VSS.t594 VSS.n92 199.989
R645 VSS.t597 VSS.n78 199.989
R646 VSS.t600 VSS.n94 199.989
R647 VSS.t603 VSS.n76 199.989
R648 VSS.t606 VSS.n96 199.989
R649 VSS.t609 VSS.n74 199.989
R650 VSS.t612 VSS.n98 199.989
R651 VSS.t615 VSS.n72 199.989
R652 VSS.t618 VSS.n100 199.989
R653 VSS.t621 VSS.n70 199.989
R654 VSS.t624 VSS.n102 199.989
R655 VSS.t627 VSS.n68 199.989
R656 VSS.t630 VSS.n104 199.989
R657 VSS.t633 VSS.n66 199.989
R658 VSS.t636 VSS.n106 199.989
R659 VSS.t705 VSS.n84 199.989
R660 VSS.t707 VSS.n82 199.989
R661 VSS.t709 VSS.n85 199.989
R662 VSS.t711 VSS.n80 199.989
R663 VSS.n88 VSS.t589 243.139
R664 VSS.t653 VSS.n63 199.989
R665 VSS.t394 VSS.n32 199.989
R666 VSS.t96 VSS.t42 193.411
R667 VSS.t2490 VSS.n24 109.001
R668 VSS.n24 VSS.t2485 108.999
R669 VSS.t2480 VSS.n24 109.001
R670 VSS.n24 VSS.t2475 108.999
R671 VSS.t2470 VSS.n24 109.001
R672 VSS.n24 VSS.t2465 109.001
R673 VSS.t2460 VSS.n24 108.999
R674 VSS.t2458 VSS.n24 109.993
R675 VSS.n24 VSS.t2445 109.001
R676 VSS.t2440 VSS.n24 108.999
R677 VSS.t2438 VSS.n24 109.992
R678 VSS.n24 VSS.t2433 109.993
R679 VSS.n24 VSS.t2425 109.001
R680 VSS.t2420 VSS.n24 108.999
R681 VSS.n24 VSS.t2415 109.001
R682 VSS.n24 VSS.t2405 108.999
R683 VSS.t2400 VSS.n24 109.001
R684 VSS.t2398 VSS.n24 109.993
R685 VSS.t2390 VSS.n24 109.001
R686 VSS.t2388 VSS.n24 109.993
R687 VSS.t2380 VSS.n24 109.001
R688 VSS.n24 VSS.t2375 108.999
R689 VSS.t2370 VSS.n24 109.001
R690 VSS.n24 VSS.t2365 108.999
R691 VSS.t2360 VSS.n24 109.001
R692 VSS.t2358 VSS.n24 109.993
R693 VSS.t2350 VSS.n24 109.001
R694 VSS.t2348 VSS.n24 109.993
R695 VSS.t2340 VSS.n24 109.001
R696 VSS.n24 VSS.t2333 109.992
R697 VSS.n24 VSS.t2325 108.999
R698 VSS.t2320 VSS.n24 109.001
R699 VSS.t2318 VSS.n24 109.993
R700 VSS.n24 VSS.t2305 108.999
R701 VSS.n24 VSS.t2303 109.992
R702 VSS.n24 VSS.t2295 108.999
R703 VSS.t2290 VSS.n24 109.001
R704 VSS.t2288 VSS.n24 109.993
R705 VSS.t2280 VSS.n24 109.001
R706 VSS.n24 VSS.t2275 108.999
R707 VSS.n24 VSS.t2273 109.992
R708 VSS.t2268 VSS.n24 109.993
R709 VSS.t2260 VSS.n24 109.001
R710 VSS.t2250 VSS.n24 109.001
R711 VSS.n24 VSS.t2245 108.999
R712 VSS.n24 VSS.t2240 109.001
R713 VSS.n24 VSS.t2233 109.993
R714 VSS.t2225 VSS.n24 109.001
R715 VSS.n24 VSS.t2310 109.001
R716 VSS.n22 VSS.t2103 108.999
R717 VSS.n22 VSS.t2101 109.992
R718 VSS.t2096 VSS.n22 109.993
R719 VSS.t2088 VSS.n22 109.001
R720 VSS.n22 VSS.t2081 109.992
R721 VSS.t2076 VSS.n22 109.993
R722 VSS.t2068 VSS.n22 109.001
R723 VSS.t2058 VSS.n22 108.999
R724 VSS.n22 VSS.t2056 109.992
R725 VSS.t2048 VSS.n22 108.999
R726 VSS.t2043 VSS.n22 109.001
R727 VSS.t2038 VSS.n22 108.999
R728 VSS.t2028 VSS.n22 108.999
R729 VSS.t2023 VSS.n22 109.001
R730 VSS.n22 VSS.t2016 109.992
R731 VSS.t2008 VSS.n22 108.999
R732 VSS.n22 VSS.t2006 109.993
R733 VSS.t1998 VSS.n22 109.001
R734 VSS.t1996 VSS.n22 109.992
R735 VSS.t1988 VSS.n22 108.999
R736 VSS.t1978 VSS.n22 109.001
R737 VSS.n22 VSS.t1973 109.001
R738 VSS.t1968 VSS.n22 108.999
R739 VSS.n22 VSS.t1961 109.992
R740 VSS.t1956 VSS.n22 109.993
R741 VSS.t1948 VSS.n22 109.001
R742 VSS.n22 VSS.t1943 108.999
R743 VSS.t1938 VSS.n22 109.001
R744 VSS.t1936 VSS.n22 109.993
R745 VSS.t1928 VSS.n22 109.001
R746 VSS.n22 VSS.t1923 108.999
R747 VSS.t1913 VSS.n22 108.999
R748 VSS.t1908 VSS.n22 109.001
R749 VSS.t1898 VSS.n22 109.001
R750 VSS.t1893 VSS.n22 108.999
R751 VSS.n22 VSS.t1891 109.992
R752 VSS.n22 VSS.t1886 109.993
R753 VSS.t1878 VSS.n22 109.001
R754 VSS.t1873 VSS.n22 108.999
R755 VSS.n22 VSS.t1871 109.992
R756 VSS.t1858 VSS.n22 109.001
R757 VSS.n22 VSS.t1856 109.993
R758 VSS.t1848 VSS.n22 109.001
R759 VSS.t1843 VSS.n22 108.999
R760 VSS.n22 VSS.t1841 109.993
R761 VSS.n22 VSS.t1836 109.992
R762 VSS.n22 VSS.t1918 109.001
R763 VSS.t1711 VSS.n23 108.999
R764 VSS.n23 VSS.t1706 109.001
R765 VSS.n23 VSS.t1704 109.993
R766 VSS.n23 VSS.t1696 109.001
R767 VSS.t1691 VSS.n23 108.999
R768 VSS.n23 VSS.t1686 109.001
R769 VSS.n23 VSS.t1676 109.001
R770 VSS.t1671 VSS.n23 108.999
R771 VSS.n23 VSS.t1666 109.001
R772 VSS.n23 VSS.t1656 109.001
R773 VSS.t1651 VSS.n23 109.001
R774 VSS.n23 VSS.t1646 108.999
R775 VSS.t1639 VSS.n23 109.992
R776 VSS.t1631 VSS.n23 109.001
R777 VSS.t1629 VSS.n23 109.993
R778 VSS.n23 VSS.t1624 109.993
R779 VSS.n23 VSS.t1616 108.999
R780 VSS.t1611 VSS.n23 109.001
R781 VSS.t1601 VSS.n23 108.999
R782 VSS.t1596 VSS.n23 109.001
R783 VSS.t1591 VSS.n23 109.001
R784 VSS.n23 VSS.t1589 109.993
R785 VSS.t1581 VSS.n23 109.001
R786 VSS.t1576 VSS.n23 108.999
R787 VSS.n23 VSS.t1569 109.992
R788 VSS.t1561 VSS.n23 108.999
R789 VSS.n23 VSS.t1559 109.992
R790 VSS.t1551 VSS.n23 108.999
R791 VSS.t1546 VSS.n23 109.001
R792 VSS.t1536 VSS.n23 108.999
R793 VSS.n23 VSS.t1534 109.992
R794 VSS.t1516 VSS.n23 109.001
R795 VSS.n23 VSS.t1511 108.999
R796 VSS.t1506 VSS.n23 109.001
R797 VSS.n23 VSS.t1499 109.992
R798 VSS.t1494 VSS.n23 109.993
R799 VSS.t1486 VSS.n23 109.001
R800 VSS.t1484 VSS.n23 109.993
R801 VSS.t1476 VSS.n23 109.001
R802 VSS.t1466 VSS.n23 109.001
R803 VSS.t1464 VSS.n23 109.993
R804 VSS.n23 VSS.t1456 109.001
R805 VSS.t1451 VSS.n23 108.999
R806 VSS.n23 VSS.t1449 109.993
R807 VSS.n23 VSS.t1444 109.992
R808 VSS.t1436 VSS.n23 108.722
R809 VSS.n23 VSS.t1526 108.999
R810 VSS.t1032 VSS.n117 109.001
R811 VSS.n117 VSS.t1027 108.999
R812 VSS.n117 VSS.t1025 109.993
R813 VSS.n117 VSS.t1017 109.001
R814 VSS.n117 VSS.t1015 109.992
R815 VSS.n117 VSS.t1007 109.001
R816 VSS.t1002 VSS.n117 109.001
R817 VSS.t997 VSS.n117 108.999
R818 VSS.t992 VSS.n117 109.001
R819 VSS.t987 VSS.n117 109.001
R820 VSS.t982 VSS.n117 109.001
R821 VSS.n117 VSS.t980 109.992
R822 VSS.n117 VSS.t975 109.993
R823 VSS.n117 VSS.t970 109.992
R824 VSS.n117 VSS.t965 109.993
R825 VSS.t957 VSS.n117 108.999
R826 VSS.t947 VSS.n117 109.001
R827 VSS.t942 VSS.n117 109.001
R828 VSS.t937 VSS.n117 109.001
R829 VSS.t932 VSS.n117 109.001
R830 VSS.n117 VSS.t930 109.993
R831 VSS.t922 VSS.n117 109.001
R832 VSS.t917 VSS.n117 109.001
R833 VSS.t912 VSS.n117 109.001
R834 VSS.t907 VSS.n117 108.999
R835 VSS.t902 VSS.n117 109.001
R836 VSS.t897 VSS.n117 109.001
R837 VSS.t892 VSS.n117 109.001
R838 VSS.n117 VSS.t885 109.992
R839 VSS.t877 VSS.n117 109.001
R840 VSS.t872 VSS.n117 109.001
R841 VSS.t867 VSS.n117 108.999
R842 VSS.n117 VSS.t865 109.992
R843 VSS.n117 VSS.t850 109.993
R844 VSS.t842 VSS.n117 109.001
R845 VSS.t837 VSS.n117 108.999
R846 VSS.n117 VSS.t835 109.993
R847 VSS.n117 VSS.t830 109.993
R848 VSS.t822 VSS.n117 109.001
R849 VSS.t817 VSS.n117 108.999
R850 VSS.t812 VSS.n117 108.999
R851 VSS.n117 VSS.t810 109.993
R852 VSS.t802 VSS.n117 109.001
R853 VSS.n117 VSS.t800 109.993
R854 VSS.t792 VSS.n117 109.001
R855 VSS.n117 VSS.t790 109.992
R856 VSS.t782 VSS.n117 109.001
R857 VSS.t772 VSS.n117 109.001
R858 VSS.n117 VSS.t770 109.993
R859 VSS.t762 VSS.n118 108.556
R860 VSS.t66 VSS.n147 96.0268
R861 VSS.t567 VSS.t66 109.993
R862 VSS.t562 VSS.t66 109.992
R863 VSS.t552 VSS.t66 109.992
R864 VSS.t66 VSS.t547 109.993
R865 VSS.t542 VSS.t66 109.993
R866 VSS.t534 VSS.t66 108.999
R867 VSS.t66 VSS.t529 108.999
R868 VSS.t66 VSS.t527 109.993
R869 VSS.n136 VSS.t572 105.683
R870 VSS.t66 VSS.n129 3.67126
R871 VSS.t514 VSS.t66 109.001
R872 VSS.t513 VSS.t66 109.993
R873 VSS.t510 VSS.t66 109.001
R874 VSS.t66 VSS.t507 108.999
R875 VSS.t504 VSS.t66 109.001
R876 VSS.t66 VSS.t502 108.999
R877 VSS.t66 VSS.t500 108.722
R878 VSS.t66 VSS.t554 109.001
R879 VSS.t385 VSS.t4 108.722
R880 VSS.t694 VSS.n135 22.241
R881 VSS.t718 VSS.t249 191.667
R882 VSS.t730 VSS.n93 191.417
R883 VSS.n77 VSS.t732 191.417
R884 VSS.n95 VSS.t734 191.417
R885 VSS.n75 VSS.t736 191.417
R886 VSS.n97 VSS.t738 191.417
R887 VSS.n73 VSS.t740 191.417
R888 VSS.n99 VSS.t742 191.417
R889 VSS.n71 VSS.t744 191.417
R890 VSS.n101 VSS.t746 191.417
R891 VSS.n69 VSS.t748 191.417
R892 VSS.n103 VSS.t750 191.417
R893 VSS.n67 VSS.t752 191.417
R894 VSS.n105 VSS.t754 191.417
R895 VSS.n65 VSS.t756 191.417
R896 VSS.n107 VSS.t758 191.417
R897 VSS.n83 VSS.t688 191.417
R898 VSS.n81 VSS.t577 191.417
R899 VSS.n86 VSS.t581 191.417
R900 VSS.n79 VSS.t584 191.417
R901 VSS.n87 VSS.t587 191.417
R902 VSS.t716 VSS.n91 191.417
R903 VSS.n62 VSS.t517 191.417
R904 VSS.t654 VSS.n108 191.417
R905 VSS.n53 VSS.t4 12.2522
R906 VSS.t463 VSS.n31 191.417
R907 VSS.t465 VSS.n30 191.417
R908 VSS.n64 VSS.t680 186.502
R909 VSS.n817 VSS.t53 184.815
R910 VSS.t97 VSS.n158 188.911
R911 VSS.t731 VSS.n907 184.286
R912 VSS.t733 VSS.n912 184.286
R913 VSS.t735 VSS.n913 184.286
R914 VSS.t737 VSS.n914 184.286
R915 VSS.t739 VSS.n915 184.286
R916 VSS.t741 VSS.n916 184.286
R917 VSS.t743 VSS.n917 184.286
R918 VSS.t745 VSS.n918 184.286
R919 VSS.t747 VSS.n919 184.286
R920 VSS.t749 VSS.n920 184.286
R921 VSS.t751 VSS.n921 184.286
R922 VSS.t753 VSS.n922 184.286
R923 VSS.t755 VSS.n923 184.286
R924 VSS.t757 VSS.n924 184.286
R925 VSS.t759 VSS.n925 184.286
R926 VSS.t697 VSS.n751 184.286
R927 VSS.t579 VSS.n761 184.286
R928 VSS.t582 VSS.n762 184.286
R929 VSS.t585 VSS.n764 184.286
R930 VSS.n898 VSS.t589 184.286
R931 VSS.t717 VSS.n899 184.286
R932 VSS.t518 VSS.n884 184.286
R933 VSS.t656 VSS.n885 184.286
R934 VSS.t460 VSS.n53 188.386
R935 VSS.t464 VSS.n867 184.286
R936 VSS.n149 VSS.t466 100.871
R937 VSS.t3170 VSS.t52 184.286
R938 VSS.t391 VSS.n795 184.286
R939 VSS.t3200 VSS.n793 183.333
R940 VSS.t3248 VSS.t697 180
R941 VSS.t682 VSS.n748 179.167
R942 VSS.t722 VSS.n904 176.219
R943 VSS.n908 VSS.t727 175.714
R944 VSS.t592 VSS.n907 175.714
R945 VSS.t595 VSS.n912 175.714
R946 VSS.t598 VSS.n913 175.714
R947 VSS.t601 VSS.n914 175.714
R948 VSS.t604 VSS.n915 175.714
R949 VSS.t607 VSS.n916 175.714
R950 VSS.t610 VSS.n917 175.714
R951 VSS.t613 VSS.n918 175.714
R952 VSS.t616 VSS.n919 175.714
R953 VSS.t619 VSS.n920 175.714
R954 VSS.t622 VSS.n921 175.714
R955 VSS.t625 VSS.n922 175.714
R956 VSS.t628 VSS.n923 175.714
R957 VSS.t631 VSS.n924 175.714
R958 VSS.t634 VSS.n925 175.714
R959 VSS.n756 VSS.t698 175.714
R960 VSS.t706 VSS.n761 175.714
R961 VSS.t708 VSS.n762 175.714
R962 VSS.t710 VSS.n764 175.714
R963 VSS.n898 VSS.t712 175.714
R964 VSS.t652 VSS.n884 175.714
R965 VSS.n871 VSS.t461 175.714
R966 VSS.t393 VSS.n867 175.714
R967 VSS.t205 VSS.t3216 171.53
R968 VSS.t727 VSS.t190 171.429
R969 VSS.t91 VSS.t691 171.429
R970 VSS.t449 VSS.n792 170.833
R971 VSS.t61 VSS.n927 166.667
R972 VSS.n932 VSS.t48 166.667
R973 VSS.n766 VSS.t137 166.667
R974 VSS.t181 VSS.n859 166.667
R975 VSS.n857 VSS.t12 166.667
R976 VSS.t114 VSS.n792 166.667
R977 VSS.n38 VSS.t132 165.692
R978 VSS.t451 VSS.n49 165.669
R979 VSS.n819 VSS.t218 159.026
R980 VSS.t64 VSS.n926 157.335
R981 VSS.n51 VSS.t3280 157.335
R982 VSS.n814 VSS.t96 154.728
R983 VSS.t3194 VSS.n802 154.728
R984 VSS.t3219 VSS.n789 154.286
R985 VSS.t256 VSS.n885 154.286
R986 VSS.n126 VSS.t247 167.082
R987 VSS.n935 VSS.t252 154.167
R988 VSS.t2 VSS.n893 154.167
R989 VSS.n861 VSS.t3270 154.167
R990 VSS.t72 VSS.n25 153.243
R991 VSS.n39 VSS.t70 153.243
R992 VSS.n877 VSS.t3180 153.243
R993 VSS.n138 VSS.t149 93.6797
R994 VSS.n168 VSS.t684 165.669
R995 VSS.t178 VSS.n859 150
R996 VSS.t148 VSS.n868 150
R997 VSS.t3233 VSS.n845 150
R998 VSS.t200 VSS.t455 145.714
R999 VSS.t21 VSS.t460 145.714
R1000 VSS.n933 VSS.t3191 141.667
R1001 VSS.t45 VSS.n838 141.667
R1002 VSS.n199 VSS.t259 157.335
R1003 VSS.t3238 VSS.t457 141.429
R1004 VSS.t71 VSS.n904 137.536
R1005 VSS.t183 VSS.t125 137.143
R1006 VSS.n34 VSS.t3170 135.703
R1007 VSS.t151 VSS.n752 124.287
R1008 VSS.n873 VSS.t146 124.287
R1009 VSS.n850 VSS.t3234 124.287
R1010 VSS.n825 VSS.t116 120.344
R1011 VSS.n881 VSS.t3215 120.001
R1012 VSS.n887 VSS.t220 120.001
R1013 VSS.t455 VSS.t3237 120.001
R1014 VSS.n926 VSS.t177 119.835
R1015 VSS.n26 VSS.t237 119.835
R1016 VSS.t154 VSS.n51 119.835
R1017 VSS.n863 VSS.t3208 116.668
R1018 VSS.t264 VSS.n838 116.668
R1019 VSS.t452 VSS.t140 116.046
R1020 VSS.t3263 VSS.t692 115.715
R1021 VSS.t233 VSS.t3273 112.501
R1022 VSS.t29 VSS.t462 111.43
R1023 VSS.t3280 VSS.t178 108.334
R1024 VSS.n816 VSS.n811 107.451
R1025 VSS.t95 VSS.t115 107.451
R1026 VSS.t3178 VSS.t3185 107.451
R1027 VSS.n906 VSS.t725 107.144
R1028 VSS.n749 VSS.t684 107.144
R1029 VSS.t3254 VSS.n758 107.144
R1030 VSS.t703 VSS.t82 107.144
R1031 VSS.t170 VSS.n899 107.144
R1032 VSS.t3265 VSS.n936 107.144
R1033 VSS.n828 VSS.t168 107.144
R1034 VSS.n53 VSS.t19 77.2144
R1035 VSS.t52 VSS.n839 107.144
R1036 VSS.n798 VSS.t135 107.144
R1037 VSS.t225 VSS.n794 107.144
R1038 VSS.t3213 VSS.n748 104.168
R1039 VSS.n856 VSS.t74 104.168
R1040 VSS.n199 VSS.t222 119.835
R1041 VSS.t195 VSS.t3163 100.001
R1042 VSS.n753 VSS.t152 98.5719
R1043 VSS.t3189 VSS.n787 98.5719
R1044 VSS.t145 VSS.n869 98.5719
R1045 VSS.t3246 VSS.t3225 98.5719
R1046 VSS.t390 VSS.t117 98.5719
R1047 VSS.t3173 VSS.t75 94.5564
R1048 VSS.t142 VSS.t3229 94.5564
R1049 VSS.t691 VSS.t254 94.2862
R1050 VSS.t99 VSS.t3195 94.2862
R1051 VSS.n172 VSS.t88 16.4378
R1052 VSS.n142 VSS.t7 4.63044
R1053 VSS.n814 VSS.t3165 90.2584
R1054 VSS.t248 VSS.n908 90.0005
R1055 VSS.t254 VSS.n750 90.0005
R1056 VSS.n832 VSS.t200 90.0005
R1057 VSS.t7 VSS.n157 0.219075
R1058 VSS.n154 VSS.t7 0.219019
R1059 VSS.t311 VSS.n150 26.2517
R1060 VSS.t316 VSS.n144 26.2517
R1061 VSS.n329 VSS.t165 72.8451
R1062 VSS.n141 VSS.t7 0.121827
R1063 VSS.n140 VSS.t7 0.121819
R1064 VSS.n137 VSS.t337 26.1547
R1065 VSS.t342 VSS.n132 26.2515
R1066 VSS.n328 VSS.t105 89.7897
R1067 VSS.t3204 VSS.n52 88.7727
R1068 VSS.t184 VSS.n41 88.7727
R1069 VSS.t259 VSS.t449 87.5005
R1070 VSS.t100 VSS.n152 66.199
R1071 VSS.t4 VSS.t236 87.1423
R1072 VSS.n27 VSS.t3209 86.5025
R1073 VSS.n815 VSS.t40 85.9604
R1074 VSS.t3287 VSS.t169 85.9604
R1075 VSS.t3176 VSS.t229 85.9604
R1076 VSS.t240 VSS.n777 85.7543
R1077 VSS.n4 VSS.t226 85.7543
R1078 VSS.n911 VSS.t203 85.7148
R1079 VSS.n134 VSS.t92 65.92
R1080 VSS.t214 VSS.n835 85.7148
R1081 VSS.t3236 VSS.n781 83.6281
R1082 VSS.t15 VSS.t3211 83.3338
R1083 VSS.t210 VSS.n20 83.3336
R1084 VSS.t3253 VSS.n757 81.4291
R1085 VSS.n833 VSS.t21 81.4291
R1086 VSS.n848 VSS.t3276 81.4291
R1087 VSS.n854 VSS.t3245 81.4291
R1088 VSS.t42 VSS.t4 80.7982
R1089 VSS.n83 VSS.t161 79.9891
R1090 VSS.t143 VSS.n831 79.9891
R1091 VSS.n722 VSS.n220 3692.29
R1092 VSS.n109 VSS.t3262 10.1739
R1093 VSS.n818 VSS.t118 77.3644
R1094 VSS.n825 VSS.t119 77.3644
R1095 VSS.t700 VSS.t3254 77.1434
R1096 VSS.t117 VSS.n796 77.1434
R1097 VSS.t140 VSS.t4 76.5012
R1098 VSS.t66 VSS.t3263 76.3274
R1099 VSS.n775 VSS.t18 74.234
R1100 VSS.t7 VSS.n195 2.33095
R1101 VSS.t31 VSS.n811 73.0664
R1102 VSS.t3247 VSS.n751 72.8576
R1103 VSS.n163 VSS.t215 88.5605
R1104 VSS.n872 VSS.t29 72.8576
R1105 VSS.t3235 VSS.t167 72.8576
R1106 VSS.n851 VSS.t3239 72.8576
R1107 VSS.n785 VSS.t3257 72.8451
R1108 VSS.t3286 VSS.n3 72.8441
R1109 VSS.n6 VSS.t3218 72.8441
R1110 VSS.n9 VSS.t3228 72.8441
R1111 VSS.n12 VSS.t3166 72.8441
R1112 VSS.t3182 VSS.n196 12.8073
R1113 VSS.n784 VSS.t3268 72.6202
R1114 VSS.t3256 VSS.n60 76.9095
R1115 VSS.t228 VSS.n771 72.6202
R1116 VSS.t223 VSS.n772 72.6202
R1117 VSS.t3237 VSS.t4 72.0417
R1118 VSS.n909 VSS.t202 71.4177
R1119 VSS.t109 VSS.n35 71.4177
R1120 VSS.t43 VSS.n934 70.8338
R1121 VSS.n862 VSS.t180 70.8338
R1122 VSS.n862 VSS.t221 70.8338
R1123 VSS.t245 VSS.n793 70.8338
R1124 VSS.n231 VSS.t3201 72.8451
R1125 VSS.t122 VSS.n230 72.8451
R1126 VSS.n195 VSS.t130 14.8819
R1127 VSS.n786 VSS.t159 70.1995
R1128 VSS.t3257 VSS.n112 29.5338
R1129 VSS.n179 VSS.t3284 13.9374
R1130 VSS.n193 VSS.t230 13.9422
R1131 VSS.t234 VSS.t14 68.7684
R1132 VSS.t82 VSS.n754 68.5719
R1133 VSS.t166 VSS.n901 68.5719
R1134 VSS.n25 VSS.t234 67.2827
R1135 VSS.n52 VSS.t3281 67.2827
R1136 VSS.n39 VSS.t46 67.2827
R1137 VSS.t260 VSS.n877 67.2827
R1138 VSS.t247 VSS.t717 66.6672
R1139 VSS.t177 VSS.t718 66.6672
R1140 VSS.t8 VSS.t2 66.6672
R1141 VSS.t3270 VSS.t13 66.6672
R1142 VSS.t3224 VSS.n784 64.5513
R1143 VSS.t73 VSS.t3204 64.4704
R1144 VSS.t238 VSS.n804 64.4704
R1145 VSS.n60 VSS.t7 10.0545
R1146 VSS.t190 VSS.t66 80.6121
R1147 VSS.n1 VSS.t63 63.9684
R1148 VSS.n5 VSS.t6 63.9684
R1149 VSS.n774 VSS.t162 63.7444
R1150 VSS.n783 VSS.t3255 62.3556
R1151 VSS.n779 VSS.t239 62.3556
R1152 VSS.t255 VSS.n19 62.3556
R1153 VSS.n142 VSS.t3269 16.9203
R1154 VSS.n813 VSS.t261 60.1724
R1155 VSS.t3190 VSS.n803 60.1724
R1156 VSS.t33 VSS.n802 60.1724
R1157 VSS.n931 VSS.t3193 60.0005
R1158 VSS.t173 VSS.n790 60.0005
R1159 VSS.n829 VSS.t99 60.0005
R1160 VSS.n836 VSS.t213 60.0005
R1161 VSS.t4 VSS.t3183 51.2106
R1162 VSS.n114 VSS.t275 26.106
R1163 VSS.t277 VSS.n113 26.1053
R1164 VSS.n116 VSS.t280 26.106
R1165 VSS.n115 VSS.t7 0.12186
R1166 VSS.t288 VSS.n2 26.1053
R1167 VSS.n121 VSS.t291 26.106
R1168 VSS.t293 VSS.n120 26.1053
R1169 VSS.t7 VSS.n123 0.12182
R1170 VSS.n124 VSS.t7 0.12186
R1171 VSS.n7 VSS.t353 26.0021
R1172 VSS.t355 VSS.n17 58.6622
R1173 VSS.t7 VSS.n59 0.22519
R1174 VSS.t360 VSS.n16 58.6622
R1175 VSS.n8 VSS.t363 26.1052
R1176 VSS.t7 VSS.n56 0.22519
R1177 VSS.t371 VSS.n15 58.6622
R1178 VSS.n11 VSS.t374 26.0021
R1179 VSS.t376 VSS.n14 58.6622
R1180 VSS.n54 VSS.t379 58.6622
R1181 VSS.n84 VSS.t3174 58.5605
R1182 VSS.n1 VSS.t272 58.3211
R1183 VSS.t286 VSS.n3 58.3211
R1184 VSS.n6 VSS.t350 58.3211
R1185 VSS.n9 VSS.t366 58.3211
R1186 VSS.n12 VSS.t382 58.3211
R1187 VSS.n781 VSS.t3222 57.8078
R1188 VSS.t7 VSS.n164 0.219073
R1189 VSS.t7 VSS.n131 0.219018
R1190 VSS.n114 VSS.t7 0.12182
R1191 VSS.t7 VSS.n113 0.121828
R1192 VSS.n116 VSS.t7 0.12182
R1193 VSS.n119 VSS.t7 0.219018
R1194 VSS.n121 VSS.t7 0.12182
R1195 VSS.t7 VSS.n120 0.121828
R1196 VSS.t297 VSS.n123 26.2515
R1197 VSS.n18 VSS.t351 26.1544
R1198 VSS.t354 VSS.n17 57.0465
R1199 VSS.t7 VSS.n58 0.219018
R1200 VSS.t359 VSS.n16 57.0465
R1201 VSS.t7 VSS.n57 0.219018
R1202 VSS.t7 VSS.n55 0.219018
R1203 VSS.t370 VSS.n15 57.0465
R1204 VSS.t7 VSS.n21 0.219018
R1205 VSS.t375 VSS.n14 57.0465
R1206 VSS.n54 VSS.t378 57.0465
R1207 VSS.t39 VSS.n810 55.8744
R1208 VSS.t3177 VSS.t217 55.8744
R1209 VSS.t155 VSS.n803 55.8744
R1210 VSS.t3226 VSS.t156 55.8744
R1211 VSS.t3252 VSS.n756 55.7148
R1212 VSS.n834 VSS.t23 55.7148
R1213 VSS.t3244 VSS.n841 55.7148
R1214 VSS.n110 VSS.t127 64.8343
R1215 VSS.n172 VSS.t94 64.8293
R1216 VSS.n774 VSS.t241 54.8687
R1217 VSS.n800 VSS.t195 54.1672
R1218 VSS.n780 VSS.t78 54.0618
R1219 VSS.t5 VSS.t4 53.8079
R1220 VSS.t3210 VSS.t4 53.8079
R1221 VSS.n64 VSS.t253 53.1692
R1222 VSS.t3164 VSS.n28 53.1692
R1223 VSS.t271 VSS.t7 26.5065
R1224 VSS.t285 VSS.t7 26.5067
R1225 VSS.t7 VSS.t365 26.5067
R1226 VSS.n178 VSS.t7 0.203701
R1227 VSS.t7 VSS.t300 26.5067
R1228 VSS.t381 VSS.t7 26.5067
R1229 VSS.n178 VSS.t348 26.334
R1230 VSS.t75 VSS.n159 66.3233
R1231 VSS.n821 VSS.t54 51.5764
R1232 VSS.t3186 VSS.t55 51.5764
R1233 VSS.t0 VSS.n801 51.5764
R1234 VSS.t574 VSS.n135 23.2337
R1235 VSS.t696 VSS.t151 51.4291
R1236 VSS.n797 VSS.t133 51.4291
R1237 VSS.n157 VSS.t269 26.1613
R1238 VSS.t274 VSS.n131 26.1544
R1239 VSS.n114 VSS.t276 26.2515
R1240 VSS.t279 VSS.n113 26.2522
R1241 VSS.n116 VSS.t281 26.2515
R1242 VSS.t284 VSS.n115 26.2591
R1243 VSS.n119 VSS.t287 26.1544
R1244 VSS.t290 VSS.n2 26.2522
R1245 VSS.n121 VSS.t292 26.2515
R1246 VSS.t295 VSS.n120 26.2522
R1247 VSS.t299 VSS.n124 26.2591
R1248 VSS.t303 VSS.n154 26.1547
R1249 VSS.n153 VSS.t306 26.2524
R1250 VSS.n145 VSS.t321 48.8187
R1251 VSS.n141 VSS.t324 26.2524
R1252 VSS.n140 VSS.t329 26.2517
R1253 VSS.n139 VSS.t334 26.2635
R1254 VSS.t335 VSS.n137 47.2102
R1255 VSS.n133 VSS.t347 48.8187
R1256 VSS.n18 VSS.t350 47.2102
R1257 VSS.n7 VSS.t354 48.8187
R1258 VSS.t357 VSS.n58 26.1544
R1259 VSS.n59 VSS.t359 48.8187
R1260 VSS.t362 VSS.n57 26.1544
R1261 VSS.n8 VSS.t364 26.2591
R1262 VSS.t367 VSS.n55 26.1544
R1263 VSS.n56 VSS.t370 48.8187
R1264 VSS.t373 VSS.n21 26.1544
R1265 VSS.n11 VSS.t375 48.8187
R1266 VSS.t378 VSS.n13 48.6385
R1267 VSS.n0 VSS.t380 26.1613
R1268 VSS.t383 VSS.n164 26.1611
R1269 VSS.t4 VSS.n122 2.49582
R1270 VSS.t3232 VSS.n808 47.2784
R1271 VSS.n820 VSS.t192 47.2784
R1272 VSS.t232 VSS.t3283 47.2784
R1273 VSS.n929 VSS.t3248 47.1434
R1274 VSS.t28 VSS.n870 47.1434
R1275 VSS.t3240 VSS.n843 47.1434
R1276 VSS.t296 VSS.n123 26.106
R1277 VSS.t308 VSS.n150 26.1056
R1278 VSS.t313 VSS.n144 26.1056
R1279 VSS.t318 VSS.n145 26.0017
R1280 VSS.t339 VSS.n132 26.1056
R1281 VSS.t344 VSS.n133 26.0019
R1282 VSS.t358 VSS.n59 26.0021
R1283 VSS.t368 VSS.n56 26.0021
R1284 VSS.n13 VSS.t376 47.0238
R1285 VSS.t236 VSS.t36 45.8338
R1286 VSS.t237 VSS.t3279 45.8338
R1287 VSS.t3258 VSS.n38 45.7789
R1288 VSS.t3273 VSS.n26 44.8359
R1289 VSS.n220 VSS.t266 56.194
R1290 VSS.n231 VSS.t301 58.3202
R1291 VSS.n153 VSS.t304 26.1049
R1292 VSS.t7 VSS.n150 0.121819
R1293 VSS.t7 VSS.n144 0.121819
R1294 VSS.t7 VSS.n145 0.225187
R1295 VSS.n141 VSS.t322 26.1049
R1296 VSS.n140 VSS.t326 26.1056
R1297 VSS.n139 VSS.t331 26.1048
R1298 VSS.n230 VSS.t335 58.3202
R1299 VSS.t7 VSS.n132 0.121819
R1300 VSS.t7 VSS.n133 0.225189
R1301 VSS.t3187 VSS.n804 42.9804
R1302 VSS.n161 VSS.t59 50.7208
R1303 VSS.t104 VSS.n789 42.8576
R1304 VSS.n855 VSS.t175 42.8576
R1305 VSS.t321 VSS.n329 56.7064
R1306 VSS.n139 VSS.t7 0.121878
R1307 VSS.t347 VSS.n328 56.7064
R1308 VSS.t4 VSS.n159 1.60658
R1309 VSS.t4 VSS.t232 42.1172
R1310 VSS.t3266 VSS.n759 41.4177
R1311 VSS.t3255 VSS.n782 40.8632
R1312 VSS.t239 VSS.n778 40.8632
R1313 VSS.n770 VSS.t255 40.8632
R1314 VSS.t219 VSS.n808 38.6824
R1315 VSS.n827 VSS.n824 38.6824
R1316 VSS.t3241 VSS.t17 38.5719
R1317 VSS.t249 VSS.t66 53.8079
R1318 VSS.n863 VSS.t3272 37.5005
R1319 VSS.n44 VSS.t3287 37.1968
R1320 VSS.t3249 VSS.n928 37.1319
R1321 VSS.t127 VSS.n783 36.5343
R1322 VSS.t94 VSS.n779 36.5343
R1323 VSS.t241 VSS.n19 36.5343
R1324 VSS.n823 VSS.t3177 34.3845
R1325 VSS.n882 VSS.t3188 34.2862
R1326 VSS.n866 VSS.t212 34.2862
R1327 VSS.t80 VSS.n842 34.2862
R1328 VSS.t263 VSS.t3210 33.3338
R1329 VSS.t125 VSS.n37 32.8462
R1330 VSS.t3222 VSS.n780 31.469
R1331 VSS.t3230 VSS.n810 30.0865
R1332 VSS.t3185 VSS.n806 30.0865
R1333 VSS.n824 VSS.t3226 30.0865
R1334 VSS.t3251 VSS.n755 30.0005
R1335 VSS.n883 VSS.t37 30.0005
R1336 VSS.n148 VSS.t3288 26.8308
R1337 VSS.t677 VSS.n147 12.9737
R1338 VSS.t3202 VSS.n830 30.0005
R1339 VSS.n876 VSS.t24 30.0005
R1340 VSS.n853 VSS.t3243 30.0005
R1341 VSS.n799 VSS.t194 30.0005
R1342 VSS.t115 VSS.t4 29.2233
R1343 VSS.n864 VSS.t3264 29.1672
R1344 VSS.t229 VSS.n40 28.6008
R1345 VSS.n110 VSS.t265 16.4142
R1346 VSS.t162 VSS.n20 27.6595
R1347 VSS.t63 VSS.n196 38.7811
R1348 VSS.n60 VSS.t188 16.225
R1349 VSS.t6 VSS.n771 27.4346
R1350 VSS.t3275 VSS.n772 27.4346
R1351 VSS.t258 VSS.n858 25.7885
R1352 VSS.t3171 VSS.n900 25.7148
R1353 VSS.t167 VSS.n844 25.7148
R1354 VSS.t3277 VSS.n795 25.7148
R1355 VSS.t211 VSS.t4 24.8989
R1356 VSS.t111 VSS.n90 24.2748
R1357 VSS.n37 VSS.t108 24.2748
R1358 VSS.t78 VSS.n142 33.1136
R1359 VSS.n111 VSS.t84 14.2643
R1360 VSS.n218 VSS.t68 13.9422
R1361 VSS.n194 VSS.t3172 13.9422
R1362 VSS.n193 VSS.t7 3.37712
R1363 VSS.t3221 VSS.n227 13.9422
R1364 VSS.n179 VSS.t7 3.37595
R1365 VSS.n61 VSS.t189 13.9092
R1366 VSS.t10 VSS.n112 13.9082
R1367 VSS.t101 VSS.n807 21.4905
R1368 VSS.n871 VSS.t27 21.4291
R1369 VSS.t3234 VSS.t56 21.4291
R1370 VSS.n852 VSS.t3241 21.4291
R1371 VSS.t108 VSS.t3168 21.4291
R1372 VSS.t159 VSS.n785 21.2035
R1373 VSS.t3197 VSS.n44 20.0048
R1374 VSS.n928 VSS.t3250 19.9891
R1375 VSS.t7 VSS.n196 2.99891
R1376 VSS.n777 VSS.t3256 18.7838
R1377 VSS.n4 VSS.t228 18.7838
R1378 VSS.n5 VSS.t223 18.7838
R1379 VSS.t3231 VSS.n195 20.3752
R1380 VSS.n218 VSS.t3286 29.5272
R1381 VSS.n194 VSS.t3201 29.5272
R1382 VSS.t165 VSS.n786 18.5589
R1383 VSS.n61 VSS.t122 29.5336
R1384 VSS.t3218 VSS.n179 29.5281
R1385 VSS.t3228 VSS.n193 29.5272
R1386 VSS.t3166 VSS.n227 29.5272
R1387 VSS.n782 VSS.t3236 17.4635
R1388 VSS.n778 VSS.t240 17.4635
R1389 VSS.t226 VSS.n770 17.4635
R1390 VSS.t235 VSS.t3171 17.1434
R1391 VSS.t141 VSS.t250 17.1434
R1392 VSS.t3245 VSS.t85 17.1434
R1393 VSS.t3199 VSS.t225 17.1434
R1394 VSS.t7 VSS.n220 2.5939
R1395 VSS.n331 VSS.n127 5.64438
R1396 VSS.n127 VSS.n332 5.64438
R1397 VSS.t7 VSS.n218 3.37712
R1398 VSS.t7 VSS.n194 3.37712
R1399 VSS.n891 VSS.t7 17.0005
R1400 VSS.n786 VSS.t7 17.0005
R1401 VSS.n112 VSS.t7 3.3689
R1402 VSS.n111 VSS.t7 3.49528
R1403 VSS.n784 VSS.t7 17.0005
R1404 VSS.n110 VSS.t7 4.37826
R1405 VSS.n780 VSS.t7 17.0005
R1406 VSS.n172 VSS.t7 4.38457
R1407 VSS.n61 VSS.t7 3.36914
R1408 VSS.n230 VSS.t7 0.405951
R1409 VSS.t7 VSS.n262 5.6463
R1410 VSS.t7 VSS.n775 17.0005
R1411 VSS.t7 VSS.n774 17.0005
R1412 VSS.t7 VSS.n771 17.0005
R1413 VSS.t7 VSS.n772 17.0005
R1414 VSS.t7 VSS.n227 3.37712
R1415 VSS.t206 VSS.t2706 17.0005
R1416 VSS.n730 VSS.t206 17.0005
R1417 VSS.t2777 VSS.t206 17.0005
R1418 VSS.n24 VSS.n310 5.64438
R1419 VSS.n311 VSS.n24 5.64438
R1420 VSS.n22 VSS.n308 5.64438
R1421 VSS.n309 VSS.n22 5.64438
R1422 VSS.n306 VSS.n23 5.64438
R1423 VSS.n23 VSS.n307 5.64438
R1424 VSS.t1211 VSS.n577 0.120486
R1425 VSS.t1154 VSS.n305 4.17719
R1426 VSS.n186 VSS.t1255 0.238308
R1427 VSS.t1154 VSS.n207 4.17719
R1428 VSS.t1329 VSS.n301 0.179761
R1429 VSS.t66 VSS.n673 5.6463
R1430 VSS.n168 VSS.t66 0.666899
R1431 VSS.n932 VSS.t66 17.0005
R1432 VSS.t66 VSS.n933 17.0005
R1433 VSS.t66 VSS.n748 17.0005
R1434 VSS.n934 VSS.t66 17.0005
R1435 VSS.t66 VSS.n935 17.0005
R1436 VSS.n936 VSS.t66 17.0005
R1437 VSS.t66 VSS.n885 17.0005
R1438 VSS.t66 VSS.n887 17.0005
R1439 VSS.t66 VSS.n886 17.0005
R1440 VSS.n163 VSS.t66 0.649813
R1441 VSS.t66 VSS.n884 17.0005
R1442 VSS.n888 VSS.t66 17.0005
R1443 VSS.t66 VSS.n889 17.0005
R1444 VSS.t66 VSS.n787 17.0005
R1445 VSS.t66 VSS.n883 17.0005
R1446 VSS.t66 VSS.n789 17.0005
R1447 VSS.t66 VSS.n882 17.0005
R1448 VSS.t66 VSS.n790 17.0005
R1449 VSS.t66 VSS.n881 17.0005
R1450 VSS.t66 VSS.n136 3.31704
R1451 VSS.t66 VSS.n750 17.0005
R1452 VSS.n930 VSS.t66 17.0005
R1453 VSS.t66 VSS.n931 17.0005
R1454 VSS.t66 VSS.n749 17.0005
R1455 VSS.n758 VSS.t66 17.0005
R1456 VSS.n757 VSS.t66 17.0005
R1457 VSS.n756 VSS.t66 17.0005
R1458 VSS.n755 VSS.t66 17.0005
R1459 VSS.t66 VSS.n929 17.0005
R1460 VSS.t66 VSS.n751 17.0005
R1461 VSS.t66 VSS.n753 17.0005
R1462 VSS.t66 VSS.n752 17.0005
R1463 VSS.t66 VSS.n898 17.0005
R1464 VSS.n198 VSS.t66 0.649813
R1465 VSS.t66 VSS.n763 17.0005
R1466 VSS.t66 VSS.n764 17.0005
R1467 VSS.t66 VSS.n201 0.649813
R1468 VSS.t66 VSS.n762 17.0005
R1469 VSS.t66 VSS.n203 0.649813
R1470 VSS.t66 VSS.n761 17.0005
R1471 VSS.t66 VSS.n212 0.649813
R1472 VSS.t66 VSS.n754 17.0005
R1473 VSS.t66 VSS.n760 17.0005
R1474 VSS.t66 VSS.n128 14.3867
R1475 VSS.n927 VSS.t66 17.0005
R1476 VSS.t66 VSS.n899 17.0005
R1477 VSS.t66 VSS.n903 17.0005
R1478 VSS.t66 VSS.n900 17.0005
R1479 VSS.t66 VSS.n902 17.0005
R1480 VSS.t66 VSS.n901 17.0005
R1481 VSS.t66 VSS.n161 8.48857
R1482 VSS.t66 VSS.n904 17.0005
R1483 VSS.t66 VSS.n171 0.325424
R1484 VSS.t66 VSS.n925 17.0005
R1485 VSS.n173 VSS.t66 0.649813
R1486 VSS.t66 VSS.n924 17.0005
R1487 VSS.n174 VSS.t66 0.649813
R1488 VSS.t66 VSS.n923 17.0005
R1489 VSS.t66 VSS.n175 0.649813
R1490 VSS.t66 VSS.n922 17.0005
R1491 VSS.n177 VSS.t66 0.649813
R1492 VSS.t66 VSS.n921 17.0005
R1493 VSS.n180 VSS.t66 0.649813
R1494 VSS.t66 VSS.n920 17.0005
R1495 VSS.t66 VSS.n181 0.649813
R1496 VSS.t66 VSS.n919 17.0005
R1497 VSS.t66 VSS.n182 0.649813
R1498 VSS.t66 VSS.n918 17.0005
R1499 VSS.n183 VSS.t66 0.649813
R1500 VSS.t66 VSS.n917 17.0005
R1501 VSS.t66 VSS.n184 0.649813
R1502 VSS.t66 VSS.n916 17.0005
R1503 VSS.n185 VSS.t66 0.649813
R1504 VSS.t66 VSS.n915 17.0005
R1505 VSS.t66 VSS.n187 0.649813
R1506 VSS.t66 VSS.n914 17.0005
R1507 VSS.t66 VSS.n188 0.649813
R1508 VSS.t66 VSS.n913 17.0005
R1509 VSS.t66 VSS.n189 0.649813
R1510 VSS.t66 VSS.n912 17.0005
R1511 VSS.n190 VSS.t66 0.649813
R1512 VSS.t66 VSS.n907 17.0005
R1513 VSS.n191 VSS.t66 0.649813
R1514 VSS.n911 VSS.t66 17.0005
R1515 VSS.n910 VSS.t66 17.0005
R1516 VSS.n908 VSS.t66 17.0005
R1517 VSS.t66 VSS.n143 1.11651
R1518 VSS.t66 VSS.n906 17.0005
R1519 VSS.t66 VSS.n905 17.0005
R1520 VSS.t66 VSS.n151 3.41028
R1521 VSS.t4 VSS.n867 17.0005
R1522 VSS.t4 VSS.n874 17.0005
R1523 VSS.t4 VSS.n868 17.0005
R1524 VSS.t4 VSS.n873 17.0005
R1525 VSS.t4 VSS.n869 17.0005
R1526 VSS.t4 VSS.n872 17.0005
R1527 VSS.t4 VSS.n870 17.0005
R1528 VSS.t4 VSS.n871 17.0005
R1529 VSS.n875 VSS.t4 17.0005
R1530 VSS.t4 VSS.n876 17.0005
R1531 VSS.t4 VSS.n834 17.0005
R1532 VSS.n833 VSS.t4 17.0005
R1533 VSS.t4 VSS.n837 17.0005
R1534 VSS.t4 VSS.n857 17.0005
R1535 VSS.t4 VSS.n838 17.0005
R1536 VSS.t4 VSS.n856 17.0005
R1537 VSS.t4 VSS.n152 3.41984
R1538 VSS.t4 VSS.n839 17.0005
R1539 VSS.t4 VSS.n855 17.0005
R1540 VSS.t4 VSS.n840 17.0005
R1541 VSS.t4 VSS.n854 17.0005
R1542 VSS.t4 VSS.n841 17.0005
R1543 VSS.t4 VSS.n853 17.0005
R1544 VSS.t4 VSS.n842 17.0005
R1545 VSS.t4 VSS.n852 17.0005
R1546 VSS.t4 VSS.n843 17.0005
R1547 VSS.t4 VSS.n851 17.0005
R1548 VSS.t4 VSS.n844 17.0005
R1549 VSS.t4 VSS.n850 17.0005
R1550 VSS.t4 VSS.n845 17.0005
R1551 VSS.t4 VSS.n849 17.0005
R1552 VSS.t4 VSS.n846 17.0005
R1553 VSS.t4 VSS.n848 17.0005
R1554 VSS.t4 VSS.n243 0.649813
R1555 VSS.t4 VSS.n847 17.0005
R1556 VSS.t4 VSS.n835 17.0005
R1557 VSS.t4 VSS.n836 17.0005
R1558 VSS.t4 VSS.n866 17.0005
R1559 VSS.t4 VSS.n858 17.0005
R1560 VSS.t4 VSS.n864 17.0005
R1561 VSS.t4 VSS.n859 17.0005
R1562 VSS.t4 VSS.n863 17.0005
R1563 VSS.t4 VSS.n860 17.0005
R1564 VSS.t4 VSS.n862 17.0005
R1565 VSS.t4 VSS.n861 17.0005
R1566 VSS.t4 VSS.n865 17.0005
R1567 VSS.t4 VSS.n765 17.0005
R1568 VSS.t4 VSS.n766 17.0005
R1569 VSS.n893 VSS.t4 17.0005
R1570 VSS.n219 VSS.t81 0.238308
R1571 VSS.n162 VSS.t4 5.61485
R1572 VSS.t4 VSS.n156 2.91846
R1573 VSS.t4 VSS.n832 17.0005
R1574 VSS.n830 VSS.t4 17.0005
R1575 VSS.n829 VSS.t4 17.0005
R1576 VSS.n828 VSS.t4 17.0005
R1577 VSS.n158 VSS.t4 12.2567
R1578 VSS.t4 VSS.n801 17.0005
R1579 VSS.t4 VSS.n825 17.0005
R1580 VSS.t4 VSS.n802 17.0005
R1581 VSS.t4 VSS.n824 17.0005
R1582 VSS.t4 VSS.n803 17.0005
R1583 VSS.t4 VSS.n823 17.0005
R1584 VSS.t4 VSS.n804 17.0005
R1585 VSS.t4 VSS.n822 17.0005
R1586 VSS.t4 VSS.n806 17.0005
R1587 VSS.t4 VSS.n821 17.0005
R1588 VSS.t4 VSS.n807 17.0005
R1589 VSS.t4 VSS.n820 17.0005
R1590 VSS.t4 VSS.n808 17.0005
R1591 VSS.t4 VSS.n819 17.0005
R1592 VSS.t4 VSS.n809 17.0005
R1593 VSS.t4 VSS.n818 17.0005
R1594 VSS.t4 VSS.n817 17.0005
R1595 VSS.t4 VSS.n815 17.0005
R1596 VSS.t4 VSS.n810 17.0005
R1597 VSS.t4 VSS.n814 17.0005
R1598 VSS.t4 VSS.n813 17.0005
R1599 VSS.t4 VSS.n811 17.0005
R1600 VSS.t4 VSS.n812 17.0005
R1601 VSS.t4 VSS.n878 17.0005
R1602 VSS.t4 VSS.n792 17.0005
R1603 VSS.t4 VSS.n199 0.666899
R1604 VSS.t4 VSS.n793 17.0005
R1605 VSS.t4 VSS.n800 17.0005
R1606 VSS.t4 VSS.n794 17.0005
R1607 VSS.t4 VSS.n799 17.0005
R1608 VSS.t4 VSS.n798 17.0005
R1609 VSS.t4 VSS.n795 17.0005
R1610 VSS.t4 VSS.n797 17.0005
R1611 VSS.t4 VSS.n796 17.0005
R1612 VSS.t250 VSS.n90 15.7034
R1613 VSS.n759 VSS.t3184 15.7034
R1614 VSS.t18 VSS.n769 15.0429
R1615 VSS.n109 VSS.t7 2.23361
R1616 VSS.n879 VSS.t273 14.1658
R1617 VSS.n892 VSS.t369 14.1658
R1618 VSS.n895 VSS.t341 14.1658
R1619 VSS.n957 VSS.n733 14.1658
R1620 VSS.t3124 VSS.n956 14.1658
R1621 VSS.n959 VSS.n958 14.1658
R1622 VSS.t305 VSS.n747 14.1658
R1623 VSS.n879 VSS.t32 13.5005
R1624 VSS.t509 VSS.n880 13.5005
R1625 VSS.t781 VSS.n736 13.5005
R1626 VSS.t1166 VSS.n955 13.5005
R1627 VSS.n954 VSS.t1455 13.5005
R1628 VSS.t1847 VSS.n740 13.5005
R1629 VSS.n739 VSS.t2239 13.5005
R1630 VSS.t2622 VSS.n728 13.5005
R1631 VSS.n960 VSS.t2901 13.5005
R1632 VSS.n895 VSS.n894 13.5005
R1633 VSS.t586 VSS.n897 13.5005
R1634 VSS.n896 VSS.n746 13.5005
R1635 VSS.n942 VSS.n743 13.5005
R1636 VSS.n948 VSS.n744 13.5005
R1637 VSS.n950 VSS.n949 13.5005
R1638 VSS.n738 VSS.n732 13.5005
R1639 VSS.n731 VSS.n957 13.5005
R1640 VSS.t424 VSS.n892 13.5005
R1641 VSS.t614 VSS.n745 13.5005
R1642 VSS.n941 VSS.t1004 13.5005
R1643 VSS.n945 VSS.n944 13.5005
R1644 VSS.t1678 VSS.n947 13.5005
R1645 VSS.n946 VSS.t2070 13.5005
R1646 VSS.t2462 VSS.n734 13.5005
R1647 VSS.n956 VSS.t2748 13.5005
R1648 VSS.n958 VSS.t2808 13.5005
R1649 VSS.n737 VSS.n729 13.5005
R1650 VSS.n952 VSS.n951 13.5005
R1651 VSS.n741 VSS.n953 13.5005
R1652 VSS.t1359 VSS.n742 13.5005
R1653 VSS.n940 VSS.n939 13.5005
R1654 VSS.n938 VSS.n937 13.5005
R1655 VSS.t147 VSS.n747 13.5005
R1656 VSS.n769 VSS.t105 13.4291
R1657 VSS.n111 VSS.t3224 23.7593
R1658 VSS.t208 VSS.t57 12.8945
R1659 VSS.t3229 VSS.n809 12.8945
R1660 VSS.n819 VSS.t3196 12.8945
R1661 VSS.t49 VSS.n930 12.8576
R1662 VSS.n830 VSS.t129 12.8576
R1663 VSS.t3243 VSS.t3223 12.8576
R1664 VSS.t720 VSS.t61 12.5005
R1665 VSS.n822 VSS.t3186 8.59649
R1666 VSS.n889 VSS.t102 8.57193
R1667 VSS.t3225 VSS.n840 8.57193
R1668 VSS.t1154 VSS.n333 3.31921
R1669 VSS.n127 VSS.t3161 8.50199
R1670 VSS.t2499 VSS.n24 8.50198
R1671 VSS.t2107 VSS.n22 8.50198
R1672 VSS.n23 VSS.t1715 8.50198
R1673 VSS.t1041 VSS.n117 8.50198
R1674 VSS.n389 VSS.t3158 0.130189
R1675 VSS.t3156 VSS.n127 8.501
R1676 VSS.n388 VSS.t3153 0.130189
R1677 VSS.t3151 VSS.n127 8.501
R1678 VSS.n387 VSS.t3148 0.130189
R1679 VSS.t3146 VSS.n127 8.501
R1680 VSS.n386 VSS.t3143 0.130189
R1681 VSS.t3141 VSS.n127 8.501
R1682 VSS.n385 VSS.t3138 0.130189
R1683 VSS.t3136 VSS.n127 8.501
R1684 VSS.n384 VSS.t3133 0.130189
R1685 VSS.t3131 VSS.n127 8.501
R1686 VSS.n383 VSS.t3128 0.130189
R1687 VSS.t3126 VSS.n331 0.0362711
R1688 VSS.n382 VSS.t3123 0.0793054
R1689 VSS.t3121 VSS.n127 8.501
R1690 VSS.n381 VSS.t3118 0.130189
R1691 VSS.t3116 VSS.n127 8.501
R1692 VSS.n380 VSS.t3113 0.130189
R1693 VSS.t3111 VSS.n127 8.501
R1694 VSS.n379 VSS.t3108 0.130189
R1695 VSS.t3106 VSS.n127 8.501
R1696 VSS.n378 VSS.t3103 0.130189
R1697 VSS.t3101 VSS.n127 8.501
R1698 VSS.n377 VSS.t3098 0.130189
R1699 VSS.t3096 VSS.n127 8.501
R1700 VSS.n376 VSS.t3093 0.130189
R1701 VSS.t3091 VSS.n127 8.501
R1702 VSS.n375 VSS.t3088 0.130189
R1703 VSS.t3086 VSS.n127 8.501
R1704 VSS.n374 VSS.t3083 0.130189
R1705 VSS.t3081 VSS.n127 8.501
R1706 VSS.n373 VSS.t3078 0.130189
R1707 VSS.t3076 VSS.n127 8.501
R1708 VSS.n372 VSS.t3073 0.130189
R1709 VSS.t3071 VSS.n127 8.501
R1710 VSS.n371 VSS.t3068 0.130189
R1711 VSS.t3066 VSS.n127 8.501
R1712 VSS.n370 VSS.t3063 0.130189
R1713 VSS.t3061 VSS.n127 8.501
R1714 VSS.n369 VSS.t3058 0.130189
R1715 VSS.t3056 VSS.n127 8.501
R1716 VSS.n368 VSS.t3053 0.130189
R1717 VSS.t3051 VSS.n332 0.0362711
R1718 VSS.n367 VSS.t3048 0.0793054
R1719 VSS.n127 VSS.t3046 8.501
R1720 VSS.t3043 VSS.n366 0.130189
R1721 VSS.t3041 VSS.n127 8.501
R1722 VSS.t3038 VSS.n365 0.130189
R1723 VSS.t3036 VSS.n127 8.501
R1724 VSS.t3033 VSS.n364 0.130189
R1725 VSS.t3031 VSS.n127 8.501
R1726 VSS.t3028 VSS.n363 0.130189
R1727 VSS.t3026 VSS.n127 8.501
R1728 VSS.t3023 VSS.n362 0.130189
R1729 VSS.t3021 VSS.n127 8.501
R1730 VSS.t3018 VSS.n361 0.130189
R1731 VSS.t3016 VSS.n127 8.501
R1732 VSS.t3013 VSS.n360 0.130189
R1733 VSS.t3011 VSS.n127 8.501
R1734 VSS.t3008 VSS.n359 0.130189
R1735 VSS.t3006 VSS.n127 8.501
R1736 VSS.t3003 VSS.n358 0.130189
R1737 VSS.t3001 VSS.n127 8.501
R1738 VSS.t2998 VSS.n357 0.130189
R1739 VSS.t2996 VSS.n127 8.501
R1740 VSS.t2993 VSS.n356 0.130189
R1741 VSS.t2991 VSS.n127 8.501
R1742 VSS.t2988 VSS.n355 0.130189
R1743 VSS.t2986 VSS.n127 8.501
R1744 VSS.t2983 VSS.n354 0.130189
R1745 VSS.t2981 VSS.n127 8.501
R1746 VSS.t2978 VSS.n353 0.130189
R1747 VSS.n127 VSS.t2976 8.501
R1748 VSS.t2973 VSS.n352 0.130189
R1749 VSS.t2971 VSS.n127 8.501
R1750 VSS.t2968 VSS.n351 0.130189
R1751 VSS.t2966 VSS.n127 8.501
R1752 VSS.t2963 VSS.n350 0.130189
R1753 VSS.t2961 VSS.n127 8.501
R1754 VSS.t2958 VSS.n349 0.130189
R1755 VSS.t2956 VSS.n127 8.501
R1756 VSS.t2953 VSS.n348 0.130189
R1757 VSS.t2951 VSS.n127 8.501
R1758 VSS.t2948 VSS.n347 0.130189
R1759 VSS.t2946 VSS.n127 8.501
R1760 VSS.t2943 VSS.n346 0.130189
R1761 VSS.t2941 VSS.n127 8.501
R1762 VSS.t2938 VSS.n345 0.130189
R1763 VSS.t2936 VSS.n127 8.501
R1764 VSS.t2933 VSS.n344 0.130189
R1765 VSS.t2931 VSS.n127 8.501
R1766 VSS.t2928 VSS.n343 0.130189
R1767 VSS.t2926 VSS.n127 8.501
R1768 VSS.t2923 VSS.n342 0.130189
R1769 VSS.t2921 VSS.n127 8.501
R1770 VSS.t2918 VSS.n341 0.130189
R1771 VSS.t2916 VSS.n127 8.501
R1772 VSS.t2913 VSS.n340 0.130189
R1773 VSS.t2911 VSS.n127 8.501
R1774 VSS.n339 VSS.t2908 0.130189
R1775 VSS.t2906 VSS.n127 8.501
R1776 VSS.n338 VSS.t2903 0.130189
R1777 VSS.t2898 VSS.n337 0.215686
R1778 VSS.t2896 VSS.n127 8.501
R1779 VSS.n336 VSS.t2893 0.130189
R1780 VSS.t2891 VSS.n127 8.501
R1781 VSS.n335 VSS.t2888 0.130189
R1782 VSS.t2886 VSS.n127 8.501
R1783 VSS.n127 VSS.n334 3.33079
R1784 VSS.t267 VSS.t7 8.501
R1785 VSS.t7 VSS.n727 3.32876
R1786 VSS.n330 VSS.t7 0.531755
R1787 VSS.n390 VSS.t7 4.20253
R1788 VSS.t309 VSS.t7 8.501
R1789 VSS.n391 VSS.t7 3.32876
R1790 VSS.t314 VSS.t7 8.501
R1791 VSS.n392 VSS.t7 3.32876
R1792 VSS.t319 VSS.t7 8.501
R1793 VSS.n393 VSS.t7 3.32876
R1794 VSS.n394 VSS.t7 0.35896
R1795 VSS.n395 VSS.t7 3.32876
R1796 VSS.t327 VSS.t7 8.501
R1797 VSS.n396 VSS.t7 3.32876
R1798 VSS.t332 VSS.t7 8.501
R1799 VSS.n397 VSS.t7 3.32876
R1800 VSS.t123 VSS.n398 0.835741
R1801 VSS.t7 VSS.n399 3.32876
R1802 VSS.t340 VSS.n262 0.0333775
R1803 VSS.n400 VSS.t7 4.20253
R1804 VSS.t345 VSS.t7 8.501
R1805 VSS.n401 VSS.t106 0.135296
R1806 VSS.n404 VSS.t206 4.20253
R1807 VSS.n462 VSS.t2496 0.130189
R1808 VSS.t2494 VSS.n24 8.501
R1809 VSS.n461 VSS.t2491 0.130189
R1810 VSS.t2489 VSS.n24 8.501
R1811 VSS.n460 VSS.t2486 0.130189
R1812 VSS.t2484 VSS.n24 8.501
R1813 VSS.n459 VSS.t2481 0.130189
R1814 VSS.t2479 VSS.n24 8.501
R1815 VSS.n458 VSS.t2476 0.130189
R1816 VSS.t2474 VSS.n24 8.501
R1817 VSS.n457 VSS.t2471 0.130189
R1818 VSS.t2469 VSS.n24 8.501
R1819 VSS.n456 VSS.t2466 0.130189
R1820 VSS.t2464 VSS.n310 0.0362711
R1821 VSS.n455 VSS.t2461 0.0793054
R1822 VSS.t2459 VSS.n24 8.501
R1823 VSS.n454 VSS.t2456 0.130189
R1824 VSS.t2454 VSS.n24 8.501
R1825 VSS.n453 VSS.t2451 0.130189
R1826 VSS.t2449 VSS.n24 8.501
R1827 VSS.n452 VSS.t2446 0.130189
R1828 VSS.t2444 VSS.n24 8.501
R1829 VSS.n451 VSS.t2441 0.130189
R1830 VSS.t2439 VSS.n24 8.501
R1831 VSS.n450 VSS.t2436 0.130189
R1832 VSS.t2434 VSS.n24 8.501
R1833 VSS.n449 VSS.t2431 0.130189
R1834 VSS.t2429 VSS.n24 8.501
R1835 VSS.n448 VSS.t2426 0.130189
R1836 VSS.t2424 VSS.n24 8.501
R1837 VSS.n447 VSS.t2421 0.130189
R1838 VSS.t2419 VSS.n24 8.501
R1839 VSS.n446 VSS.t2416 0.130189
R1840 VSS.t2414 VSS.n24 8.501
R1841 VSS.n445 VSS.t2411 0.130189
R1842 VSS.t2409 VSS.n24 8.501
R1843 VSS.n444 VSS.t2406 0.130189
R1844 VSS.t2404 VSS.n24 8.501
R1845 VSS.n443 VSS.t2401 0.130189
R1846 VSS.t2399 VSS.n24 8.501
R1847 VSS.n442 VSS.t2396 0.130189
R1848 VSS.t2394 VSS.n24 8.501
R1849 VSS.n441 VSS.t2391 0.130189
R1850 VSS.t2389 VSS.n311 0.0362711
R1851 VSS.n440 VSS.t2386 0.0793054
R1852 VSS.t2384 VSS.n24 8.501
R1853 VSS.n439 VSS.t2381 0.130189
R1854 VSS.t2379 VSS.n24 8.501
R1855 VSS.n438 VSS.t2376 0.130189
R1856 VSS.t2374 VSS.n24 8.501
R1857 VSS.n437 VSS.t2371 0.130189
R1858 VSS.t2369 VSS.n24 8.501
R1859 VSS.n436 VSS.t2366 0.130189
R1860 VSS.t2364 VSS.n24 8.501
R1861 VSS.n435 VSS.t2361 0.130189
R1862 VSS.t2359 VSS.n24 8.501
R1863 VSS.n434 VSS.t2356 0.130189
R1864 VSS.t2354 VSS.n24 8.501
R1865 VSS.n433 VSS.t2351 0.130189
R1866 VSS.t2349 VSS.n24 8.501
R1867 VSS.n432 VSS.t2346 0.130189
R1868 VSS.t2344 VSS.n24 8.501
R1869 VSS.n431 VSS.t2341 0.130189
R1870 VSS.t2339 VSS.n24 8.501
R1871 VSS.n430 VSS.t2336 0.130189
R1872 VSS.t2334 VSS.n24 8.501
R1873 VSS.n429 VSS.t2331 0.130189
R1874 VSS.t2329 VSS.n24 8.501
R1875 VSS.n428 VSS.t2326 0.130189
R1876 VSS.t2324 VSS.n24 8.501
R1877 VSS.n427 VSS.t2321 0.130189
R1878 VSS.t2319 VSS.n24 8.501
R1879 VSS.n426 VSS.t2316 0.130189
R1880 VSS.n425 VSS.t2311 0.130189
R1881 VSS.t2309 VSS.n24 8.501
R1882 VSS.n424 VSS.t2306 0.130189
R1883 VSS.t2304 VSS.n24 8.501
R1884 VSS.n423 VSS.t2301 0.130189
R1885 VSS.t2299 VSS.n24 8.501
R1886 VSS.n422 VSS.t2296 0.130189
R1887 VSS.t2294 VSS.n24 8.501
R1888 VSS.n421 VSS.t2291 0.130189
R1889 VSS.t2289 VSS.n24 8.501
R1890 VSS.n420 VSS.t2286 0.130189
R1891 VSS.t2284 VSS.n24 8.501
R1892 VSS.n419 VSS.t2281 0.130189
R1893 VSS.t2279 VSS.n24 8.501
R1894 VSS.n418 VSS.t2276 0.130189
R1895 VSS.t2274 VSS.n24 8.501
R1896 VSS.n417 VSS.t2271 0.130189
R1897 VSS.t2269 VSS.n24 8.501
R1898 VSS.n416 VSS.t2266 0.130189
R1899 VSS.t2264 VSS.n24 8.501
R1900 VSS.n415 VSS.t2261 0.130189
R1901 VSS.t2259 VSS.n24 8.501
R1902 VSS.n414 VSS.t2256 0.130189
R1903 VSS.t2254 VSS.n24 8.501
R1904 VSS.n413 VSS.t2251 0.130189
R1905 VSS.t2249 VSS.n24 8.501
R1906 VSS.n412 VSS.t2246 0.130189
R1907 VSS.t2244 VSS.n24 8.501
R1908 VSS.n411 VSS.t2241 0.130189
R1909 VSS.t2239 VSS.n24 8.501
R1910 VSS.t2236 VSS.n410 0.130189
R1911 VSS.t2234 VSS.n24 8.501
R1912 VSS.t2231 VSS.n409 0.130189
R1913 VSS.t2229 VSS.n24 8.501
R1914 VSS.t2226 VSS.n408 0.130189
R1915 VSS.t2224 VSS.n24 8.501
R1916 VSS.n407 VSS.n24 3.33079
R1917 VSS.n519 VSS.t2104 0.130189
R1918 VSS.t2102 VSS.n22 8.501
R1919 VSS.n518 VSS.t2099 0.130189
R1920 VSS.t2097 VSS.n22 8.501
R1921 VSS.n517 VSS.t2094 0.130189
R1922 VSS.t2092 VSS.n22 8.501
R1923 VSS.n516 VSS.t2089 0.130189
R1924 VSS.t2087 VSS.n22 8.501
R1925 VSS.n515 VSS.t2084 0.130189
R1926 VSS.t2082 VSS.n22 8.501
R1927 VSS.n514 VSS.t2079 0.130189
R1928 VSS.t2077 VSS.n22 8.501
R1929 VSS.n513 VSS.t2074 0.130189
R1930 VSS.t2072 VSS.n308 0.0362711
R1931 VSS.n512 VSS.t2069 0.0793054
R1932 VSS.n22 VSS.t2067 8.501
R1933 VSS.t2064 VSS.n511 0.130189
R1934 VSS.t2062 VSS.n22 8.501
R1935 VSS.t2059 VSS.n510 0.130189
R1936 VSS.t2057 VSS.n22 8.501
R1937 VSS.t2054 VSS.n509 0.130189
R1938 VSS.t2052 VSS.n22 8.501
R1939 VSS.t2049 VSS.n508 0.130189
R1940 VSS.t2047 VSS.n22 8.501
R1941 VSS.t2044 VSS.n507 0.130189
R1942 VSS.t2042 VSS.n22 8.501
R1943 VSS.t2039 VSS.n506 0.130189
R1944 VSS.t2037 VSS.n22 8.501
R1945 VSS.t2034 VSS.n505 0.130189
R1946 VSS.t2032 VSS.n22 8.501
R1947 VSS.t2029 VSS.n504 0.130189
R1948 VSS.t2027 VSS.n22 8.501
R1949 VSS.t2024 VSS.n503 0.130189
R1950 VSS.t2022 VSS.n22 8.501
R1951 VSS.t2019 VSS.n502 0.130189
R1952 VSS.t2017 VSS.n22 8.501
R1953 VSS.t2014 VSS.n501 0.130189
R1954 VSS.t2012 VSS.n22 8.501
R1955 VSS.t2009 VSS.n500 0.130189
R1956 VSS.t2007 VSS.n22 8.501
R1957 VSS.t2004 VSS.n499 0.130189
R1958 VSS.t2002 VSS.n22 8.501
R1959 VSS.t1999 VSS.n498 0.130189
R1960 VSS.t1997 VSS.n309 0.0362711
R1961 VSS.n497 VSS.t1994 0.0793054
R1962 VSS.t1992 VSS.n22 8.501
R1963 VSS.n496 VSS.t1989 0.130189
R1964 VSS.t1987 VSS.n22 8.501
R1965 VSS.n495 VSS.t1984 0.130189
R1966 VSS.t1982 VSS.n22 8.501
R1967 VSS.n494 VSS.t1979 0.130189
R1968 VSS.t1977 VSS.n22 8.501
R1969 VSS.n493 VSS.t1974 0.130189
R1970 VSS.t1972 VSS.n22 8.501
R1971 VSS.n492 VSS.t1969 0.130189
R1972 VSS.t1967 VSS.n22 8.501
R1973 VSS.n491 VSS.t1964 0.130189
R1974 VSS.t1962 VSS.n22 8.501
R1975 VSS.n490 VSS.t1959 0.130189
R1976 VSS.t1957 VSS.n22 8.501
R1977 VSS.n489 VSS.t1954 0.130189
R1978 VSS.t1952 VSS.n22 8.501
R1979 VSS.n488 VSS.t1949 0.130189
R1980 VSS.t1947 VSS.n22 8.501
R1981 VSS.n487 VSS.t1944 0.130189
R1982 VSS.t1942 VSS.n22 8.501
R1983 VSS.n486 VSS.t1939 0.130189
R1984 VSS.t1937 VSS.n22 8.501
R1985 VSS.n485 VSS.t1934 0.130189
R1986 VSS.t1932 VSS.n22 8.501
R1987 VSS.n484 VSS.t1929 0.130189
R1988 VSS.t1927 VSS.n22 8.501
R1989 VSS.n483 VSS.t1924 0.130189
R1990 VSS.n482 VSS.t1919 0.130189
R1991 VSS.t1917 VSS.n22 8.501
R1992 VSS.t1914 VSS.n481 0.130189
R1993 VSS.t1912 VSS.n22 8.501
R1994 VSS.t1909 VSS.n480 0.130189
R1995 VSS.t1907 VSS.n22 8.501
R1996 VSS.t1904 VSS.n479 0.130189
R1997 VSS.t1902 VSS.n22 8.501
R1998 VSS.t1899 VSS.n478 0.130189
R1999 VSS.t1897 VSS.n22 8.501
R2000 VSS.t1894 VSS.n477 0.130189
R2001 VSS.t1892 VSS.n22 8.501
R2002 VSS.t1889 VSS.n476 0.130189
R2003 VSS.t1887 VSS.n22 8.501
R2004 VSS.t1884 VSS.n475 0.130189
R2005 VSS.t1882 VSS.n22 8.501
R2006 VSS.t1879 VSS.n474 0.130189
R2007 VSS.t1877 VSS.n22 8.501
R2008 VSS.t1874 VSS.n473 0.130189
R2009 VSS.t1872 VSS.n22 8.501
R2010 VSS.t1869 VSS.n472 0.130189
R2011 VSS.t1867 VSS.n22 8.501
R2012 VSS.t1864 VSS.n471 0.130189
R2013 VSS.t1862 VSS.n22 8.501
R2014 VSS.t1859 VSS.n470 0.130189
R2015 VSS.t1857 VSS.n22 8.501
R2016 VSS.t1854 VSS.n469 0.130189
R2017 VSS.t1852 VSS.n22 8.501
R2018 VSS.t1849 VSS.n468 0.130189
R2019 VSS.t1847 VSS.n22 8.501
R2020 VSS.t1844 VSS.n467 0.130189
R2021 VSS.t1842 VSS.n22 8.501
R2022 VSS.t1839 VSS.n466 0.130189
R2023 VSS.t1837 VSS.n22 8.501
R2024 VSS.t1834 VSS.n465 0.130189
R2025 VSS.t1832 VSS.n22 8.501
R2026 VSS.n464 VSS.n22 3.33079
R2027 VSS.n576 VSS.t1712 0.130189
R2028 VSS.t1710 VSS.n23 8.501
R2029 VSS.n575 VSS.t1707 0.130189
R2030 VSS.t1705 VSS.n23 8.501
R2031 VSS.n574 VSS.t1702 0.130189
R2032 VSS.t1700 VSS.n23 8.501
R2033 VSS.n573 VSS.t1697 0.130189
R2034 VSS.t1695 VSS.n23 8.501
R2035 VSS.n572 VSS.t1692 0.130189
R2036 VSS.t1690 VSS.n23 8.501
R2037 VSS.n571 VSS.t1687 0.130189
R2038 VSS.t1685 VSS.n23 8.501
R2039 VSS.n570 VSS.t1682 0.130189
R2040 VSS.t1680 VSS.n306 0.0362711
R2041 VSS.n569 VSS.t1677 0.0793054
R2042 VSS.t1675 VSS.n23 8.501
R2043 VSS.n568 VSS.t1672 0.130189
R2044 VSS.t1670 VSS.n23 8.501
R2045 VSS.n567 VSS.t1667 0.130189
R2046 VSS.t1665 VSS.n23 8.501
R2047 VSS.n566 VSS.t1662 0.130189
R2048 VSS.t1660 VSS.n23 8.501
R2049 VSS.n565 VSS.t1657 0.130189
R2050 VSS.t1655 VSS.n23 8.501
R2051 VSS.n564 VSS.t1652 0.130189
R2052 VSS.t1650 VSS.n23 8.501
R2053 VSS.n563 VSS.t1647 0.130189
R2054 VSS.t1645 VSS.n23 8.501
R2055 VSS.n562 VSS.t1642 0.130189
R2056 VSS.t1640 VSS.n23 8.501
R2057 VSS.n561 VSS.t1637 0.130189
R2058 VSS.t1635 VSS.n23 8.501
R2059 VSS.n560 VSS.t1632 0.130189
R2060 VSS.t1630 VSS.n23 8.501
R2061 VSS.n559 VSS.t1627 0.130189
R2062 VSS.t1625 VSS.n23 8.501
R2063 VSS.n558 VSS.t1622 0.130189
R2064 VSS.t1620 VSS.n23 8.501
R2065 VSS.n557 VSS.t1617 0.130189
R2066 VSS.t1615 VSS.n23 8.501
R2067 VSS.n556 VSS.t1612 0.130189
R2068 VSS.t1610 VSS.n23 8.501
R2069 VSS.n555 VSS.t1607 0.130189
R2070 VSS.t1605 VSS.n307 0.0362711
R2071 VSS.n554 VSS.t1602 0.0793054
R2072 VSS.n23 VSS.t1600 8.501
R2073 VSS.t1597 VSS.n553 0.130189
R2074 VSS.t1595 VSS.n23 8.501
R2075 VSS.t1592 VSS.n552 0.130189
R2076 VSS.t1590 VSS.n23 8.501
R2077 VSS.t1587 VSS.n551 0.130189
R2078 VSS.t1585 VSS.n23 8.501
R2079 VSS.t1582 VSS.n550 0.130189
R2080 VSS.t1580 VSS.n23 8.501
R2081 VSS.t1577 VSS.n549 0.130189
R2082 VSS.t1575 VSS.n23 8.501
R2083 VSS.t1572 VSS.n548 0.130189
R2084 VSS.t1570 VSS.n23 8.501
R2085 VSS.t1567 VSS.n547 0.130189
R2086 VSS.t1565 VSS.n23 8.501
R2087 VSS.t1562 VSS.n546 0.130189
R2088 VSS.t1560 VSS.n23 8.501
R2089 VSS.t1557 VSS.n545 0.130189
R2090 VSS.t1555 VSS.n23 8.501
R2091 VSS.t1552 VSS.n544 0.130189
R2092 VSS.t1550 VSS.n23 8.501
R2093 VSS.t1547 VSS.n543 0.130189
R2094 VSS.t1545 VSS.n23 8.501
R2095 VSS.t1542 VSS.n542 0.130189
R2096 VSS.t1540 VSS.n23 8.501
R2097 VSS.t1537 VSS.n541 0.130189
R2098 VSS.t1535 VSS.n23 8.501
R2099 VSS.t1532 VSS.n540 0.130189
R2100 VSS.n539 VSS.t1527 0.130189
R2101 VSS.t1525 VSS.n23 8.501
R2102 VSS.n538 VSS.t1522 0.130189
R2103 VSS.t1520 VSS.n23 8.501
R2104 VSS.n537 VSS.t1517 0.130189
R2105 VSS.t1515 VSS.n23 8.501
R2106 VSS.n536 VSS.t1512 0.130189
R2107 VSS.t1510 VSS.n23 8.501
R2108 VSS.n535 VSS.t1507 0.130189
R2109 VSS.t1505 VSS.n23 8.501
R2110 VSS.n534 VSS.t1502 0.130189
R2111 VSS.t1500 VSS.n23 8.501
R2112 VSS.n533 VSS.t1497 0.130189
R2113 VSS.t1495 VSS.n23 8.501
R2114 VSS.n532 VSS.t1492 0.130189
R2115 VSS.t1490 VSS.n23 8.501
R2116 VSS.n531 VSS.t1487 0.130189
R2117 VSS.t1485 VSS.n23 8.501
R2118 VSS.n530 VSS.t1482 0.130189
R2119 VSS.t1480 VSS.n23 8.501
R2120 VSS.n529 VSS.t1477 0.130189
R2121 VSS.t1475 VSS.n23 8.501
R2122 VSS.n528 VSS.t1472 0.130189
R2123 VSS.t1470 VSS.n23 8.501
R2124 VSS.n527 VSS.t1467 0.130189
R2125 VSS.t1465 VSS.n23 8.501
R2126 VSS.n526 VSS.t1462 0.130189
R2127 VSS.t1460 VSS.n23 8.501
R2128 VSS.n525 VSS.t1457 0.130189
R2129 VSS.t1455 VSS.n23 8.501
R2130 VSS.t1452 VSS.n524 0.130189
R2131 VSS.t1450 VSS.n23 8.501
R2132 VSS.t1447 VSS.n523 0.130189
R2133 VSS.t1445 VSS.n23 8.501
R2134 VSS.t1442 VSS.n522 0.130189
R2135 VSS.t1440 VSS.n23 8.501
R2136 VSS.n521 VSS.n23 3.33079
R2137 VSS.n658 VSS.t1038 0.130189
R2138 VSS.t1036 VSS.n117 8.501
R2139 VSS.n657 VSS.t1033 0.130189
R2140 VSS.t1031 VSS.n117 8.501
R2141 VSS.n656 VSS.t1028 0.130189
R2142 VSS.t1026 VSS.n117 8.501
R2143 VSS.n655 VSS.t1023 0.130189
R2144 VSS.t1021 VSS.n117 8.501
R2145 VSS.n654 VSS.t1018 0.130189
R2146 VSS.t1016 VSS.n117 8.501
R2147 VSS.n653 VSS.t1013 0.130189
R2148 VSS.t1011 VSS.n117 8.501
R2149 VSS.n652 VSS.t1008 0.130189
R2150 VSS.n197 VSS.n117 5.64438
R2151 VSS.n651 VSS.t1003 0.0793054
R2152 VSS.n117 VSS.t1001 8.501
R2153 VSS.t998 VSS.n650 0.130189
R2154 VSS.t996 VSS.n117 8.501
R2155 VSS.t993 VSS.n649 0.130189
R2156 VSS.t991 VSS.n117 8.501
R2157 VSS.t988 VSS.n648 0.130189
R2158 VSS.t986 VSS.n117 8.501
R2159 VSS.t983 VSS.n647 0.130189
R2160 VSS.t981 VSS.n117 8.501
R2161 VSS.t978 VSS.n646 0.130189
R2162 VSS.t976 VSS.n117 8.501
R2163 VSS.t973 VSS.n645 0.130189
R2164 VSS.t971 VSS.n117 8.501
R2165 VSS.t968 VSS.n644 0.130189
R2166 VSS.t966 VSS.n117 8.501
R2167 VSS.t963 VSS.n643 0.130189
R2168 VSS.t961 VSS.n117 8.501
R2169 VSS.t958 VSS.n642 0.130189
R2170 VSS.t956 VSS.n117 8.501
R2171 VSS.t953 VSS.n641 0.130189
R2172 VSS.t951 VSS.n117 8.501
R2173 VSS.t948 VSS.n640 0.130189
R2174 VSS.t946 VSS.n117 8.501
R2175 VSS.t943 VSS.n639 0.130189
R2176 VSS.t941 VSS.n117 8.501
R2177 VSS.t938 VSS.n638 0.130189
R2178 VSS.t936 VSS.n117 8.501
R2179 VSS.t933 VSS.n637 0.130189
R2180 VSS.n166 VSS.n117 5.64438
R2181 VSS.t928 VSS.n636 0.0793054
R2182 VSS.t926 VSS.n117 8.501
R2183 VSS.t923 VSS.n635 0.130189
R2184 VSS.t921 VSS.n117 8.501
R2185 VSS.t918 VSS.n634 0.130189
R2186 VSS.t916 VSS.n117 8.501
R2187 VSS.t913 VSS.n633 0.130189
R2188 VSS.t911 VSS.n117 8.501
R2189 VSS.t908 VSS.n632 0.130189
R2190 VSS.t906 VSS.n117 8.501
R2191 VSS.t903 VSS.n631 0.130189
R2192 VSS.t901 VSS.n117 8.501
R2193 VSS.t898 VSS.n630 0.130189
R2194 VSS.t896 VSS.n117 8.501
R2195 VSS.t893 VSS.n629 0.130189
R2196 VSS.t891 VSS.n117 8.501
R2197 VSS.t888 VSS.n628 0.130189
R2198 VSS.t886 VSS.n117 8.501
R2199 VSS.t883 VSS.n627 0.130189
R2200 VSS.t881 VSS.n117 8.501
R2201 VSS.t878 VSS.n626 0.130189
R2202 VSS.t876 VSS.n117 8.501
R2203 VSS.t873 VSS.n625 0.130189
R2204 VSS.t871 VSS.n117 8.501
R2205 VSS.t868 VSS.n624 0.130189
R2206 VSS.t866 VSS.n117 8.501
R2207 VSS.t863 VSS.n623 0.130189
R2208 VSS.t861 VSS.n117 8.501
R2209 VSS.t858 VSS.n622 0.130189
R2210 VSS.t853 VSS.n621 0.130189
R2211 VSS.t851 VSS.n117 8.501
R2212 VSS.t848 VSS.n620 0.130189
R2213 VSS.t846 VSS.n117 8.501
R2214 VSS.t843 VSS.n619 0.130189
R2215 VSS.t841 VSS.n117 8.501
R2216 VSS.t838 VSS.n618 0.130189
R2217 VSS.t836 VSS.n117 8.501
R2218 VSS.t833 VSS.n617 0.130189
R2219 VSS.t831 VSS.n117 8.501
R2220 VSS.t828 VSS.n616 0.130189
R2221 VSS.t826 VSS.n117 8.501
R2222 VSS.t823 VSS.n615 0.130189
R2223 VSS.t821 VSS.n117 8.501
R2224 VSS.t818 VSS.n614 0.130189
R2225 VSS.t816 VSS.n117 8.501
R2226 VSS.t813 VSS.n613 0.130189
R2227 VSS.t811 VSS.n117 8.501
R2228 VSS.t808 VSS.n612 0.130189
R2229 VSS.t806 VSS.n117 8.501
R2230 VSS.t803 VSS.n611 0.130189
R2231 VSS.t801 VSS.n117 8.501
R2232 VSS.t798 VSS.n610 0.130189
R2233 VSS.t796 VSS.n117 8.501
R2234 VSS.t793 VSS.n609 0.130189
R2235 VSS.t791 VSS.n117 8.501
R2236 VSS.t788 VSS.n608 0.130189
R2237 VSS.t786 VSS.n117 8.501
R2238 VSS.t783 VSS.n607 0.130189
R2239 VSS.t781 VSS.n117 8.501
R2240 VSS.t778 VSS.n606 0.130189
R2241 VSS.t776 VSS.n117 8.501
R2242 VSS.t773 VSS.n605 0.130189
R2243 VSS.t771 VSS.n117 8.501
R2244 VSS.t768 VSS.n604 0.130189
R2245 VSS.t766 VSS.n117 8.501
R2246 VSS.n603 VSS.n117 3.33079
R2247 VSS.t685 VSS.n673 0.0333775
R2248 VSS.t683 VSS.t66 8.501
R2249 VSS.t44 VSS.n672 0.129991
R2250 VSS.t679 VSS.t66 8.501
R2251 VSS.t571 VSS.n671 0.123414
R2252 VSS.t568 VSS.t66 8.501
R2253 VSS.t565 VSS.n670 0.130189
R2254 VSS.t563 VSS.t66 8.501
R2255 VSS.n669 VSS.t560 0.130189
R2256 VSS.t555 VSS.n668 0.130189
R2257 VSS.t553 VSS.t66 8.501
R2258 VSS.n667 VSS.t550 0.130189
R2259 VSS.t548 VSS.t66 8.501
R2260 VSS.n666 VSS.t545 0.130189
R2261 VSS.t543 VSS.t66 8.501
R2262 VSS.n665 VSS.t540 0.130189
R2263 VSS.t538 VSS.t66 8.501
R2264 VSS.n664 VSS.t535 0.130189
R2265 VSS.t533 VSS.t66 8.501
R2266 VSS.n663 VSS.t530 0.130189
R2267 VSS.t528 VSS.t66 8.501
R2268 VSS.n662 VSS.t525 0.130189
R2269 VSS.t523 VSS.t66 8.501
R2270 VSS.n661 VSS.t520 0.130189
R2271 VSS.t257 VSS.t66 8.501
R2272 VSS.n660 VSS.t66 2.31514
R2273 VSS.t103 VSS.n659 0.235729
R2274 VSS.n675 VSS.t66 0.983384
R2275 VSS.t689 VSS.n674 0.130189
R2276 VSS.n282 VSS.t687 0.0836055
R2277 VSS.t66 VSS.n214 0.991884
R2278 VSS.n222 VSS.t66 1.74964
R2279 VSS.t588 VSS.n680 0.235729
R2280 VSS.t583 VSS.n679 0.182614
R2281 VSS.t580 VSS.n678 0.235729
R2282 VSS.t578 VSS.n677 0.235729
R2283 VSS.t83 VSS.n676 0.129991
R2284 VSS.t576 VSS.n214 0.575462
R2285 VSS.t590 VSS.t66 8.501
R2286 VSS.t723 VSS.n683 0.130189
R2287 VSS.t721 VSS.t66 8.501
R2288 VSS.n682 VSS.t243 0.130189
R2289 VSS.n681 VSS.t66 0.808749
R2290 VSS.t635 VSS.n700 0.096752
R2291 VSS.t632 VSS.n699 0.235729
R2292 VSS.t629 VSS.n698 0.235729
R2293 VSS.t626 VSS.n697 0.235729
R2294 VSS.t623 VSS.n696 0.235729
R2295 VSS.t620 VSS.n695 0.235729
R2296 VSS.t617 VSS.n694 0.235729
R2297 VSS.t614 VSS.n693 0.235729
R2298 VSS.t611 VSS.n692 0.235729
R2299 VSS.t608 VSS.n691 0.235729
R2300 VSS.t605 VSS.n690 0.235729
R2301 VSS.t602 VSS.n689 0.235729
R2302 VSS.t599 VSS.n688 0.235729
R2303 VSS.t596 VSS.n687 0.235729
R2304 VSS.t593 VSS.n686 0.235729
R2305 VSS.t187 VSS.n685 0.235729
R2306 VSS.t66 VSS.n684 2.31576
R2307 VSS.t726 VSS.t66 8.501
R2308 VSS.n701 VSS.t25 0.578618
R2309 VSS.t22 VSS.t4 8.501
R2310 VSS.n232 VSS.t4 0.99289
R2311 VSS.t399 VSS.t4 8.501
R2312 VSS.t445 VSS.n718 0.096752
R2313 VSS.t4 VSS.t444 8.501
R2314 VSS.t442 VSS.n717 0.130189
R2315 VSS.t4 VSS.t441 8.501
R2316 VSS.t439 VSS.n716 0.130189
R2317 VSS.t4 VSS.t438 8.501
R2318 VSS.t436 VSS.n715 0.130189
R2319 VSS.t4 VSS.t435 8.501
R2320 VSS.t433 VSS.n714 0.130189
R2321 VSS.t4 VSS.t432 8.501
R2322 VSS.t430 VSS.n713 0.130189
R2323 VSS.t4 VSS.t429 8.501
R2324 VSS.t427 VSS.n712 0.130189
R2325 VSS.t4 VSS.t426 8.501
R2326 VSS.t424 VSS.n711 0.130189
R2327 VSS.t4 VSS.t423 8.501
R2328 VSS.t421 VSS.n710 0.130189
R2329 VSS.t4 VSS.t420 8.501
R2330 VSS.t418 VSS.n709 0.130189
R2331 VSS.t4 VSS.t417 8.501
R2332 VSS.t415 VSS.n708 0.130189
R2333 VSS.t4 VSS.t414 8.501
R2334 VSS.t412 VSS.n707 0.130189
R2335 VSS.t4 VSS.t411 8.501
R2336 VSS.t409 VSS.n706 0.130189
R2337 VSS.t4 VSS.t408 8.501
R2338 VSS.t406 VSS.n705 0.130189
R2339 VSS.t4 VSS.t405 8.501
R2340 VSS.n704 VSS.t403 0.130189
R2341 VSS.t402 VSS.t4 8.501
R2342 VSS.n721 VSS.t459 0.130189
R2343 VSS.t51 VSS.t4 8.501
R2344 VSS.t144 VSS.n720 0.130189
R2345 VSS.n719 VSS.t1 0.752903
R2346 VSS.t32 VSS.n726 0.774744
R2347 VSS.n725 VSS.t4 3.33079
R2348 VSS.t134 VSS.n724 0.570079
R2349 VSS.t389 VSS.t4 8.501
R2350 VSS.n723 VSS.t4 3.33079
R2351 VSS.n24 VSS.t2314 8.5005
R2352 VSS.n22 VSS.t1922 8.5005
R2353 VSS.n23 VSS.t1530 8.5005
R2354 VSS.t856 VSS.n117 8.5005
R2355 VSS.t66 VSS.t558 8.5005
R2356 VSS.t760 VSS.n171 8.00267
R2357 VSS.n382 VSS.n127 4.20468
R2358 VSS.n367 VSS.n127 4.20468
R2359 VSS.t305 VSS.n390 0.173604
R2360 VSS.t341 VSS.n400 0.153604
R2361 VSS.t206 VSS.n202 3.30688
R2362 VSS.n213 VSS.t2751 0.119605
R2363 VSS.t2753 VSS.n288 0.119605
R2364 VSS.t206 VSS.n213 4.177
R2365 VSS.t206 VSS.n288 4.177
R2366 VSS.t2754 VSS.n402 0.119605
R2367 VSS.t206 VSS.n402 4.177
R2368 VSS.n280 VSS.t206 3.30688
R2369 VSS.t206 VSS.n215 4.177
R2370 VSS.n215 VSS.t2759 0.119605
R2371 VSS.n223 VSS.t2760 0.119605
R2372 VSS.t2762 VSS.n289 0.119605
R2373 VSS.t206 VSS.n223 4.177
R2374 VSS.t206 VSS.n289 4.177
R2375 VSS.t2763 VSS.n403 0.119605
R2376 VSS.t206 VSS.n403 4.177
R2377 VSS.n312 VSS.t206 4.177
R2378 VSS.n312 VSS.t2767 0.119605
R2379 VSS.t2769 VSS.n404 0.083315
R2380 VSS.n279 VSS.t206 3.30696
R2381 VSS.n313 VSS.t2743 0.119605
R2382 VSS.n313 VSS.t206 4.177
R2383 VSS.t206 VSS.n278 3.30688
R2384 VSS.t2735 VSS.n314 0.17801
R2385 VSS.t2729 VSS.n315 0.17801
R2386 VSS.t2723 VSS.n277 0.17801
R2387 VSS.n316 VSS.t2719 0.177814
R2388 VSS.n276 VSS.t2714 0.177814
R2389 VSS.n317 VSS.t2710 0.17801
R2390 VSS.t206 VSS.t2705 8.47111
R2391 VSS.n318 VSS.t2704 0.17801
R2392 VSS.n275 VSS.t2699 0.17801
R2393 VSS.t2695 VSS.n319 0.17801
R2394 VSS.t2690 VSS.n320 0.17801
R2395 VSS.t2685 VSS.n274 0.17801
R2396 VSS.t2681 VSS.n321 0.177814
R2397 VSS.n273 VSS.t206 3.30696
R2398 VSS.n322 VSS.t2672 0.177814
R2399 VSS.t206 VSS.t2667 8.47111
R2400 VSS.n323 VSS.t2666 0.177814
R2401 VSS.n272 VSS.t2660 0.177814
R2402 VSS.n324 VSS.t2655 0.17801
R2403 VSS.n271 VSS.t2649 0.17801
R2404 VSS.t2644 VSS.n325 0.17801
R2405 VSS.t2638 VSS.n326 0.17801
R2406 VSS.t2632 VSS.n270 0.17801
R2407 VSS.t2630 VSS.n269 0.17801
R2408 VSS.n268 VSS.t2628 0.17801
R2409 VSS.t2623 VSS.n267 0.119605
R2410 VSS.t206 VSS.n267 4.177
R2411 VSS.n327 VSS.t2619 0.177814
R2412 VSS.n266 VSS.t206 3.30688
R2413 VSS.n405 VSS.t2613 0.10425
R2414 VSS.n24 VSS.n455 4.20468
R2415 VSS.n440 VSS.n24 4.20468
R2416 VSS.n512 VSS.n22 4.20468
R2417 VSS.n497 VSS.n22 4.20468
R2418 VSS.n569 VSS.n23 4.20468
R2419 VSS.n554 VSS.n23 4.20468
R2420 VSS.n577 VSS.t1154 5.61485
R2421 VSS.n943 VSS.t1154 8.47111
R2422 VSS.n578 VSS.t1154 3.30696
R2423 VSS.n294 VSS.t1154 3.30696
R2424 VSS.t1220 VSS.n290 0.17801
R2425 VSS.t1221 VSS.n579 0.119605
R2426 VSS.n579 VSS.t1154 4.177
R2427 VSS.n580 VSS.t1154 3.30688
R2428 VSS.t1225 VSS.n169 0.17801
R2429 VSS.t1227 VSS.n581 0.177814
R2430 VSS.t1233 VSS.n228 0.291785
R2431 VSS.n242 VSS.t1154 3.30696
R2432 VSS.t1238 VSS.n582 0.17801
R2433 VSS.t1241 VSS.n583 0.119605
R2434 VSS.n583 VSS.t1154 4.177
R2435 VSS.n291 VSS.t1154 3.30688
R2436 VSS.t1245 VSS.n584 0.119605
R2437 VSS.n584 VSS.t1154 4.177
R2438 VSS.n265 VSS.t1154 3.30696
R2439 VSS.t1249 VSS.n585 0.119605
R2440 VSS.n165 VSS.t1154 2.29759
R2441 VSS.n585 VSS.t1154 4.177
R2442 VSS.n186 VSS.t1154 3.30688
R2443 VSS.t1257 VSS.n229 0.119605
R2444 VSS.n229 VSS.t1154 4.177
R2445 VSS.n586 VSS.t1154 3.30688
R2446 VSS.t1260 VSS.n192 0.235242
R2447 VSS.n192 VSS.t1154 2.72093
R2448 VSS.t1262 VSS.n587 0.119605
R2449 VSS.n587 VSS.t1154 4.177
R2450 VSS.t1264 VSS.t1154 8.47111
R2451 VSS.n287 VSS.t1154 3.30696
R2452 VSS.t1267 VSS.t1154 8.47111
R2453 VSS.t1268 VSS.n588 0.17801
R2454 VSS.t1270 VSS.n234 0.119605
R2455 VSS.t1272 VSS.n304 0.2914
R2456 VSS.n234 VSS.t1154 4.177
R2457 VSS.t1275 VSS.n246 0.2914
R2458 VSS.n246 VSS.t1154 2.29759
R2459 VSS.t1278 VSS.n245 0.2914
R2460 VSS.n245 VSS.t1154 2.29759
R2461 VSS.t1281 VSS.n286 0.119605
R2462 VSS.n286 VSS.t1154 4.177
R2463 VSS.t1286 VSS.n206 0.17801
R2464 VSS.t1287 VSS.n589 0.119605
R2465 VSS.n589 VSS.t1154 4.177
R2466 VSS.n285 VSS.t1154 4.177
R2467 VSS.t1291 VSS.n285 0.119605
R2468 VSS.t1293 VSS.n284 0.177814
R2469 VSS.t1294 VSS.t1154 8.47111
R2470 VSS.t1299 VSS.n244 0.17801
R2471 VSS.n244 VSS.t1154 3.30688
R2472 VSS.n208 VSS.t1154 4.177
R2473 VSS.n208 VSS.t1419 0.119605
R2474 VSS.n590 VSS.t1154 3.30688
R2475 VSS.t1422 VSS.t1154 8.47111
R2476 VSS.n591 VSS.t1154 3.30688
R2477 VSS.t1425 VSS.t1154 8.47111
R2478 VSS.n592 VSS.t1154 3.30688
R2479 VSS.t1428 VSS.n283 0.119605
R2480 VSS.n283 VSS.t1154 4.177
R2481 VSS.t1154 VSS.n211 3.30688
R2482 VSS.n593 VSS.t1317 0.119605
R2483 VSS.t1154 VSS.n593 4.177
R2484 VSS.n594 VSS.t1154 3.30688
R2485 VSS.n595 VSS.t1154 4.177
R2486 VSS.t1208 VSS.n595 0.119605
R2487 VSS.n292 VSS.t1154 4.177
R2488 VSS.t1206 VSS.n292 0.119605
R2489 VSS.n224 VSS.t1154 3.30688
R2490 VSS.n596 VSS.t1154 4.177
R2491 VSS.t1202 VSS.n596 0.119605
R2492 VSS.n233 VSS.t1154 2.72093
R2493 VSS.t1200 VSS.n233 0.235242
R2494 VSS.n217 VSS.t1154 3.30696
R2495 VSS.n597 VSS.t1154 4.177
R2496 VSS.t1196 VSS.n597 0.119605
R2497 VSS.n293 VSS.t1154 4.177
R2498 VSS.t1194 VSS.n293 0.119605
R2499 VSS.n225 VSS.t1154 4.177
R2500 VSS.t1192 VSS.n225 0.119605
R2501 VSS.n216 VSS.t1154 4.177
R2502 VSS.n598 VSS.t1154 4.177
R2503 VSS.t1189 VSS.n598 0.119605
R2504 VSS.t1188 VSS.t1154 8.47111
R2505 VSS.n599 VSS.t1154 4.177
R2506 VSS.t1186 VSS.n599 0.119605
R2507 VSS.t1184 VSS.n295 0.17801
R2508 VSS.t1182 VSS.n296 0.177814
R2509 VSS.t1180 VSS.n297 0.119605
R2510 VSS.n297 VSS.t1154 4.177
R2511 VSS.n600 VSS.t1154 4.177
R2512 VSS.t1177 VSS.n600 0.119605
R2513 VSS.t1175 VSS.n298 0.17801
R2514 VSS.t1173 VSS.n299 0.177814
R2515 VSS.t1171 VSS.n300 0.119605
R2516 VSS.n300 VSS.t1154 4.177
R2517 VSS.n601 VSS.t1154 4.177
R2518 VSS.t1168 VSS.n601 0.119605
R2519 VSS.n302 VSS.t1164 0.17801
R2520 VSS.n303 VSS.t1162 0.119605
R2521 VSS.t1154 VSS.n303 4.177
R2522 VSS.t1154 VSS.n602 4.177
R2523 VSS.t1159 VSS.n602 0.119605
R2524 VSS.t1154 VSS.n205 3.30696
R2525 VSS.n651 VSS.n117 4.20468
R2526 VSS.n117 VSS.n636 4.20468
R2527 VSS.n282 VSS.t66 4.20253
R2528 VSS.t66 VSS.n788 8.47111
R2529 VSS.n226 VSS.t4 1.97603
R2530 VSS.n170 VSS.t4 0.72791
R2531 VSS.t4 VSS.n703 3.30688
R2532 VSS.n167 VSS.t4 3.30696
R2533 VSS.n162 VSS.t3261 0.360811
R2534 VSS.t9 VSS.n200 0.291652
R2535 VSS.n219 VSS.t4 3.30688
R2536 VSS.n775 VSS.t210 8.06935
R2537 VSS.t3181 VSS.t684 7.1604
R2538 VSS.t168 VSS.t98 7.1604
R2539 VSS.t4 VSS.t13 0.738988
R2540 VSS.t8 VSS.t4 0.442113
R2541 VSS.t206 VSS.n405 4.19381
R2542 VSS.t66 VSS.n700 3.35999
R2543 VSS.n127 VSS.n389 3.33079
R2544 VSS.n388 VSS.n127 3.33079
R2545 VSS.n127 VSS.n387 3.33079
R2546 VSS.n386 VSS.n127 3.33079
R2547 VSS.n127 VSS.n385 3.33079
R2548 VSS.n384 VSS.n127 3.33079
R2549 VSS.n127 VSS.n383 3.33079
R2550 VSS.n127 VSS.n381 3.33079
R2551 VSS.n380 VSS.n127 3.33079
R2552 VSS.n127 VSS.n379 3.33079
R2553 VSS.n378 VSS.n127 3.33079
R2554 VSS.n127 VSS.n377 3.33079
R2555 VSS.n376 VSS.n127 3.33079
R2556 VSS.n127 VSS.n375 3.33079
R2557 VSS.n374 VSS.n127 3.33079
R2558 VSS.n127 VSS.n373 3.33079
R2559 VSS.n372 VSS.n127 3.33079
R2560 VSS.n127 VSS.n371 3.33079
R2561 VSS.n370 VSS.n127 3.33079
R2562 VSS.n127 VSS.n369 3.33079
R2563 VSS.n368 VSS.n127 3.33079
R2564 VSS.n127 VSS.n366 3.33079
R2565 VSS.n365 VSS.n127 3.33079
R2566 VSS.n364 VSS.n127 3.33079
R2567 VSS.n363 VSS.n127 3.33079
R2568 VSS.n362 VSS.n127 3.33079
R2569 VSS.n361 VSS.n127 3.33079
R2570 VSS.n360 VSS.n127 3.33079
R2571 VSS.n359 VSS.n127 3.33079
R2572 VSS.n358 VSS.n127 3.33079
R2573 VSS.n357 VSS.n127 3.33079
R2574 VSS.n356 VSS.n127 3.33079
R2575 VSS.n355 VSS.n127 3.33079
R2576 VSS.n354 VSS.n127 3.33079
R2577 VSS.n353 VSS.n127 3.33079
R2578 VSS.n352 VSS.n127 3.33079
R2579 VSS.n351 VSS.n127 3.33079
R2580 VSS.n350 VSS.n127 3.33079
R2581 VSS.n349 VSS.n127 3.33079
R2582 VSS.n348 VSS.n127 3.33079
R2583 VSS.n347 VSS.n127 3.33079
R2584 VSS.n346 VSS.n127 3.33079
R2585 VSS.n345 VSS.n127 3.33079
R2586 VSS.n344 VSS.n127 3.33079
R2587 VSS.n343 VSS.n127 3.33079
R2588 VSS.n342 VSS.n127 3.33079
R2589 VSS.n341 VSS.n127 3.33079
R2590 VSS.n340 VSS.n127 3.33079
R2591 VSS.n339 VSS.n127 3.33079
R2592 VSS.n127 VSS.n338 3.33079
R2593 VSS.n336 VSS.n127 3.33079
R2594 VSS.n127 VSS.n335 3.33079
R2595 VSS.t2884 VSS.n334 0.0863258
R2596 VSS.t268 VSS.n727 0.0896992
R2597 VSS.t310 VSS.n391 0.0896992
R2598 VSS.t315 VSS.n392 0.0896992
R2599 VSS.t320 VSS.n393 0.0896992
R2600 VSS.t323 VSS.n395 0.0896992
R2601 VSS.t328 VSS.n396 0.0896992
R2602 VSS.t333 VSS.n397 0.0896992
R2603 VSS.t336 VSS.n399 0.0896992
R2604 VSS.n401 VSS.t7 3.32876
R2605 VSS.t2747 VSS.t206 5.61485
R2606 VSS.n202 VSS.t2749 0.118323
R2607 VSS.t2756 VSS.n280 0.118323
R2608 VSS.t2765 VSS.t206 5.61485
R2609 VSS.t2768 VSS.t206 5.61485
R2610 VSS.t2745 VSS.n279 0.118193
R2611 VSS.t206 VSS.t2744 5.61485
R2612 VSS.t206 VSS.t2741 5.61485
R2613 VSS.n278 VSS.t2739 0.118323
R2614 VSS.n209 VSS.t206 2.7209
R2615 VSS.t2736 VSS.n209 0.175554
R2616 VSS.t206 VSS.n314 3.30688
R2617 VSS.n261 VSS.t2733 0.175395
R2618 VSS.n261 VSS.t206 2.72098
R2619 VSS.t2730 VSS.t206 5.61485
R2620 VSS.t206 VSS.n315 3.30688
R2621 VSS.n260 VSS.t2727 0.175395
R2622 VSS.n260 VSS.t206 2.72098
R2623 VSS.t2724 VSS.t206 5.61485
R2624 VSS.t206 VSS.n277 3.30688
R2625 VSS.n236 VSS.t2721 0.175395
R2626 VSS.n236 VSS.t206 2.72098
R2627 VSS.n316 VSS.t206 3.30696
R2628 VSS.n259 VSS.t2717 0.175554
R2629 VSS.t206 VSS.n259 2.7209
R2630 VSS.t2715 VSS.t206 5.61485
R2631 VSS.n276 VSS.t206 3.30696
R2632 VSS.n237 VSS.t2712 0.175554
R2633 VSS.t206 VSS.n237 2.7209
R2634 VSS.t206 VSS.n317 3.30688
R2635 VSS.n258 VSS.t2708 0.175714
R2636 VSS.t206 VSS.n318 3.30688
R2637 VSS.t2702 VSS.n257 0.175714
R2638 VSS.t206 VSS.n257 2.72082
R2639 VSS.t206 VSS.t2700 5.61485
R2640 VSS.t206 VSS.n275 3.30688
R2641 VSS.t2697 VSS.n238 0.175714
R2642 VSS.t206 VSS.n238 2.72082
R2643 VSS.t206 VSS.n319 3.30688
R2644 VSS.n256 VSS.t2693 0.175395
R2645 VSS.n256 VSS.t206 2.72098
R2646 VSS.t206 VSS.t2691 5.61485
R2647 VSS.t206 VSS.n320 3.30688
R2648 VSS.n255 VSS.t2688 0.175395
R2649 VSS.n255 VSS.t206 2.72098
R2650 VSS.t206 VSS.t2686 5.61485
R2651 VSS.t206 VSS.n274 3.30688
R2652 VSS.t206 VSS.n221 2.72098
R2653 VSS.t2682 VSS.n221 0.175395
R2654 VSS.n321 VSS.t206 3.30696
R2655 VSS.n254 VSS.t2679 0.175554
R2656 VSS.t206 VSS.n254 2.7209
R2657 VSS.t2677 VSS.t206 5.61485
R2658 VSS.t2675 VSS.n273 0.118193
R2659 VSS.t206 VSS.n210 2.7209
R2660 VSS.n210 VSS.t2673 0.175554
R2661 VSS.n322 VSS.t206 3.30696
R2662 VSS.t2669 VSS.n253 0.175714
R2663 VSS.t206 VSS.n253 2.72082
R2664 VSS.n323 VSS.t206 3.30696
R2665 VSS.t2663 VSS.n252 0.175714
R2666 VSS.t206 VSS.n252 2.72082
R2667 VSS.t206 VSS.t2661 5.61485
R2668 VSS.n272 VSS.t206 3.30696
R2669 VSS.t2657 VSS.n239 0.175714
R2670 VSS.t206 VSS.n239 2.72082
R2671 VSS.t206 VSS.n324 3.30688
R2672 VSS.t2652 VSS.n251 0.175554
R2673 VSS.n251 VSS.t206 2.7209
R2674 VSS.t206 VSS.t2650 5.61485
R2675 VSS.t206 VSS.n271 3.30688
R2676 VSS.t2646 VSS.n240 0.175554
R2677 VSS.n240 VSS.t206 2.7209
R2678 VSS.t206 VSS.n325 3.30688
R2679 VSS.n250 VSS.t2642 0.175395
R2680 VSS.n250 VSS.t206 2.72098
R2681 VSS.t2639 VSS.t206 5.61485
R2682 VSS.t206 VSS.n326 3.30688
R2683 VSS.n249 VSS.t2636 0.175395
R2684 VSS.n249 VSS.t206 2.72098
R2685 VSS.t2633 VSS.t206 5.61485
R2686 VSS.t206 VSS.n270 3.30688
R2687 VSS.t206 VSS.n269 3.30688
R2688 VSS.t206 VSS.n268 3.30688
R2689 VSS.t2625 VSS.n235 0.175554
R2690 VSS.n235 VSS.t206 2.7209
R2691 VSS.n241 VSS.t2621 0.175395
R2692 VSS.n241 VSS.t206 2.72098
R2693 VSS.n327 VSS.t206 3.30696
R2694 VSS.t206 VSS.t2617 5.61485
R2695 VSS.n266 VSS.t2615 0.118323
R2696 VSS.t206 VSS.t2614 5.61485
R2697 VSS.n24 VSS.n425 3.33079
R2698 VSS.n462 VSS.n24 3.33079
R2699 VSS.n24 VSS.n461 3.33079
R2700 VSS.n24 VSS.n459 3.33079
R2701 VSS.n458 VSS.n24 3.33079
R2702 VSS.n24 VSS.n457 3.33079
R2703 VSS.n456 VSS.n24 3.33079
R2704 VSS.n454 VSS.n24 3.33079
R2705 VSS.n24 VSS.n453 3.33079
R2706 VSS.n452 VSS.n24 3.33079
R2707 VSS.n24 VSS.n451 3.33079
R2708 VSS.n450 VSS.n24 3.33079
R2709 VSS.n24 VSS.n449 3.33079
R2710 VSS.n448 VSS.n24 3.33079
R2711 VSS.n24 VSS.n447 3.33079
R2712 VSS.n446 VSS.n24 3.33079
R2713 VSS.n24 VSS.n445 3.33079
R2714 VSS.n444 VSS.n24 3.33079
R2715 VSS.n24 VSS.n443 3.33079
R2716 VSS.n442 VSS.n24 3.33079
R2717 VSS.n24 VSS.n441 3.33079
R2718 VSS.n24 VSS.n439 3.33079
R2719 VSS.n438 VSS.n24 3.33079
R2720 VSS.n24 VSS.n437 3.33079
R2721 VSS.n436 VSS.n24 3.33079
R2722 VSS.n24 VSS.n435 3.33079
R2723 VSS.n434 VSS.n24 3.33079
R2724 VSS.n24 VSS.n433 3.33079
R2725 VSS.n432 VSS.n24 3.33079
R2726 VSS.n24 VSS.n431 3.33079
R2727 VSS.n430 VSS.n24 3.33079
R2728 VSS.n24 VSS.n429 3.33079
R2729 VSS.n428 VSS.n24 3.33079
R2730 VSS.n24 VSS.n427 3.33079
R2731 VSS.n426 VSS.n24 3.33079
R2732 VSS.n424 VSS.n24 3.33079
R2733 VSS.n24 VSS.n423 3.33079
R2734 VSS.n422 VSS.n24 3.33079
R2735 VSS.n24 VSS.n421 3.33079
R2736 VSS.n420 VSS.n24 3.33079
R2737 VSS.n24 VSS.n419 3.33079
R2738 VSS.n418 VSS.n24 3.33079
R2739 VSS.n24 VSS.n417 3.33079
R2740 VSS.n416 VSS.n24 3.33079
R2741 VSS.n24 VSS.n415 3.33079
R2742 VSS.n414 VSS.n24 3.33079
R2743 VSS.n24 VSS.n413 3.33079
R2744 VSS.n412 VSS.n24 3.33079
R2745 VSS.n24 VSS.n411 3.33079
R2746 VSS.n410 VSS.n24 3.33079
R2747 VSS.n409 VSS.n24 3.33079
R2748 VSS.n408 VSS.n24 3.33079
R2749 VSS.t2222 VSS.n407 0.0863258
R2750 VSS.n482 VSS.n22 3.33079
R2751 VSS.n519 VSS.n22 3.33079
R2752 VSS.n22 VSS.n518 3.33079
R2753 VSS.n22 VSS.n516 3.33079
R2754 VSS.n515 VSS.n22 3.33079
R2755 VSS.n22 VSS.n514 3.33079
R2756 VSS.n513 VSS.n22 3.33079
R2757 VSS.n22 VSS.n511 3.33079
R2758 VSS.n510 VSS.n22 3.33079
R2759 VSS.n509 VSS.n22 3.33079
R2760 VSS.n508 VSS.n22 3.33079
R2761 VSS.n507 VSS.n22 3.33079
R2762 VSS.n506 VSS.n22 3.33079
R2763 VSS.n505 VSS.n22 3.33079
R2764 VSS.n504 VSS.n22 3.33079
R2765 VSS.n503 VSS.n22 3.33079
R2766 VSS.n502 VSS.n22 3.33079
R2767 VSS.n501 VSS.n22 3.33079
R2768 VSS.n500 VSS.n22 3.33079
R2769 VSS.n499 VSS.n22 3.33079
R2770 VSS.n498 VSS.n22 3.33079
R2771 VSS.n22 VSS.n496 3.33079
R2772 VSS.n495 VSS.n22 3.33079
R2773 VSS.n22 VSS.n494 3.33079
R2774 VSS.n493 VSS.n22 3.33079
R2775 VSS.n22 VSS.n492 3.33079
R2776 VSS.n491 VSS.n22 3.33079
R2777 VSS.n22 VSS.n490 3.33079
R2778 VSS.n489 VSS.n22 3.33079
R2779 VSS.n22 VSS.n488 3.33079
R2780 VSS.n487 VSS.n22 3.33079
R2781 VSS.n22 VSS.n486 3.33079
R2782 VSS.n485 VSS.n22 3.33079
R2783 VSS.n22 VSS.n484 3.33079
R2784 VSS.n483 VSS.n22 3.33079
R2785 VSS.n481 VSS.n22 3.33079
R2786 VSS.n480 VSS.n22 3.33079
R2787 VSS.n479 VSS.n22 3.33079
R2788 VSS.n478 VSS.n22 3.33079
R2789 VSS.n477 VSS.n22 3.33079
R2790 VSS.n476 VSS.n22 3.33079
R2791 VSS.n475 VSS.n22 3.33079
R2792 VSS.n474 VSS.n22 3.33079
R2793 VSS.n473 VSS.n22 3.33079
R2794 VSS.n472 VSS.n22 3.33079
R2795 VSS.n471 VSS.n22 3.33079
R2796 VSS.n470 VSS.n22 3.33079
R2797 VSS.n469 VSS.n22 3.33079
R2798 VSS.n468 VSS.n22 3.33079
R2799 VSS.n467 VSS.n22 3.33079
R2800 VSS.n466 VSS.n22 3.33079
R2801 VSS.n465 VSS.n22 3.33079
R2802 VSS.t1830 VSS.n464 0.0863258
R2803 VSS.n23 VSS.n539 3.33079
R2804 VSS.n23 VSS.n576 3.33079
R2805 VSS.n575 VSS.n23 3.33079
R2806 VSS.n573 VSS.n23 3.33079
R2807 VSS.n23 VSS.n572 3.33079
R2808 VSS.n571 VSS.n23 3.33079
R2809 VSS.n23 VSS.n570 3.33079
R2810 VSS.n23 VSS.n568 3.33079
R2811 VSS.n567 VSS.n23 3.33079
R2812 VSS.n23 VSS.n566 3.33079
R2813 VSS.n565 VSS.n23 3.33079
R2814 VSS.n23 VSS.n564 3.33079
R2815 VSS.n563 VSS.n23 3.33079
R2816 VSS.n23 VSS.n562 3.33079
R2817 VSS.n561 VSS.n23 3.33079
R2818 VSS.n23 VSS.n560 3.33079
R2819 VSS.n559 VSS.n23 3.33079
R2820 VSS.n23 VSS.n558 3.33079
R2821 VSS.n557 VSS.n23 3.33079
R2822 VSS.n23 VSS.n556 3.33079
R2823 VSS.n555 VSS.n23 3.33079
R2824 VSS.n23 VSS.n553 3.33079
R2825 VSS.n552 VSS.n23 3.33079
R2826 VSS.n551 VSS.n23 3.33079
R2827 VSS.n550 VSS.n23 3.33079
R2828 VSS.n549 VSS.n23 3.33079
R2829 VSS.n548 VSS.n23 3.33079
R2830 VSS.n547 VSS.n23 3.33079
R2831 VSS.n546 VSS.n23 3.33079
R2832 VSS.n545 VSS.n23 3.33079
R2833 VSS.n544 VSS.n23 3.33079
R2834 VSS.n543 VSS.n23 3.33079
R2835 VSS.n542 VSS.n23 3.33079
R2836 VSS.n541 VSS.n23 3.33079
R2837 VSS.n540 VSS.n23 3.33079
R2838 VSS.n538 VSS.n23 3.33079
R2839 VSS.n23 VSS.n537 3.33079
R2840 VSS.n536 VSS.n23 3.33079
R2841 VSS.n23 VSS.n535 3.33079
R2842 VSS.n534 VSS.n23 3.33079
R2843 VSS.n23 VSS.n533 3.33079
R2844 VSS.n532 VSS.n23 3.33079
R2845 VSS.n23 VSS.n531 3.33079
R2846 VSS.n530 VSS.n23 3.33079
R2847 VSS.n23 VSS.n529 3.33079
R2848 VSS.n528 VSS.n23 3.33079
R2849 VSS.n23 VSS.n527 3.33079
R2850 VSS.n526 VSS.n23 3.33079
R2851 VSS.n23 VSS.n525 3.33079
R2852 VSS.n524 VSS.n23 3.33079
R2853 VSS.n523 VSS.n23 3.33079
R2854 VSS.n522 VSS.n23 3.33079
R2855 VSS.t1438 VSS.n521 0.0863258
R2856 VSS.t1215 VSS.n578 0.118193
R2857 VSS.t1216 VSS.t1154 5.61485
R2858 VSS.t1217 VSS.n294 0.118193
R2859 VSS.n290 VSS.t1154 3.30688
R2860 VSS.t1224 VSS.n580 0.118323
R2861 VSS.n169 VSS.t1154 3.30688
R2862 VSS.n581 VSS.t1154 3.30696
R2863 VSS.t1231 VSS.n204 0.28702
R2864 VSS.n228 VSS.t1154 2.29748
R2865 VSS.t1236 VSS.n242 0.118193
R2866 VSS.n582 VSS.t1154 3.30688
R2867 VSS.t1240 VSS.t1154 5.61485
R2868 VSS.t1243 VSS.n291 0.118323
R2869 VSS.t1247 VSS.n265 0.118193
R2870 VSS.t1252 VSS.n165 0.232176
R2871 VSS.t1258 VSS.n586 0.118323
R2872 VSS.t1265 VSS.n287 0.118193
R2873 VSS.n588 VSS.t1154 3.30688
R2874 VSS.n304 VSS.t1154 2.29759
R2875 VSS.t1282 VSS.n264 0.175554
R2876 VSS.n264 VSS.t1154 2.7209
R2877 VSS.n206 VSS.t1154 3.30688
R2878 VSS.t1289 VSS.t1154 5.61485
R2879 VSS.n284 VSS.t1154 3.30696
R2880 VSS.n281 VSS.t1154 2.72098
R2881 VSS.t1296 VSS.n281 0.175395
R2882 VSS.t1297 VSS.t1154 5.61485
R2883 VSS.n590 VSS.t1303 0.118323
R2884 VSS.n591 VSS.t1306 0.118323
R2885 VSS.n592 VSS.t1309 0.118323
R2886 VSS.n263 VSS.t1312 0.175554
R2887 VSS.t1154 VSS.n263 2.7209
R2888 VSS.t1315 VSS.n211 0.118323
R2889 VSS.t1154 VSS.t1319 5.61485
R2890 VSS.t1320 VSS.n594 0.118323
R2891 VSS.t1210 VSS.n305 0.0599544
R2892 VSS.n224 VSS.t1204 0.118323
R2893 VSS.t1198 VSS.n217 0.118193
R2894 VSS.t1185 VSS.t1154 5.61485
R2895 VSS.t1154 VSS.n295 3.30688
R2896 VSS.n296 VSS.t1154 3.30696
R2897 VSS.t1176 VSS.t1154 5.61485
R2898 VSS.t1154 VSS.n298 3.30688
R2899 VSS.n299 VSS.t1154 3.30696
R2900 VSS.t1167 VSS.n207 0.0599544
R2901 VSS.t1154 VSS.n301 4.17712
R2902 VSS.t1154 VSS.n302 3.30688
R2903 VSS.n205 VSS.t1158 0.118193
R2904 VSS.n333 VSS.t1156 0.106161
R2905 VSS.n621 VSS.n117 3.33079
R2906 VSS.n658 VSS.n117 3.33079
R2907 VSS.n117 VSS.n657 3.33079
R2908 VSS.n656 VSS.n117 3.33079
R2909 VSS.n117 VSS.n655 3.33079
R2910 VSS.n654 VSS.n117 3.33079
R2911 VSS.n117 VSS.n653 3.33079
R2912 VSS.n652 VSS.n117 3.33079
R2913 VSS.n117 VSS.n650 3.33079
R2914 VSS.n649 VSS.n117 3.33079
R2915 VSS.n648 VSS.n117 3.33079
R2916 VSS.n647 VSS.n117 3.33079
R2917 VSS.n646 VSS.n117 3.33079
R2918 VSS.n645 VSS.n117 3.33079
R2919 VSS.n644 VSS.n117 3.33079
R2920 VSS.n643 VSS.n117 3.33079
R2921 VSS.n642 VSS.n117 3.33079
R2922 VSS.n641 VSS.n117 3.33079
R2923 VSS.n640 VSS.n117 3.33079
R2924 VSS.n639 VSS.n117 3.33079
R2925 VSS.n638 VSS.n117 3.33079
R2926 VSS.n637 VSS.n117 3.33079
R2927 VSS.n635 VSS.n117 3.33079
R2928 VSS.n634 VSS.n117 3.33079
R2929 VSS.n633 VSS.n117 3.33079
R2930 VSS.n632 VSS.n117 3.33079
R2931 VSS.n631 VSS.n117 3.33079
R2932 VSS.n630 VSS.n117 3.33079
R2933 VSS.n629 VSS.n117 3.33079
R2934 VSS.n628 VSS.n117 3.33079
R2935 VSS.n627 VSS.n117 3.33079
R2936 VSS.n626 VSS.n117 3.33079
R2937 VSS.n625 VSS.n117 3.33079
R2938 VSS.n624 VSS.n117 3.33079
R2939 VSS.n623 VSS.n117 3.33079
R2940 VSS.n622 VSS.n117 3.33079
R2941 VSS.n620 VSS.n117 3.33079
R2942 VSS.n619 VSS.n117 3.33079
R2943 VSS.n618 VSS.n117 3.33079
R2944 VSS.n617 VSS.n117 3.33079
R2945 VSS.n616 VSS.n117 3.33079
R2946 VSS.n615 VSS.n117 3.33079
R2947 VSS.n614 VSS.n117 3.33079
R2948 VSS.n613 VSS.n117 3.33079
R2949 VSS.n612 VSS.n117 3.33079
R2950 VSS.n611 VSS.n117 3.33079
R2951 VSS.n610 VSS.n117 3.33079
R2952 VSS.n609 VSS.n117 3.33079
R2953 VSS.n608 VSS.n117 3.33079
R2954 VSS.n607 VSS.n117 3.33079
R2955 VSS.n606 VSS.n117 3.33079
R2956 VSS.n605 VSS.n117 3.33079
R2957 VSS.n604 VSS.n117 3.33079
R2958 VSS.t764 VSS.n603 0.0863258
R2959 VSS.n668 VSS.t66 3.33079
R2960 VSS.t66 VSS.n672 3.33087
R2961 VSS.t66 VSS.n671 3.33348
R2962 VSS.n670 VSS.t66 3.33079
R2963 VSS.n669 VSS.t66 3.33079
R2964 VSS.n667 VSS.t66 3.33079
R2965 VSS.t66 VSS.n666 3.33079
R2966 VSS.n665 VSS.t66 3.33079
R2967 VSS.t66 VSS.n664 3.33079
R2968 VSS.n663 VSS.t66 3.33079
R2969 VSS.t66 VSS.n662 3.33079
R2970 VSS.n661 VSS.t66 3.33079
R2971 VSS.t66 VSS.n674 3.33079
R2972 VSS.t66 VSS.n676 3.33087
R2973 VSS.n682 VSS.t66 3.33079
R2974 VSS.t66 VSS.n683 3.33079
R2975 VSS.n721 VSS.t4 3.33079
R2976 VSS.n226 VSS.t171 0.286727
R2977 VSS.t4 VSS.n248 0.516263
R2978 VSS.n176 VSS.t86 0.265101
R2979 VSS.t4 VSS.n176 1.99403
R2980 VSS.n167 VSS.t176 0.118193
R2981 VSS.t3261 VSS.n703 0.118323
R2982 VSS.t3 VSS.t4 1.02602
R2983 VSS.n200 VSS.t4 2.29755
R2984 VSS.t3220 VSS.n247 0.175554
R2985 VSS.n247 VSS.t4 2.7209
R2986 VSS.t4 VSS.n717 3.33079
R2987 VSS.t4 VSS.n716 3.33079
R2988 VSS.t4 VSS.n715 3.33079
R2989 VSS.t4 VSS.n714 3.33079
R2990 VSS.t4 VSS.n713 3.33079
R2991 VSS.t4 VSS.n712 3.33079
R2992 VSS.t4 VSS.n711 3.33079
R2993 VSS.t4 VSS.n710 3.33079
R2994 VSS.t4 VSS.n709 3.33079
R2995 VSS.t4 VSS.n708 3.33079
R2996 VSS.t4 VSS.n707 3.33079
R2997 VSS.t4 VSS.n706 3.33079
R2998 VSS.t4 VSS.n705 3.33079
R2999 VSS.t4 VSS.n704 3.33079
R3000 VSS.n125 VSS.t4 0.854324
R3001 VSS.t4 VSS.n720 3.33079
R3002 VSS.t450 VSS.n725 0.0863258
R3003 VSS.t387 VSS.n723 0.0863258
R3004 VSS.t3268 VSS.n109 16.952
R3005 VSS.n821 VSS.t3198 4.29849
R3006 VSS.t26 VSS.n875 4.28621
R3007 VSS.n866 VSS.t120 4.28621
R3008 VSS.t35 VSS.n846 4.28621
R3009 VSS.t3242 VSS.n842 4.28621
R3010 VSS.t66 VSS.t3181 4.251
R3011 VSS.n718 VSS.t4 3.36082
R3012 VSS.t98 VSS.t4 4.2505
R3013 VSS.n767 VSS.t7 4.20455
R3014 VSS.t66 VSS.n679 2.74175
R3015 VSS.t168 VSS.n826 3.50108
R3016 VSS.n826 VSS.t97 3.50108
R3017 VSS.n222 VSS.t153 0.331253
R3018 VSS.n660 VSS.t655 0.0933
R3019 VSS.t66 VSS.n659 2.31585
R3020 VSS.t66 VSS.n680 2.31585
R3021 VSS.t66 VSS.n678 2.31585
R3022 VSS.t66 VSS.n677 2.31585
R3023 VSS.t66 VSS.n699 2.31585
R3024 VSS.t66 VSS.n698 2.31585
R3025 VSS.t66 VSS.n697 2.31585
R3026 VSS.t66 VSS.n696 2.31585
R3027 VSS.t66 VSS.n695 2.31585
R3028 VSS.t66 VSS.n694 2.31585
R3029 VSS.t66 VSS.n693 2.31585
R3030 VSS.t66 VSS.n692 2.31585
R3031 VSS.t66 VSS.n691 2.31585
R3032 VSS.t66 VSS.n690 2.31585
R3033 VSS.t66 VSS.n689 2.31585
R3034 VSS.t66 VSS.n688 2.31585
R3035 VSS.t66 VSS.n687 2.31585
R3036 VSS.t66 VSS.n686 2.31585
R3037 VSS.t66 VSS.n685 2.31585
R3038 VSS.t728 VSS.n684 0.0923917
R3039 VSS.n776 VSS.t7 2.72109
R3040 VSS.n231 VSS.t7 0.405951
R3041 VSS.n329 VSS.t7 0.405951
R3042 VSS.n782 VSS.t7 2.59384
R3043 VSS.n781 VSS.t7 2.59384
R3044 VSS.n778 VSS.t7 2.59384
R3045 VSS.t7 VSS.n328 0.405951
R3046 VSS.t7 VSS.n769 2.59384
R3047 VSS.t7 VSS.n770 2.59384
R3048 VSS.t7 VSS.n768 2.29753
R3049 VSS.n826 VSS.t4 1.88939
R3050 VSS.t13 VSS.t107 1.37665
R3051 VSS.n232 VSS.t396 0.0815508
R3052 VSS.n724 VSS.t4 0.991912
R3053 VSS.t4 VSS.n701 0.983739
R3054 VSS.n675 VSS.t573 0.083181
R3055 VSS.t246 VSS.n125 0.0342304
R3056 VSS.t352 VSS.t349 1.17344
R3057 VSS.t41 VSS.t76 1.16654
R3058 VSS.t294 VSS.n155 0.109265
R3059 VSS.n394 VSS.t79 0.94915
R3060 VSS.t283 VSS.t69 1.1131
R3061 VSS.n773 VSS.t163 1.10319
R3062 VSS.t377 VSS.t372 1.08583
R3063 VSS.t193 VSS.n805 1.05782
R3064 VSS.t361 VSS.t356 1.03405
R3065 VSS.n702 VSS.t110 0.876217
R3066 VSS.t516 VSS.t38 1.01987
R3067 VSS.t273 VSS.t278 1.01774
R3068 VSS.t294 VSS.t289 1.01465
R3069 VSS.t361 VSS.t231 1.01399
R3070 VSS.n398 VSS.t89 1.06044
R3071 VSS.t112 VSS.n681 0.0757059
R3072 VSS.n330 VSS.t131 0.801841
R3073 VSS.n719 VSS.t144 1.00067
R3074 VSS.t509 VSS.t516 0.931054
R3075 VSS.n726 VSS.t41 0.067182
R3076 VSS.t157 VSS.t179 0.923435
R3077 VSS.t157 VSS.n170 0.0803476
R3078 VSS.t1 VSS.t34 0.876684
R3079 VSS.t193 VSS.t34 0.852391
R3080 VSS.t66 VSS.n791 0.846093
R3081 VSS.t278 VSS.t283 0.841646
R3082 VSS.t8 VSS.t57 0.829229
R3083 VSS.t7 VSS.n10 0.816197
R3084 VSS.t352 VSS.t356 0.807755
R3085 VSS.t112 VSS.t243 0.806182
R3086 VSS.t4 VSS.t34 0.800406
R3087 VSS.t60 VSS.n681 0.652244
R3088 VSS.t4 VSS.n726 0.60983
R3089 VSS.n805 VSS.t76 0.726758
R3090 VSS.t573 VSS.t150 0.716723
R3091 VSS.t147 VSS.t30 0.714038
R3092 VSS.t93 VSS.n675 0.581374
R3093 VSS.t30 VSS.n701 0.082792
R3094 VSS.n773 VSS.t349 0.698053
R3095 VSS.t136 VSS.n724 0.0822487
R3096 VSS.n232 VSS.t121 0.56497
R3097 VSS.n719 VSS.t4 0.574066
R3098 VSS.n248 VSS.t16 0.825308
R3099 VSS.t66 VSS.n64 0.666899
R3100 VSS.n926 VSS.t66 0.666899
R3101 VSS.t4 VSS.n51 0.666899
R3102 VSS.t4 VSS.n27 0.666899
R3103 VSS.t4 VSS.n26 0.666899
R3104 VSS.t4 VSS.n49 0.666899
R3105 VSS.t4 VSS.n28 0.666899
R3106 VSS.n960 VSS.n728 0.66578
R3107 VSS.n739 VSS.n728 0.66578
R3108 VSS.n740 VSS.n739 0.66578
R3109 VSS.n954 VSS.n740 0.66578
R3110 VSS.n955 VSS.n954 0.66578
R3111 VSS.n955 VSS.n736 0.66578
R3112 VSS.n880 VSS.n736 0.66578
R3113 VSS.n880 VSS.n879 0.66578
R3114 VSS.n957 VSS.n732 0.66578
R3115 VSS.n949 VSS.n732 0.66578
R3116 VSS.n949 VSS.n948 0.66578
R3117 VSS.n948 VSS.n743 0.66578
R3118 VSS.n896 VSS.n743 0.66578
R3119 VSS.n897 VSS.n896 0.66578
R3120 VSS.n897 VSS.n895 0.66578
R3121 VSS.n956 VSS.n734 0.66578
R3122 VSS.n946 VSS.n734 0.66578
R3123 VSS.n947 VSS.n946 0.66578
R3124 VSS.n947 VSS.n945 0.66578
R3125 VSS.n945 VSS.n941 0.66578
R3126 VSS.n941 VSS.n745 0.66578
R3127 VSS.n892 VSS.n745 0.66578
R3128 VSS.n958 VSS.n729 0.66578
R3129 VSS.n952 VSS.n729 0.66578
R3130 VSS.n953 VSS.n952 0.66578
R3131 VSS.n953 VSS.n742 0.66578
R3132 VSS.n939 VSS.n742 0.66578
R3133 VSS.n939 VSS.n938 0.66578
R3134 VSS.n938 VSS.n747 0.66578
R3135 VSS.t4 VSS.n38 0.655024
R3136 VSS.t4 VSS.n50 0.655024
R3137 VSS.t1000 VSS.n117 109.993
R3138 VSS.t985 VSS.n117 109.992
R3139 VSS.t945 VSS.n117 109.992
R3140 VSS.t875 VSS.n117 109.992
R3141 VSS.t845 VSS.n117 109.992
R3142 VSS.t66 VSS.n108 0.649813
R3143 VSS.t66 VSS.n63 0.649813
R3144 VSS.t66 VSS.n62 0.649813
R3145 VSS.t66 VSS.n83 0.649813
R3146 VSS.n928 VSS.t66 0.649813
R3147 VSS.t66 VSS.n88 0.356984
R3148 VSS.t66 VSS.n87 0.649813
R3149 VSS.t66 VSS.n80 0.649813
R3150 VSS.t66 VSS.n79 0.649813
R3151 VSS.t66 VSS.n85 0.649813
R3152 VSS.t66 VSS.n86 0.649813
R3153 VSS.t66 VSS.n82 0.649813
R3154 VSS.t66 VSS.n81 0.649813
R3155 VSS.t66 VSS.n84 0.649813
R3156 VSS.n759 VSS.t66 0.649813
R3157 VSS.t66 VSS.n91 0.649813
R3158 VSS.t66 VSS.n89 0.649813
R3159 VSS.t66 VSS.n90 0.649813
R3160 VSS.t66 VSS.n106 0.649813
R3161 VSS.t66 VSS.n107 0.649813
R3162 VSS.t66 VSS.n66 0.649813
R3163 VSS.t66 VSS.n65 0.649813
R3164 VSS.t66 VSS.n104 0.649813
R3165 VSS.t66 VSS.n105 0.649813
R3166 VSS.t66 VSS.n68 0.649813
R3167 VSS.t66 VSS.n67 0.649813
R3168 VSS.t66 VSS.n102 0.649813
R3169 VSS.t66 VSS.n103 0.649813
R3170 VSS.t66 VSS.n70 0.649813
R3171 VSS.t66 VSS.n69 0.649813
R3172 VSS.t66 VSS.n100 0.649813
R3173 VSS.t66 VSS.n101 0.649813
R3174 VSS.t66 VSS.n72 0.649813
R3175 VSS.t66 VSS.n71 0.649813
R3176 VSS.t66 VSS.n98 0.649813
R3177 VSS.t66 VSS.n99 0.649813
R3178 VSS.t66 VSS.n74 0.649813
R3179 VSS.t66 VSS.n73 0.649813
R3180 VSS.t66 VSS.n96 0.649813
R3181 VSS.t66 VSS.n97 0.649813
R3182 VSS.t66 VSS.n76 0.649813
R3183 VSS.t66 VSS.n75 0.649813
R3184 VSS.t66 VSS.n94 0.649813
R3185 VSS.t66 VSS.n95 0.649813
R3186 VSS.t66 VSS.n78 0.649813
R3187 VSS.t66 VSS.n77 0.649813
R3188 VSS.t66 VSS.n92 0.649813
R3189 VSS.t66 VSS.n93 0.649813
R3190 VSS.n909 VSS.t66 0.649813
R3191 VSS.t62 VSS.n143 26.1545
R3192 VSS.t4 VSS.n33 0.649813
R3193 VSS.t4 VSS.n30 0.649813
R3194 VSS.t4 VSS.n32 0.649813
R3195 VSS.t4 VSS.n31 0.649813
R3196 VSS.t4 VSS.n34 0.649813
R3197 VSS.t4 VSS.n37 0.649813
R3198 VSS.t4 VSS.n36 0.649813
R3199 VSS.t4 VSS.n35 0.649813
R3200 VSS.n831 VSS.t4 0.649813
R3201 VSS.t4 VSS.n29 0.649813
R3202 VSS.t4 VSS.n39 0.648101
R3203 VSS.t4 VSS.n52 0.648101
R3204 VSS.t4 VSS.n25 0.648101
R3205 VSS.t4 VSS.n48 0.648101
R3206 VSS.t4 VSS.n47 0.648101
R3207 VSS.t4 VSS.n40 0.648101
R3208 VSS.t4 VSS.n46 0.648101
R3209 VSS.t4 VSS.n45 0.648101
R3210 VSS.t4 VSS.n44 0.648101
R3211 VSS.t4 VSS.n41 0.648101
R3212 VSS.t4 VSS.n42 0.648101
R3213 VSS.t4 VSS.n43 0.648101
R3214 VSS.n877 VSS.t4 0.648101
R3215 VSS.n330 VSS.t273 0.845267
R3216 VSS.t369 VSS.n10 0.627512
R3217 VSS.t69 VSS.t289 0.611475
R3218 VSS.t699 VSS.n214 0.571832
R3219 VSS.t136 VSS.t196 0.600657
R3220 VSS.t7 VSS.n773 0.594402
R3221 VSS.n398 VSS.t7 0.480953
R3222 VSS.t7 VSS.t69 0.508724
R3223 VSS.t147 VSS.t396 0.489392
R3224 VSS.t16 VSS.n702 1.25839
R3225 VSS.n10 VSS.t372 0.453486
R3226 VSS.t106 VSS.n768 0.452964
R3227 VSS.t11 VSS.n394 1.13923
R3228 VSS.t266 VSS.n157 47.2101
R3229 VSS.t7 VSS.n1 0.405951
R3230 VSS.n131 VSS.t272 47.2102
R3231 VSS.n115 VSS.t282 26.1052
R3232 VSS.t7 VSS.n3 0.405951
R3233 VSS.n119 VSS.t286 47.2102
R3234 VSS.t7 VSS.n2 0.121828
R3235 VSS.n124 VSS.t298 26.1052
R3236 VSS.n154 VSS.t301 47.2102
R3237 VSS.n153 VSS.t7 0.121827
R3238 VSS.n785 VSS.t7 0.405951
R3239 VSS.n783 VSS.t7 0.405951
R3240 VSS.n779 VSS.t7 0.405951
R3241 VSS.n777 VSS.t7 0.405951
R3242 VSS.n137 VSS.t7 0.219019
R3243 VSS.t7 VSS.n20 0.405951
R3244 VSS.t7 VSS.n19 0.405951
R3245 VSS.t7 VSS.n4 0.405951
R3246 VSS.t7 VSS.n5 0.405951
R3247 VSS.n178 VSS.t3275 64.1701
R3248 VSS.t7 VSS.n6 0.405951
R3249 VSS.t7 VSS.n18 0.219018
R3250 VSS.t7 VSS.n7 0.22519
R3251 VSS.n58 VSS.t355 47.2102
R3252 VSS.n57 VSS.t360 47.2102
R3253 VSS.t7 VSS.n8 0.12186
R3254 VSS.t7 VSS.n9 0.405951
R3255 VSS.n55 VSS.t366 47.2102
R3256 VSS.n21 VSS.t371 47.2102
R3257 VSS.t7 VSS.n11 0.22519
R3258 VSS.t7 VSS.n13 0.405951
R3259 VSS.n0 VSS.t379 47.2101
R3260 VSS.t7 VSS.n12 0.405951
R3261 VSS.n164 VSS.t382 47.2101
R3262 VSS.n776 VSS.t160 0.396535
R3263 VSS.t2617 VSS.t2618 0.36115
R3264 VSS.t1297 VSS.t1296 0.36115
R3265 VSS.n258 VSS.t2707 0.175714
R3266 VSS.t2717 VSS.t2718 0.36115
R3267 VSS.t2712 VSS.t2713 0.36115
R3268 VSS.t2701 VSS.n257 0.175714
R3269 VSS.t2696 VSS.n238 0.175714
R3270 VSS.t2691 VSS.t2692 0.36115
R3271 VSS.t2686 VSS.t2687 0.36115
R3272 VSS.t1216 VSS.t1215 0.36115
R3273 VSS.t2668 VSS.n253 0.175714
R3274 VSS.t2674 VSS.t2675 0.36115
R3275 VSS.t2679 VSS.t2680 0.36115
R3276 VSS.t2650 VSS.t2651 0.36115
R3277 VSS.t2656 VSS.n239 0.175714
R3278 VSS.t2662 VSS.n252 0.175714
R3279 VSS.t113 VSS.t3220 0.36115
R3280 VSS.t2744 VSS.t2745 0.36115
R3281 VSS.t2669 VSS.t2670 0.360811
R3282 VSS.t2624 VSS.n235 0.175554
R3283 VSS.t2633 VSS.t2634 0.360811
R3284 VSS.t2639 VSS.t2640 0.360811
R3285 VSS.t2645 VSS.n240 0.175554
R3286 VSS.t2651 VSS.n251 0.175554
R3287 VSS.t2657 VSS.t2658 0.360811
R3288 VSS.t2663 VSS.t2664 0.360811
R3289 VSS.t2661 VSS.t2662 0.360811
R3290 VSS.t2643 VSS.t2642 0.360811
R3291 VSS.t2637 VSS.t2636 0.360811
R3292 VSS.t2614 VSS.t2615 0.360811
R3293 VSS.t1320 VSS.t1319 0.360811
R3294 VSS.n263 VSS.t1314 0.175554
R3295 VSS.t1217 VSS.t1216 0.360811
R3296 VSS.t1230 VSS.t1228 0.360811
R3297 VSS.t1236 VSS.t1234 0.360811
R3298 VSS.t1284 VSS.n264 0.175554
R3299 VSS.n247 VSS.t58 0.175554
R3300 VSS.t2724 VSS.t2725 0.360811
R3301 VSS.t2730 VSS.t2731 0.360811
R3302 VSS.n209 VSS.t2737 0.175554
R3303 VSS.t2734 VSS.t2733 0.360811
R3304 VSS.t2728 VSS.t2727 0.360811
R3305 VSS.t2722 VSS.t2721 0.360811
R3306 VSS.n259 VSS.t2716 0.175554
R3307 VSS.n237 VSS.t2711 0.175554
R3308 VSS.t2701 VSS.t2700 0.360811
R3309 VSS.t2693 VSS.t2694 0.360811
R3310 VSS.t2688 VSS.t2689 0.360811
R3311 VSS.t2683 VSS.t2684 0.360811
R3312 VSS.t2678 VSS.n254 0.175554
R3313 VSS.n210 VSS.t2674 0.175554
R3314 VSS.t2652 VSS.t2654 0.360471
R3315 VSS.t2646 VSS.t2648 0.360471
R3316 VSS.t2640 VSS.n250 0.175395
R3317 VSS.t2634 VSS.n249 0.175395
R3318 VSS.t2625 VSS.t2627 0.360471
R3319 VSS.t2620 VSS.n241 0.175395
R3320 VSS.t1315 VSS.t1314 0.360471
R3321 VSS.t1240 VSS.t1239 0.360471
R3322 VSS.t1285 VSS.t1284 0.360471
R3323 VSS.n281 VSS.t1295 0.175395
R3324 VSS.n248 VSS.t171 1.13314
R3325 VSS.t2737 VSS.t2739 0.360471
R3326 VSS.t2731 VSS.n261 0.175395
R3327 VSS.t2725 VSS.n260 0.175395
R3328 VSS.t2720 VSS.n236 0.175395
R3329 VSS.t2715 VSS.t2716 0.360471
R3330 VSS.t2708 VSS.t2709 0.360471
R3331 VSS.t2702 VSS.t2703 0.360471
R3332 VSS.t2697 VSS.t2698 0.360471
R3333 VSS.t2692 VSS.n256 0.175395
R3334 VSS.t2687 VSS.n255 0.175395
R3335 VSS.n221 VSS.t2683 0.175395
R3336 VSS.t2677 VSS.t2678 0.360471
R3337 VSS.t713 VSS.t590 0.344562
R3338 VSS.t257 VSS.t655 0.344562
R3339 VSS.t216 VSS.n659 0.436369
R3340 VSS.t632 VSS.n698 0.433869
R3341 VSS.t629 VSS.n697 0.433869
R3342 VSS.t626 VSS.n696 0.433869
R3343 VSS.t623 VSS.n695 0.433869
R3344 VSS.t620 VSS.n694 0.433869
R3345 VSS.t617 VSS.n693 0.433869
R3346 VSS.t614 VSS.n692 0.433869
R3347 VSS.t611 VSS.n691 0.433869
R3348 VSS.t608 VSS.n690 0.433869
R3349 VSS.t605 VSS.n689 0.433869
R3350 VSS.t602 VSS.n688 0.433869
R3351 VSS.t599 VSS.n687 0.433869
R3352 VSS.t596 VSS.n686 0.433869
R3353 VSS.t583 VSS.n678 0.433869
R3354 VSS.t580 VSS.n677 0.433869
R3355 VSS.t728 VSS.t187 0.341746
R3356 VSS.n660 VSS.t216 0.238281
R3357 VSS.t150 VSS.n222 0.328435
R3358 VSS.t11 VSS.n776 0.338658
R3359 VSS.t191 VSS.n684 0.23595
R3360 VSS.n685 VSS.t593 0.433869
R3361 VSS.n680 VSS.t713 0.0923073
R3362 VSS.t635 VSS.n699 0.422619
R3363 VSS.n337 VSS.t2899 0.0850573
R3364 VSS.n791 VSS.t509 0.302628
R3365 VSS.t2676 VSS.t2677 0.301114
R3366 VSS.t2681 VSS.t2682 0.301114
R3367 VSS.t2643 VSS.n325 0.118323
R3368 VSS.t2637 VSS.n326 0.118323
R3369 VSS.t2631 VSS.n270 0.118323
R3370 VSS.t1186 VSS.t1185 0.301114
R3371 VSS.t1177 VSS.t1176 0.301114
R3372 VSS.t1168 VSS.t1167 0.301114
R3373 VSS.n204 VSS.t1230 0.286604
R3374 VSS.t1234 VSS.n228 0.231785
R3375 VSS.n165 VSS.t1251 0.2914
R3376 VSS.n586 VSS.t1257 0.418588
R3377 VSS.t1273 VSS.n304 0.232176
R3378 VSS.t1276 VSS.n246 0.232176
R3379 VSS.t1279 VSS.n245 0.232176
R3380 VSS.t1282 VSS.n286 0.420219
R3381 VSS.t2734 VSS.n314 0.118323
R3382 VSS.t2728 VSS.n315 0.118323
R3383 VSS.t2722 VSS.n277 0.118323
R3384 VSS.t2747 VSS.t2746 0.301114
R3385 VSS.t2684 VSS.n274 0.118323
R3386 VSS.t2689 VSS.n320 0.118323
R3387 VSS.t2694 VSS.n319 0.118323
R3388 VSS.n280 VSS.t2757 0.17801
R3389 VSS.t2765 VSS.t2766 0.301114
R3390 VSS.t2768 VSS.t2769 0.301114
R3391 VSS.n202 VSS.t2750 0.17801
R3392 VSS.t2623 VSS.t2624 0.301114
R3393 VSS.t2632 VSS.t2633 0.301114
R3394 VSS.t2638 VSS.t2639 0.301114
R3395 VSS.t2644 VSS.t2645 0.301114
R3396 VSS.n266 VSS.t2616 0.17801
R3397 VSS.t2629 VSS.n269 0.118323
R3398 VSS.n324 VSS.t2654 0.118323
R3399 VSS.n271 VSS.t2648 0.118323
R3400 VSS.n268 VSS.t2627 0.118323
R3401 VSS.t2619 VSS.t2620 0.301114
R3402 VSS.t1158 VSS.t1159 0.301114
R3403 VSS.n594 VSS.t1321 0.17801
R3404 VSS.n211 VSS.t1316 0.17801
R3405 VSS.t1311 VSS.t1312 0.301114
R3406 VSS.t1308 VSS.n592 0.17801
R3407 VSS.t1305 VSS.n591 0.17801
R3408 VSS.t1302 VSS.n590 0.17801
R3409 VSS.t1172 VSS.t1171 0.301114
R3410 VSS.n298 VSS.t1174 0.118323
R3411 VSS.t1181 VSS.t1180 0.301114
R3412 VSS.n295 VSS.t1183 0.118323
R3413 VSS.t1210 VSS.t1209 0.301114
R3414 VSS.t1198 VSS.t1197 0.301114
R3415 VSS.t1205 VSS.n224 0.17801
R3416 VSS.n290 VSS.t1219 0.118323
R3417 VSS.n580 VSS.t1223 0.17801
R3418 VSS.t1226 VSS.n169 0.118323
R3419 VSS.t1239 VSS.n582 0.118323
R3420 VSS.t1241 VSS.t1240 0.301114
R3421 VSS.t1244 VSS.n291 0.17801
R3422 VSS.t1247 VSS.t1246 0.301114
R3423 VSS.t1265 VSS.t1264 0.301114
R3424 VSS.t1269 VSS.n588 0.118323
R3425 VSS.n206 VSS.t1285 0.118323
R3426 VSS.t1289 VSS.t1288 0.301114
R3427 VSS.t1292 VSS.t1291 0.301114
R3428 VSS.t1295 VSS.t1294 0.301114
R3429 VSS.t138 VSS.n703 0.17801
R3430 VSS.n170 VSS.t86 1.06371
R3431 VSS.t3 VSS.t9 0.301114
R3432 VSS.t1163 VSS.n302 0.118323
R3433 VSS.t2723 VSS.t2724 0.301114
R3434 VSS.t2729 VSS.t2730 0.301114
R3435 VSS.t2735 VSS.t2736 0.301114
R3436 VSS.t2741 VSS.t2742 0.301114
R3437 VSS.t2740 VSS.n278 0.17801
R3438 VSS.t2719 VSS.t2720 0.301114
R3439 VSS.t2714 VSS.t2715 0.301114
R3440 VSS.t2709 VSS.n317 0.118323
R3441 VSS.t2703 VSS.n318 0.118323
R3442 VSS.t2698 VSS.n275 0.118323
R3443 VSS.n273 VSS.t2676 0.177814
R3444 VSS.t2680 VSS.n321 0.118193
R3445 VSS.t2768 VSS.t2767 0.300775
R3446 VSS.t2765 VSS.t2764 0.300775
R3447 VSS.t2756 VSS.t2755 0.300775
R3448 VSS.t2670 VSS.n322 0.118193
R3449 VSS.t2618 VSS.n327 0.118193
R3450 VSS.t2658 VSS.n272 0.118193
R3451 VSS.t2664 VSS.n323 0.118193
R3452 VSS.t2660 VSS.t2661 0.300775
R3453 VSS.t2655 VSS.t2656 0.300775
R3454 VSS.t2649 VSS.t2650 0.300775
R3455 VSS.t2630 VSS.t2631 0.300775
R3456 VSS.t2628 VSS.t2629 0.300775
R3457 VSS.t2616 VSS.t2617 0.300775
R3458 VSS.t2613 VSS.t2614 0.300775
R3459 VSS.t1318 VSS.t1319 0.300775
R3460 VSS.t1309 VSS.t1428 0.300775
R3461 VSS.t1306 VSS.t1425 0.300775
R3462 VSS.t1303 VSS.t1422 0.300775
R3463 VSS.n578 VSS.t1213 0.177814
R3464 VSS.n299 VSS.t1172 0.118193
R3465 VSS.t1173 VSS.t1174 0.300775
R3466 VSS.t1176 VSS.t1175 0.300775
R3467 VSS.n296 VSS.t1181 0.118193
R3468 VSS.t1182 VSS.t1183 0.300775
R3469 VSS.t1185 VSS.t1184 0.300775
R3470 VSS.t1199 VSS.n217 0.177814
R3471 VSS.t1203 VSS.t1204 0.300775
R3472 VSS.t1218 VSS.n294 0.177814
R3473 VSS.t1219 VSS.t1218 0.300775
R3474 VSS.t1225 VSS.t1224 0.300775
R3475 VSS.t1227 VSS.t1226 0.300775
R3476 VSS.t1228 VSS.n581 0.118193
R3477 VSS.t1233 VSS.t1231 0.300775
R3478 VSS.t1237 VSS.n242 0.177814
R3479 VSS.t1243 VSS.t1242 0.300775
R3480 VSS.t1248 VSS.n265 0.177814
R3481 VSS.t1254 VSS.t1252 0.300775
R3482 VSS.t1260 VSS.t1258 0.300775
R3483 VSS.t1266 VSS.n287 0.177814
R3484 VSS.t1270 VSS.t1269 0.300775
R3485 VSS.t1275 VSS.t1273 0.300775
R3486 VSS.t1278 VSS.t1276 0.300775
R3487 VSS.t1281 VSS.t1279 0.300775
R3488 VSS.t1290 VSS.t1289 0.300775
R3489 VSS.n284 VSS.t1292 0.118193
R3490 VSS.t1299 VSS.t1297 0.300775
R3491 VSS.n226 VSS.t47 0.346587
R3492 VSS.t179 VSS.n167 0.177814
R3493 VSS.n200 VSS.t113 0.231606
R3494 VSS.t1164 VSS.t1165 0.300775
R3495 VSS.t1162 VSS.t1163 0.300775
R3496 VSS.t1156 VSS.t1157 0.300775
R3497 VSS.t1157 VSS.n205 0.177814
R3498 VSS.n279 VSS.t2746 0.177814
R3499 VSS.t2743 VSS.t2744 0.300775
R3500 VSS.t2740 VSS.t2741 0.300775
R3501 VSS.t2713 VSS.n276 0.118193
R3502 VSS.t2718 VSS.n316 0.118193
R3503 VSS.t2710 VSS.t2711 0.300775
R3504 VSS.t2699 VSS.t2700 0.300775
R3505 VSS.t2695 VSS.t2696 0.300775
R3506 VSS.t2690 VSS.t2691 0.300775
R3507 VSS.t2685 VSS.t2686 0.300775
R3508 VSS.t2672 VSS.t2673 0.300775
R3509 VSS.t2667 VSS.t2668 0.300775
R3510 VSS.t7 VSS.n155 0.151732
R3511 VSS.t586 VSS.n679 0.379757
R3512 VSS.n333 VSS.t1155 0.160265
R3513 VSS.t7 VSS.t361 0.268975
R3514 VSS.n312 VSS.t2766 0.119605
R3515 VSS.t2764 VSS.n403 0.119605
R3516 VSS.t2758 VSS.t2757 0.241078
R3517 VSS.t2755 VSS.n402 0.119605
R3518 VSS.t2778 VSS.n267 0.119605
R3519 VSS.n208 VSS.t1301 0.119605
R3520 VSS.t1301 VSS.t1302 0.241078
R3521 VSS.t1422 VSS.t1305 0.241078
R3522 VSS.t1425 VSS.t1308 0.241078
R3523 VSS.n283 VSS.t1311 0.119605
R3524 VSS.t1261 VSS.n192 0.235599
R3525 VSS.t1213 VSS.n943 0.241078
R3526 VSS.t1201 VSS.n233 0.235599
R3527 VSS.t1192 VSS.n216 0.360183
R3528 VSS.n288 VSS.t2754 0.360183
R3529 VSS.n289 VSS.t2763 0.360183
R3530 VSS.t2761 VSS.t2762 0.241078
R3531 VSS.n223 VSS.t2761 0.119605
R3532 VSS.t2758 VSS.n215 0.119605
R3533 VSS.t2759 VSS.t2760 0.241078
R3534 VSS.t2752 VSS.t2753 0.241078
R3535 VSS.n213 VSS.t2752 0.119605
R3536 VSS.t2750 VSS.t2751 0.241078
R3537 VSS.n593 VSS.t1318 0.119605
R3538 VSS.t1316 VSS.t1317 0.241078
R3539 VSS.n943 VSS.t1212 0.241078
R3540 VSS.n216 VSS.t1191 0.119605
R3541 VSS.t1169 VSS.n601 0.119605
R3542 VSS.t1170 VSS.t1169 0.241078
R3543 VSS.n300 VSS.t1170 0.119605
R3544 VSS.t1178 VSS.n600 0.119605
R3545 VSS.t1179 VSS.t1178 0.241078
R3546 VSS.n297 VSS.t1179 0.119605
R3547 VSS.t1187 VSS.n599 0.119605
R3548 VSS.t1188 VSS.t1187 0.241078
R3549 VSS.t1189 VSS.t1188 0.241078
R3550 VSS.t1190 VSS.n598 0.119605
R3551 VSS.t1191 VSS.t1190 0.241078
R3552 VSS.t1193 VSS.n225 0.119605
R3553 VSS.t1194 VSS.t1193 0.241078
R3554 VSS.t1195 VSS.n293 0.119605
R3555 VSS.t1196 VSS.t1195 0.241078
R3556 VSS.t1197 VSS.n597 0.119605
R3557 VSS.t1200 VSS.t1199 0.241078
R3558 VSS.t1202 VSS.t1201 0.241078
R3559 VSS.t1203 VSS.n596 0.119605
R3560 VSS.t1206 VSS.t1205 0.241078
R3561 VSS.t1207 VSS.n292 0.119605
R3562 VSS.t1208 VSS.t1207 0.241078
R3563 VSS.t1209 VSS.n595 0.119605
R3564 VSS.t1221 VSS.t1220 0.241078
R3565 VSS.t1222 VSS.n579 0.119605
R3566 VSS.t1223 VSS.t1222 0.241078
R3567 VSS.t1238 VSS.t1237 0.241078
R3568 VSS.t1242 VSS.n583 0.119605
R3569 VSS.t1245 VSS.t1244 0.241078
R3570 VSS.t1246 VSS.n584 0.119605
R3571 VSS.t1249 VSS.t1248 0.241078
R3572 VSS.t1250 VSS.n585 0.119605
R3573 VSS.t1251 VSS.t1250 0.241078
R3574 VSS.n229 VSS.t1256 0.119605
R3575 VSS.t1262 VSS.t1261 0.241078
R3576 VSS.t1263 VSS.n587 0.119605
R3577 VSS.t1264 VSS.t1263 0.241078
R3578 VSS.t1267 VSS.t1266 0.241078
R3579 VSS.t1268 VSS.t1267 0.241078
R3580 VSS.t1271 VSS.n234 0.119605
R3581 VSS.t1272 VSS.t1271 0.241078
R3582 VSS.t1287 VSS.t1286 0.241078
R3583 VSS.t1288 VSS.n589 0.119605
R3584 VSS.n285 VSS.t1290 0.119605
R3585 VSS.t1294 VSS.t1293 0.241078
R3586 VSS.t1161 VSS.n303 0.119605
R3587 VSS.n602 VSS.t1160 0.119605
R3588 VSS.t1160 VSS.t1161 0.241078
R3589 VSS.t2742 VSS.n313 0.119605
R3590 VSS.t2704 VSS.t2705 0.241078
R3591 VSS.t2777 VSS.t2621 0.240825
R3592 VSS.n301 VSS.t1165 0.0600369
R3593 VSS.t1166 VSS.n207 0.229511
R3594 VSS.t2707 VSS.t2706 0.240486
R3595 VSS.n768 VSS.t163 0.231805
R3596 VSS.t2748 VSS.t2749 0.230486
R3597 VSS.t7 VSS.t352 0.228622
R3598 VSS.n401 VSS.t346 0.0896992
R3599 VSS.t338 VSS.n399 0.135296
R3600 VSS.t89 VSS.n397 0.135296
R3601 VSS.t330 VSS.n396 0.135296
R3602 VSS.t325 VSS.n395 0.135296
R3603 VSS.t160 VSS.n393 0.135296
R3604 VSS.t317 VSS.n392 0.135296
R3605 VSS.t312 VSS.n391 0.135296
R3606 VSS.t270 VSS.n727 0.135296
R3607 VSS.t681 VSS.t683 0.227075
R3608 VSS.t679 VSS.t570 0.227075
R3609 VSS.t2884 VSS.t2886 0.226736
R3610 VSS.t2891 VSS.t2889 0.226736
R3611 VSS.t2894 VSS.t2896 0.226736
R3612 VSS.t3054 VSS.t3056 0.226736
R3613 VSS.t3061 VSS.t3059 0.226736
R3614 VSS.t3064 VSS.t3066 0.226736
R3615 VSS.t3071 VSS.t3069 0.226736
R3616 VSS.t3074 VSS.t3076 0.226736
R3617 VSS.t3081 VSS.t3079 0.226736
R3618 VSS.t3084 VSS.t3086 0.226736
R3619 VSS.t3091 VSS.t3089 0.226736
R3620 VSS.t3094 VSS.t3096 0.226736
R3621 VSS.t3101 VSS.t3099 0.226736
R3622 VSS.t3104 VSS.t3106 0.226736
R3623 VSS.t3111 VSS.t3109 0.226736
R3624 VSS.t3114 VSS.t3116 0.226736
R3625 VSS.t3121 VSS.t3119 0.226736
R3626 VSS.t3131 VSS.t3129 0.226736
R3627 VSS.t3134 VSS.t3136 0.226736
R3628 VSS.t3141 VSS.t3139 0.226736
R3629 VSS.t3144 VSS.t3146 0.226736
R3630 VSS.t3151 VSS.t3149 0.226736
R3631 VSS.t3154 VSS.t3156 0.226736
R3632 VSS.t3161 VSS.t3159 0.226736
R3633 VSS.t2981 VSS.t2979 0.226736
R3634 VSS.t2986 VSS.t2984 0.226736
R3635 VSS.t2991 VSS.t2989 0.226736
R3636 VSS.t2996 VSS.t2994 0.226736
R3637 VSS.t3001 VSS.t2999 0.226736
R3638 VSS.t3006 VSS.t3004 0.226736
R3639 VSS.t3011 VSS.t3009 0.226736
R3640 VSS.t3016 VSS.t3014 0.226736
R3641 VSS.t3021 VSS.t3019 0.226736
R3642 VSS.t3026 VSS.t3024 0.226736
R3643 VSS.t3031 VSS.t3029 0.226736
R3644 VSS.t3036 VSS.t3034 0.226736
R3645 VSS.t3041 VSS.t3039 0.226736
R3646 VSS.t3046 VSS.t3044 0.226736
R3647 VSS.t2969 VSS.t2971 0.226736
R3648 VSS.t2964 VSS.t2966 0.226736
R3649 VSS.t2959 VSS.t2961 0.226736
R3650 VSS.t2954 VSS.t2956 0.226736
R3651 VSS.t2949 VSS.t2951 0.226736
R3652 VSS.t2944 VSS.t2946 0.226736
R3653 VSS.t2939 VSS.t2941 0.226736
R3654 VSS.t2934 VSS.t2936 0.226736
R3655 VSS.t2929 VSS.t2931 0.226736
R3656 VSS.t2924 VSS.t2926 0.226736
R3657 VSS.t2919 VSS.t2921 0.226736
R3658 VSS.t2914 VSS.t2916 0.226736
R3659 VSS.t2909 VSS.t2911 0.226736
R3660 VSS.t2906 VSS.t2904 0.226736
R3661 VSS.t2224 VSS.t2222 0.226736
R3662 VSS.t2229 VSS.t2227 0.226736
R3663 VSS.t2234 VSS.t2232 0.226736
R3664 VSS.t2239 VSS.t2237 0.226736
R3665 VSS.t2244 VSS.t2242 0.226736
R3666 VSS.t2247 VSS.t2249 0.226736
R3667 VSS.t2254 VSS.t2252 0.226736
R3668 VSS.t2257 VSS.t2259 0.226736
R3669 VSS.t2264 VSS.t2262 0.226736
R3670 VSS.t2267 VSS.t2269 0.226736
R3671 VSS.t2274 VSS.t2272 0.226736
R3672 VSS.t2277 VSS.t2279 0.226736
R3673 VSS.t2284 VSS.t2282 0.226736
R3674 VSS.t2287 VSS.t2289 0.226736
R3675 VSS.t2294 VSS.t2292 0.226736
R3676 VSS.t2297 VSS.t2299 0.226736
R3677 VSS.t2304 VSS.t2302 0.226736
R3678 VSS.t2307 VSS.t2309 0.226736
R3679 VSS.t2317 VSS.t2319 0.226736
R3680 VSS.t2324 VSS.t2322 0.226736
R3681 VSS.t2327 VSS.t2329 0.226736
R3682 VSS.t2334 VSS.t2332 0.226736
R3683 VSS.t2337 VSS.t2339 0.226736
R3684 VSS.t2344 VSS.t2342 0.226736
R3685 VSS.t2347 VSS.t2349 0.226736
R3686 VSS.t2354 VSS.t2352 0.226736
R3687 VSS.t2357 VSS.t2359 0.226736
R3688 VSS.t2364 VSS.t2362 0.226736
R3689 VSS.t2367 VSS.t2369 0.226736
R3690 VSS.t2374 VSS.t2372 0.226736
R3691 VSS.t2377 VSS.t2379 0.226736
R3692 VSS.t2384 VSS.t2382 0.226736
R3693 VSS.t2394 VSS.t2392 0.226736
R3694 VSS.t2397 VSS.t2399 0.226736
R3695 VSS.t2404 VSS.t2402 0.226736
R3696 VSS.t2407 VSS.t2409 0.226736
R3697 VSS.t2414 VSS.t2412 0.226736
R3698 VSS.t2417 VSS.t2419 0.226736
R3699 VSS.t2424 VSS.t2422 0.226736
R3700 VSS.t2427 VSS.t2429 0.226736
R3701 VSS.t2434 VSS.t2432 0.226736
R3702 VSS.t2437 VSS.t2439 0.226736
R3703 VSS.t2444 VSS.t2442 0.226736
R3704 VSS.t2447 VSS.t2449 0.226736
R3705 VSS.t2454 VSS.t2452 0.226736
R3706 VSS.t2457 VSS.t2459 0.226736
R3707 VSS.t2467 VSS.t2469 0.226736
R3708 VSS.t2474 VSS.t2472 0.226736
R3709 VSS.t2477 VSS.t2479 0.226736
R3710 VSS.t2484 VSS.t2482 0.226736
R3711 VSS.t2487 VSS.t2489 0.226736
R3712 VSS.t2494 VSS.t2492 0.226736
R3713 VSS.t2497 VSS.t2499 0.226736
R3714 VSS.t1832 VSS.t1830 0.226736
R3715 VSS.t1837 VSS.t1835 0.226736
R3716 VSS.t1842 VSS.t1840 0.226736
R3717 VSS.t1847 VSS.t1845 0.226736
R3718 VSS.t1852 VSS.t1850 0.226736
R3719 VSS.t1857 VSS.t1855 0.226736
R3720 VSS.t1862 VSS.t1860 0.226736
R3721 VSS.t1867 VSS.t1865 0.226736
R3722 VSS.t1872 VSS.t1870 0.226736
R3723 VSS.t1877 VSS.t1875 0.226736
R3724 VSS.t1882 VSS.t1880 0.226736
R3725 VSS.t1887 VSS.t1885 0.226736
R3726 VSS.t1892 VSS.t1890 0.226736
R3727 VSS.t1897 VSS.t1895 0.226736
R3728 VSS.t1902 VSS.t1900 0.226736
R3729 VSS.t1907 VSS.t1905 0.226736
R3730 VSS.t1912 VSS.t1910 0.226736
R3731 VSS.t1917 VSS.t1915 0.226736
R3732 VSS.t1925 VSS.t1927 0.226736
R3733 VSS.t1932 VSS.t1930 0.226736
R3734 VSS.t1935 VSS.t1937 0.226736
R3735 VSS.t1942 VSS.t1940 0.226736
R3736 VSS.t1945 VSS.t1947 0.226736
R3737 VSS.t1952 VSS.t1950 0.226736
R3738 VSS.t1955 VSS.t1957 0.226736
R3739 VSS.t1962 VSS.t1960 0.226736
R3740 VSS.t1965 VSS.t1967 0.226736
R3741 VSS.t1972 VSS.t1970 0.226736
R3742 VSS.t1975 VSS.t1977 0.226736
R3743 VSS.t1982 VSS.t1980 0.226736
R3744 VSS.t1985 VSS.t1987 0.226736
R3745 VSS.t1992 VSS.t1990 0.226736
R3746 VSS.t2002 VSS.t2000 0.226736
R3747 VSS.t2007 VSS.t2005 0.226736
R3748 VSS.t2012 VSS.t2010 0.226736
R3749 VSS.t2017 VSS.t2015 0.226736
R3750 VSS.t2022 VSS.t2020 0.226736
R3751 VSS.t2027 VSS.t2025 0.226736
R3752 VSS.t2032 VSS.t2030 0.226736
R3753 VSS.t2037 VSS.t2035 0.226736
R3754 VSS.t2042 VSS.t2040 0.226736
R3755 VSS.t2047 VSS.t2045 0.226736
R3756 VSS.t2052 VSS.t2050 0.226736
R3757 VSS.t2057 VSS.t2055 0.226736
R3758 VSS.t2062 VSS.t2060 0.226736
R3759 VSS.t2067 VSS.t2065 0.226736
R3760 VSS.t2075 VSS.t2077 0.226736
R3761 VSS.t2082 VSS.t2080 0.226736
R3762 VSS.t2085 VSS.t2087 0.226736
R3763 VSS.t2092 VSS.t2090 0.226736
R3764 VSS.t2095 VSS.t2097 0.226736
R3765 VSS.t2102 VSS.t2100 0.226736
R3766 VSS.t2105 VSS.t2107 0.226736
R3767 VSS.t1440 VSS.t1438 0.226736
R3768 VSS.t1445 VSS.t1443 0.226736
R3769 VSS.t1450 VSS.t1448 0.226736
R3770 VSS.t1455 VSS.t1453 0.226736
R3771 VSS.t1460 VSS.t1458 0.226736
R3772 VSS.t1463 VSS.t1465 0.226736
R3773 VSS.t1470 VSS.t1468 0.226736
R3774 VSS.t1473 VSS.t1475 0.226736
R3775 VSS.t1480 VSS.t1478 0.226736
R3776 VSS.t1483 VSS.t1485 0.226736
R3777 VSS.t1490 VSS.t1488 0.226736
R3778 VSS.t1493 VSS.t1495 0.226736
R3779 VSS.t1500 VSS.t1498 0.226736
R3780 VSS.t1503 VSS.t1505 0.226736
R3781 VSS.t1510 VSS.t1508 0.226736
R3782 VSS.t1513 VSS.t1515 0.226736
R3783 VSS.t1520 VSS.t1518 0.226736
R3784 VSS.t1523 VSS.t1525 0.226736
R3785 VSS.t1535 VSS.t1533 0.226736
R3786 VSS.t1540 VSS.t1538 0.226736
R3787 VSS.t1545 VSS.t1543 0.226736
R3788 VSS.t1550 VSS.t1548 0.226736
R3789 VSS.t1555 VSS.t1553 0.226736
R3790 VSS.t1560 VSS.t1558 0.226736
R3791 VSS.t1565 VSS.t1563 0.226736
R3792 VSS.t1570 VSS.t1568 0.226736
R3793 VSS.t1575 VSS.t1573 0.226736
R3794 VSS.t1580 VSS.t1578 0.226736
R3795 VSS.t1585 VSS.t1583 0.226736
R3796 VSS.t1590 VSS.t1588 0.226736
R3797 VSS.t1595 VSS.t1593 0.226736
R3798 VSS.t1600 VSS.t1598 0.226736
R3799 VSS.t1608 VSS.t1610 0.226736
R3800 VSS.t1615 VSS.t1613 0.226736
R3801 VSS.t1618 VSS.t1620 0.226736
R3802 VSS.t1625 VSS.t1623 0.226736
R3803 VSS.t1628 VSS.t1630 0.226736
R3804 VSS.t1635 VSS.t1633 0.226736
R3805 VSS.t1638 VSS.t1640 0.226736
R3806 VSS.t1645 VSS.t1643 0.226736
R3807 VSS.t1648 VSS.t1650 0.226736
R3808 VSS.t1655 VSS.t1653 0.226736
R3809 VSS.t1658 VSS.t1660 0.226736
R3810 VSS.t1665 VSS.t1663 0.226736
R3811 VSS.t1668 VSS.t1670 0.226736
R3812 VSS.t1675 VSS.t1673 0.226736
R3813 VSS.t1685 VSS.t1683 0.226736
R3814 VSS.t1688 VSS.t1690 0.226736
R3815 VSS.t1695 VSS.t1693 0.226736
R3816 VSS.t1698 VSS.t1700 0.226736
R3817 VSS.t1705 VSS.t1703 0.226736
R3818 VSS.t1708 VSS.t1710 0.226736
R3819 VSS.t1715 VSS.t1713 0.226736
R3820 VSS.t766 VSS.t764 0.226736
R3821 VSS.t771 VSS.t769 0.226736
R3822 VSS.t776 VSS.t774 0.226736
R3823 VSS.t781 VSS.t779 0.226736
R3824 VSS.t786 VSS.t784 0.226736
R3825 VSS.t791 VSS.t789 0.226736
R3826 VSS.t796 VSS.t794 0.226736
R3827 VSS.t801 VSS.t799 0.226736
R3828 VSS.t806 VSS.t804 0.226736
R3829 VSS.t811 VSS.t809 0.226736
R3830 VSS.t816 VSS.t814 0.226736
R3831 VSS.t821 VSS.t819 0.226736
R3832 VSS.t826 VSS.t824 0.226736
R3833 VSS.t831 VSS.t829 0.226736
R3834 VSS.t836 VSS.t834 0.226736
R3835 VSS.t841 VSS.t839 0.226736
R3836 VSS.t846 VSS.t844 0.226736
R3837 VSS.t851 VSS.t849 0.226736
R3838 VSS.t861 VSS.t859 0.226736
R3839 VSS.t866 VSS.t864 0.226736
R3840 VSS.t871 VSS.t869 0.226736
R3841 VSS.t876 VSS.t874 0.226736
R3842 VSS.t881 VSS.t879 0.226736
R3843 VSS.t886 VSS.t884 0.226736
R3844 VSS.t891 VSS.t889 0.226736
R3845 VSS.t896 VSS.t894 0.226736
R3846 VSS.t901 VSS.t899 0.226736
R3847 VSS.t906 VSS.t904 0.226736
R3848 VSS.t911 VSS.t909 0.226736
R3849 VSS.t916 VSS.t914 0.226736
R3850 VSS.t921 VSS.t919 0.226736
R3851 VSS.t926 VSS.t924 0.226736
R3852 VSS.t936 VSS.t934 0.226736
R3853 VSS.t941 VSS.t939 0.226736
R3854 VSS.t946 VSS.t944 0.226736
R3855 VSS.t951 VSS.t949 0.226736
R3856 VSS.t956 VSS.t954 0.226736
R3857 VSS.t961 VSS.t959 0.226736
R3858 VSS.t966 VSS.t964 0.226736
R3859 VSS.t971 VSS.t969 0.226736
R3860 VSS.t976 VSS.t974 0.226736
R3861 VSS.t981 VSS.t979 0.226736
R3862 VSS.t986 VSS.t984 0.226736
R3863 VSS.t991 VSS.t989 0.226736
R3864 VSS.t996 VSS.t994 0.226736
R3865 VSS.t1001 VSS.t999 0.226736
R3866 VSS.t1009 VSS.t1011 0.226736
R3867 VSS.t1016 VSS.t1014 0.226736
R3868 VSS.t1019 VSS.t1021 0.226736
R3869 VSS.t1026 VSS.t1024 0.226736
R3870 VSS.t1029 VSS.t1031 0.226736
R3871 VSS.t1036 VSS.t1034 0.226736
R3872 VSS.t1039 VSS.t1041 0.226736
R3873 VSS.t726 VSS.t724 0.226736
R3874 VSS.t719 VSS.t721 0.226736
R3875 VSS.t566 VSS.t568 0.226736
R3876 VSS.t561 VSS.t563 0.226736
R3877 VSS.t521 VSS.t523 0.226736
R3878 VSS.t528 VSS.t526 0.226736
R3879 VSS.t531 VSS.t533 0.226736
R3880 VSS.t538 VSS.t536 0.226736
R3881 VSS.t541 VSS.t543 0.226736
R3882 VSS.t548 VSS.t546 0.226736
R3883 VSS.t551 VSS.t553 0.226736
R3884 VSS.t401 VSS.t402 0.226736
R3885 VSS.t405 VSS.t404 0.226736
R3886 VSS.t408 VSS.t407 0.226736
R3887 VSS.t411 VSS.t410 0.226736
R3888 VSS.t414 VSS.t413 0.226736
R3889 VSS.t417 VSS.t416 0.226736
R3890 VSS.t420 VSS.t419 0.226736
R3891 VSS.t423 VSS.t422 0.226736
R3892 VSS.t426 VSS.t425 0.226736
R3893 VSS.t429 VSS.t428 0.226736
R3894 VSS.t432 VSS.t431 0.226736
R3895 VSS.t435 VSS.t434 0.226736
R3896 VSS.t438 VSS.t437 0.226736
R3897 VSS.t441 VSS.t440 0.226736
R3898 VSS.t444 VSS.t443 0.226736
R3899 VSS.t389 VSS.t387 0.226736
R3900 VSS.t32 VSS.t450 0.226736
R3901 VSS.t51 VSS.t456 0.226736
R3902 VSS.t20 VSS.t22 0.226736
R3903 VSS.t93 VSS.t690 0.226736
R3904 VSS.t578 VSS.t704 0.224575
R3905 VSS.n339 VSS.t2909 0.0863258
R3906 VSS.n340 VSS.t2914 0.0863258
R3907 VSS.n341 VSS.t2919 0.0863258
R3908 VSS.n342 VSS.t2924 0.0863258
R3909 VSS.n343 VSS.t2929 0.0863258
R3910 VSS.n344 VSS.t2934 0.0863258
R3911 VSS.n345 VSS.t2939 0.0863258
R3912 VSS.n346 VSS.t2944 0.0863258
R3913 VSS.n347 VSS.t2949 0.0863258
R3914 VSS.n348 VSS.t2954 0.0863258
R3915 VSS.n349 VSS.t2959 0.0863258
R3916 VSS.n350 VSS.t2964 0.0863258
R3917 VSS.n351 VSS.t2969 0.0863258
R3918 VSS.n352 VSS.t2974 0.0863258
R3919 VSS.n368 VSS.t3054 0.0863258
R3920 VSS.n370 VSS.t3064 0.0863258
R3921 VSS.n372 VSS.t3074 0.0863258
R3922 VSS.n374 VSS.t3084 0.0863258
R3923 VSS.n376 VSS.t3094 0.0863258
R3924 VSS.n378 VSS.t3104 0.0863258
R3925 VSS.n380 VSS.t3114 0.0863258
R3926 VSS.n526 VSS.t1463 0.0863258
R3927 VSS.n528 VSS.t1473 0.0863258
R3928 VSS.n530 VSS.t1483 0.0863258
R3929 VSS.n532 VSS.t1493 0.0863258
R3930 VSS.n534 VSS.t1503 0.0863258
R3931 VSS.n536 VSS.t1513 0.0863258
R3932 VSS.n538 VSS.t1523 0.0863258
R3933 VSS.n483 VSS.t1925 0.0863258
R3934 VSS.n485 VSS.t1935 0.0863258
R3935 VSS.n487 VSS.t1945 0.0863258
R3936 VSS.n489 VSS.t1955 0.0863258
R3937 VSS.n491 VSS.t1965 0.0863258
R3938 VSS.n493 VSS.t1975 0.0863258
R3939 VSS.n495 VSS.t1985 0.0863258
R3940 VSS.n555 VSS.t1608 0.0863258
R3941 VSS.n557 VSS.t1618 0.0863258
R3942 VSS.n559 VSS.t1628 0.0863258
R3943 VSS.n561 VSS.t1638 0.0863258
R3944 VSS.n563 VSS.t1648 0.0863258
R3945 VSS.n565 VSS.t1658 0.0863258
R3946 VSS.n567 VSS.t1668 0.0863258
R3947 VSS.n513 VSS.t2075 0.0863258
R3948 VSS.n515 VSS.t2085 0.0863258
R3949 VSS.n517 VSS.t2095 0.0863258
R3950 VSS.n519 VSS.t2105 0.0863258
R3951 VSS.t2100 VSS.n518 0.0863258
R3952 VSS.t2090 VSS.n516 0.0863258
R3953 VSS.t2080 VSS.n514 0.0863258
R3954 VSS.t2065 VSS.n511 0.0863258
R3955 VSS.t2000 VSS.n498 0.0863258
R3956 VSS.t2005 VSS.n499 0.0863258
R3957 VSS.t2010 VSS.n500 0.0863258
R3958 VSS.t2015 VSS.n501 0.0863258
R3959 VSS.t2020 VSS.n502 0.0863258
R3960 VSS.t2025 VSS.n503 0.0863258
R3961 VSS.t2030 VSS.n504 0.0863258
R3962 VSS.t2035 VSS.n505 0.0863258
R3963 VSS.t2040 VSS.n506 0.0863258
R3964 VSS.t2045 VSS.n507 0.0863258
R3965 VSS.t2050 VSS.n508 0.0863258
R3966 VSS.t2055 VSS.n509 0.0863258
R3967 VSS.t2060 VSS.n510 0.0863258
R3968 VSS.n652 VSS.t1009 0.0863258
R3969 VSS.n654 VSS.t1019 0.0863258
R3970 VSS.n656 VSS.t1029 0.0863258
R3971 VSS.n658 VSS.t1039 0.0863258
R3972 VSS.t1034 VSS.n657 0.0863258
R3973 VSS.t1024 VSS.n655 0.0863258
R3974 VSS.t1014 VSS.n653 0.0863258
R3975 VSS.t999 VSS.n650 0.0863258
R3976 VSS.n669 VSS.t561 0.0863258
R3977 VSS.n670 VSS.t566 0.0863258
R3978 VSS.n682 VSS.t719 0.0863258
R3979 VSS.n683 VSS.t724 0.0863258
R3980 VSS.n125 VSS.t401 0.179669
R3981 VSS.n661 VSS.t521 0.0863258
R3982 VSS.n663 VSS.t531 0.0863258
R3983 VSS.n665 VSS.t541 0.0863258
R3984 VSS.n667 VSS.t551 0.0863258
R3985 VSS.t546 VSS.n666 0.0863258
R3986 VSS.t536 VSS.n664 0.0863258
R3987 VSS.t526 VSS.n662 0.0863258
R3988 VSS.n721 VSS.t20 0.0863258
R3989 VSS.n720 VSS.t456 0.0863258
R3990 VSS.n723 VSS.t386 0.130189
R3991 VSS.n725 VSS.t196 0.130189
R3992 VSS.n717 VSS.t443 0.0863258
R3993 VSS.n716 VSS.t440 0.0863258
R3994 VSS.n715 VSS.t437 0.0863258
R3995 VSS.n714 VSS.t434 0.0863258
R3996 VSS.n713 VSS.t431 0.0863258
R3997 VSS.n712 VSS.t428 0.0863258
R3998 VSS.n711 VSS.t425 0.0863258
R3999 VSS.n710 VSS.t422 0.0863258
R4000 VSS.n709 VSS.t419 0.0863258
R4001 VSS.n708 VSS.t416 0.0863258
R4002 VSS.n707 VSS.t413 0.0863258
R4003 VSS.n706 VSS.t410 0.0863258
R4004 VSS.n705 VSS.t407 0.0863258
R4005 VSS.t404 VSS.n704 0.0863258
R4006 VSS.t690 VSS.n674 0.0863258
R4007 VSS.n668 VSS.t556 0.0863258
R4008 VSS.t854 VSS.n621 0.0863258
R4009 VSS.n603 VSS.t763 0.130189
R4010 VSS.t769 VSS.n604 0.0863258
R4011 VSS.t774 VSS.n605 0.0863258
R4012 VSS.t779 VSS.n606 0.0863258
R4013 VSS.t784 VSS.n607 0.0863258
R4014 VSS.t789 VSS.n608 0.0863258
R4015 VSS.t794 VSS.n609 0.0863258
R4016 VSS.t799 VSS.n610 0.0863258
R4017 VSS.t804 VSS.n611 0.0863258
R4018 VSS.t809 VSS.n612 0.0863258
R4019 VSS.t814 VSS.n613 0.0863258
R4020 VSS.t819 VSS.n614 0.0863258
R4021 VSS.t824 VSS.n615 0.0863258
R4022 VSS.t829 VSS.n616 0.0863258
R4023 VSS.t834 VSS.n617 0.0863258
R4024 VSS.t839 VSS.n618 0.0863258
R4025 VSS.t844 VSS.n619 0.0863258
R4026 VSS.t849 VSS.n620 0.0863258
R4027 VSS.t859 VSS.n622 0.0863258
R4028 VSS.t864 VSS.n623 0.0863258
R4029 VSS.t869 VSS.n624 0.0863258
R4030 VSS.t874 VSS.n625 0.0863258
R4031 VSS.t879 VSS.n626 0.0863258
R4032 VSS.t884 VSS.n627 0.0863258
R4033 VSS.t889 VSS.n628 0.0863258
R4034 VSS.t894 VSS.n629 0.0863258
R4035 VSS.t899 VSS.n630 0.0863258
R4036 VSS.t904 VSS.n631 0.0863258
R4037 VSS.t909 VSS.n632 0.0863258
R4038 VSS.t914 VSS.n633 0.0863258
R4039 VSS.t919 VSS.n634 0.0863258
R4040 VSS.t924 VSS.n635 0.0863258
R4041 VSS.t934 VSS.n637 0.0863258
R4042 VSS.t939 VSS.n638 0.0863258
R4043 VSS.t944 VSS.n639 0.0863258
R4044 VSS.t949 VSS.n640 0.0863258
R4045 VSS.t954 VSS.n641 0.0863258
R4046 VSS.t959 VSS.n642 0.0863258
R4047 VSS.t964 VSS.n643 0.0863258
R4048 VSS.t969 VSS.n644 0.0863258
R4049 VSS.t974 VSS.n645 0.0863258
R4050 VSS.t979 VSS.n646 0.0863258
R4051 VSS.t984 VSS.n647 0.0863258
R4052 VSS.t989 VSS.n648 0.0863258
R4053 VSS.t994 VSS.n649 0.0863258
R4054 VSS.n571 VSS.t1688 0.0863258
R4055 VSS.n573 VSS.t1698 0.0863258
R4056 VSS.n575 VSS.t1708 0.0863258
R4057 VSS.t1713 VSS.n576 0.0863258
R4058 VSS.t1703 VSS.n574 0.0863258
R4059 VSS.t1693 VSS.n572 0.0863258
R4060 VSS.t1683 VSS.n570 0.0863258
R4061 VSS.t1673 VSS.n568 0.0863258
R4062 VSS.t1663 VSS.n566 0.0863258
R4063 VSS.t1653 VSS.n564 0.0863258
R4064 VSS.t1643 VSS.n562 0.0863258
R4065 VSS.t1633 VSS.n560 0.0863258
R4066 VSS.t1623 VSS.n558 0.0863258
R4067 VSS.t1613 VSS.n556 0.0863258
R4068 VSS.t1598 VSS.n553 0.0863258
R4069 VSS.t1533 VSS.n540 0.0863258
R4070 VSS.t1538 VSS.n541 0.0863258
R4071 VSS.t1543 VSS.n542 0.0863258
R4072 VSS.t1548 VSS.n543 0.0863258
R4073 VSS.t1553 VSS.n544 0.0863258
R4074 VSS.t1558 VSS.n545 0.0863258
R4075 VSS.t1563 VSS.n546 0.0863258
R4076 VSS.t1568 VSS.n547 0.0863258
R4077 VSS.t1573 VSS.n548 0.0863258
R4078 VSS.t1578 VSS.n549 0.0863258
R4079 VSS.t1583 VSS.n550 0.0863258
R4080 VSS.t1588 VSS.n551 0.0863258
R4081 VSS.t1593 VSS.n552 0.0863258
R4082 VSS.t1990 VSS.n496 0.0863258
R4083 VSS.t1980 VSS.n494 0.0863258
R4084 VSS.t1970 VSS.n492 0.0863258
R4085 VSS.t1960 VSS.n490 0.0863258
R4086 VSS.t1950 VSS.n488 0.0863258
R4087 VSS.t1940 VSS.n486 0.0863258
R4088 VSS.t1930 VSS.n484 0.0863258
R4089 VSS.n464 VSS.t1829 0.130189
R4090 VSS.t1835 VSS.n465 0.0863258
R4091 VSS.t1840 VSS.n466 0.0863258
R4092 VSS.t1845 VSS.n467 0.0863258
R4093 VSS.t1850 VSS.n468 0.0863258
R4094 VSS.t1855 VSS.n469 0.0863258
R4095 VSS.t1860 VSS.n470 0.0863258
R4096 VSS.t1865 VSS.n471 0.0863258
R4097 VSS.t1870 VSS.n472 0.0863258
R4098 VSS.t1875 VSS.n473 0.0863258
R4099 VSS.t1880 VSS.n474 0.0863258
R4100 VSS.t1885 VSS.n475 0.0863258
R4101 VSS.t1890 VSS.n476 0.0863258
R4102 VSS.t1895 VSS.n477 0.0863258
R4103 VSS.t1900 VSS.n478 0.0863258
R4104 VSS.t1905 VSS.n479 0.0863258
R4105 VSS.t1910 VSS.n480 0.0863258
R4106 VSS.t1915 VSS.n481 0.0863258
R4107 VSS.n482 VSS.t1920 0.0863258
R4108 VSS.t1528 VSS.n539 0.0863258
R4109 VSS.t1518 VSS.n537 0.0863258
R4110 VSS.t1508 VSS.n535 0.0863258
R4111 VSS.t1498 VSS.n533 0.0863258
R4112 VSS.t1488 VSS.n531 0.0863258
R4113 VSS.t1478 VSS.n529 0.0863258
R4114 VSS.t1468 VSS.n527 0.0863258
R4115 VSS.t1458 VSS.n525 0.0863258
R4116 VSS.n521 VSS.t1437 0.130189
R4117 VSS.t1443 VSS.n522 0.0863258
R4118 VSS.t1448 VSS.n523 0.0863258
R4119 VSS.t1453 VSS.n524 0.0863258
R4120 VSS.n412 VSS.t2247 0.0863258
R4121 VSS.n414 VSS.t2257 0.0863258
R4122 VSS.n416 VSS.t2267 0.0863258
R4123 VSS.n418 VSS.t2277 0.0863258
R4124 VSS.n420 VSS.t2287 0.0863258
R4125 VSS.n422 VSS.t2297 0.0863258
R4126 VSS.n424 VSS.t2307 0.0863258
R4127 VSS.n426 VSS.t2317 0.0863258
R4128 VSS.n428 VSS.t2327 0.0863258
R4129 VSS.n430 VSS.t2337 0.0863258
R4130 VSS.n432 VSS.t2347 0.0863258
R4131 VSS.n434 VSS.t2357 0.0863258
R4132 VSS.n436 VSS.t2367 0.0863258
R4133 VSS.n438 VSS.t2377 0.0863258
R4134 VSS.n442 VSS.t2397 0.0863258
R4135 VSS.n444 VSS.t2407 0.0863258
R4136 VSS.n446 VSS.t2417 0.0863258
R4137 VSS.n448 VSS.t2427 0.0863258
R4138 VSS.n450 VSS.t2437 0.0863258
R4139 VSS.n452 VSS.t2447 0.0863258
R4140 VSS.n454 VSS.t2457 0.0863258
R4141 VSS.n456 VSS.t2467 0.0863258
R4142 VSS.n458 VSS.t2477 0.0863258
R4143 VSS.n460 VSS.t2487 0.0863258
R4144 VSS.n462 VSS.t2497 0.0863258
R4145 VSS.t2492 VSS.n461 0.0863258
R4146 VSS.t2482 VSS.n459 0.0863258
R4147 VSS.t2472 VSS.n457 0.0863258
R4148 VSS.t2452 VSS.n453 0.0863258
R4149 VSS.t2442 VSS.n451 0.0863258
R4150 VSS.t2432 VSS.n449 0.0863258
R4151 VSS.t2422 VSS.n447 0.0863258
R4152 VSS.t2412 VSS.n445 0.0863258
R4153 VSS.t2402 VSS.n443 0.0863258
R4154 VSS.t2392 VSS.n441 0.0863258
R4155 VSS.t2382 VSS.n439 0.0863258
R4156 VSS.t2372 VSS.n437 0.0863258
R4157 VSS.t2362 VSS.n435 0.0863258
R4158 VSS.t2352 VSS.n433 0.0863258
R4159 VSS.t2342 VSS.n431 0.0863258
R4160 VSS.t2332 VSS.n429 0.0863258
R4161 VSS.t2322 VSS.n427 0.0863258
R4162 VSS.t2312 VSS.n425 0.0863258
R4163 VSS.t2302 VSS.n423 0.0863258
R4164 VSS.t2292 VSS.n421 0.0863258
R4165 VSS.t2282 VSS.n419 0.0863258
R4166 VSS.t2272 VSS.n417 0.0863258
R4167 VSS.t2262 VSS.n415 0.0863258
R4168 VSS.t2252 VSS.n413 0.0863258
R4169 VSS.t2242 VSS.n411 0.0863258
R4170 VSS.n407 VSS.t2221 0.130189
R4171 VSS.t2227 VSS.n408 0.0863258
R4172 VSS.t2232 VSS.n409 0.0863258
R4173 VSS.t2237 VSS.n410 0.0863258
R4174 VSS.t2883 VSS.n334 0.130189
R4175 VSS.n336 VSS.t2894 0.0863258
R4176 VSS.t2889 VSS.n335 0.0863258
R4177 VSS.n384 VSS.t3134 0.0863258
R4178 VSS.n386 VSS.t3144 0.0863258
R4179 VSS.n388 VSS.t3154 0.0863258
R4180 VSS.t3159 VSS.n389 0.0863258
R4181 VSS.t3149 VSS.n387 0.0863258
R4182 VSS.t3139 VSS.n385 0.0863258
R4183 VSS.t3129 VSS.n383 0.0863258
R4184 VSS.t3119 VSS.n381 0.0863258
R4185 VSS.t3109 VSS.n379 0.0863258
R4186 VSS.t3099 VSS.n377 0.0863258
R4187 VSS.t3089 VSS.n375 0.0863258
R4188 VSS.t3079 VSS.n373 0.0863258
R4189 VSS.t3069 VSS.n371 0.0863258
R4190 VSS.t3059 VSS.n369 0.0863258
R4191 VSS.t3044 VSS.n366 0.0863258
R4192 VSS.t2979 VSS.n353 0.0863258
R4193 VSS.t2984 VSS.n354 0.0863258
R4194 VSS.t2989 VSS.n355 0.0863258
R4195 VSS.t2994 VSS.n356 0.0863258
R4196 VSS.t2999 VSS.n357 0.0863258
R4197 VSS.t3004 VSS.n358 0.0863258
R4198 VSS.t3009 VSS.n359 0.0863258
R4199 VSS.t3014 VSS.n360 0.0863258
R4200 VSS.t3019 VSS.n361 0.0863258
R4201 VSS.t3024 VSS.n362 0.0863258
R4202 VSS.t3029 VSS.n363 0.0863258
R4203 VSS.t3034 VSS.n364 0.0863258
R4204 VSS.t3039 VSS.n365 0.0863258
R4205 VSS.t2904 VSS.n338 0.0863258
R4206 VSS.t346 VSS.t345 0.217986
R4207 VSS.t336 VSS.t123 0.217986
R4208 VSS.t333 VSS.t332 0.217986
R4209 VSS.t328 VSS.t327 0.217986
R4210 VSS.t323 VSS.t79 0.217986
R4211 VSS.t320 VSS.t319 0.217986
R4212 VSS.t315 VSS.t314 0.217986
R4213 VSS.t310 VSS.t309 0.217986
R4214 VSS.t268 VSS.t267 0.217986
R4215 VSS.n676 VSS.t704 0.0861948
R4216 VSS.n672 VSS.t681 0.0861948
R4217 VSS.t176 VSS.t399 0.213325
R4218 VSS.t2974 VSS.n959 0.210486
R4219 VSS.t2312 VSS.n737 0.210486
R4220 VSS.n951 VSS.t1920 0.210486
R4221 VSS.t1528 VSS.n741 0.210486
R4222 VSS.n940 VSS.t854 0.210486
R4223 VSS.n937 VSS.t556 0.210486
R4224 VSS.n405 VSS.t207 0.104635
R4225 VSS.n671 VSS.t570 0.0818513
R4226 VSS.t468 VSS.n176 0.280699
R4227 VSS.t7 VSS.t377 0.204291
R4228 VSS.t1300 VSS.n244 0.238308
R4229 VSS.n186 VSS.t1254 0.17801
R4230 VSS.t1212 VSS.n577 0.0605362
R4231 VSS.n673 VSS.t686 0.24604
R4232 VSS.t38 VSS.n788 0.180789
R4233 VSS.t58 VSS.n219 0.478284
R4234 VSS.n730 VSS.t2666 0.180789
R4235 VSS.n944 VSS.t1419 0.170789
R4236 VSS.n733 VSS.t3049 0.170789
R4237 VSS.t1995 VSS.n950 0.170789
R4238 VSS.n744 VSS.t1603 0.170789
R4239 VSS.t929 VSS.n746 0.170789
R4240 VSS.t2387 VSS.n738 0.170789
R4241 VSS.n731 VSS.t2705 0.170789
R4242 VSS.t343 VSS.n400 0.0836055
R4243 VSS.n404 VSS.t2770 0.0836055
R4244 VSS.t1321 VSS.t1322 0.167039
R4245 VSS.t686 VSS.n282 0.083315
R4246 VSS.t307 VSS.n390 0.0836055
R4247 VSS.t103 VSS.n788 0.164539
R4248 VSS.t761 VSS.n700 0.0647427
R4249 VSS.n718 VSS.t446 0.0647427
R4250 VSS.t3049 VSS.n367 0.07903
R4251 VSS.n440 VSS.t2387 0.07903
R4252 VSS.n497 VSS.t1995 0.07903
R4253 VSS.t1603 VSS.n554 0.07903
R4254 VSS.t929 VSS.n636 0.07903
R4255 VSS.t7 VSS.t278 0.157212
R4256 VSS.t47 VSS.t468 0.153289
R4257 VSS.t369 VSS.n767 0.149321
R4258 VSS.t399 VSS.t138 0.147039
R4259 VSS.t2901 VSS.t2899 0.135506
R4260 VSS.t2748 VSS.t2747 0.130486
R4261 VSS.t2778 VSS.t2622 0.110789
R4262 VSS.n262 VSS.t341 0.175751
R4263 VSS.t1255 VSS.n942 0.1105
R4264 VSS.t1004 VSS.n197 0.181538
R4265 VSS.n894 VSS.n162 0.230486
R4266 VSS.n332 VSS.n733 0.081538
R4267 VSS.t3124 VSS.n331 0.181538
R4268 VSS.n738 VSS.n311 0.081538
R4269 VSS.n310 VSS.t2462 0.181538
R4270 VSS.n309 VSS.n950 0.081538
R4271 VSS.n308 VSS.t2070 0.181538
R4272 VSS.n307 VSS.n744 0.081538
R4273 VSS.t1678 VSS.n306 0.181538
R4274 VSS.t931 VSS.n166 0.0362711
R4275 VSS.t1006 VSS.n197 0.0362711
R4276 VSS.t588 VSS.n763 0.10425
R4277 VSS.n891 VSS.t302 0.098
R4278 VSS.t2808 VSS.t2667 0.090789
R4279 VSS.t305 VSS.n891 0.0905
R4280 VSS.t2808 VSS.n730 0.0905
R4281 VSS.n305 VSS.t1359 0.269511
R4282 VSS.t2886 VSS.t2888 0.0855
R4283 VSS.t2893 VSS.t2891 0.0855
R4284 VSS.t2896 VSS.t2898 0.0855
R4285 VSS.t338 VSS.t340 0.0855
R4286 VSS.t345 VSS.t343 0.0855
R4287 VSS.t3053 VSS.t3051 0.0855
R4288 VSS.t3056 VSS.t3058 0.0855
R4289 VSS.t3063 VSS.t3061 0.0855
R4290 VSS.t3066 VSS.t3068 0.0855
R4291 VSS.t3073 VSS.t3071 0.0855
R4292 VSS.t3076 VSS.t3078 0.0855
R4293 VSS.t3083 VSS.t3081 0.0855
R4294 VSS.t3086 VSS.t3088 0.0855
R4295 VSS.t3093 VSS.t3091 0.0855
R4296 VSS.t3096 VSS.t3098 0.0855
R4297 VSS.t3103 VSS.t3101 0.0855
R4298 VSS.t3106 VSS.t3108 0.0855
R4299 VSS.t3113 VSS.t3111 0.0855
R4300 VSS.t3116 VSS.t3118 0.0855
R4301 VSS.t3123 VSS.t3121 0.0855
R4302 VSS.t3126 VSS.t3128 0.0855
R4303 VSS.t3133 VSS.t3131 0.0855
R4304 VSS.t3136 VSS.t3138 0.0855
R4305 VSS.t3143 VSS.t3141 0.0855
R4306 VSS.t3146 VSS.t3148 0.0855
R4307 VSS.t3153 VSS.t3151 0.0855
R4308 VSS.t3156 VSS.t3158 0.0855
R4309 VSS.t2978 VSS.t2976 0.0855
R4310 VSS.t2983 VSS.t2981 0.0855
R4311 VSS.t2988 VSS.t2986 0.0855
R4312 VSS.t2993 VSS.t2991 0.0855
R4313 VSS.t2998 VSS.t2996 0.0855
R4314 VSS.t3003 VSS.t3001 0.0855
R4315 VSS.t3008 VSS.t3006 0.0855
R4316 VSS.t3013 VSS.t3011 0.0855
R4317 VSS.t3018 VSS.t3016 0.0855
R4318 VSS.t3023 VSS.t3021 0.0855
R4319 VSS.t3028 VSS.t3026 0.0855
R4320 VSS.t3033 VSS.t3031 0.0855
R4321 VSS.t3038 VSS.t3036 0.0855
R4322 VSS.t3043 VSS.t3041 0.0855
R4323 VSS.t3046 VSS.t3048 0.0855
R4324 VSS.t2971 VSS.t2973 0.0855
R4325 VSS.t2966 VSS.t2968 0.0855
R4326 VSS.t2961 VSS.t2963 0.0855
R4327 VSS.t2956 VSS.t2958 0.0855
R4328 VSS.t2951 VSS.t2953 0.0855
R4329 VSS.t2946 VSS.t2948 0.0855
R4330 VSS.t2941 VSS.t2943 0.0855
R4331 VSS.t2936 VSS.t2938 0.0855
R4332 VSS.t2931 VSS.t2933 0.0855
R4333 VSS.t2926 VSS.t2928 0.0855
R4334 VSS.t2921 VSS.t2923 0.0855
R4335 VSS.t2916 VSS.t2918 0.0855
R4336 VSS.t2911 VSS.t2913 0.0855
R4337 VSS.t2908 VSS.t2906 0.0855
R4338 VSS.t2901 VSS.t2903 0.0855
R4339 VSS.t2226 VSS.t2224 0.0855
R4340 VSS.t2231 VSS.t2229 0.0855
R4341 VSS.t2236 VSS.t2234 0.0855
R4342 VSS.t2239 VSS.t2241 0.0855
R4343 VSS.t2246 VSS.t2244 0.0855
R4344 VSS.t2249 VSS.t2251 0.0855
R4345 VSS.t2256 VSS.t2254 0.0855
R4346 VSS.t2259 VSS.t2261 0.0855
R4347 VSS.t2266 VSS.t2264 0.0855
R4348 VSS.t2269 VSS.t2271 0.0855
R4349 VSS.t2276 VSS.t2274 0.0855
R4350 VSS.t2279 VSS.t2281 0.0855
R4351 VSS.t2286 VSS.t2284 0.0855
R4352 VSS.t2289 VSS.t2291 0.0855
R4353 VSS.t2296 VSS.t2294 0.0855
R4354 VSS.t2299 VSS.t2301 0.0855
R4355 VSS.t2306 VSS.t2304 0.0855
R4356 VSS.t2309 VSS.t2311 0.0855
R4357 VSS.t2316 VSS.t2314 0.0855
R4358 VSS.t2319 VSS.t2321 0.0855
R4359 VSS.t2326 VSS.t2324 0.0855
R4360 VSS.t2329 VSS.t2331 0.0855
R4361 VSS.t2336 VSS.t2334 0.0855
R4362 VSS.t2339 VSS.t2341 0.0855
R4363 VSS.t2346 VSS.t2344 0.0855
R4364 VSS.t2349 VSS.t2351 0.0855
R4365 VSS.t2356 VSS.t2354 0.0855
R4366 VSS.t2359 VSS.t2361 0.0855
R4367 VSS.t2366 VSS.t2364 0.0855
R4368 VSS.t2369 VSS.t2371 0.0855
R4369 VSS.t2376 VSS.t2374 0.0855
R4370 VSS.t2379 VSS.t2381 0.0855
R4371 VSS.t2386 VSS.t2384 0.0855
R4372 VSS.t2389 VSS.t2391 0.0855
R4373 VSS.t2396 VSS.t2394 0.0855
R4374 VSS.t2399 VSS.t2401 0.0855
R4375 VSS.t2406 VSS.t2404 0.0855
R4376 VSS.t2409 VSS.t2411 0.0855
R4377 VSS.t2416 VSS.t2414 0.0855
R4378 VSS.t2419 VSS.t2421 0.0855
R4379 VSS.t2426 VSS.t2424 0.0855
R4380 VSS.t2429 VSS.t2431 0.0855
R4381 VSS.t2436 VSS.t2434 0.0855
R4382 VSS.t2439 VSS.t2441 0.0855
R4383 VSS.t2446 VSS.t2444 0.0855
R4384 VSS.t2449 VSS.t2451 0.0855
R4385 VSS.t2456 VSS.t2454 0.0855
R4386 VSS.t2459 VSS.t2461 0.0855
R4387 VSS.t2466 VSS.t2464 0.0855
R4388 VSS.t2469 VSS.t2471 0.0855
R4389 VSS.t2476 VSS.t2474 0.0855
R4390 VSS.t2479 VSS.t2481 0.0855
R4391 VSS.t2486 VSS.t2484 0.0855
R4392 VSS.t2489 VSS.t2491 0.0855
R4393 VSS.t2496 VSS.t2494 0.0855
R4394 VSS.t1834 VSS.t1832 0.0855
R4395 VSS.t1839 VSS.t1837 0.0855
R4396 VSS.t1844 VSS.t1842 0.0855
R4397 VSS.t1849 VSS.t1847 0.0855
R4398 VSS.t1854 VSS.t1852 0.0855
R4399 VSS.t1859 VSS.t1857 0.0855
R4400 VSS.t1864 VSS.t1862 0.0855
R4401 VSS.t1869 VSS.t1867 0.0855
R4402 VSS.t1874 VSS.t1872 0.0855
R4403 VSS.t1879 VSS.t1877 0.0855
R4404 VSS.t1884 VSS.t1882 0.0855
R4405 VSS.t1889 VSS.t1887 0.0855
R4406 VSS.t1894 VSS.t1892 0.0855
R4407 VSS.t1899 VSS.t1897 0.0855
R4408 VSS.t1904 VSS.t1902 0.0855
R4409 VSS.t1909 VSS.t1907 0.0855
R4410 VSS.t1914 VSS.t1912 0.0855
R4411 VSS.t1919 VSS.t1917 0.0855
R4412 VSS.t1924 VSS.t1922 0.0855
R4413 VSS.t1927 VSS.t1929 0.0855
R4414 VSS.t1934 VSS.t1932 0.0855
R4415 VSS.t1937 VSS.t1939 0.0855
R4416 VSS.t1944 VSS.t1942 0.0855
R4417 VSS.t1947 VSS.t1949 0.0855
R4418 VSS.t1954 VSS.t1952 0.0855
R4419 VSS.t1957 VSS.t1959 0.0855
R4420 VSS.t1964 VSS.t1962 0.0855
R4421 VSS.t1967 VSS.t1969 0.0855
R4422 VSS.t1974 VSS.t1972 0.0855
R4423 VSS.t1977 VSS.t1979 0.0855
R4424 VSS.t1984 VSS.t1982 0.0855
R4425 VSS.t1987 VSS.t1989 0.0855
R4426 VSS.t1994 VSS.t1992 0.0855
R4427 VSS.t1999 VSS.t1997 0.0855
R4428 VSS.t2004 VSS.t2002 0.0855
R4429 VSS.t2009 VSS.t2007 0.0855
R4430 VSS.t2014 VSS.t2012 0.0855
R4431 VSS.t2019 VSS.t2017 0.0855
R4432 VSS.t2024 VSS.t2022 0.0855
R4433 VSS.t2029 VSS.t2027 0.0855
R4434 VSS.t2034 VSS.t2032 0.0855
R4435 VSS.t2039 VSS.t2037 0.0855
R4436 VSS.t2044 VSS.t2042 0.0855
R4437 VSS.t2049 VSS.t2047 0.0855
R4438 VSS.t2054 VSS.t2052 0.0855
R4439 VSS.t2059 VSS.t2057 0.0855
R4440 VSS.t2064 VSS.t2062 0.0855
R4441 VSS.t2067 VSS.t2069 0.0855
R4442 VSS.t2074 VSS.t2072 0.0855
R4443 VSS.t2077 VSS.t2079 0.0855
R4444 VSS.t2084 VSS.t2082 0.0855
R4445 VSS.t2087 VSS.t2089 0.0855
R4446 VSS.t2094 VSS.t2092 0.0855
R4447 VSS.t2097 VSS.t2099 0.0855
R4448 VSS.t2104 VSS.t2102 0.0855
R4449 VSS.t1442 VSS.t1440 0.0855
R4450 VSS.t1447 VSS.t1445 0.0855
R4451 VSS.t1452 VSS.t1450 0.0855
R4452 VSS.t1455 VSS.t1457 0.0855
R4453 VSS.t1462 VSS.t1460 0.0855
R4454 VSS.t1465 VSS.t1467 0.0855
R4455 VSS.t1472 VSS.t1470 0.0855
R4456 VSS.t1475 VSS.t1477 0.0855
R4457 VSS.t1482 VSS.t1480 0.0855
R4458 VSS.t1485 VSS.t1487 0.0855
R4459 VSS.t1492 VSS.t1490 0.0855
R4460 VSS.t1495 VSS.t1497 0.0855
R4461 VSS.t1502 VSS.t1500 0.0855
R4462 VSS.t1505 VSS.t1507 0.0855
R4463 VSS.t1512 VSS.t1510 0.0855
R4464 VSS.t1515 VSS.t1517 0.0855
R4465 VSS.t1522 VSS.t1520 0.0855
R4466 VSS.t1525 VSS.t1527 0.0855
R4467 VSS.t1532 VSS.t1530 0.0855
R4468 VSS.t1537 VSS.t1535 0.0855
R4469 VSS.t1542 VSS.t1540 0.0855
R4470 VSS.t1547 VSS.t1545 0.0855
R4471 VSS.t1552 VSS.t1550 0.0855
R4472 VSS.t1557 VSS.t1555 0.0855
R4473 VSS.t1562 VSS.t1560 0.0855
R4474 VSS.t1567 VSS.t1565 0.0855
R4475 VSS.t1572 VSS.t1570 0.0855
R4476 VSS.t1577 VSS.t1575 0.0855
R4477 VSS.t1582 VSS.t1580 0.0855
R4478 VSS.t1587 VSS.t1585 0.0855
R4479 VSS.t1592 VSS.t1590 0.0855
R4480 VSS.t1597 VSS.t1595 0.0855
R4481 VSS.t1600 VSS.t1602 0.0855
R4482 VSS.t1607 VSS.t1605 0.0855
R4483 VSS.t1610 VSS.t1612 0.0855
R4484 VSS.t1617 VSS.t1615 0.0855
R4485 VSS.t1620 VSS.t1622 0.0855
R4486 VSS.t1627 VSS.t1625 0.0855
R4487 VSS.t1630 VSS.t1632 0.0855
R4488 VSS.t1637 VSS.t1635 0.0855
R4489 VSS.t1640 VSS.t1642 0.0855
R4490 VSS.t1647 VSS.t1645 0.0855
R4491 VSS.t1650 VSS.t1652 0.0855
R4492 VSS.t1657 VSS.t1655 0.0855
R4493 VSS.t1660 VSS.t1662 0.0855
R4494 VSS.t1667 VSS.t1665 0.0855
R4495 VSS.t1670 VSS.t1672 0.0855
R4496 VSS.t1677 VSS.t1675 0.0855
R4497 VSS.t1680 VSS.t1682 0.0855
R4498 VSS.t1687 VSS.t1685 0.0855
R4499 VSS.t1690 VSS.t1692 0.0855
R4500 VSS.t1697 VSS.t1695 0.0855
R4501 VSS.t1700 VSS.t1702 0.0855
R4502 VSS.t1707 VSS.t1705 0.0855
R4503 VSS.t1710 VSS.t1712 0.0855
R4504 VSS.t768 VSS.t766 0.0855
R4505 VSS.t773 VSS.t771 0.0855
R4506 VSS.t778 VSS.t776 0.0855
R4507 VSS.t783 VSS.t781 0.0855
R4508 VSS.t788 VSS.t786 0.0855
R4509 VSS.t793 VSS.t791 0.0855
R4510 VSS.t798 VSS.t796 0.0855
R4511 VSS.t803 VSS.t801 0.0855
R4512 VSS.t808 VSS.t806 0.0855
R4513 VSS.t813 VSS.t811 0.0855
R4514 VSS.t818 VSS.t816 0.0855
R4515 VSS.t823 VSS.t821 0.0855
R4516 VSS.t828 VSS.t826 0.0855
R4517 VSS.t833 VSS.t831 0.0855
R4518 VSS.t838 VSS.t836 0.0855
R4519 VSS.t843 VSS.t841 0.0855
R4520 VSS.t848 VSS.t846 0.0855
R4521 VSS.t853 VSS.t851 0.0855
R4522 VSS.t858 VSS.t856 0.0855
R4523 VSS.t863 VSS.t861 0.0855
R4524 VSS.t868 VSS.t866 0.0855
R4525 VSS.t873 VSS.t871 0.0855
R4526 VSS.t878 VSS.t876 0.0855
R4527 VSS.t883 VSS.t881 0.0855
R4528 VSS.t888 VSS.t886 0.0855
R4529 VSS.t893 VSS.t891 0.0855
R4530 VSS.t898 VSS.t896 0.0855
R4531 VSS.t903 VSS.t901 0.0855
R4532 VSS.t908 VSS.t906 0.0855
R4533 VSS.t913 VSS.t911 0.0855
R4534 VSS.t918 VSS.t916 0.0855
R4535 VSS.t923 VSS.t921 0.0855
R4536 VSS.t928 VSS.t926 0.0855
R4537 VSS.t933 VSS.t931 0.0855
R4538 VSS.t938 VSS.t936 0.0855
R4539 VSS.t943 VSS.t941 0.0855
R4540 VSS.t948 VSS.t946 0.0855
R4541 VSS.t953 VSS.t951 0.0855
R4542 VSS.t958 VSS.t956 0.0855
R4543 VSS.t963 VSS.t961 0.0855
R4544 VSS.t968 VSS.t966 0.0855
R4545 VSS.t973 VSS.t971 0.0855
R4546 VSS.t978 VSS.t976 0.0855
R4547 VSS.t983 VSS.t981 0.0855
R4548 VSS.t988 VSS.t986 0.0855
R4549 VSS.t993 VSS.t991 0.0855
R4550 VSS.t998 VSS.t996 0.0855
R4551 VSS.t1001 VSS.t1003 0.0855
R4552 VSS.t1008 VSS.t1006 0.0855
R4553 VSS.t1011 VSS.t1013 0.0855
R4554 VSS.t1018 VSS.t1016 0.0855
R4555 VSS.t1021 VSS.t1023 0.0855
R4556 VSS.t1028 VSS.t1026 0.0855
R4557 VSS.t1031 VSS.t1033 0.0855
R4558 VSS.t1038 VSS.t1036 0.0855
R4559 VSS.t191 VSS.t726 0.0855
R4560 VSS.t721 VSS.t723 0.0855
R4561 VSS.t699 VSS.t153 0.0855
R4562 VSS.t689 VSS.t687 0.0855
R4563 VSS.t685 VSS.t683 0.0855
R4564 VSS.t44 VSS.t679 0.0855
R4565 VSS.t563 VSS.t565 0.0855
R4566 VSS.t560 VSS.t558 0.0855
R4567 VSS.t520 VSS.t257 0.0855
R4568 VSS.t523 VSS.t525 0.0855
R4569 VSS.t530 VSS.t528 0.0855
R4570 VSS.t533 VSS.t535 0.0855
R4571 VSS.t540 VSS.t538 0.0855
R4572 VSS.t543 VSS.t545 0.0855
R4573 VSS.t550 VSS.t548 0.0855
R4574 VSS.t553 VSS.t555 0.0855
R4575 VSS.t402 VSS.t403 0.0855
R4576 VSS.t405 VSS.t406 0.0855
R4577 VSS.t408 VSS.t409 0.0855
R4578 VSS.t411 VSS.t412 0.0855
R4579 VSS.t414 VSS.t415 0.0855
R4580 VSS.t417 VSS.t418 0.0855
R4581 VSS.t420 VSS.t421 0.0855
R4582 VSS.t423 VSS.t424 0.0855
R4583 VSS.t426 VSS.t427 0.0855
R4584 VSS.t429 VSS.t430 0.0855
R4585 VSS.t432 VSS.t433 0.0855
R4586 VSS.t435 VSS.t436 0.0855
R4587 VSS.t438 VSS.t439 0.0855
R4588 VSS.t441 VSS.t442 0.0855
R4589 VSS.t134 VSS.t389 0.0855
R4590 VSS.t459 VSS.t51 0.0855
R4591 VSS.t22 VSS.t25 0.0855
R4592 VSS.t309 VSS.t307 0.0855
R4593 VSS.t314 VSS.t312 0.0855
R4594 VSS.t319 VSS.t317 0.0855
R4595 VSS.t327 VSS.t325 0.0855
R4596 VSS.t332 VSS.t330 0.0855
R4597 VSS.t576 VSS.t83 0.0855
R4598 VSS.n767 VSS.t231 0.0793031
R4599 VSS.t590 VSS.t60 0.07425
R4600 VSS.t568 VSS.t571 0.07425
R4601 VSS.t444 VSS.t445 0.07425
R4602 VSS.t270 VSS.t131 0.07425
R4603 VSS.n942 VSS.t1256 0.070789
R4604 VSS.n382 VSS.t3124 0.149319
R4605 VSS.n569 VSS.t1678 0.149319
R4606 VSS.t2070 VSS.n512 0.149319
R4607 VSS.t1004 VSS.n651 0.149319
R4608 VSS.n455 VSS.t2462 0.149319
R4609 VSS.t2622 VSS.t2777 0.0705
R4610 VSS.t1166 VSS.t1329 0.0705
R4611 VSS.t7 VSS.n17 0.0643474
R4612 VSS.t7 VSS.n16 0.0643474
R4613 VSS.t7 VSS.n15 0.0643474
R4614 VSS.t7 VSS.n0 0.219075
R4615 VSS.t121 VSS.t110 0.05925
R4616 VSS.n791 VSS.t506 0.0505812
R4617 VSS.t1211 VSS.t1359 0.0305
R4618 VSS.n24 VSS.t2493 109.992
R4619 VSS.n24 VSS.t2473 109.992
R4620 VSS.t2468 VSS.n24 109.992
R4621 VSS.t2418 VSS.n24 109.992
R4622 VSS.n24 VSS.t2393 109.992
R4623 VSS.n24 VSS.t2373 109.992
R4624 VSS.n24 VSS.t2353 109.992
R4625 VSS.n24 VSS.t2323 109.992
R4626 VSS.n24 VSS.t2283 109.992
R4627 VSS.n24 VSS.t2253 109.992
R4628 VSS.n24 VSS.t2228 109.992
R4629 VSS.n22 VSS.t2091 109.992
R4630 VSS.n22 VSS.t2071 109.992
R4631 VSS.n22 VSS.t1951 109.992
R4632 VSS.n22 VSS.t1941 109.992
R4633 VSS.n22 VSS.t1931 109.992
R4634 VSS.n22 VSS.t1851 109.992
R4635 VSS.t1699 VSS.n23 109.992
R4636 VSS.t1689 VSS.n23 109.992
R4637 VSS.t1679 VSS.n23 109.992
R4638 VSS.t1669 VSS.n23 109.992
R4639 VSS.n23 VSS.t1599 109.992
R4640 VSS.n23 VSS.t1594 109.992
R4641 VSS.n23 VSS.t1549 109.992
R4642 VSS.n23 VSS.t1509 109.992
R4643 VSS.n23 VSS.t1479 109.992
R4644 VSS.n23 VSS.t1459 109.992
R4645 VSS.n117 VSS.t1035 109.992
R4646 VSS.t1020 VSS.n117 109.992
R4647 VSS.t1010 VSS.n117 109.992
R4648 VSS.n117 VSS.t1005 109.992
R4649 VSS.n117 VSS.t935 109.992
R4650 VSS.n117 VSS.t920 109.992
R4651 VSS.n117 VSS.t915 109.992
R4652 VSS.n117 VSS.t895 109.992
R4653 VSS.n117 VSS.t795 109.992
R4654 VSS.n151 VSS.t3274 67.9
R4655 VSS.t66 VSS.t511 109.992
R4656 VSS.t66 VSS.t505 109.992
R4657 VSS VSS.n960 0.01986
R4658 VSS.n959 VSS.t2976 0.01675
R4659 VSS.n737 VSS.t2314 0.01675
R4660 VSS.n951 VSS.t1922 0.01675
R4661 VSS.n741 VSS.t1530 0.01675
R4662 VSS.t856 VSS.n940 0.01675
R4663 VSS.n937 VSS.t558 0.01675
R4664 VSS.t2706 VSS.n731 0.0105
R4665 VSS.n944 VSS.t1300 0.0105
R4666 VSS.n166 VSS.n746 0.081538
R4667 VSS.t586 VSS.n763 0.0105
R4668 VSS.n894 VSS.t81 0.0105
R4669 VSS.n127 VSS.t2900 183.806
R4670 VSS.n127 VSS.t3100 183.805
R4671 VSS.t3075 VSS.n127 183.805
R4672 VSS.n127 VSS.t3070 183.805
R4673 VSS.n127 VSS.t3045 183.805
R4674 VSS.n127 VSS.t3020 183.805
R4675 VSS.n127 VSS.t2995 183.805
R4676 VSS.t2975 VSS.n127 183.805
R4677 VSS.t2950 VSS.n127 183.805
R4678 VSS.t1154 VSS.t1322 8.50454
R4679 VSS.n23 VSS.n574 4.29334
R4680 VSS.n517 VSS.n22 4.29334
R4681 VSS.n460 VSS.n24 4.29333
R4682 VSS.n258 VSS.t206 2.98041
R4683 VSS.n337 VSS.n127 2.86037
R4684 VSS.n204 VSS.t1154 2.21302
R4685 VSS.t4 VSS.n805 1.39125
R4686 VSS.n702 VSS.t4 1.262
R4687 VSS.t66 VSS.t516 1.1042
R4688 VSS.n118 VSS.n117 0.575488
R4689 VSS.t302 VSS.n155 1.04272
R4690 VSS.t7 VSS.n14 1.02715
R4691 VSS.t7 VSS.n54 1.01419
C0 a_26475_14495# sg13cmos5l_dfrbpq_1_7.Q 0.03274f
C1 counter_value_o[6] a_32200_16082# 0.02116f
C2 sg13cmos5l_o21ai_1_1.Y sg13cmos5l_or3_1_2.A 0.23707f
C3 sg13cmos5l_dlygate4sd3_1_17.A VDD 0.29477f
C4 a_27215_14845# VDD 0.17631f
C5 a_2528_15366# sg13cmos5l_and2_1_0.X 0.03662f
C6 a_27502_15423# VDD 0.16013f
C7 sg13cmos5l_dfrbpq_1_6.D a_21070_15423# 0.03572f
C8 sg13cmos5l_dlygate4sd3_1_0.X a_5896_13854# 0.01652f
C9 sg13cmos5l_buf_1_10.X a_2490_14447# 0.01712f
C10 clock_i VDD 1.62643f
C11 a_26565_13701# sg13cmos5l_dfrbpq_1_5.RESET_B 0.03932f
C12 sg13cmos5l_inv_1_0.Y a_16969_16020# 0.16895f
C13 a_6372_14488# sg13cmos5l_xor2_1_0.B 0.02396f
C14 counter_value_o[0] a_2248_16082# 0.02116f
C15 a_6286_13911# VDD 0.15952f
C16 counter_value_o[4] sg13cmos5l_dfrbpq_1_3.Q 0.01007f
C17 sg13cmos5l_tiehi_1.L_HI sg13cmos5l_dlygate4sd3_1_8.A 0.02474f
C18 a_7829_15238# sg13cmos5l_dlygate4sd3_1_8.X 0.02577f
C19 a_25670_14922# a_26373_14495# 0.02431f
C20 sg13cmos5l_nand3_1_0.Y a_7923_15532# 0.01019f
C21 a_24169_14508# VDD 0.25699f
C22 a_20603_15532# sg13cmos5l_a21oi_1_1.Y 0.09955f
C23 sg13cmos5l_dfrbpq_1_5.RESET_B a_26249_16334# 0.01855f
C24 sg13cmos5l_xnor2_1_2.A sg13cmos5l_dlygate4sd3_1_0.A 0.09582f
C25 sg13cmos5l_buf_8_2.A a_19323_13726# 0.35369f
C26 a_26170_16237# a_26249_16334# 0.08889f
C27 a_26753_15424# sg13cmos5l_dfrbpq_1_5.RESET_B 0.01144f
C28 sg13cmos5l_dlygate4sd3_1_17.A sg13cmos5l_or3_1_1.A 0.15251f
C29 a_27502_15423# sg13cmos5l_or3_1_1.A 0.12348f
C30 a_18769_14845# a_17604_14488# 0.25046f
C31 sg13cmos5l_or3_1_2.B sg13cmos5l_dfrbpq_1_3.Q 0.36223f
C32 a_18021_14495# a_18202_15202# 0.0121f
C33 sg13cmos5l_o21ai_1_2.Y sg13cmos5l_or3_1_1.C 0.14946f
C34 sg13cmos5l_dfrbpq_1_2.Q a_23168_15366# 0.02676f
C35 a_6372_14488# sg13cmos5l_dfrbpq_1_2.CLK 0.08815f
C36 a_24923_15996# sg13cmos5l_dlygate4sd3_1_17.A 0.11419f
C37 sg13cmos5l_dfrbpq_1_7.RESET_B a_27472_14726# 0.09622f
C38 sg13cmos5l_dfrbpq_1_6.D sg13cmos5l_or3_1_2.X 0.04306f
C39 a_25203_13320# sg13cmos5l_a21oi_1_3.A1 0.01172f
C40 sg13cmos5l_or3_1_2.A a_20278_14862# 0.02431f
C41 counter_value_o[7] VDD 0.1164f
C42 a_21166_16263# sg13cmos5l_a21oi_1_1.Y 0.01491f
C43 VDD a_21824_15366# 0.07818f
C44 a_18106_15960# sg13cmos5l_dlygate4sd3_1_4.X 0.01488f
C45 sg13cmos5l_a21oi_1_0.A1 a_17825_16262# 0.01004f
C46 a_6086_14922# a_6660_14909# 0.18486f
C47 a_18021_14495# a_17318_14922# 0.02431f
C48 sg13cmos5l_o21ai_1_1.Y a_20774_14922# 0.03526f
C49 a_22030_15423# VDD 0.16094f
C50 a_22986_14484# VDD 0.30036f
C51 sg13cmos5l_inv_1_0.Y sg13cmos5l_dlygate4sd3_1_4.X 0.90342f
C52 sg13cmos5l_dfrbpq_1_2.Q VDD 1.33086f
C53 sg13cmos5l_or3_1_2.C sg13cmos5l_a21oi_1_3.B1 0.03201f
C54 a_19048_13854# VDD 0.14253f
C55 sg13cmos5l_dfrbpq_1_1.RESET_B sg13cmos5l_dlygate4sd3_1_1.A 0.02096f
C56 a_3209_16334# a_3333_16033# 0.08186f
C57 a_3130_16237# a_3008_16082# 0.01854f
C58 sg13cmos5l_dfrbpq_1_6.Q sg13cmos5l_o21ai_1_2.B1 1.63709f
C59 sg13cmos5l_o21ai_1_1.Y a_21348_14909# 0.02008f
C60 a_26373_14495# VDD 0.24869f
C61 a_23638_14862# sg13cmos5l_or3_1_2.B 0.06579f
C62 a_7160_15242# sg13cmos5l_buf_1_0.X 0.01376f
C63 sg13cmos5l_inv_1_0.A sg13cmos5l_a21oi_1_0.A1 0.01808f
C64 a_5886_15486# VDD 0.09482f
C65 a_22025_16334# VDD 0.07626f
C66 sg13cmos5l_dfrbpq_1_2.Q a_17806_15423# 0.01441f
C67 a_24704_13854# sg13cmos5l_or3_1_1.C 0.02884f
C68 a_21251_13690# sg13cmos5l_or3_1_2.C 0.16807f
C69 a_16068_14040# sg13cmos5l_or3_1_1.B 0.03267f
C70 a_6540_13238# a_6280_13058# 0.01728f
C71 sg13cmos5l_dfrbpq_1_1.RESET_B sg13cmos5l_xnor2_1_2.A 0.04487f
C72 a_16068_14040# a_16485_13701# 0.28324f
C73 a_15782_13722# a_16587_13844# 0.07916f
C74 counter_value_o[6] VDD 0.12121f
C75 a_22149_16033# a_22304_16082# 0.03131f
C76 a_27313_13799# a_26565_13701# 0.01058f
C77 a_25930_14452# sg13cmos5l_dfrbpq_1_5.RESET_B 0.0148f
C78 a_16587_13844# a_17584_13942# 0.03412f
C79 a_17604_14488# sg13cmos5l_dfrbpq_1_2.Q 0.02704f
C80 VDD a_3333_16033# 0.07215f
C81 sg13cmos5l_dlygate4sd3_1_4.X a_18789_15277# 0.03893f
C82 a_11752_15366# VDD 0.15245f
C83 sg13cmos5l_dlygate4sd3_1_5.A a_18454_16374# 0.07345f
C84 a_25862_13722# a_26565_13701# 0.02453f
C85 a_26244_14909# sg13cmos5l_dfrbpq_1_5.RESET_B 0.01674f
C86 sg13cmos5l_xnor2_1_2.A sg13cmos5l_dlygate4sd3_1_1.A 0.06433f
C87 a_25956_14488# sg13cmos5l_dfrbpq_1_7.RESET_B 0.28972f
C88 a_2916_15552# sg13cmos5l_buf_1_0.X 0.0434f
C89 a_2916_15552# a_4081_15311# 0.25046f
C90 a_8685_14832# sg13cmos5l_buf_1_10.X 0.108f
C91 sg13cmos5l_buf_8_2.X sg13cmos5l_o21ai_1_2.Y 0.51052f
C92 a_17892_14909# sg13cmos5l_dfrbpq_1_3.RESET_B 0.0197f
C93 sg13cmos5l_inv_1_0.A sg13cmos5l_a21oi_1_0.A2 0.0306f
C94 a_6372_14488# sg13cmos5l_xnor2_1_2.B 0.03099f
C95 sg13cmos5l_or3_1_2.B sg13cmos5l_o21ai_1_2.B1 0.35664f
C96 sg13cmos5l_inv_1_0.A a_17126_15238# 0.01214f
C97 a_15579_14854# sg13cmos5l_a21oi_1_3.B1 0.06371f
C98 sg13cmos5l_a21oi_1_3.A1 sg13cmos5l_a21oi_1_3.B1 0.26386f
C99 a_26667_13844# a_27407_13799# 0.17382f
C100 a_1856_14570# VDD 0.08533f
C101 clock_i sg13cmos5l_or3_1_1.B 0.07955f
C102 a_18123_14495# a_18863_14845# 0.17382f
C103 a_26475_14495# sg13cmos5l_dfrbpq_1_7.RESET_B 0.27969f
C104 a_10222_14751# sg13cmos5l_dlygate4sd3_1_8.X 0.1126f
C105 a_21034_14452# a_21477_14495# 0.02241f
C106 counter_value_o[5] VDD 0.13222f
C107 a_8582_15238# VDD 0.21098f
C108 a_27898_15202# sg13cmos5l_dfrbpq_1_5.Q 0.2865f
C109 sg13cmos5l_a21oi_1_3.B1 sg13cmos5l_dfrbpq_1_2.CLK 0.1602f
C110 a_3872_14570# VDD 0.08604f
C111 a_4078_14751# a_3872_14570# 0.01604f
C112 a_21060_14488# a_22319_14845# 0.01412f
C113 sg13cmos5l_dfrbpq_1_6.Q VDD 0.92075f
C114 sg13cmos5l_dfrbpq_1_1.RESET_B sg13cmos5l_xor2_1_0.B 0.04436f
C115 a_8694_15302# sg13cmos5l_and2_1_2.B 0.12545f
C116 sg13cmos5l_dfrbpq_1_2.Q sg13cmos5l_dlygate4sd3_1_9.X 0.01954f
C117 sg13cmos5l_dlygate4sd3_1_5.A VDD 0.30993f
C118 a_18454_16374# sg13cmos5l_or3_1_2.B 0.0782f
C119 sg13cmos5l_a21oi_1_0.Y VDD 0.26526f
C120 sg13cmos5l_a21oi_1_0.A2 a_17238_15302# 0.03082f
C121 a_24841_13726# sg13cmos5l_a21oi_1_3.A1 0.05315f
C122 a_17126_15238# a_17238_15302# 0.3854f
C123 a_7680_15549# sg13cmos5l_dlygate4sd3_1_1.A 0.05742f
C124 a_9963_15356# sg13cmos5l_dfrbpq_1_2.CLK 0.02366f
C125 a_9963_15356# sg13cmos5l_nand4_1_0.Y 0.02274f
C126 a_27215_14845# a_27882_14484# 0.09257f
C127 sg13cmos5l_buf_1_0.X a_3435_15356# 0.01828f
C128 a_24310_15230# sg13cmos5l_o21ai_1_3.Y 0.06016f
C129 a_27502_15423# a_27617_15424# 0.3854f
C130 sg13cmos5l_xor2_1_0.X a_1965_14832# 0.19131f
C131 a_26554_16237# VDD 0.09431f
C132 sg13cmos5l_dlygate4sd3_1_4.X a_16969_16020# 0.2162f
C133 a_7888_14726# sg13cmos5l_dlygate4sd3_1_8.X 0.01017f
C134 sg13cmos5l_buf_8_2.X sg13cmos5l_dfrbpq_1_6.D 0.02715f
C135 a_12010_15202# sg13cmos5l_dfrbpq_1_2.CLK 0.67763f
C136 a_12010_15202# sg13cmos5l_nand4_1_0.Y 0.04366f
C137 sg13cmos5l_xor2_1_0.B sg13cmos5l_dlygate4sd3_1_1.A 0.01964f
C138 sg13cmos5l_dfrbpq_1_6.Q sg13cmos5l_or3_1_1.A 1.7649f
C139 sg13cmos5l_dfrbpq_1_1.RESET_B sg13cmos5l_dfrbpq_1_2.CLK 0.03866f
C140 sg13cmos5l_xor2_1_0.X a_2516_14484# 0.06124f
C141 sg13cmos5l_dfrbpq_1_3.Q sg13cmos5l_a21oi_1_3.B1 0.86219f
C142 a_17318_14922# sg13cmos5l_dfrbpq_1_3.D 0.17256f
C143 counter_value_o[4] VDD 0.09581f
C144 sg13cmos5l_buf_8_2.X a_26667_13844# 0.04348f
C145 a_25889_15424# VDD 0.20712f
C146 a_6372_14488# sg13cmos5l_dlygate4sd3_1_8.X 0.02859f
C147 a_24824_14525# sg13cmos5l_dlygate4sd3_1_17.A 0.29888f
C148 a_16068_14040# a_16356_13735# 0.24435f
C149 sg13cmos5l_buf_8_2.X a_19530_14484# 0.02075f
C150 sg13cmos5l_or3_1_2.A sg13cmos5l_dfrbpq_1_6.D 0.02907f
C151 sg13cmos5l_dfrbpq_1_2.Q sg13cmos5l_or3_1_1.B 0.01742f
C152 sg13cmos5l_xor2_1_0.B sg13cmos5l_xnor2_1_2.A 0.34223f
C153 a_10609_15311# sg13cmos5l_dfrbpq_1_2.CLK 0.0137f
C154 a_10222_14751# VDD 0.16191f
C155 sg13cmos5l_xnor2_1_2.B sg13cmos5l_dlygate4sd3_1_0.A 0.34813f
C156 sg13cmos5l_or3_1_2.B VDD 2.19079f
C157 a_18123_14495# sg13cmos5l_a21oi_1_3.B1 0.01374f
C158 a_2516_14484# sg13cmos5l_xor2_1_0.B 0.01121f
C159 a_17327_13799# a_17233_13799# 0.16704f
C160 sg13cmos5l_dfrbpq_1_2.CLK sg13cmos5l_dlygate4sd3_1_1.A 0.27858f
C161 a_6401_13912# sg13cmos5l_dlygate4sd3_1_0.A 0.04884f
C162 sg13cmos5l_nand4_1_0.Y sg13cmos5l_dlygate4sd3_1_1.A 0.27454f
C163 a_4175_15311# a_4432_15454# 0.23043f
C164 sg13cmos5l_dfrbpq_1_2.Q sg13cmos5l_dfrbpq_1_6.RESET_B 0.01328f
C165 sg13cmos5l_a21oi_1_3.Y sg13cmos5l_dfrbpq_1_6.Q 0.01464f
C166 sg13cmos5l_and2_1_2.X sg13cmos5l_dfrbpq_1_2.CLK 0.02931f
C167 sg13cmos5l_dfrbpq_1_1.RESET_B sg13cmos5l_dlygate4sd3_1_3.A 0.14117f
C168 sg13cmos5l_and2_1_2.X sg13cmos5l_nand4_1_0.Y 0.01576f
C169 a_25889_15424# sg13cmos5l_or3_1_1.A 0.01269f
C170 sg13cmos5l_or3_1_2.B a_21579_14495# 0.01018f
C171 a_18665_15180# VDD 0.0736f
C172 a_24824_15238# VDD 0.26964f
C173 a_22025_16334# sg13cmos5l_dfrbpq_1_6.RESET_B 0.01142f
C174 a_21166_16263# a_21281_16262# 0.3854f
C175 sg13cmos5l_xnor2_1_2.A sg13cmos5l_dfrbpq_1_2.CLK 0.07807f
C176 sg13cmos5l_a21oi_1_2.A1 sg13cmos5l_dlygate4sd3_1_17.A 0.07757f
C177 sg13cmos5l_nand4_1_0.Y sg13cmos5l_xnor2_1_2.A 0.05029f
C178 sg13cmos5l_dlygate4sd3_1_3.A a_2824_16082# 0.03948f
C179 sg13cmos5l_nand3_1_0.Y sg13cmos5l_dfrbpq_1_1.RESET_B 0.01467f
C180 counter_value_o[3] VDD 0.07686f
C181 sg13cmos5l_a21oi_1_0.A2 sg13cmos5l_dfrbpq_1_3.RESET_B 0.01456f
C182 sg13cmos5l_xor2_1_0.X sg13cmos5l_xor2_1_0.B 0.07025f
C183 sg13cmos5l_inv_1_0.Y a_16140_15424# 0.08646f
C184 a_7532_15960# a_7240_16082# 0.01635f
C185 a_7888_14726# VDD 0.13652f
C186 sg13cmos5l_dlygate4sd3_1_1.A sg13cmos5l_dlygate4sd3_1_3.A 0.1901f
C187 a_8218_13690# sg13cmos5l_dlygate4sd3_1_1.A 0.30158f
C188 sg13cmos5l_dfrbpq_1_7.D sg13cmos5l_dfrbpq_1_7.RESET_B 0.11217f
C189 a_16587_13844# sg13cmos5l_dfrbpq_1_2.RESET_B 0.27963f
C190 a_24824_15238# sg13cmos5l_or3_1_1.A 0.02528f
C191 a_25956_14488# a_27121_14845# 0.25046f
C192 a_6372_14488# VDD 0.07271f
C193 a_1192_9948# VDD 0.18614f
C194 sg13cmos5l_nand3_1_0.Y sg13cmos5l_dlygate4sd3_1_1.A 0.37433f
C195 a_38536_13854# VDD 0.13998f
C196 a_15680_13854# VDD 0.10463f
C197 a_10703_15311# sg13cmos5l_dlygate4sd3_1_8.A 0.05509f
C198 a_24520_13854# VDD 0.14054f
C199 a_16140_15424# sg13cmos5l_nor2_1_0.B 0.1273f
C200 sg13cmos5l_dfrbpq_1_6.D a_20774_14922# 0.17726f
C201 sg13cmos5l_dlygate4sd3_1_0.X a_5613_14832# 0.20961f
C202 a_10222_14751# a_10337_14750# 0.3854f
C203 a_21946_16237# VDD 0.09557f
C204 sg13cmos5l_nand4_1_0.Y a_7680_15549# 0.03194f
C205 sg13cmos5l_xnor2_1_2.B sg13cmos5l_dfrbpq_1_1.RESET_B 0.15083f
C206 a_17892_14909# sg13cmos5l_dfrbpq_1_2.Q 0.02394f
C207 a_37192_16082# VDD 0.16744f
C208 a_17327_13799# VDD 0.18096f
C209 a_25774_15423# sg13cmos5l_dfrbpq_1_7.D 0.10701f
C210 counter_value_o[2] VDD 0.12104f
C211 sg13cmos5l_a21oi_1_3.A2 a_24841_13726# 0.06354f
C212 a_26565_13701# VDD 0.28166f
C213 sg13cmos5l_a21oi_1_3.B1 sg13cmos5l_o21ai_1_2.B1 0.01704f
C214 sg13cmos5l_or3_1_2.C sg13cmos5l_dfrbpq_1_3.Q 0.20063f
C215 sg13cmos5l_buf_8_2.X a_25956_14488# 0.09542f
C216 a_32492_15960# sg13cmos5l_dfrbpq_1_7.Q 0.1927f
C217 sg13cmos5l_xor2_1_0.B sg13cmos5l_dfrbpq_1_2.CLK 0.10767f
C218 a_18863_14845# VDD 0.17376f
C219 a_21466_15202# sg13cmos5l_or3_1_2.A 0.03705f
C220 sg13cmos5l_a21oi_1_0.Y sg13cmos5l_or3_1_1.B 0.21476f
C221 sg13cmos5l_o21ai_1_1.Y a_21824_15366# 0.03907f
C222 a_22030_15423# a_22145_15424# 0.3854f
C223 sg13cmos5l_dfrbpq_1_2.Q a_22145_15424# 0.01328f
C224 a_16856_15238# sg13cmos5l_dfrbpq_1_2.CLK 0.01408f
C225 a_25670_14922# sg13cmos5l_a21oi_1_3.B1 0.0136f
C226 a_17584_13942# a_17994_14020# 0.07015f
C227 a_26249_16334# VDD 0.07375f
C228 sg13cmos5l_buf_8_2.X sg13cmos5l_buf_8_2.A 0.17028f
C229 sg13cmos5l_buf_8_2.X a_26475_14495# 0.0491f
C230 a_26753_15424# VDD 0.20784f
C231 a_19169_15424# a_19450_15202# 0.18796f
C232 sg13cmos5l_o21ai_1_1.Y sg13cmos5l_dfrbpq_1_2.Q 0.02544f
C233 a_25862_13722# sg13cmos5l_dfrbpq_1_5.RESET_B 0.11402f
C234 a_18586_15455# sg13cmos5l_dfrbpq_1_3.RESET_B 0.04249f
C235 sg13cmos5l_tiehi_1.L_HI sg13cmos5l_buf_1_10.X 0.03277f
C236 a_9444_15552# a_9963_15356# 0.20773f
C237 sg13cmos5l_dfrbpq_1_0.RESET_B sg13cmos5l_dlygate4sd3_1_3.A 0.11811f
C238 a_25670_14922# a_25930_14452# 0.45119f
C239 VDD a_12232_16082# 0.16754f
C240 sg13cmos5l_nand4_1_0.Y sg13cmos5l_dfrbpq_1_2.CLK 1.61147f
C241 sg13cmos5l_nand3_1_0.Y a_7680_15549# 0.23616f
C242 sg13cmos5l_xnor2_1_2.B sg13cmos5l_xnor2_1_2.A 0.34537f
C243 sg13cmos5l_xor2_1_0.B sg13cmos5l_dlygate4sd3_1_3.A 0.05133f
C244 a_21251_13690# a_21460_14020# 0.01485f
C245 a_19048_13854# a_19232_13854# 0.05762f
C246 a_23368_14570# VDD 0.13204f
C247 a_27664_13942# sg13cmos5l_dfrbpq_1_5.RESET_B 0.09962f
C248 counter_value_o[1] VDD 0.11682f
C249 a_27617_15424# sg13cmos5l_dfrbpq_1_6.Q 0.04727f
C250 sg13cmos5l_dlygate4sd3_1_0.A VDD 0.32455f
C251 a_25109_12972# sg13cmos5l_a21oi_1_3.A1 0.02752f
C252 a_18863_14845# a_17604_14488# 0.01412f
C253 a_9963_15356# a_10960_15454# 0.03412f
C254 a_26753_15424# sg13cmos5l_or3_1_1.A 0.01592f
C255 a_25670_14922# a_26244_14909# 0.18486f
C256 sg13cmos5l_or3_1_2.B sg13cmos5l_or3_1_1.B 0.04606f
C257 a_5886_15486# a_5687_15315# 0.02453f
C258 sg13cmos5l_a21oi_1_0.A1 sg13cmos5l_dfrbpq_1_2.Q 0.1004f
C259 a_26170_16237# a_25786_15960# 0.01303f
C260 a_25505_16262# sg13cmos5l_o21ai_1_3.Y 0.02436f
C261 a_19816_15366# sg13cmos5l_dfrbpq_1_3.Q 0.05363f
C262 sg13cmos5l_or3_1_2.B sg13cmos5l_dfrbpq_1_6.RESET_B 0.24505f
C263 sg13cmos5l_buf_8_2.X a_21477_14495# 0.21497f
C264 sg13cmos5l_dfrbpq_1_2.CLK sg13cmos5l_dlygate4sd3_1_3.A 0.05316f
C265 a_9444_15552# a_10609_15311# 0.25046f
C266 a_9963_15356# a_9732_15247# 0.07823f
C267 a_7631_14845# a_8298_14484# 0.09257f
C268 sg13cmos5l_a21oi_1_3.B1 VDD 1.64688f
C269 a_6086_14922# a_6789_14495# 0.02431f
C270 sg13cmos5l_dlygate4sd3_1_8.X sg13cmos5l_dlygate4sd3_1_1.A 0.16183f
C271 a_7537_14845# a_6372_14488# 0.25046f
C272 sg13cmos5l_nand3_1_0.Y sg13cmos5l_nand4_1_0.Y 0.14351f
C273 sg13cmos5l_and2_1_2.X sg13cmos5l_dlygate4sd3_1_8.X 0.03283f
C274 a_21185_15424# VDD 0.20696f
C275 counter_value_o[0] clock_i 0.04197f
C276 a_6372_14488# a_6660_14909# 0.24435f
C277 a_21251_13690# VDD 0.28201f
C278 sg13cmos5l_dfrbpq_1_7.RESET_B sg13cmos5l_dfrbpq_1_7.Q 0.0164f
C279 a_38536_10034# a_38720_10034# 0.05762f
C280 a_9737_14822# a_9658_14725# 0.08889f
C281 a_9861_15213# sg13cmos5l_tiehi_1.L_HI 0.03738f
C282 a_15870_15486# a_15671_15549# 0.08889f
C283 sg13cmos5l_dlygate4sd3_1_8.X sg13cmos5l_xnor2_1_2.A 0.06752f
C284 a_9963_15356# VDD 0.20809f
C285 sg13cmos5l_xnor2_1_2.B sg13cmos5l_xor2_1_0.B 0.02186f
C286 a_25930_14452# VDD 0.0966f
C287 a_7262_15242# sg13cmos5l_dlygate4sd3_1_8.X 0.01812f
C288 sg13cmos5l_a21oi_1_0.A2 sg13cmos5l_dfrbpq_1_2.Q 0.02237f
C289 a_14344_14570# sg13cmos5l_buf_1_10.X 0.03427f
C290 sg13cmos5l_o21ai_1_2.Y sg13cmos5l_dlygate4sd3_1_17.A 0.21213f
C291 sg13cmos5l_a21oi_1_3.B1 sg13cmos5l_or3_1_1.A 0.13946f
C292 a_24841_13726# VDD 0.26704f
C293 sg13cmos5l_o21ai_1_1.Y sg13cmos5l_dfrbpq_1_6.Q 0.01042f
C294 a_12010_15202# VDD 1.01037f
C295 a_25206_14508# sg13cmos5l_dfrbpq_1_7.D 0.01672f
C296 sg13cmos5l_nand3_1_0.Y sg13cmos5l_dlygate4sd3_1_3.A 0.01196f
C297 sg13cmos5l_dfrbpq_1_5.RESET_B sg13cmos5l_o21ai_1_2.B1 0.12304f
C298 sg13cmos5l_inv_1_0.A sg13cmos5l_dfrbpq_1_2.RESET_B 0.01762f
C299 a_15782_13722# a_16068_14040# 0.26205f
C300 sg13cmos5l_dfrbpq_1_1.RESET_B VDD 1.16726f
C301 a_21562_15960# VDD 0.26426f
C302 a_17604_14488# sg13cmos5l_a21oi_1_3.B1 0.03688f
C303 a_26436_13735# a_26565_13701# 0.01562f
C304 a_24923_15996# sg13cmos5l_a21oi_1_3.B1 0.01453f
C305 a_17327_13799# sg13cmos5l_or3_1_1.B 0.01909f
C306 a_25670_14922# sg13cmos5l_dfrbpq_1_5.RESET_B 0.04146f
C307 sg13cmos5l_xnor2_1_2.B sg13cmos5l_dfrbpq_1_2.CLK 0.02511f
C308 sg13cmos5l_buf_8_2.X sg13cmos5l_dfrbpq_1_7.D 0.01301f
C309 sg13cmos5l_a21oi_1_3.A2 sg13cmos5l_a21oi_1_3.A1 0.17776f
C310 a_24169_14508# sg13cmos5l_o21ai_1_2.Y 0.05936f
C311 a_24824_14525# a_24824_15238# 0.01163f
C312 VDD a_2824_16082# 0.12267f
C313 a_15671_15549# VDD 0.08776f
C314 a_21946_16237# sg13cmos5l_dfrbpq_1_6.RESET_B 0.04633f
C315 a_18106_15960# a_17825_16262# 0.18796f
C316 sg13cmos5l_a21oi_1_3.Y sg13cmos5l_a21oi_1_3.B1 0.63581f
C317 a_24841_13726# sg13cmos5l_or3_1_1.A 0.20349f
C318 a_24310_15230# sg13cmos5l_or3_1_1.C 0.11145f
C319 a_26122_13945# a_26148_14040# 0.24169f
C320 VDD sg13cmos5l_dlygate4sd3_1_1.A 0.97447f
C321 sg13cmos5l_dlygate4sd3_1_8.X a_7680_15549# 0.10198f
C322 sg13cmos5l_and2_1_2.X VDD 0.32197f
C323 a_17825_16262# sg13cmos5l_inv_1_0.Y 0.01405f
C324 sg13cmos5l_o21ai_1_3.Y sg13cmos5l_or3_1_1.C 0.05321f
C325 sg13cmos5l_a21oi_1_0.A1 sg13cmos5l_a21oi_1_0.Y 0.0944f
C326 a_26148_14040# a_27407_13799# 0.01412f
C327 a_17578_14452# sg13cmos5l_buf_8_2.A 0.01404f
C328 a_25206_15302# sg13cmos5l_a21oi_1_3.B1 0.01649f
C329 a_1965_14832# VDD 0.305f
C330 a_7829_15238# sg13cmos5l_xnor2_1_0.Y 0.02386f
C331 a_5613_14832# sg13cmos5l_and2_1_1.X 0.08726f
C332 sg13cmos5l_xnor2_1_2.B sg13cmos5l_dlygate4sd3_1_3.A 0.11793f
C333 sg13cmos5l_a21oi_1_3.Y a_25930_14452# 0.0453f
C334 a_17057_14832# sg13cmos5l_a21oi_1_0.A1 0.01159f
C335 a_20603_15532# sg13cmos5l_or3_1_2.X 0.06091f
C336 a_20774_14922# a_21477_14495# 0.02431f
C337 sg13cmos5l_xnor2_1_2.A VDD 0.73342f
C338 a_21060_14488# VDD 0.07667f
C339 sg13cmos5l_a21oi_1_3.A1 sg13cmos5l_o21ai_1_2.B1 0.02427f
C340 sg13cmos5l_o21ai_1_1.Y sg13cmos5l_or3_1_2.B 0.1545f
C341 a_25109_12972# sg13cmos5l_a21oi_1_3.A2 0.05791f
C342 a_17921_15424# VDD 0.20695f
C343 a_27407_13799# a_28074_14020# 0.09257f
C344 sg13cmos5l_dlygate4sd3_1_9.X sg13cmos5l_a21oi_1_3.B1 0.10511f
C345 a_2516_14484# VDD 0.14128f
C346 sg13cmos5l_a21oi_1_3.Y a_26244_14909# 0.01169f
C347 a_21477_14495# a_21348_14909# 0.01562f
C348 a_21060_14488# a_21579_14495# 0.20754f
C349 sg13cmos5l_dfrbpq_1_7.D sg13cmos5l_dfrbpq_1_5.D 0.03838f
C350 a_22319_14845# VDD 0.19988f
C351 sg13cmos5l_inv_1_0.A sg13cmos5l_inv_1_0.Y 0.12555f
C352 sg13cmos5l_or3_1_2.C VDD 0.6831f
C353 a_8582_15238# a_8694_15302# 0.3854f
C354 sg13cmos5l_dfrbpq_1_2.Q a_19169_15424# 0.0208f
C355 sg13cmos5l_dfrbpq_1_2.Q a_18586_15455# 0.04669f
C356 a_6280_13058# sg13cmos5l_dlygate4sd3_1_0.A 0.01639f
C357 a_17710_16263# VDD 0.16005f
C358 a_17806_15423# a_17921_15424# 0.3854f
C359 sg13cmos5l_dfrbpq_1_0.RESET_B a_3209_16334# 0.01409f
C360 a_9444_15552# sg13cmos5l_dfrbpq_1_2.CLK 0.08307f
C361 a_9444_15552# sg13cmos5l_nand4_1_0.Y 0.02334f
C362 a_21579_14495# a_22319_14845# 0.17382f
C363 a_27472_14726# a_27215_14845# 0.23043f
C364 sg13cmos5l_dlygate4sd3_1_8.X sg13cmos5l_dfrbpq_1_2.CLK 0.39427f
C365 sg13cmos5l_dlygate4sd3_1_8.X sg13cmos5l_nand4_1_0.Y 0.20079f
C366 sg13cmos5l_dfrbpq_1_5.RESET_B VDD 1.27461f
C367 sg13cmos5l_or3_1_2.C a_21579_14495# 0.01468f
C368 a_26170_16237# VDD 0.09144f
C369 sg13cmos5l_xor2_1_0.X VDD 0.14666f
C370 a_10960_15454# sg13cmos5l_nand4_1_0.Y 0.0126f
C371 sg13cmos5l_buf_8_2.A sg13cmos5l_dfrbpq_1_3.RESET_B 0.03701f
C372 a_25390_16263# sg13cmos5l_o21ai_1_3.Y 0.01565f
C373 a_7680_15549# VDD 0.1878f
C374 sg13cmos5l_buf_8_2.X a_26148_14040# 0.04861f
C375 sg13cmos5l_a21oi_1_3.B1 sg13cmos5l_or3_1_1.B 0.03473f
C376 clock_i sg13cmos5l_dlygate4sd3_1_8.A 0.08616f
C377 sg13cmos5l_buf_8_2.X a_19120_14726# 0.01548f
C378 a_27500_15960# a_27296_16082# 0.01689f
C379 counter_value_o[7] sg13cmos5l_dfrbpq_1_5.Q 0.01279f
C380 sg13cmos5l_dfrbpq_1_2.Q a_16168_15996# 0.01748f
C381 sg13cmos5l_dfrbpq_1_5.RESET_B sg13cmos5l_or3_1_1.A 0.02336f
C382 VDD sg13cmos5l_dfrbpq_1_0.RESET_B 1.2525f
C383 a_9732_15247# sg13cmos5l_dfrbpq_1_2.CLK 0.01421f
C384 sg13cmos5l_xor2_1_0.B VDD 0.49614f
C385 sg13cmos5l_dfrbpq_1_6.RESET_B sg13cmos5l_a21oi_1_3.B1 0.0175f
C386 a_21251_13690# sg13cmos5l_or3_1_1.B 0.02075f
C387 sg13cmos5l_or3_1_2.B a_20278_14862# 0.08485f
C388 sg13cmos5l_dfrbpq_1_7.Q a_27121_14845# 0.02056f
C389 sg13cmos5l_xnor2_1_2.B a_6401_13912# 0.03894f
C390 a_4078_14751# sg13cmos5l_xor2_1_0.B 0.11637f
C391 a_16856_15238# VDD 0.28158f
C392 a_17318_14922# a_17578_14452# 0.45119f
C393 a_21185_15424# sg13cmos5l_dfrbpq_1_6.RESET_B 0.04526f
C394 a_26554_16237# a_26757_16033# 0.02453f
C395 sg13cmos5l_dfrbpq_1_2.Q sg13cmos5l_dfrbpq_1_6.D 0.01319f
C396 sg13cmos5l_dlygate4sd3_1_8.X sg13cmos5l_nand3_1_0.Y 0.28523f
C397 a_15579_14854# VDD 0.86798f
C398 a_21034_14452# sg13cmos5l_or3_1_2.X 0.02296f
C399 a_24841_13726# sg13cmos5l_or3_1_1.B 0.16221f
C400 sg13cmos5l_a21oi_1_3.A1 VDD 0.28007f
C401 a_19816_15366# VDD 0.12937f
C402 a_19054_15423# VDD 0.15932f
C403 a_1965_14832# sg13cmos5l_and2_1_0.X 0.07702f
C404 a_2630_15234# a_3204_15247# 0.18486f
C405 a_24062_15242# sg13cmos5l_o21ai_1_2.B1 0.01812f
C406 a_22025_16334# a_22149_16033# 0.08186f
C407 a_24841_13726# a_25037_14020# 0.01485f
C408 sg13cmos5l_a21oi_1_3.Y sg13cmos5l_dfrbpq_1_5.RESET_B 0.50817f
C409 sg13cmos5l_or3_1_1.X sg13cmos5l_o21ai_1_3.Y 0.04258f
C410 a_2540_15960# a_2824_16082# 0.01225f
C411 sg13cmos5l_dfrbpq_1_2.CLK VDD 1.58512f
C412 a_9418_15457# sg13cmos5l_nand4_1_0.Y 0.01592f
C413 sg13cmos5l_nand4_1_0.Y VDD 1.02388f
C414 a_7537_14845# sg13cmos5l_dlygate4sd3_1_1.A 0.01546f
C415 a_2516_14484# sg13cmos5l_and2_1_0.X 0.03166f
C416 a_18202_15202# sg13cmos5l_dfrbpq_1_3.RESET_B 0.06264f
C417 a_4078_14751# sg13cmos5l_dfrbpq_1_2.CLK 0.01392f
C418 a_2630_15234# sg13cmos5l_dfrbpq_1_0.RESET_B 0.10309f
C419 sg13cmos5l_buf_8_2.X sg13cmos5l_dfrbpq_1_7.Q 0.1448f
C420 a_18021_14495# sg13cmos5l_buf_8_2.X 0.20547f
C421 a_21562_15960# sg13cmos5l_dfrbpq_1_6.RESET_B 0.04463f
C422 a_7822_13911# sg13cmos5l_dlygate4sd3_1_1.A 0.01022f
C423 a_16068_14040# sg13cmos5l_dfrbpq_1_2.RESET_B 0.30414f
C424 sg13cmos5l_o21ai_1_2.Y sg13cmos5l_dfrbpq_1_6.Q 0.02669f
C425 a_23638_14862# sg13cmos5l_o21ai_1_2.B1 0.02318f
C426 sg13cmos5l_or3_1_2.X a_21070_15423# 0.04119f
C427 a_25889_15424# a_26170_15202# 0.18796f
C428 sg13cmos5l_a21oi_1_3.A1 sg13cmos5l_or3_1_1.A 0.08765f
C429 a_25956_14488# a_27215_14845# 0.01412f
C430 a_25109_12972# VDD 0.21318f
C431 a_25774_15423# sg13cmos5l_dfrbpq_1_7.RESET_B 0.02935f
C432 a_17318_14922# sg13cmos5l_dfrbpq_1_3.RESET_B 0.10741f
C433 a_7822_13911# sg13cmos5l_xnor2_1_2.A 0.11116f
C434 VDD sg13cmos5l_dlygate4sd3_1_3.A 1.34734f
C435 a_8218_13690# VDD 0.29954f
C436 a_26475_14495# a_27215_14845# 0.17382f
C437 sg13cmos5l_xor2_1_0.X sg13cmos5l_and2_1_0.X 0.28573f
C438 a_9536_14570# sg13cmos5l_tiehi_1.L_HI 0.01076f
C439 a_38720_3986# VDD 0.0582f
C440 a_8685_14832# sg13cmos5l_and2_1_2.B 0.17752f
C441 sg13cmos5l_buf_8_2.A clock_i 0.02615f
C442 a_2916_15552# a_3435_15356# 0.20773f
C443 sg13cmos5l_dfrbpq_1_3.Q VDD 1.10993f
C444 a_3333_15213# a_3204_15247# 0.01562f
C445 a_9861_14521# a_10016_14570# 0.03131f
C446 a_20960_16082# VDD 0.08507f
C447 sg13cmos5l_a21oi_1_3.A1 sg13cmos5l_a21oi_1_3.Y 0.35f
C448 sg13cmos5l_nand3_1_0.Y VDD 0.70369f
C449 sg13cmos5l_buf_8_2.X a_19323_13726# 0.66336f
C450 a_25862_13722# VDD 0.53201f
C451 sg13cmos5l_and2_1_0.X sg13cmos5l_dfrbpq_1_0.RESET_B 0.07063f
C452 sg13cmos5l_dfrbpq_1_6.RESET_B a_21060_14488# 0.27212f
C453 a_3333_15213# sg13cmos5l_dfrbpq_1_0.RESET_B 0.03853f
C454 sg13cmos5l_or3_1_2.C sg13cmos5l_or3_1_1.B 0.09208f
C455 sg13cmos5l_and2_1_0.X sg13cmos5l_xor2_1_0.B 0.16893f
C456 sg13cmos5l_dfrbpq_1_2.RESET_B clock_i 0.18083f
C457 a_18123_14495# VDD 0.20905f
C458 sg13cmos5l_a21oi_1_3.B1 sg13cmos5l_a21oi_1_2.A1 0.05556f
C459 a_25206_15302# sg13cmos5l_a21oi_1_3.A1 0.11555f
C460 a_17825_16262# sg13cmos5l_dlygate4sd3_1_4.X 0.01299f
C461 a_27664_13942# VDD 0.14131f
C462 sg13cmos5l_o21ai_1_1.Y sg13cmos5l_a21oi_1_3.B1 0.03114f
C463 sg13cmos5l_dfrbpq_1_6.RESET_B a_22319_14845# 0.10879f
C464 sg13cmos5l_or3_1_2.C sg13cmos5l_dfrbpq_1_6.RESET_B 0.02463f
C465 sg13cmos5l_dfrbpq_1_6.Q sg13cmos5l_dfrbpq_1_5.Q 0.01209f
C466 a_11752_15366# sg13cmos5l_dlygate4sd3_1_8.A 0.03099f
C467 a_2630_15234# sg13cmos5l_dlygate4sd3_1_3.A 0.03756f
C468 sg13cmos5l_inv_1_0.Y a_16552_15996# 0.01509f
C469 a_4842_15532# sg13cmos5l_dlygate4sd3_1_3.A 0.12425f
C470 sg13cmos5l_dlygate4sd3_1_0.X sg13cmos5l_buf_1_10.X 0.06585f
C471 a_24824_15238# sg13cmos5l_o21ai_1_2.Y 0.27487f
C472 a_18586_15455# a_18665_15180# 0.08889f
C473 a_25109_12972# sg13cmos5l_a21oi_1_3.Y 0.10082f
C474 a_25786_15960# VDD 0.26183f
C475 a_9158_15234# a_9861_15213# 0.02453f
C476 a_38720_15366# VDD 0.09056f
C477 sg13cmos5l_dfrbpq_1_0.RESET_B a_2540_15960# 0.0105f
C478 a_3333_15213# sg13cmos5l_dfrbpq_1_2.CLK 0.20287f
C479 sg13cmos5l_buf_8_2.X sg13cmos5l_o21ai_1_2.A2 0.05556f
C480 sg13cmos5l_xnor2_1_2.B VDD 0.63659f
C481 VDD a_24408_15552# 0.01784f
C482 a_6660_14909# sg13cmos5l_xor2_1_0.B 0.023f
C483 a_9861_14521# a_9658_14725# 0.02453f
C484 a_27034_15202# sg13cmos5l_dfrbpq_1_6.Q 0.01446f
C485 a_6401_13912# VDD 0.20914f
C486 sg13cmos5l_and2_1_2.B sg13cmos5l_buf_1_10.X 0.19757f
C487 a_18123_14495# a_17604_14488# 0.20754f
C488 counter_value_o[4] a_22149_16033# 0.0172f
C489 sg13cmos5l_a21oi_1_0.A1 sg13cmos5l_a21oi_1_3.B1 0.06245f
C490 a_25956_14488# a_26373_14495# 0.28418f
C491 sg13cmos5l_or3_1_2.B a_16168_15996# 0.15767f
C492 sg13cmos5l_buf_8_2.A sg13cmos5l_dfrbpq_1_2.Q 0.04399f
C493 a_20376_14464# sg13cmos5l_or3_1_2.C 0.01238f
C494 sg13cmos5l_a21oi_1_3.A2 VDD 0.40843f
C495 a_32200_16082# VDD 0.1695f
C496 a_26554_16237# a_26633_16334# 0.08889f
C497 a_25505_16262# a_25390_16263# 0.3854f
C498 a_15579_14854# sg13cmos5l_or3_1_1.B 0.05153f
C499 a_10703_15311# a_11370_15532# 0.09257f
C500 sg13cmos5l_a21oi_1_3.A1 sg13cmos5l_or3_1_1.B 0.01717f
C501 a_26373_14495# a_26475_14495# 0.3643f
C502 sg13cmos5l_and2_1_0.X sg13cmos5l_dlygate4sd3_1_3.A 0.01628f
C503 a_6891_14495# a_6086_14922# 0.07916f
C504 sg13cmos5l_or3_1_2.B sg13cmos5l_dfrbpq_1_6.D 0.02411f
C505 a_9444_15552# a_9732_15247# 0.24435f
C506 a_3333_15213# sg13cmos5l_dlygate4sd3_1_3.A 0.01794f
C507 a_7888_14726# a_7631_14845# 0.23043f
C508 clock_i sg13cmos5l_inv_1_0.Y 0.06063f
C509 sg13cmos5l_a21oi_1_1.Y a_22025_16334# 0.01284f
C510 a_1192_9948# reset_n_i 0.19796f
C511 a_20278_14862# sg13cmos5l_a21oi_1_3.B1 0.01435f
C512 sg13cmos5l_dfrbpq_1_2.CLK sg13cmos5l_or3_1_1.B 0.21155f
C513 sg13cmos5l_nand4_1_0.Y sg13cmos5l_or3_1_1.B 0.01086f
C514 sg13cmos5l_dfrbpq_1_3.Q sg13cmos5l_dlygate4sd3_1_9.X 0.01028f
C515 a_6086_14922# a_6346_14452# 0.45119f
C516 sg13cmos5l_buf_8_2.X a_22576_14726# 0.0155f
C517 a_7631_14845# a_6372_14488# 0.01412f
C518 a_16485_13701# sg13cmos5l_dfrbpq_1_2.CLK 0.22095f
C519 sg13cmos5l_a21oi_1_3.A2 sg13cmos5l_or3_1_1.A 0.11755f
C520 sg13cmos5l_or3_1_2.A a_21034_14452# 0.02529f
C521 a_16955_14484# sg13cmos5l_a21oi_1_0.Y 0.0998f
C522 VDD sg13cmos5l_o21ai_1_2.B1 0.449f
C523 a_6372_14488# a_6789_14495# 0.28418f
C524 sg13cmos5l_a21oi_1_0.A2 sg13cmos5l_a21oi_1_3.B1 0.02675f
C525 a_18021_14495# a_17578_14452# 0.02241f
C526 a_9158_15234# sg13cmos5l_tiehi_1.L_HI 0.08086f
C527 a_9444_15552# a_9418_15457# 0.24169f
C528 a_2540_15960# sg13cmos5l_dlygate4sd3_1_3.A 0.19598f
C529 a_19120_14726# sg13cmos5l_dfrbpq_1_3.RESET_B 0.09622f
C530 a_9444_15552# VDD 0.0722f
C531 sg13cmos5l_o21ai_1_1.Y a_21060_14488# 0.0268f
C532 a_25670_14922# VDD 0.52312f
C533 sg13cmos5l_dlygate4sd3_1_8.X VDD 0.35396f
C534 clock_i sg13cmos5l_nor2_1_0.B 0.09977f
C535 a_25505_16262# sg13cmos5l_or3_1_1.X 0.01201f
C536 sg13cmos5l_dfrbpq_1_2.Q a_18202_15202# 0.34354f
C537 sg13cmos5l_buf_8_2.X sg13cmos5l_dfrbpq_1_7.RESET_B 0.0607f
C538 sg13cmos5l_dfrbpq_1_2.D clock_i 0.02532f
C539 a_10703_15311# sg13cmos5l_tiehi_1.L_HI 0.1087f
C540 a_10960_15454# VDD 0.13649f
C541 a_38536_13854# a_38720_13854# 0.05762f
C542 sg13cmos5l_inv_1_0.A a_15671_15315# 0.03242f
C543 a_16042_13945# a_16068_14040# 0.24169f
C544 a_20705_15260# sg13cmos5l_dlygate4sd3_1_9.X 0.01276f
C545 sg13cmos5l_or3_1_2.C sg13cmos5l_o21ai_1_1.Y 0.03402f
C546 a_23552_14570# sg13cmos5l_or3_1_2.B 0.0358f
C547 sg13cmos5l_o21ai_1_2.B1 sg13cmos5l_or3_1_1.A 0.03039f
C548 a_5600_15366# VDD 0.09581f
C549 sg13cmos5l_dfrbpq_1_7.RESET_B sg13cmos5l_or3_1_1.X 0.01339f
C550 a_26436_13735# a_25862_13722# 0.18486f
C551 a_24520_13854# a_24704_13854# 0.05762f
C552 a_16969_16020# a_17063_16020# 0.02103f
C553 a_17318_14922# sg13cmos5l_dfrbpq_1_2.Q 0.02985f
C554 VDD a_3209_16334# 0.10631f
C555 a_15870_15486# VDD 0.09411f
C556 VDD a_23168_15366# 0.10558f
C557 sg13cmos5l_dfrbpq_1_2.Q sg13cmos5l_inv_1_0.Y 0.06528f
C558 sg13cmos5l_dfrbpq_1_6.RESET_B sg13cmos5l_dfrbpq_1_3.Q 0.02561f
C559 a_21946_16237# a_22149_16033# 0.02453f
C560 a_17327_13799# a_17584_13942# 0.23043f
C561 sg13cmos5l_buf_8_2.X sg13cmos5l_or3_1_2.X 0.02259f
C562 a_8298_14484# sg13cmos5l_buf_1_10.X 0.03737f
C563 a_18021_14495# sg13cmos5l_dfrbpq_1_3.RESET_B 0.04294f
C564 sg13cmos5l_buf_8_2.A sg13cmos5l_a21oi_1_0.Y 0.21299f
C565 sg13cmos5l_a21oi_1_3.Y sg13cmos5l_o21ai_1_2.B1 0.05014f
C566 sg13cmos5l_dlygate4sd3_1_4.X sg13cmos5l_dfrbpq_1_3.RESET_B 0.01938f
C567 a_17710_16263# sg13cmos5l_a21oi_1_0.A1 0.10824f
C568 a_26565_13701# a_26667_13844# 0.36168f
C569 sg13cmos5l_a21oi_1_3.Y a_25670_14922# 0.04949f
C570 sg13cmos5l_or3_1_2.A sg13cmos5l_or3_1_2.X 0.55116f
C571 a_20774_14922# a_21034_14452# 0.45119f
C572 a_8694_15302# sg13cmos5l_and2_1_2.X 0.02064f
C573 a_21466_15202# sg13cmos5l_or3_1_2.B 0.05836f
C574 a_9418_15457# VDD 0.1001f
C575 sg13cmos5l_inv_1_0.A sg13cmos5l_dfrbpq_1_3.D 0.1171f
C576 a_18863_14845# a_19530_14484# 0.09257f
C577 sg13cmos5l_o21ai_1_2.Y sg13cmos5l_a21oi_1_3.B1 0.01177f
C578 a_4078_14751# VDD 0.15946f
C579 a_10337_14750# sg13cmos5l_dlygate4sd3_1_8.X 0.01066f
C580 a_21579_14495# VDD 0.21266f
C581 a_25094_14484# VDD 0.20607f
C582 sg13cmos5l_or3_1_2.C a_20278_14862# 0.06102f
C583 a_25025_16344# sg13cmos5l_a21oi_1_2.A1 0.01276f
C584 a_17806_15423# VDD 0.1592f
C585 sg13cmos5l_a21oi_1_3.A2 sg13cmos5l_or3_1_1.B 0.10458f
C586 a_20968_13854# sg13cmos5l_or3_1_2.X 0.02112f
C587 counter_value_o[2] sg13cmos5l_dlygate4sd3_1_8.A 0.01367f
C588 counter_value_o[5] a_27296_16082# 0.01377f
C589 sg13cmos5l_and2_1_1.X sg13cmos5l_buf_1_10.X 0.04042f
C590 sg13cmos5l_buf_8_2.X sg13cmos5l_or3_1_1.C 0.01896f
C591 a_26753_15424# a_27034_15202# 0.18796f
C592 VDD sg13cmos5l_or3_1_1.A 0.48327f
C593 sg13cmos5l_a21oi_1_1.Y sg13cmos5l_or3_1_2.B 0.39227f
C594 sg13cmos5l_a21oi_1_0.A1 a_16856_15238# 0.067f
C595 a_17238_15302# sg13cmos5l_dfrbpq_1_3.D 0.12541f
C596 sg13cmos5l_o21ai_1_3.Y sg13cmos5l_dlygate4sd3_1_17.A 0.0459f
C597 a_17604_14488# VDD 0.07286f
C598 a_2630_15234# VDD 0.54684f
C599 a_4842_15532# VDD 0.28434f
C600 a_24923_15996# VDD 0.16154f
C601 a_25094_14484# sg13cmos5l_or3_1_1.A 0.0598f
C602 a_4193_14750# sg13cmos5l_xor2_1_0.B 0.01654f
C603 sg13cmos5l_inv_1_0.A a_16140_15424# 0.01251f
C604 sg13cmos5l_buf_1_10.X clock_i 0.01285f
C605 a_18106_15960# sg13cmos5l_dlygate4sd3_1_5.A 0.28314f
C606 a_7537_14845# sg13cmos5l_dlygate4sd3_1_8.X 0.02247f
C607 a_17892_14909# a_18123_14495# 0.07823f
C608 a_18021_14495# a_18769_14845# 0.01058f
C609 sg13cmos5l_dfrbpq_1_3.Q a_22145_15424# 0.01469f
C610 sg13cmos5l_o21ai_1_2.B1 sg13cmos5l_or3_1_1.B 0.03172f
C611 counter_value_o[7] a_37484_15960# 0.15504f
C612 a_8582_15238# a_8312_15238# 0.18796f
C613 sg13cmos5l_a21oi_1_0.A1 sg13cmos5l_dfrbpq_1_2.CLK 0.27031f
C614 sg13cmos5l_a21oi_1_3.Y VDD 0.39493f
C615 sg13cmos5l_dfrbpq_1_6.D sg13cmos5l_a21oi_1_3.B1 0.04716f
C616 sg13cmos5l_dlygate4sd3_1_5.A sg13cmos5l_inv_1_0.Y 0.2384f
C617 sg13cmos5l_dfrbpq_1_7.Q a_27215_14845# 0.0476f
C618 a_27502_15423# sg13cmos5l_dfrbpq_1_7.Q 0.01894f
C619 sg13cmos5l_inv_1_0.Y sg13cmos5l_a21oi_1_0.Y 0.02996f
C620 a_7631_14845# sg13cmos5l_dfrbpq_1_1.RESET_B 0.10879f
C621 a_16485_13701# a_17233_13799# 0.01058f
C622 a_26373_16033# a_26554_16237# 0.04141f
C623 a_23368_14570# a_23552_14570# 0.05762f
C624 a_14261_15238# sg13cmos5l_dfrbpq_1_2.CLK 0.01831f
C625 a_14261_15238# sg13cmos5l_nand4_1_0.Y 0.23765f
C626 a_10337_14750# VDD 0.20387f
C627 a_20774_14922# sg13cmos5l_or3_1_2.X 0.02499f
C628 sg13cmos5l_or3_1_2.B a_21477_14495# 0.01108f
C629 a_25206_15302# VDD 0.16099f
C630 a_4193_14750# sg13cmos5l_dfrbpq_1_2.CLK 0.01906f
C631 a_6789_14495# sg13cmos5l_dfrbpq_1_1.RESET_B 0.03692f
C632 a_16856_15238# a_17126_15238# 0.18796f
C633 a_24824_14525# sg13cmos5l_a21oi_1_3.A2 0.06269f
C634 a_26170_15202# sg13cmos5l_dfrbpq_1_5.RESET_B 0.02237f
C635 sg13cmos5l_or3_1_1.X a_25390_16263# 0.03003f
C636 sg13cmos5l_and2_1_0.X VDD 0.30117f
C637 sg13cmos5l_a21oi_1_3.Y sg13cmos5l_or3_1_1.A 0.01853f
C638 a_3333_15213# VDD 0.28955f
C639 sg13cmos5l_dlygate4sd3_1_9.X VDD 0.18623f
C640 a_7631_14845# sg13cmos5l_dlygate4sd3_1_1.A 0.04295f
C641 a_18106_15960# sg13cmos5l_or3_1_2.B 0.01302f
C642 a_4175_15311# sg13cmos5l_dfrbpq_1_0.RESET_B 0.10904f
C643 sg13cmos5l_buf_8_2.X a_25206_14508# 0.01098f
C644 sg13cmos5l_a21oi_1_1.Y a_21946_16237# 0.03498f
C645 a_7680_15549# sg13cmos5l_xnor2_1_0.Y 0.14663f
C646 a_6789_14495# sg13cmos5l_dlygate4sd3_1_1.A 0.01319f
C647 a_8694_15302# sg13cmos5l_nand4_1_0.Y 0.0137f
C648 a_25206_15302# sg13cmos5l_or3_1_1.A 0.01524f
C649 sg13cmos5l_or3_1_2.B sg13cmos5l_inv_1_0.Y 0.96765f
C650 a_25206_14508# sg13cmos5l_or3_1_1.X 0.04711f
C651 sg13cmos5l_dfrbpq_1_3.D sg13cmos5l_dfrbpq_1_3.RESET_B 0.09733f
C652 a_5504_14570# VDD 0.08633f
C653 a_18863_14845# sg13cmos5l_buf_8_2.A 0.01736f
C654 a_17327_13799# sg13cmos5l_dfrbpq_1_2.RESET_B 0.10868f
C655 VDD a_2540_15960# 0.19767f
C656 a_7822_13911# VDD 0.16525f
C657 a_6789_14495# sg13cmos5l_xnor2_1_2.A 0.02956f
C658 sg13cmos5l_buf_8_2.X sg13cmos5l_or3_1_1.X 0.02628f
C659 a_9658_14725# sg13cmos5l_tiehi_1.L_HI 0.06039f
C660 a_9963_15356# sg13cmos5l_dlygate4sd3_1_8.A 0.0308f
C661 a_1192_3900# VDD 0.18614f
C662 a_23480_15242# sg13cmos5l_o21ai_1_2.A2 0.01468f
C663 sg13cmos5l_and2_1_0.X a_2630_15234# 0.18471f
C664 a_3435_15356# a_4432_15454# 0.03412f
C665 a_2630_15234# a_3333_15213# 0.02453f
C666 sg13cmos5l_buf_8_2.X sg13cmos5l_or3_1_2.A 0.58091f
C667 VDD sg13cmos5l_or3_1_1.B 1.88587f
C668 a_18021_14495# sg13cmos5l_dfrbpq_1_2.Q 0.02098f
C669 a_16485_13701# VDD 0.27675f
C670 counter_value_o[3] sg13cmos5l_inv_1_0.Y 0.15994f
C671 a_6280_13058# VDD 0.16648f
C672 sg13cmos5l_dfrbpq_1_2.Q sg13cmos5l_dlygate4sd3_1_4.X 0.07532f
C673 a_12010_15202# sg13cmos5l_dlygate4sd3_1_8.A 0.02872f
C674 sg13cmos5l_or3_1_2.B sg13cmos5l_nor2_1_0.B 0.03734f
C675 a_2890_15457# sg13cmos5l_dfrbpq_1_0.RESET_B 0.20779f
C676 sg13cmos5l_dfrbpq_1_6.D a_21060_14488# 0.03479f
C677 sg13cmos5l_dfrbpq_1_6.RESET_B VDD 1.15314f
C678 a_26373_14495# sg13cmos5l_dfrbpq_1_7.Q 0.01321f
C679 a_25206_14508# sg13cmos5l_dfrbpq_1_5.D 0.10738f
C680 sg13cmos5l_nand4_1_0.Y sg13cmos5l_xnor2_1_0.Y 0.04658f
C681 a_15671_15315# clock_i 0.02493f
C682 sg13cmos5l_dfrbpq_1_6.RESET_B a_21579_14495# 0.27969f
C683 sg13cmos5l_or3_1_1.A sg13cmos5l_or3_1_1.B 0.12822f
C684 a_10609_15311# sg13cmos5l_dlygate4sd3_1_8.A 0.0173f
C685 sg13cmos5l_buf_8_2.X sg13cmos5l_dfrbpq_1_5.D 0.07404f
C686 a_4175_15311# sg13cmos5l_dlygate4sd3_1_3.A 0.04571f
C687 a_24169_14508# sg13cmos5l_o21ai_1_2.A2 0.15962f
C688 a_21185_15424# a_21466_15202# 0.18796f
C689 a_18789_15277# a_18665_15180# 0.08186f
C690 a_19054_15423# a_19169_15424# 0.3854f
C691 a_27882_14484# VDD 0.28095f
C692 a_27617_15424# VDD 0.20604f
C693 sg13cmos5l_dlygate4sd3_1_0.X a_6080_13854# 0.01464f
C694 a_22225_14845# a_21060_14488# 0.25046f
C695 sg13cmos5l_buf_1_10.X a_1856_14570# 0.02603f
C696 a_20376_14464# VDD 0.01867f
C697 a_26667_13844# sg13cmos5l_dfrbpq_1_5.RESET_B 0.28617f
C698 sg13cmos5l_buf_8_2.A sg13cmos5l_a21oi_1_3.B1 0.56082f
C699 a_5896_13854# VDD 0.14015f
C700 sg13cmos5l_a21oi_1_1.Y sg13cmos5l_a21oi_1_3.B1 0.23211f
C701 a_25930_14452# a_25956_14488# 0.24169f
C702 sg13cmos5l_nand3_1_0.Y sg13cmos5l_xnor2_1_0.Y 0.05205f
C703 a_22225_14845# a_22319_14845# 0.16704f
C704 a_24824_14525# VDD 0.2598f
C705 sg13cmos5l_dfrbpq_1_5.RESET_B a_26633_16334# 0.01098f
C706 a_26373_16033# a_26249_16334# 0.08186f
C707 sg13cmos5l_dfrbpq_1_2.RESET_B sg13cmos5l_a21oi_1_3.B1 0.03328f
C708 a_16175_15238# sg13cmos5l_or3_1_1.B 0.02065f
C709 a_25956_14488# a_26244_14909# 0.24435f
C710 a_2890_15457# sg13cmos5l_dlygate4sd3_1_3.A 0.01478f
C711 a_24824_14525# a_25094_14484# 0.18796f
C712 sg13cmos5l_dfrbpq_1_2.D a_15680_13854# 0.03989f
C713 sg13cmos5l_buf_8_2.X a_20774_14922# 0.01038f
C714 sg13cmos5l_dfrbpq_1_1.RESET_B sg13cmos5l_buf_1_0.X 0.16585f
C715 a_6891_14495# a_7888_14726# 0.03546f
C716 a_5687_15315# a_5600_15366# 0.03131f
C717 a_5886_15486# a_5687_15549# 0.08889f
C718 sg13cmos5l_dfrbpq_1_2.Q sg13cmos5l_o21ai_1_2.A2 0.02634f
C719 a_6789_14495# sg13cmos5l_dfrbpq_1_2.CLK 0.2273f
C720 sg13cmos5l_or3_1_2.B a_16969_16020# 0.17174f
C721 sg13cmos5l_dfrbpq_1_7.RESET_B a_27215_14845# 0.10879f
C722 a_12010_15202# sg13cmos5l_buf_8_2.A 0.34017f
C723 sg13cmos5l_dfrbpq_1_6.Q sg13cmos5l_dfrbpq_1_7.Q 0.04426f
C724 a_26244_14909# a_26475_14495# 0.07823f
C725 a_6891_14495# a_6372_14488# 0.20754f
C726 counter_value_o[6] a_32492_15960# 0.15504f
C727 a_24824_14525# sg13cmos5l_or3_1_1.A 0.0282f
C728 sg13cmos5l_or3_1_2.A a_20774_14922# 0.03212f
C729 VDD a_22145_15424# 0.21275f
C730 a_21562_15960# sg13cmos5l_a21oi_1_1.Y 0.28648f
C731 sg13cmos5l_dlygate4sd3_1_5.A sg13cmos5l_dlygate4sd3_1_4.X 0.24548f
C732 sg13cmos5l_a21oi_1_2.A1 VDD 0.17436f
C733 a_6346_14452# a_6372_14488# 0.24169f
C734 sg13cmos5l_buf_1_0.X sg13cmos5l_dlygate4sd3_1_1.A 0.27666f
C735 a_24310_15230# sg13cmos5l_or3_1_2.B 0.07683f
C736 a_11370_15532# a_11752_15366# 0.01648f
C737 sg13cmos5l_or3_1_2.A a_21348_14909# 0.01104f
C738 counter_value_o[3] a_16969_16020# 0.08229f
C739 sg13cmos5l_o21ai_1_1.Y VDD 0.29617f
C740 a_5613_14832# sg13cmos5l_dfrbpq_1_2.CLK 0.01227f
C741 a_10222_14751# sg13cmos5l_buf_1_10.X 0.01427f
C742 sg13cmos5l_or3_1_2.B sg13cmos5l_o21ai_1_3.Y 0.05035f
C743 a_17892_14909# a_17604_14488# 0.24435f
C744 a_19232_13854# VDD 0.06399f
C745 a_9658_14725# a_9536_14570# 0.01854f
C746 a_3130_16237# a_3333_16033# 0.02453f
C747 a_2824_16082# a_3008_16082# 0.05762f
C748 a_9158_15234# sg13cmos5l_and2_1_2.B 0.02349f
C749 a_22986_14484# a_22576_14726# 0.07015f
C750 a_15671_15549# sg13cmos5l_dfrbpq_1_2.RESET_B 0.01966f
C751 sg13cmos5l_buf_1_0.X sg13cmos5l_xnor2_1_2.A 0.16524f
C752 a_23736_14464# VDD 0.01784f
C753 a_5687_15315# VDD 0.07168f
C754 a_20000_15366# sg13cmos5l_dfrbpq_1_2.Q 0.02435f
C755 a_17318_14922# sg13cmos5l_a21oi_1_3.B1 0.01499f
C756 sg13cmos5l_dfrbpq_1_2.Q sg13cmos5l_dfrbpq_1_3.D 0.01008f
C757 a_2516_14484# sg13cmos5l_buf_1_0.X 0.01414f
C758 a_24824_15238# sg13cmos5l_o21ai_1_3.Y 0.03926f
C759 a_16485_13701# sg13cmos5l_or3_1_1.B 0.02104f
C760 a_16068_14040# a_16587_13844# 0.20773f
C761 a_6540_13238# a_6575_13342# 0.19075f
C762 a_23638_14862# sg13cmos5l_o21ai_1_2.Y 0.06016f
C763 a_22508_15960# a_22304_16082# 0.01689f
C764 sg13cmos5l_or3_1_2.B sg13cmos5l_dlygate4sd3_1_4.X 0.18148f
C765 sg13cmos5l_a21oi_1_0.A1 VDD 0.33029f
C766 sg13cmos5l_dfrbpq_1_6.D sg13cmos5l_dfrbpq_1_3.Q 0.01666f
C767 a_24923_15996# sg13cmos5l_a21oi_1_2.A1 0.0686f
C768 sg13cmos5l_dfrbpq_1_6.D a_20960_16082# 0.01243f
C769 sg13cmos5l_dfrbpq_1_2.CLK sg13cmos5l_dlygate4sd3_1_8.A 0.11676f
C770 sg13cmos5l_nand4_1_0.Y sg13cmos5l_dlygate4sd3_1_8.A 0.30072f
C771 a_15338_14484# sg13cmos5l_dfrbpq_1_2.D 0.01367f
C772 a_25956_14488# sg13cmos5l_dfrbpq_1_5.RESET_B 0.01473f
C773 a_37484_15960# a_37192_16082# 0.01635f
C774 sg13cmos5l_a21oi_1_3.A2 sg13cmos5l_o21ai_1_2.Y 0.04308f
C775 a_7888_14726# sg13cmos5l_buf_1_10.X 0.01264f
C776 a_26170_15202# sg13cmos5l_o21ai_1_2.B1 0.05397f
C777 a_14261_15238# VDD 0.49384f
C778 sg13cmos5l_dlygate4sd3_1_4.X a_18665_15180# 0.04007f
C779 a_19530_14484# sg13cmos5l_dfrbpq_1_3.Q 0.08004f
C780 a_25094_15238# sg13cmos5l_or3_1_1.X 0.04107f
C781 sg13cmos5l_dfrbpq_1_7.D sg13cmos5l_a21oi_1_3.B1 0.26997f
C782 a_4193_14750# VDD 0.20555f
C783 a_26148_14040# a_26565_13701# 0.28324f
C784 a_25862_13722# a_26667_13844# 0.07916f
C785 a_26475_14495# sg13cmos5l_dfrbpq_1_5.RESET_B 0.02481f
C786 a_16955_14484# sg13cmos5l_dfrbpq_1_2.CLK 0.02772f
C787 a_26373_14495# sg13cmos5l_dfrbpq_1_7.RESET_B 0.03634f
C788 sg13cmos5l_buf_1_0.X a_3204_15247# 0.01531f
C789 a_6372_14488# sg13cmos5l_buf_1_10.X 0.01881f
C790 sg13cmos5l_nor2_1_0.B sg13cmos5l_a21oi_1_3.B1 0.08511f
C791 a_4193_14750# a_4078_14751# 0.3854f
C792 sg13cmos5l_dfrbpq_1_6.Q sg13cmos5l_o21ai_1_2.A2 0.19177f
C793 sg13cmos5l_dlygate4sd3_1_8.X sg13cmos5l_xnor2_1_0.Y 0.01362f
C794 a_1192_9948# sg13cmos5l_buf_1_10.X 0.15509f
C795 sg13cmos5l_buf_8_2.X sg13cmos5l_dfrbpq_1_3.RESET_B 0.01196f
C796 a_1965_14832# a_2490_14447# 0.01705f
C797 a_20278_14862# VDD 0.01267f
C798 sg13cmos5l_inv_1_0.A a_17238_15302# 0.01275f
C799 sg13cmos5l_dfrbpq_1_2.D sg13cmos5l_a21oi_1_3.B1 0.08258f
C800 sg13cmos5l_dfrbpq_1_2.Q a_16140_15424# 0.03116f
C801 a_26667_13844# a_27664_13942# 0.03412f
C802 a_19120_14726# a_18863_14845# 0.23043f
C803 sg13cmos5l_buf_1_0.X sg13cmos5l_dfrbpq_1_0.RESET_B 0.05907f
C804 counter_value_o[1] a_7532_15960# 0.15504f
C805 a_2490_14447# a_2516_14484# 0.21976f
C806 a_24169_14508# sg13cmos5l_or3_1_1.C 0.03594f
C807 a_21060_14488# a_21477_14495# 0.28418f
C808 sg13cmos5l_buf_1_0.X sg13cmos5l_xor2_1_0.B 0.67613f
C809 a_20774_14922# a_21348_14909# 0.18486f
C810 a_15671_15549# sg13cmos5l_inv_1_0.Y 0.01387f
C811 sg13cmos5l_dfrbpq_1_2.Q sg13cmos5l_or3_1_2.X 0.33145f
C812 sg13cmos5l_o21ai_1_2.Y sg13cmos5l_o21ai_1_2.B1 0.55898f
C813 a_8694_15302# VDD 0.15959f
C814 sg13cmos5l_a21oi_1_0.A2 VDD 0.3392f
C815 a_17126_15238# VDD 0.20971f
C816 a_17921_15424# a_18202_15202# 0.18796f
C817 counter_value_o[2] a_12524_15960# 0.15504f
C818 a_15579_14854# sg13cmos5l_buf_8_2.A 0.68123f
C819 sg13cmos5l_o21ai_1_3.Y a_26249_16334# 0.01284f
C820 a_27215_14845# a_27121_14845# 0.16704f
C821 sg13cmos5l_buf_1_0.X sg13cmos5l_dfrbpq_1_2.CLK 0.05368f
C822 sg13cmos5l_nand4_1_0.Y sg13cmos5l_buf_1_0.X 0.0546f
C823 a_4175_15311# VDD 0.17883f
C824 sg13cmos5l_xor2_1_0.X a_2490_14447# 0.14671f
C825 a_26757_16033# VDD 0.07049f
C826 sg13cmos5l_or3_1_2.B sg13cmos5l_o21ai_1_2.A2 0.55335f
C827 sg13cmos5l_buf_8_2.A sg13cmos5l_dfrbpq_1_2.CLK 0.3488f
C828 sg13cmos5l_buf_8_2.A sg13cmos5l_nand4_1_0.Y 0.03656f
C829 a_15579_14854# sg13cmos5l_dfrbpq_1_2.RESET_B 0.11274f
C830 sg13cmos5l_xnor2_1_0.Y VDD 0.31635f
C831 enable_i VDD 0.25464f
C832 a_26170_15202# VDD 0.25937f
C833 a_6789_14495# sg13cmos5l_dlygate4sd3_1_8.X 0.01594f
C834 a_16356_13735# sg13cmos5l_or3_1_1.B 0.01005f
C835 a_9737_14822# sg13cmos5l_dlygate4sd3_1_8.X 0.02198f
C836 a_12524_15960# a_12232_16082# 0.01635f
C837 counter_value_o[0] VDD 0.11896f
C838 a_2490_14447# sg13cmos5l_xor2_1_0.B 0.22356f
C839 a_6891_14495# sg13cmos5l_dfrbpq_1_1.RESET_B 0.28013f
C840 a_16485_13701# a_16356_13735# 0.01562f
C841 sg13cmos5l_dfrbpq_1_7.RESET_B sg13cmos5l_dfrbpq_1_6.Q 0.01935f
C842 a_6286_13911# a_6080_13854# 0.01604f
C843 a_26170_16237# a_26373_16033# 0.02453f
C844 sg13cmos5l_dfrbpq_1_2.RESET_B sg13cmos5l_dfrbpq_1_2.CLK 0.04617f
C845 sg13cmos5l_buf_1_0.X sg13cmos5l_dlygate4sd3_1_3.A 0.67869f
C846 a_10618_14448# VDD 0.28771f
C847 sg13cmos5l_inv_1_0.A sg13cmos5l_dfrbpq_1_3.RESET_B 0.03151f
C848 sg13cmos5l_or3_1_2.B a_21034_14452# 0.03049f
C849 sg13cmos5l_buf_8_2.X sg13cmos5l_dlygate4sd3_1_17.A 0.02847f
C850 a_6346_14452# sg13cmos5l_dfrbpq_1_1.RESET_B 0.18209f
C851 sg13cmos5l_o21ai_1_1.Y sg13cmos5l_dfrbpq_1_6.RESET_B 0.02262f
C852 a_6682_13690# sg13cmos5l_dlygate4sd3_1_0.A 0.31148f
C853 a_4175_15311# a_4842_15532# 0.09257f
C854 sg13cmos5l_or3_1_1.X sg13cmos5l_dlygate4sd3_1_17.A 0.05473f
C855 sg13cmos5l_nand3_1_0.Y sg13cmos5l_buf_1_0.X 0.18201f
C856 a_2890_15457# VDD 0.10858f
C857 a_26170_15202# sg13cmos5l_or3_1_1.A 0.01215f
C858 a_19169_15424# VDD 0.21183f
C859 a_18586_15455# VDD 0.09516f
C860 sg13cmos5l_o21ai_1_2.Y VDD 0.33363f
C861 a_6891_14495# sg13cmos5l_dlygate4sd3_1_1.A 0.03657f
C862 a_16140_15424# sg13cmos5l_a21oi_1_0.Y 0.03336f
C863 sg13cmos5l_a21oi_1_1.Y sg13cmos5l_dfrbpq_1_3.Q 0.01499f
C864 a_21562_15960# a_21281_16262# 0.18796f
C865 a_25889_15424# sg13cmos5l_dfrbpq_1_7.RESET_B 0.08041f
C866 sg13cmos5l_a21oi_1_3.B1 sg13cmos5l_o21ai_1_3.Y 0.37884f
C867 sg13cmos5l_buf_1_10.X sg13cmos5l_a21oi_1_3.B1 0.10047f
C868 reset_n_i VDD 0.14588f
C869 a_8685_14832# sg13cmos5l_dlygate4sd3_1_1.A 0.06006f
C870 a_6891_14495# sg13cmos5l_xnor2_1_2.A 0.06395f
C871 a_8685_14832# sg13cmos5l_and2_1_2.X 0.07413f
C872 a_7532_15960# sg13cmos5l_dlygate4sd3_1_1.A 0.19272f
C873 a_18123_14495# sg13cmos5l_buf_8_2.A 0.02096f
C874 a_7631_14845# VDD 0.17872f
C875 a_14261_15238# sg13cmos5l_or3_1_1.B 0.25178f
C876 a_20376_14464# sg13cmos5l_o21ai_1_1.Y 0.01087f
C877 a_15579_14854# sg13cmos5l_inv_1_0.Y 0.02441f
C878 a_26170_15202# sg13cmos5l_a21oi_1_3.Y 0.28819f
C879 sg13cmos5l_o21ai_1_2.Y sg13cmos5l_or3_1_1.A 0.04759f
C880 a_26373_14495# a_27121_14845# 0.01058f
C881 a_18021_14495# sg13cmos5l_a21oi_1_3.B1 0.01249f
C882 a_6789_14495# VDD 0.24623f
C883 a_38536_10034# VDD 0.1399f
C884 a_9444_15552# sg13cmos5l_dlygate4sd3_1_8.A 0.02593f
C885 a_9737_14822# VDD 0.0769f
C886 a_2890_15457# a_2630_15234# 0.45119f
C887 VDD a_16168_15996# 0.22709f
C888 a_17578_14452# sg13cmos5l_dfrbpq_1_3.RESET_B 0.19309f
C889 sg13cmos5l_xnor2_1_2.B sg13cmos5l_buf_1_0.X 0.22918f
C890 sg13cmos5l_inv_1_0.Y sg13cmos5l_dfrbpq_1_2.CLK 0.01047f
C891 a_25774_15423# a_25889_15424# 0.3854f
C892 a_38720_13854# VDD 0.05657f
C893 a_15782_13722# VDD 0.52997f
C894 a_24704_13854# VDD 0.06781f
C895 a_10960_15454# sg13cmos5l_dlygate4sd3_1_8.A 0.01793f
C896 sg13cmos5l_buf_1_10.X sg13cmos5l_dfrbpq_1_1.RESET_B 0.02402f
C897 sg13cmos5l_or3_1_2.B a_16140_15424# 0.23811f
C898 sg13cmos5l_dlygate4sd3_1_0.X sg13cmos5l_and2_1_1.X 0.05101f
C899 a_10618_14448# a_10337_14750# 0.18796f
C900 a_24169_14508# a_24263_14508# 0.02103f
C901 a_22149_16033# VDD 0.06428f
C902 a_8312_15238# sg13cmos5l_dfrbpq_1_2.CLK 0.01101f
C903 sg13cmos5l_buf_8_2.X a_22986_14484# 0.01572f
C904 sg13cmos5l_dfrbpq_1_6.D VDD 0.33298f
C905 sg13cmos5l_nand4_1_0.Y a_8312_15238# 0.0158f
C906 sg13cmos5l_dfrbpq_1_6.Q sg13cmos5l_or3_1_1.C 0.13093f
C907 sg13cmos5l_buf_8_2.X sg13cmos5l_dfrbpq_1_2.Q 0.04395f
C908 sg13cmos5l_dfrbpq_1_5.Q VDD 2.16343f
C909 a_17584_13942# VDD 0.13897f
C910 sg13cmos5l_a21oi_1_3.A1 sg13cmos5l_dfrbpq_1_7.D 0.09285f
C911 sg13cmos5l_or3_1_2.A a_21824_15366# 0.01319f
C912 sg13cmos5l_or3_1_2.B sg13cmos5l_or3_1_2.X 0.03269f
C913 sg13cmos5l_dfrbpq_1_1.RESET_B a_6682_13690# 0.01306f
C914 a_26667_13844# VDD 0.20664f
C915 a_20603_15532# sg13cmos5l_a21oi_1_3.B1 0.03672f
C916 a_5613_14832# VDD 0.30068f
C917 a_15579_14854# sg13cmos5l_dfrbpq_1_2.D 0.09154f
C918 sg13cmos5l_buf_8_2.X a_26373_14495# 0.23747f
C919 sg13cmos5l_dlygate4sd3_1_5.A a_18552_15976# 0.01087f
C920 sg13cmos5l_inv_1_0.A clock_i 0.04697f
C921 a_19530_14484# VDD 0.28068f
C922 a_22030_15423# sg13cmos5l_or3_1_2.A 0.10722f
C923 sg13cmos5l_or3_1_2.A sg13cmos5l_dfrbpq_1_2.Q 0.09838f
C924 a_19054_15423# a_18789_15277# 0.0144f
C925 sg13cmos5l_nor2_1_0.B sg13cmos5l_dfrbpq_1_2.CLK 0.18311f
C926 sg13cmos5l_dfrbpq_1_2.Q a_22426_15202# 0.01343f
C927 sg13cmos5l_buf_1_10.X sg13cmos5l_dlygate4sd3_1_1.A 0.16121f
C928 a_17710_16263# a_16969_16020# 0.01693f
C929 a_26633_16334# VDD 0.10189f
C930 sg13cmos5l_and2_1_2.X sg13cmos5l_buf_1_10.X 0.01634f
C931 a_27472_14726# VDD 0.13629f
C932 a_27034_15202# VDD 0.25715f
C933 a_2890_15457# a_3333_15213# 0.02241f
C934 sg13cmos5l_dlygate4sd3_1_0.X a_6286_13911# 0.10725f
C935 counter_value_o[1] a_7240_16082# 0.02116f
C936 sg13cmos5l_buf_1_10.X a_1965_14832# 0.10177f
C937 a_26148_14040# sg13cmos5l_dfrbpq_1_5.RESET_B 0.28728f
C938 a_1192_3900# enable_i 0.1951f
C939 counter_value_o[0] a_2540_15960# 0.15504f
C940 a_23960_15242# sg13cmos5l_dfrbpq_1_6.Q 0.01412f
C941 sg13cmos5l_buf_1_10.X sg13cmos5l_xnor2_1_2.A 0.03534f
C942 a_38720_14570# VDD 0.08963f
C943 counter_value_o[4] a_22304_16082# 0.01136f
C944 a_9861_15213# a_9963_15356# 0.36168f
C945 a_18123_14495# a_17318_14922# 0.07916f
C946 VDD sg13cmos5l_dlygate4sd3_1_8.A 0.84676f
C947 a_25670_14922# a_25956_14488# 0.26205f
C948 sg13cmos5l_dlygate4sd3_1_8.X sg13cmos5l_buf_1_0.X 0.15391f
C949 a_23552_14570# VDD 0.06435f
C950 a_21251_13690# a_21549_14020# 0.02103f
C951 sg13cmos5l_or3_1_2.B sg13cmos5l_or3_1_1.C 0.39924f
C952 sg13cmos5l_xnor2_1_2.A a_6682_13690# 0.03858f
C953 a_27898_15202# sg13cmos5l_dfrbpq_1_6.Q 0.012f
C954 a_6891_14495# sg13cmos5l_dfrbpq_1_2.CLK 0.02479f
C955 a_27034_15202# sg13cmos5l_or3_1_1.A 0.05929f
C956 a_25670_14922# a_26475_14495# 0.07916f
C957 a_16955_14484# VDD 0.20174f
C958 a_6346_14452# sg13cmos5l_dfrbpq_1_2.CLK 0.01513f
C959 sg13cmos5l_dfrbpq_1_7.RESET_B a_26249_16334# 0.01098f
C960 a_26170_16237# sg13cmos5l_o21ai_1_3.Y 0.03498f
C961 sg13cmos5l_o21ai_1_2.Y sg13cmos5l_or3_1_1.B 0.01359f
C962 a_9861_15213# a_10609_15311# 0.01058f
C963 a_7631_14845# a_7537_14845# 0.16704f
C964 a_5687_15549# sg13cmos5l_dfrbpq_1_1.RESET_B 0.01133f
C965 sg13cmos5l_buf_1_10.X sg13cmos5l_xor2_1_0.X 0.14017f
C966 sg13cmos5l_inv_1_0.A sg13cmos5l_dfrbpq_1_2.Q 0.70863f
C967 a_17710_16263# sg13cmos5l_dlygate4sd3_1_4.X 0.01296f
C968 sg13cmos5l_buf_8_2.X sg13cmos5l_dfrbpq_1_6.Q 0.11448f
C969 sg13cmos5l_dfrbpq_1_6.D sg13cmos5l_dlygate4sd3_1_9.X 0.09017f
C970 sg13cmos5l_dfrbpq_1_5.RESET_B sg13cmos5l_dfrbpq_1_7.Q 0.02776f
C971 a_7537_14845# a_6789_14495# 0.01058f
C972 sg13cmos5l_o21ai_1_1.Y a_20278_14862# 0.06702f
C973 a_21466_15202# VDD 0.265f
C974 sg13cmos5l_dfrbpq_1_6.Q sg13cmos5l_or3_1_1.X 0.01503f
C975 sg13cmos5l_buf_1_10.X sg13cmos5l_xor2_1_0.B 2.58844f
C976 a_25094_15238# sg13cmos5l_dlygate4sd3_1_17.A 0.01415f
C977 a_6789_14495# a_6660_14909# 0.01562f
C978 sg13cmos5l_dfrbpq_1_3.D sg13cmos5l_a21oi_1_3.B1 0.03309f
C979 a_9963_15356# sg13cmos5l_tiehi_1.L_HI 0.28158f
C980 a_15870_15486# sg13cmos5l_dfrbpq_1_2.RESET_B 0.06273f
C981 sg13cmos5l_dfrbpq_1_6.Q a_22426_15202# 0.27955f
C982 a_15671_15315# a_15671_15549# 0.08186f
C983 a_25956_14488# VDD 0.07273f
C984 sg13cmos5l_buf_1_0.X VDD 3.99477f
C985 a_16168_15996# sg13cmos5l_or3_1_1.B 0.18678f
C986 a_24520_13854# sg13cmos5l_or3_1_1.C 0.0191f
C987 sg13cmos5l_dfrbpq_1_2.Q a_17238_15302# 0.01082f
C988 a_15782_13722# sg13cmos5l_or3_1_1.B 0.04779f
C989 sg13cmos5l_and2_1_1.X a_6086_14922# 0.18067f
C990 a_17994_14020# sg13cmos5l_dfrbpq_1_2.Q 0.0782f
C991 sg13cmos5l_buf_8_2.A VDD 1.75883f
C992 a_15782_13722# a_16485_13701# 0.02453f
C993 a_26475_14495# VDD 0.20647f
C994 a_21185_15424# a_21070_15423# 0.3854f
C995 sg13cmos5l_a21oi_1_1.Y VDD 0.38748f
C996 a_27313_13799# a_26148_14040# 0.25046f
C997 a_26436_13735# a_26667_13844# 0.07823f
C998 sg13cmos5l_dfrbpq_1_7.RESET_B sg13cmos5l_a21oi_1_3.B1 0.04148f
C999 sg13cmos5l_buf_1_10.X sg13cmos5l_dfrbpq_1_2.CLK 2.24876f
C1000 a_17584_13942# sg13cmos5l_or3_1_1.B 0.01425f
C1001 a_16587_13844# a_17327_13799# 0.17382f
C1002 a_17578_14452# sg13cmos5l_dfrbpq_1_2.Q 0.01204f
C1003 a_24824_14525# sg13cmos5l_o21ai_1_2.Y 0.01349f
C1004 sg13cmos5l_buf_8_2.X sg13cmos5l_or3_1_2.B 0.10287f
C1005 VDD a_3008_16082# 0.06559f
C1006 sg13cmos5l_dfrbpq_1_2.RESET_B VDD 1.18089f
C1007 sg13cmos5l_dlygate4sd3_1_4.X a_19054_15423# 0.10798f
C1008 sg13cmos5l_dfrbpq_1_6.D sg13cmos5l_dfrbpq_1_6.RESET_B 0.64332f
C1009 a_18106_15960# a_18454_16374# 0.02803f
C1010 sg13cmos5l_a21oi_1_0.A2 sg13cmos5l_a21oi_1_0.A1 0.83799f
C1011 sg13cmos5l_a21oi_1_0.A1 a_17126_15238# 0.02337f
C1012 a_26122_13945# a_26565_13701# 0.02241f
C1013 a_25862_13722# a_26148_14040# 0.26205f
C1014 a_25930_14452# sg13cmos5l_dfrbpq_1_7.RESET_B 0.17295f
C1015 sg13cmos5l_buf_1_0.X a_4842_15532# 0.01204f
C1016 sg13cmos5l_tiehi_1.L_HI sg13cmos5l_and2_1_2.X 0.10137f
C1017 sg13cmos5l_dfrbpq_1_7.D sg13cmos5l_o21ai_1_2.B1 0.02262f
C1018 sg13cmos5l_or3_1_2.A sg13cmos5l_or3_1_2.B 0.76615f
C1019 a_18454_16374# sg13cmos5l_inv_1_0.Y 0.05732f
C1020 a_6346_14452# sg13cmos5l_xnor2_1_2.B 0.01548f
C1021 sg13cmos5l_buf_1_10.X sg13cmos5l_dlygate4sd3_1_3.A 0.02697f
C1022 sg13cmos5l_or3_1_2.X sg13cmos5l_a21oi_1_3.B1 0.02158f
C1023 a_17604_14488# sg13cmos5l_buf_8_2.A 0.01462f
C1024 a_25774_15423# sg13cmos5l_a21oi_1_3.B1 0.01368f
C1025 a_2490_14447# VDD 0.19284f
C1026 a_18123_14495# a_19120_14726# 0.03546f
C1027 a_9861_14521# sg13cmos5l_dlygate4sd3_1_8.X 0.02311f
C1028 sg13cmos5l_a21oi_1_3.Y a_25956_14488# 0.02684f
C1029 sg13cmos5l_dfrbpq_1_7.D a_25670_14922# 0.16976f
C1030 a_21034_14452# a_21060_14488# 0.24169f
C1031 a_21185_15424# sg13cmos5l_or3_1_2.X 0.02913f
C1032 a_21477_14495# VDD 0.24916f
C1033 sg13cmos5l_dfrbpq_1_5.Q a_27882_14484# 0.01003f
C1034 sg13cmos5l_inv_1_0.A sg13cmos5l_a21oi_1_0.Y 0.03371f
C1035 a_18202_15202# VDD 0.26193f
C1036 a_27664_13942# a_28074_14020# 0.07015f
C1037 a_21251_13690# sg13cmos5l_or3_1_2.X 0.13427f
C1038 a_2942_14484# VDD 0.01096f
C1039 a_6714_12972# sg13cmos5l_xnor2_1_2.B 0.01001f
C1040 a_21477_14495# a_21579_14495# 0.3643f
C1041 a_27296_16082# VDD 0.10061f
C1042 sg13cmos5l_or3_1_2.C a_21034_14452# 0.01367f
C1043 sg13cmos5l_dfrbpq_1_2.Q a_19450_15202# 0.02358f
C1044 a_8582_15238# sg13cmos5l_and2_1_2.B 0.01938f
C1045 a_6575_13342# sg13cmos5l_dlygate4sd3_1_0.A 0.03821f
C1046 sg13cmos5l_dfrbpq_1_2.Q sg13cmos5l_dfrbpq_1_3.RESET_B 0.24996f
C1047 a_18106_15960# VDD 0.28888f
C1048 sg13cmos5l_a21oi_1_0.A2 a_17126_15238# 0.0707f
C1049 a_9861_15213# sg13cmos5l_dfrbpq_1_2.CLK 0.21068f
C1050 sg13cmos5l_dfrbpq_1_0.RESET_B a_3130_16237# 0.05105f
C1051 a_9861_15213# sg13cmos5l_nand4_1_0.Y 0.0176f
C1052 sg13cmos5l_and2_1_0.X sg13cmos5l_buf_1_0.X 0.11175f
C1053 a_27472_14726# a_27882_14484# 0.07015f
C1054 a_22576_14726# a_22319_14845# 0.23043f
C1055 sg13cmos5l_buf_1_0.X a_3333_15213# 0.01557f
C1056 a_17318_14922# VDD 0.52408f
C1057 a_4081_15311# a_3333_15213# 0.01058f
C1058 sg13cmos5l_o21ai_1_2.Y a_23736_14464# 0.01095f
C1059 a_26373_16033# VDD 0.0659f
C1060 sg13cmos5l_inv_1_0.Y VDD 0.76193f
C1061 a_15870_15486# sg13cmos5l_nor2_1_0.B 0.0389f
C1062 a_6891_14495# sg13cmos5l_dlygate4sd3_1_8.X 0.01277f
C1063 sg13cmos5l_a21oi_1_3.B1 sg13cmos5l_or3_1_1.C 0.10968f
C1064 a_11370_15532# sg13cmos5l_nand4_1_0.Y 0.01256f
C1065 a_18021_14495# a_18123_14495# 0.3643f
C1066 counter_value_o[5] a_27500_15960# 0.15495f
C1067 a_25786_15960# sg13cmos5l_o21ai_1_3.Y 0.29053f
C1068 a_8312_15238# VDD 0.27567f
C1069 sg13cmos5l_buf_8_2.X a_26565_13701# 0.21461f
C1070 sg13cmos5l_a21oi_1_1.Y sg13cmos5l_dlygate4sd3_1_9.X 0.07532f
C1071 sg13cmos5l_inv_1_0.A sg13cmos5l_or3_1_2.B 0.02593f
C1072 a_24169_14508# sg13cmos5l_dlygate4sd3_1_17.A 0.01646f
C1073 sg13cmos5l_xnor2_1_2.B sg13cmos5l_buf_1_10.X 0.01762f
C1074 sg13cmos5l_o21ai_1_3.Y a_24408_15552# 0.01291f
C1075 a_15782_13722# a_16356_13735# 0.18486f
C1076 sg13cmos5l_buf_8_2.X a_18863_14845# 0.02216f
C1077 a_27500_15960# sg13cmos5l_dfrbpq_1_6.Q 0.19565f
C1078 sg13cmos5l_dfrbpq_1_2.Q a_16552_15996# 0.19543f
C1079 a_9861_14521# VDD 0.06515f
C1080 sg13cmos5l_dfrbpq_1_7.D VDD 0.19689f
C1081 sg13cmos5l_or3_1_2.B a_20774_14922# 0.04313f
C1082 sg13cmos5l_xnor2_1_2.B a_6682_13690# 0.01246f
C1083 a_1192_3900# sg13cmos5l_buf_1_0.X 0.15903f
C1084 sg13cmos5l_nor2_1_0.B VDD 0.25674f
C1085 a_24841_13726# sg13cmos5l_or3_1_1.C 0.14829f
C1086 a_17318_14922# a_17604_14488# 0.26205f
C1087 a_6401_13912# a_6682_13690# 0.18796f
C1088 sg13cmos5l_dfrbpq_1_7.RESET_B sg13cmos5l_dfrbpq_1_5.RESET_B 0.12636f
C1089 sg13cmos5l_o21ai_1_1.Y sg13cmos5l_dfrbpq_1_6.D 0.09542f
C1090 a_26170_16237# sg13cmos5l_dfrbpq_1_7.RESET_B 0.0434f
C1091 sg13cmos5l_dfrbpq_1_2.D VDD 0.43023f
C1092 a_5687_15549# sg13cmos5l_dlygate4sd3_1_3.A 0.01959f
C1093 a_21060_14488# sg13cmos5l_or3_1_2.X 0.04034f
C1094 sg13cmos5l_or3_1_2.B a_21348_14909# 0.01476f
C1095 a_18789_15277# VDD 0.06795f
C1096 a_2490_14447# sg13cmos5l_and2_1_0.X 0.05334f
C1097 sg13cmos5l_buf_8_2.A sg13cmos5l_or3_1_1.B 0.33039f
C1098 a_2916_15552# a_3204_15247# 0.24435f
C1099 a_21166_16263# a_20960_16082# 0.01604f
C1100 sg13cmos5l_tiehi_1.L_HI sg13cmos5l_dfrbpq_1_2.CLK 0.04608f
C1101 sg13cmos5l_tiehi_1.L_HI sg13cmos5l_nand4_1_0.Y 0.03669f
C1102 sg13cmos5l_or3_1_2.C sg13cmos5l_or3_1_2.X 0.02676f
C1103 a_19816_15366# a_20000_15366# 0.05762f
C1104 a_4474_14448# sg13cmos5l_dfrbpq_1_2.CLK 0.01341f
C1105 a_2916_15552# sg13cmos5l_dfrbpq_1_0.RESET_B 0.28678f
C1106 sg13cmos5l_dfrbpq_1_2.RESET_B sg13cmos5l_or3_1_1.B 0.15658f
C1107 a_6891_14495# VDD 0.20627f
C1108 sg13cmos5l_dfrbpq_1_3.Q sg13cmos5l_o21ai_1_2.A2 0.12945f
C1109 sg13cmos5l_a21oi_1_1.Y sg13cmos5l_dfrbpq_1_6.RESET_B 0.15755f
C1110 a_2916_15552# sg13cmos5l_xor2_1_0.B 0.01285f
C1111 a_7937_13912# sg13cmos5l_dlygate4sd3_1_1.A 0.02056f
C1112 a_16485_13701# sg13cmos5l_dfrbpq_1_2.RESET_B 0.0353f
C1113 sg13cmos5l_inv_1_0.Y a_16175_15238# 0.01129f
C1114 a_6346_14452# VDD 0.09662f
C1115 sg13cmos5l_dlygate4sd3_1_8.X sg13cmos5l_buf_1_10.X 1.2223f
C1116 a_38720_13058# VDD 0.09066f
C1117 a_8685_14832# VDD 0.28623f
C1118 VDD a_7532_15960# 0.22643f
C1119 a_7937_13912# sg13cmos5l_xnor2_1_2.A 0.01378f
C1120 a_16042_13945# VDD 0.09565f
C1121 sg13cmos5l_buf_8_2.X sg13cmos5l_a21oi_1_3.B1 0.47568f
C1122 a_4474_14448# sg13cmos5l_dlygate4sd3_1_3.A 0.28823f
C1123 a_2916_15552# sg13cmos5l_dfrbpq_1_2.CLK 0.07118f
C1124 a_3435_15356# a_3204_15247# 0.07823f
C1125 a_10222_14751# a_10016_14570# 0.01604f
C1126 a_21281_16262# VDD 0.2072f
C1127 a_6575_13342# sg13cmos5l_xnor2_1_2.A 0.01681f
C1128 sg13cmos5l_a21oi_1_3.B1 sg13cmos5l_or3_1_1.X 0.09969f
C1129 a_37484_15960# VDD 0.22428f
C1130 a_16969_16020# VDD 0.24435f
C1131 sg13cmos5l_nor2_1_0.B a_16175_15238# 0.0301f
C1132 a_26148_14040# VDD 0.08291f
C1133 sg13cmos5l_or3_1_2.A sg13cmos5l_a21oi_1_3.B1 0.01884f
C1134 sg13cmos5l_dfrbpq_1_6.RESET_B a_21477_14495# 0.03611f
C1135 a_3435_15356# sg13cmos5l_dfrbpq_1_0.RESET_B 0.28294f
C1136 sg13cmos5l_buf_8_2.X a_25930_14452# 0.01411f
C1137 a_32492_15960# a_32200_16082# 0.01635f
C1138 a_21185_15424# sg13cmos5l_or3_1_2.A 0.01897f
C1139 a_19120_14726# VDD 0.13647f
C1140 a_23638_14862# sg13cmos5l_o21ai_1_2.A2 0.10051f
C1141 a_22030_15423# a_21824_15366# 0.01604f
C1142 a_24824_15238# a_25094_15238# 0.18796f
C1143 a_18454_16374# sg13cmos5l_dlygate4sd3_1_4.X 0.02479f
C1144 a_28074_14020# VDD 0.28333f
C1145 a_17327_13799# a_17994_14020# 0.09257f
C1146 a_21251_13690# sg13cmos5l_or3_1_2.A 0.20657f
C1147 a_2916_15552# sg13cmos5l_dlygate4sd3_1_3.A 0.0212f
C1148 sg13cmos5l_inv_1_0.Y sg13cmos5l_or3_1_1.B 0.86348f
C1149 a_24841_13726# sg13cmos5l_or3_1_1.X 0.12621f
C1150 a_21466_15202# sg13cmos5l_o21ai_1_1.Y 0.28384f
C1151 a_16955_14484# sg13cmos5l_a21oi_1_0.A1 0.02731f
C1152 a_22030_15423# sg13cmos5l_dfrbpq_1_2.Q 0.01335f
C1153 sg13cmos5l_dfrbpq_1_3.RESET_B a_18665_15180# 0.01111f
C1154 a_26122_13945# sg13cmos5l_dfrbpq_1_5.RESET_B 0.20792f
C1155 sg13cmos5l_dfrbpq_1_5.D sg13cmos5l_a21oi_1_3.B1 0.19488f
C1156 sg13cmos5l_o21ai_1_3.Y VDD 0.48036f
C1157 sg13cmos5l_buf_1_10.X VDD 2.54445f
C1158 a_9444_15552# a_9861_15213# 0.28324f
C1159 a_9158_15234# a_9963_15356# 0.07916f
C1160 a_3435_15356# sg13cmos5l_dfrbpq_1_2.CLK 0.01756f
C1161 VDD a_12524_15960# 0.22898f
C1162 sg13cmos5l_or3_1_2.C a_20218_15238# 0.01849f
C1163 a_21251_13690# a_20968_13854# 0.01625f
C1164 a_27407_13799# sg13cmos5l_dfrbpq_1_5.RESET_B 0.10868f
C1165 sg13cmos5l_dfrbpq_1_6.Q sg13cmos5l_dlygate4sd3_1_17.A 0.01411f
C1166 a_27502_15423# sg13cmos5l_dfrbpq_1_6.Q 0.0569f
C1167 a_6682_13690# VDD 0.28405f
C1168 a_24310_15230# sg13cmos5l_or3_1_1.A 0.02324f
C1169 counter_value_o[4] a_22508_15960# 0.15504f
C1170 a_9963_15356# a_10703_15311# 0.17382f
C1171 sg13cmos5l_or3_1_2.B a_16552_15996# 0.09282f
C1172 a_18021_14495# VDD 0.24448f
C1173 sg13cmos5l_nor2_1_0.B sg13cmos5l_or3_1_1.B 0.1517f
C1174 sg13cmos5l_dfrbpq_1_7.Q VDD 1.33022f
C1175 sg13cmos5l_o21ai_1_2.B1 sg13cmos5l_o21ai_1_2.A2 0.18866f
C1176 sg13cmos5l_dlygate4sd3_1_4.X VDD 0.58517f
C1177 sg13cmos5l_buf_8_2.A a_19232_13854# 0.0236f
C1178 a_26757_16033# a_26633_16334# 0.08186f
C1179 a_25505_16262# a_25786_15960# 0.18796f
C1180 sg13cmos5l_o21ai_1_3.Y sg13cmos5l_or3_1_1.A 0.21954f
C1181 sg13cmos5l_inv_1_0.A sg13cmos5l_a21oi_1_3.B1 0.05318f
C1182 a_10960_15454# a_11370_15532# 0.07015f
C1183 sg13cmos5l_buf_8_2.X a_21060_14488# 0.06778f
C1184 a_3435_15356# sg13cmos5l_dlygate4sd3_1_3.A 0.0271f
C1185 a_9861_15213# a_9732_15247# 0.01562f
C1186 a_7888_14726# a_8298_14484# 0.07015f
C1187 a_16955_14484# sg13cmos5l_a21oi_1_0.A2 0.05566f
C1188 sg13cmos5l_dfrbpq_1_7.RESET_B a_25786_15960# 0.03625f
C1189 a_26753_15424# a_26638_15423# 0.3854f
C1190 a_6086_14922# a_6372_14488# 0.26205f
C1191 counter_value_o[3] a_16552_15996# 0.1598f
C1192 a_6891_14495# a_6660_14909# 0.07823f
C1193 sg13cmos5l_buf_8_2.X a_22319_14845# 0.02057f
C1194 a_10703_15311# a_10609_15311# 0.16704f
C1195 a_16587_13844# sg13cmos5l_dfrbpq_1_2.CLK 0.04306f
C1196 a_9158_15234# sg13cmos5l_and2_1_2.X 0.16719f
C1197 sg13cmos5l_buf_8_2.X sg13cmos5l_or3_1_2.C 0.15474f
C1198 sg13cmos5l_or3_1_2.A a_21060_14488# 0.03179f
C1199 sg13cmos5l_dfrbpq_1_7.Q sg13cmos5l_or3_1_1.A 0.08495f
C1200 a_17327_13799# sg13cmos5l_dfrbpq_1_3.RESET_B 0.01722f
C1201 a_20603_15532# VDD 0.16158f
C1202 a_18021_14495# a_17604_14488# 0.28418f
C1203 a_19323_13726# VDD 0.94636f
C1204 a_17892_14909# a_17318_14922# 0.18486f
C1205 sg13cmos5l_buf_8_2.X sg13cmos5l_dfrbpq_1_5.RESET_B 0.10136f
C1206 a_9861_15213# a_9418_15457# 0.02241f
C1207 a_3209_16334# a_3130_16237# 0.08889f
C1208 a_9444_15552# sg13cmos5l_tiehi_1.L_HI 0.29159f
C1209 a_18863_14845# sg13cmos5l_dfrbpq_1_3.RESET_B 0.10879f
C1210 a_9861_15213# VDD 0.24352f
C1211 a_15870_15486# a_15671_15315# 0.02453f
C1212 sg13cmos5l_or3_1_2.C sg13cmos5l_or3_1_2.A 0.72302f
C1213 a_7937_13912# a_8218_13690# 0.18796f
C1214 sg13cmos5l_tiehi_1.L_HI sg13cmos5l_dlygate4sd3_1_8.X 0.04348f
C1215 a_10337_14750# sg13cmos5l_buf_1_10.X 0.01927f
C1216 a_24824_15238# sg13cmos5l_dlygate4sd3_1_17.A 0.06549f
C1217 a_10618_14448# sg13cmos5l_dlygate4sd3_1_8.A 0.28818f
C1218 a_16042_13945# sg13cmos5l_or3_1_1.B 0.0385f
C1219 sg13cmos5l_dfrbpq_1_3.Q sg13cmos5l_or3_1_1.C 0.09624f
C1220 a_38536_3986# a_38720_3986# 0.05762f
C1221 a_22986_14484# sg13cmos5l_dfrbpq_1_6.Q 0.08106f
C1222 a_10960_15454# sg13cmos5l_tiehi_1.L_HI 0.09962f
C1223 a_11370_15532# VDD 0.27891f
C1224 a_16042_13945# a_16485_13701# 0.02241f
C1225 sg13cmos5l_dfrbpq_1_2.Q sg13cmos5l_dfrbpq_1_6.Q 0.44792f
C1226 sg13cmos5l_inv_1_0.A a_15671_15549# 0.01207f
C1227 a_32492_15960# VDD 0.22858f
C1228 a_24169_14508# sg13cmos5l_or3_1_2.B 0.16618f
C1229 a_5687_15549# VDD 0.09536f
C1230 a_21166_16263# VDD 0.15938f
C1231 a_17578_14452# sg13cmos5l_a21oi_1_3.B1 0.01016f
C1232 sg13cmos5l_buf_1_10.X sg13cmos5l_and2_1_0.X 0.04444f
C1233 a_26436_13735# a_26148_14040# 0.24435f
C1234 sg13cmos5l_dfrbpq_1_2.Q sg13cmos5l_a21oi_1_0.Y 0.01608f
C1235 a_16969_16020# a_17165_16020# 0.01485f
C1236 a_16068_14040# a_17327_13799# 0.01412f
C1237 a_25206_14508# sg13cmos5l_a21oi_1_3.A1 0.03685f
C1238 sg13cmos5l_dfrbpq_1_7.RESET_B sg13cmos5l_o21ai_1_2.B1 0.02543f
C1239 VDD a_3130_16237# 0.10639f
C1240 a_15671_15315# VDD 0.06777f
C1241 VDD sg13cmos5l_o21ai_1_2.A2 0.55223f
C1242 a_27313_13799# a_27407_13799# 0.16704f
C1243 a_21281_16262# sg13cmos5l_dfrbpq_1_6.RESET_B 0.02115f
C1244 a_17710_16263# a_17825_16262# 0.3854f
C1245 a_26122_13945# a_25862_13722# 0.45119f
C1246 sg13cmos5l_dfrbpq_1_5.D sg13cmos5l_dfrbpq_1_5.RESET_B 0.09565f
C1247 a_25670_14922# sg13cmos5l_dfrbpq_1_7.RESET_B 0.07823f
C1248 a_5504_14570# sg13cmos5l_buf_1_10.X 0.02387f
C1249 sg13cmos5l_buf_1_0.X a_4175_15311# 0.0138f
C1250 VDD a_7240_16082# 0.1655f
C1251 a_4081_15311# a_4175_15311# 0.16704f
C1252 sg13cmos5l_buf_8_2.X sg13cmos5l_a21oi_1_3.A1 0.02668f
C1253 sg13cmos5l_inv_1_0.A a_17921_15424# 0.01143f
C1254 sg13cmos5l_a21oi_1_3.A1 sg13cmos5l_or3_1_1.X 0.59456f
C1255 enable_i sg13cmos5l_buf_1_0.X 0.0337f
C1256 a_20774_14922# a_21060_14488# 0.26205f
C1257 a_22025_16334# counter_value_o[4] 0.0192f
C1258 sg13cmos5l_or3_1_1.C a_24408_15552# 0.01124f
C1259 sg13cmos5l_and2_1_2.B sg13cmos5l_and2_1_2.X 0.13511f
C1260 a_9418_15457# sg13cmos5l_tiehi_1.L_HI 0.17464f
C1261 a_21034_14452# VDD 0.09647f
C1262 sg13cmos5l_tiehi_1.L_HI VDD 1.09488f
C1263 sg13cmos5l_a21oi_1_0.A1 sg13cmos5l_inv_1_0.Y 0.05298f
C1264 sg13cmos5l_or3_1_2.B sg13cmos5l_dfrbpq_1_2.Q 0.38942f
C1265 a_27407_13799# a_27664_13942# 0.23043f
C1266 a_18863_14845# a_18769_14845# 0.16704f
C1267 a_4474_14448# VDD 0.29254f
C1268 sg13cmos5l_dfrbpq_1_3.RESET_B sg13cmos5l_a21oi_1_3.B1 0.04636f
C1269 a_6575_13342# sg13cmos5l_xnor2_1_2.B 0.01242f
C1270 counter_value_o[2] clock_i 0.0407f
C1271 a_21060_14488# a_21348_14909# 0.24435f
C1272 sg13cmos5l_a21oi_1_3.A2 sg13cmos5l_or3_1_1.C 0.14595f
C1273 a_20603_15532# sg13cmos5l_dlygate4sd3_1_9.X 0.06946f
C1274 sg13cmos5l_or3_1_2.C a_20774_14922# 0.03077f
C1275 a_22576_14726# VDD 0.13981f
C1276 a_20000_15366# VDD 0.07202f
C1277 sg13cmos5l_dfrbpq_1_2.Q a_18665_15180# 0.02237f
C1278 a_6540_13238# sg13cmos5l_dlygate4sd3_1_0.A 0.12959f
C1279 sg13cmos5l_dfrbpq_1_3.D VDD 0.20543f
C1280 a_9158_15234# sg13cmos5l_dfrbpq_1_2.CLK 0.01121f
C1281 counter_value_o[5] sg13cmos5l_dfrbpq_1_6.Q 0.01034f
C1282 a_9158_15234# sg13cmos5l_nand4_1_0.Y 0.02144f
C1283 a_21579_14495# a_22576_14726# 0.03546f
C1284 sg13cmos5l_a21oi_1_3.A1 sg13cmos5l_dfrbpq_1_5.D 0.10222f
C1285 a_25505_16262# VDD 0.20709f
C1286 a_21070_15423# VDD 0.15921f
C1287 counter_value_o[3] sg13cmos5l_dfrbpq_1_2.Q 0.01238f
C1288 sg13cmos5l_buf_8_2.X sg13cmos5l_dfrbpq_1_3.Q 0.02606f
C1289 a_10703_15311# sg13cmos5l_dfrbpq_1_2.CLK 0.01174f
C1290 a_10703_15311# sg13cmos5l_nand4_1_0.Y 0.01618f
C1291 a_2916_15552# VDD 0.09493f
C1292 sg13cmos5l_dfrbpq_1_7.RESET_B VDD 1.10388f
C1293 sg13cmos5l_o21ai_1_2.B1 sg13cmos5l_or3_1_1.C 0.46973f
C1294 sg13cmos5l_a21oi_1_0.A2 sg13cmos5l_inv_1_0.Y 0.01864f
C1295 sg13cmos5l_buf_8_2.X a_18123_14495# 0.02452f
C1296 sg13cmos5l_dfrbpq_1_3.Q a_22426_15202# 0.03081f
C1297 counter_value_o[7] a_37192_16082# 0.02116f
C1298 counter_value_o[1] clock_i 0.0407f
C1299 a_19323_13726# sg13cmos5l_or3_1_1.B 0.05142f
C1300 sg13cmos5l_dfrbpq_1_7.Q a_27882_14484# 0.09875f
C1301 a_6086_14922# sg13cmos5l_dfrbpq_1_1.RESET_B 0.07767f
C1302 a_16140_15424# VDD 0.18406f
C1303 a_6286_13911# sg13cmos5l_dlygate4sd3_1_0.A 0.02097f
C1304 sg13cmos5l_dfrbpq_1_7.RESET_B sg13cmos5l_or3_1_1.A 0.02533f
C1305 sg13cmos5l_inv_1_0.A sg13cmos5l_dfrbpq_1_2.CLK 0.34455f
C1306 a_14344_14570# VDD 0.15065f
C1307 sg13cmos5l_or3_1_2.X VDD 0.34653f
C1308 a_25774_15423# VDD 0.15949f
C1309 a_18769_14845# sg13cmos5l_a21oi_1_3.B1 0.01028f
C1310 sg13cmos5l_dlygate4sd3_1_0.X sg13cmos5l_dfrbpq_1_2.CLK 0.03779f
C1311 a_2630_15234# a_2916_15552# 0.26205f
C1312 a_22025_16334# a_21946_16237# 0.08889f
C1313 a_24841_13726# a_24935_14020# 0.02103f
C1314 a_26638_15423# sg13cmos5l_dfrbpq_1_5.RESET_B 0.01351f
C1315 sg13cmos5l_a21oi_1_3.B1 sg13cmos5l_dlygate4sd3_1_17.A 0.24924f
C1316 sg13cmos5l_or3_1_2.B sg13cmos5l_dfrbpq_1_6.Q 0.20181f
C1317 a_3435_15356# VDD 0.20564f
C1318 a_8298_14484# sg13cmos5l_dlygate4sd3_1_1.A 0.09568f
C1319 a_25862_13722# sg13cmos5l_dfrbpq_1_5.D 0.17436f
C1320 sg13cmos5l_dlygate4sd3_1_5.A sg13cmos5l_or3_1_2.B 0.19226f
C1321 a_18202_15202# a_18586_15455# 0.01303f
C1322 a_17921_15424# sg13cmos5l_dfrbpq_1_3.RESET_B 0.07437f
C1323 clock_i sg13cmos5l_a21oi_1_3.B1 0.02814f
C1324 sg13cmos5l_or3_1_2.B sg13cmos5l_a21oi_1_0.Y 0.01754f
C1325 a_4432_15454# sg13cmos5l_dfrbpq_1_0.RESET_B 0.09976f
C1326 sg13cmos5l_buf_8_2.X sg13cmos5l_a21oi_1_3.A2 0.01098f
C1327 a_18021_14495# a_17892_14909# 0.01562f
C1328 a_21166_16263# sg13cmos5l_dfrbpq_1_6.RESET_B 0.02119f
C1329 sg13cmos5l_a21oi_1_1.Y sg13cmos5l_dfrbpq_1_6.D 0.02843f
C1330 sg13cmos5l_a21oi_1_3.Y sg13cmos5l_dfrbpq_1_7.RESET_B 0.10426f
C1331 a_8312_15238# sg13cmos5l_xnor2_1_0.Y 0.30653f
C1332 sg13cmos5l_a21oi_1_2.A1 sg13cmos5l_o21ai_1_3.Y 0.03141f
C1333 a_15782_13722# sg13cmos5l_dfrbpq_1_2.RESET_B 0.11354f
C1334 sg13cmos5l_and2_1_2.B sg13cmos5l_dfrbpq_1_2.CLK 0.03578f
C1335 sg13cmos5l_and2_1_2.B sg13cmos5l_nand4_1_0.Y 0.01346f
C1336 a_25774_15423# sg13cmos5l_or3_1_1.A 0.01031f
C1337 sg13cmos5l_a21oi_1_0.A1 a_16969_16020# 0.01278f
C1338 a_6086_14922# sg13cmos5l_xnor2_1_2.A 0.01661f
C1339 sg13cmos5l_and2_1_1.X sg13cmos5l_dfrbpq_1_1.RESET_B 0.07099f
C1340 a_17584_13942# sg13cmos5l_dfrbpq_1_2.RESET_B 0.09962f
C1341 a_22986_14484# a_23368_14570# 0.01648f
C1342 sg13cmos5l_dlygate4sd3_1_9.X a_21070_15423# 0.10667f
C1343 VDD a_2248_16082# 0.16554f
C1344 a_7937_13912# VDD 0.21568f
C1345 VDD sg13cmos5l_or3_1_1.C 0.82343f
C1346 a_26475_14495# a_27472_14726# 0.03546f
C1347 a_38536_3986# VDD 0.1399f
C1348 a_9536_14570# VDD 0.10026f
C1349 a_2916_15552# a_3333_15213# 0.28324f
C1350 a_2630_15234# a_3435_15356# 0.07916f
C1351 a_22304_16082# VDD 0.07521f
C1352 a_18552_15976# VDD 0.01784f
C1353 a_6540_13238# sg13cmos5l_xnor2_1_2.A 0.12802f
C1354 sg13cmos5l_buf_8_2.X sg13cmos5l_o21ai_1_2.B1 0.22463f
C1355 a_16587_13844# VDD 0.21312f
C1356 a_6680_15242# sg13cmos5l_nand3_1_0.Y 0.01437f
C1357 a_16140_15424# a_16175_15238# 0.19075f
C1358 a_26122_13945# VDD 0.09474f
C1359 sg13cmos5l_or3_1_1.X sg13cmos5l_o21ai_1_2.B1 0.01824f
C1360 sg13cmos5l_dfrbpq_1_6.RESET_B a_21034_14452# 0.17208f
C1361 sg13cmos5l_buf_8_2.X a_25670_14922# 0.01876f
C1362 a_15671_15549# clock_i 0.03769f
C1363 a_25206_15302# a_25774_15423# 0.01641f
C1364 sg13cmos5l_or3_1_1.C sg13cmos5l_or3_1_1.A 0.19409f
C1365 sg13cmos5l_a21oi_1_0.A2 a_16969_16020# 0.13879f
C1366 a_27407_13799# VDD 0.18933f
C1367 sg13cmos5l_dfrbpq_1_6.RESET_B a_22576_14726# 0.09622f
C1368 sg13cmos5l_dfrbpq_1_2.Q sg13cmos5l_a21oi_1_3.B1 0.27687f
C1369 clock_i sg13cmos5l_dlygate4sd3_1_1.A 0.01208f
C1370 sg13cmos5l_inv_1_0.Y a_16168_15996# 0.03785f
C1371 a_4432_15454# sg13cmos5l_dlygate4sd3_1_3.A 0.05808f
C1372 sg13cmos5l_dlygate4sd3_1_9.X sg13cmos5l_or3_1_2.X 0.17041f
C1373 counter_value_o[3] sg13cmos5l_or3_1_2.B 0.48267f
C1374 a_18586_15455# a_18789_15277# 0.02453f
C1375 sg13cmos5l_a21oi_1_0.A1 sg13cmos5l_dlygate4sd3_1_4.X 0.09426f
C1376 sg13cmos5l_dlygate4sd3_1_0.X sg13cmos5l_xnor2_1_2.B 0.10767f
C1377 a_25390_16263# VDD 0.16049f
C1378 sg13cmos5l_dfrbpq_1_6.RESET_B a_21070_15423# 0.05075f
C1379 a_27898_15202# VDD 0.2847f
C1380 a_9158_15234# a_9444_15552# 0.26205f
C1381 a_3333_15213# a_3435_15356# 0.36168f
C1382 a_22225_14845# a_21477_14495# 0.01058f
C1383 a_9861_14521# a_9737_14822# 0.08186f
C1384 a_26753_15424# sg13cmos5l_dfrbpq_1_6.Q 0.01045f
C1385 a_6080_13854# VDD 0.07075f
C1386 a_9444_15552# a_10703_15311# 0.01412f
C1387 a_25930_14452# a_26373_14495# 0.02241f
C1388 sg13cmos5l_dfrbpq_1_5.D a_25670_14922# 0.04812f
C1389 a_25206_14508# VDD 0.16141f
C1390 a_4081_15311# sg13cmos5l_buf_1_0.X 0.0102f
C1391 a_16140_15424# sg13cmos5l_or3_1_1.B 0.03017f
C1392 a_6086_14922# sg13cmos5l_dfrbpq_1_2.CLK 0.01616f
C1393 a_26554_16237# a_26249_16334# 0.01055f
C1394 a_10703_15311# a_10960_15454# 0.23043f
C1395 sg13cmos5l_or3_1_2.X sg13cmos5l_or3_1_1.B 0.01428f
C1396 a_25956_14488# a_26475_14495# 0.20754f
C1397 a_23368_14570# sg13cmos5l_dfrbpq_1_6.Q 0.0251f
C1398 a_26373_14495# a_26244_14909# 0.01562f
C1399 a_25206_14508# a_25094_14484# 0.3854f
C1400 sg13cmos5l_dfrbpq_1_2.D a_15782_13722# 0.16401f
C1401 a_9158_15234# a_9732_15247# 0.18486f
C1402 sg13cmos5l_buf_8_2.X VDD 1.73258f
C1403 a_6891_14495# a_7631_14845# 0.17382f
C1404 a_5886_15486# sg13cmos5l_dfrbpq_1_1.RESET_B 0.04267f
C1405 a_5687_15315# a_5687_15549# 0.08186f
C1406 sg13cmos5l_a21oi_1_0.A2 sg13cmos5l_dlygate4sd3_1_4.X 0.04461f
C1407 sg13cmos5l_and2_1_1.X sg13cmos5l_xor2_1_0.B 0.01253f
C1408 sg13cmos5l_or3_1_1.X VDD 0.43882f
C1409 sg13cmos5l_dfrbpq_1_6.RESET_B sg13cmos5l_or3_1_2.X 0.36966f
C1410 sg13cmos5l_dfrbpq_1_3.Q a_19450_15202# 0.28632f
C1411 sg13cmos5l_buf_8_2.X a_21579_14495# 0.03908f
C1412 sg13cmos5l_buf_8_2.X a_25094_14484# 0.01175f
C1413 a_6891_14495# a_6789_14495# 0.3643f
C1414 sg13cmos5l_xnor2_1_2.B a_6202_15238# 0.01843f
C1415 a_16068_14040# sg13cmos5l_dfrbpq_1_2.CLK 0.04723f
C1416 a_25206_14508# sg13cmos5l_or3_1_1.A 0.0186f
C1417 sg13cmos5l_or3_1_2.A VDD 0.38339f
C1418 VDD a_22426_15202# 0.29669f
C1419 a_25094_14484# sg13cmos5l_or3_1_1.X 0.03354f
C1420 a_6346_14452# a_6789_14495# 0.02241f
C1421 sg13cmos5l_buf_8_2.A sg13cmos5l_dfrbpq_1_2.RESET_B 0.08449f
C1422 a_12010_15202# a_11752_15366# 0.01836f
C1423 sg13cmos5l_buf_8_2.X sg13cmos5l_or3_1_1.A 0.02847f
C1424 a_18123_14495# sg13cmos5l_dfrbpq_1_3.RESET_B 0.28174f
C1425 a_9158_15234# a_9418_15457# 0.45119f
C1426 a_9158_15234# VDD 0.52421f
C1427 a_2540_15960# a_2248_16082# 0.01635f
C1428 a_21466_15202# a_21477_14495# 0.01088f
C1429 a_7822_13911# a_7937_13912# 0.3854f
C1430 sg13cmos5l_and2_1_1.X sg13cmos5l_dfrbpq_1_2.CLK 0.02079f
C1431 sg13cmos5l_dfrbpq_1_6.Q sg13cmos5l_a21oi_1_3.B1 0.03563f
C1432 a_10618_14448# sg13cmos5l_buf_1_10.X 0.01712f
C1433 sg13cmos5l_dfrbpq_1_2.Q a_17921_15424# 0.03888f
C1434 a_2490_14447# sg13cmos5l_buf_1_0.X 0.09015f
C1435 sg13cmos5l_or3_1_1.X sg13cmos5l_or3_1_1.A 0.269f
C1436 sg13cmos5l_buf_8_2.X a_17604_14488# 0.05299f
C1437 a_20968_13854# VDD 0.1724f
C1438 sg13cmos5l_or3_1_1.C sg13cmos5l_or3_1_1.B 0.12764f
C1439 a_15579_14854# clock_i 0.3255f
C1440 sg13cmos5l_a21oi_1_0.Y sg13cmos5l_a21oi_1_3.B1 0.43231f
C1441 a_10703_15311# VDD 0.19385f
C1442 a_22986_14484# a_22319_14845# 0.09257f
C1443 a_16042_13945# a_15782_13722# 0.45119f
C1444 sg13cmos5l_and2_1_2.B sg13cmos5l_dlygate4sd3_1_8.X 0.03311f
C1445 sg13cmos5l_dfrbpq_1_5.D VDD 0.42253f
C1446 sg13cmos5l_or3_1_2.C sg13cmos5l_dfrbpq_1_2.Q 0.11689f
C1447 a_17825_16262# VDD 0.20672f
C1448 a_24923_15996# sg13cmos5l_or3_1_1.X 0.06735f
C1449 sg13cmos5l_o21ai_1_2.Y sg13cmos5l_o21ai_1_3.Y 0.07365f
C1450 a_16587_13844# sg13cmos5l_or3_1_1.B 0.03034f
C1451 sg13cmos5l_buf_8_2.X sg13cmos5l_a21oi_1_3.Y 0.07372f
C1452 clock_i sg13cmos5l_dfrbpq_1_2.CLK 0.03525f
C1453 sg13cmos5l_nand4_1_0.Y clock_i 0.14857f
C1454 a_16485_13701# a_16587_13844# 0.36168f
C1455 a_22508_15960# sg13cmos5l_dfrbpq_1_3.Q 0.19275f
C1456 sg13cmos5l_buf_1_10.X reset_n_i 0.01015f
C1457 sg13cmos5l_a21oi_1_3.Y sg13cmos5l_or3_1_1.X 0.01332f
C1458 a_26373_14495# sg13cmos5l_dfrbpq_1_5.RESET_B 0.01805f
C1459 a_37484_15960# sg13cmos5l_dfrbpq_1_5.Q 0.19611f
C1460 a_7631_14845# sg13cmos5l_buf_1_10.X 0.02226f
C1461 a_26638_15423# sg13cmos5l_o21ai_1_2.B1 0.10722f
C1462 sg13cmos5l_inv_1_0.A VDD 0.2568f
C1463 a_6086_14922# sg13cmos5l_xnor2_1_2.B 0.05954f
C1464 sg13cmos5l_dlygate4sd3_1_0.X VDD 0.44473f
C1465 a_25206_15302# sg13cmos5l_or3_1_1.X 0.05682f
C1466 a_26148_14040# a_26667_13844# 0.20773f
C1467 a_17318_14922# sg13cmos5l_buf_8_2.A 0.02999f
C1468 sg13cmos5l_or3_1_2.B sg13cmos5l_a21oi_1_3.B1 1.50917f
C1469 a_7829_15238# a_7680_15549# 0.19075f
C1470 a_6789_14495# sg13cmos5l_buf_1_10.X 0.01284f
C1471 a_4193_14750# a_4474_14448# 0.18796f
C1472 clock_i sg13cmos5l_dlygate4sd3_1_3.A 0.14753f
C1473 a_28074_14020# sg13cmos5l_dfrbpq_1_5.Q 0.07823f
C1474 a_20774_14922# VDD 0.52379f
C1475 a_21185_15424# sg13cmos5l_or3_1_2.B 0.03542f
C1476 sg13cmos5l_inv_1_0.A a_17806_15423# 0.12443f
C1477 sg13cmos5l_dfrbpq_1_2.Q a_16856_15238# 0.01361f
C1478 a_19120_14726# a_19530_14484# 0.07015f
C1479 a_21251_13690# sg13cmos5l_or3_1_2.B 0.15851f
C1480 a_10016_14570# sg13cmos5l_dlygate4sd3_1_8.X 0.01314f
C1481 sg13cmos5l_nand3_1_0.Y clock_i 0.04233f
C1482 sg13cmos5l_a21oi_1_3.Y sg13cmos5l_dfrbpq_1_5.D 0.30057f
C1483 a_6540_13238# sg13cmos5l_xnor2_1_2.B 0.25625f
C1484 sg13cmos5l_o21ai_1_1.Y sg13cmos5l_or3_1_2.X 0.05673f
C1485 a_20774_14922# a_21579_14495# 0.07916f
C1486 sg13cmos5l_dfrbpq_1_2.RESET_B sg13cmos5l_inv_1_0.Y 0.01813f
C1487 sg13cmos5l_and2_1_2.B VDD 0.23394f
C1488 sg13cmos5l_dfrbpq_1_2.Q a_19054_15423# 0.01821f
C1489 a_17238_15302# VDD 0.16045f
C1490 counter_value_o[2] a_12232_16082# 0.02116f
C1491 a_17994_14020# VDD 0.28402f
C1492 a_5613_14832# sg13cmos5l_buf_1_10.X 0.09367f
C1493 a_21348_14909# a_21579_14495# 0.07823f
C1494 sg13cmos5l_dfrbpq_1_2.Q sg13cmos5l_dfrbpq_1_2.CLK 0.01544f
C1495 sg13cmos5l_buf_8_2.A sg13cmos5l_nor2_1_0.B 0.19122f
C1496 sg13cmos5l_and2_1_1.X sg13cmos5l_xnor2_1_2.B 0.04672f
C1497 sg13cmos5l_a21oi_1_0.A2 sg13cmos5l_dfrbpq_1_3.D 0.13532f
C1498 sg13cmos5l_buf_8_2.X sg13cmos5l_or3_1_1.B 0.1628f
C1499 a_17126_15238# sg13cmos5l_dfrbpq_1_3.D 0.02016f
C1500 a_17238_15302# a_17806_15423# 0.01641f
C1501 sg13cmos5l_dfrbpq_1_7.Q sg13cmos5l_dfrbpq_1_5.Q 0.45875f
C1502 a_17578_14452# VDD 0.09602f
C1503 a_4432_15454# VDD 0.13966f
C1504 a_27500_15960# VDD 0.22496f
C1505 a_27617_15424# a_27898_15202# 0.18796f
C1506 sg13cmos5l_dfrbpq_1_2.RESET_B sg13cmos5l_nor2_1_0.B 0.07964f
C1507 sg13cmos5l_buf_8_2.X sg13cmos5l_dfrbpq_1_6.RESET_B 0.0379f
C1508 sg13cmos5l_or3_1_2.A sg13cmos5l_or3_1_1.B 0.02451f
C1509 sg13cmos5l_dfrbpq_1_5.RESET_B sg13cmos5l_dfrbpq_1_6.Q 0.03307f
C1510 sg13cmos5l_dfrbpq_1_2.D sg13cmos5l_dfrbpq_1_2.RESET_B 0.3532f
C1511 sg13cmos5l_o21ai_1_2.Y sg13cmos5l_o21ai_1_2.A2 0.08237f
C1512 a_26638_15423# VDD 0.15952f
C1513 sg13cmos5l_buf_1_10.X sg13cmos5l_dlygate4sd3_1_8.A 0.03261f
C1514 sg13cmos5l_a21oi_1_3.A2 sg13cmos5l_dlygate4sd3_1_17.A 0.05288f
C1515 a_18106_15960# sg13cmos5l_inv_1_0.Y 0.01212f
C1516 sg13cmos5l_dfrbpq_1_7.Q a_27472_14726# 0.01873f
C1517 sg13cmos5l_xnor2_1_2.B a_6286_13911# 0.05827f
C1518 a_27034_15202# sg13cmos5l_dfrbpq_1_7.Q 0.28887f
C1519 a_12524_15960# sg13cmos5l_dlygate4sd3_1_8.A 0.1978f
C1520 a_7888_14726# sg13cmos5l_dfrbpq_1_1.RESET_B 0.09622f
C1521 a_16587_13844# a_16356_13735# 0.07823f
C1522 a_16068_14040# a_17233_13799# 0.25046f
C1523 sg13cmos5l_or3_1_2.A sg13cmos5l_dfrbpq_1_6.RESET_B 0.02401f
C1524 a_5896_13854# a_6080_13854# 0.05762f
C1525 a_6286_13911# a_6401_13912# 0.3854f
C1526 sg13cmos5l_dfrbpq_1_2.Q sg13cmos5l_dfrbpq_1_3.Q 2.85025f
C1527 a_26554_16237# sg13cmos5l_dfrbpq_1_5.RESET_B 0.0434f
C1528 a_5886_15486# sg13cmos5l_dlygate4sd3_1_3.A 0.03759f
C1529 a_10016_14570# VDD 0.07441f
C1530 sg13cmos5l_or3_1_2.B a_21060_14488# 0.01273f
C1531 a_25094_15238# VDD 0.20673f
C1532 a_6372_14488# sg13cmos5l_dfrbpq_1_1.RESET_B 0.29766f
C1533 a_3872_14570# sg13cmos5l_xor2_1_0.B 0.01249f
C1534 a_17578_14452# a_17604_14488# 0.24169f
C1535 a_2916_15552# a_4175_15311# 0.01412f
C1536 a_4432_15454# a_4842_15532# 0.07015f
C1537 a_24169_14508# sg13cmos5l_a21oi_1_3.A2 0.12591f
C1538 a_2528_15366# VDD 0.08632f
C1539 a_18123_14495# sg13cmos5l_dfrbpq_1_2.Q 0.04207f
C1540 a_26638_15423# sg13cmos5l_or3_1_1.A 0.01026f
C1541 a_19450_15202# VDD 0.27372f
C1542 sg13cmos5l_or3_1_2.C sg13cmos5l_or3_1_2.B 0.64121f
C1543 a_7888_14726# sg13cmos5l_dlygate4sd3_1_1.A 0.01306f
C1544 sg13cmos5l_dfrbpq_1_3.RESET_B VDD 1.16418f
C1545 sg13cmos5l_dlygate4sd3_1_17.A sg13cmos5l_o21ai_1_2.B1 0.02204f
C1546 a_16856_15238# sg13cmos5l_a21oi_1_0.Y 0.27231f
C1547 sg13cmos5l_buf_8_2.X a_24824_14525# 0.01711f
C1548 a_21562_15960# a_21946_16237# 0.01303f
C1549 sg13cmos5l_a21oi_1_1.Y a_21281_16262# 0.02116f
C1550 a_21166_16263# sg13cmos5l_dfrbpq_1_6.D 0.10665f
C1551 a_26170_15202# sg13cmos5l_dfrbpq_1_7.RESET_B 0.03678f
C1552 sg13cmos5l_a21oi_1_2.A1 a_25390_16263# 0.10831f
C1553 a_16042_13945# sg13cmos5l_dfrbpq_1_2.RESET_B 0.19612f
C1554 a_8582_15238# sg13cmos5l_nand4_1_0.Y 0.0177f
C1555 a_6372_14488# sg13cmos5l_dlygate4sd3_1_1.A 0.03332f
C1556 a_25094_15238# sg13cmos5l_or3_1_1.A 0.04844f
C1557 a_15579_14854# sg13cmos5l_a21oi_1_0.Y 0.03237f
C1558 a_17806_15423# sg13cmos5l_dfrbpq_1_3.RESET_B 0.05914f
C1559 sg13cmos5l_inv_1_0.Y sg13cmos5l_nor2_1_0.B 0.02795f
C1560 a_6086_14922# VDD 0.52224f
C1561 a_8298_14484# VDD 0.27815f
C1562 sg13cmos5l_inv_1_0.A sg13cmos5l_or3_1_1.B 0.44688f
C1563 a_24169_14508# sg13cmos5l_o21ai_1_2.B1 0.24209f
C1564 a_26638_15423# sg13cmos5l_a21oi_1_3.Y 0.01596f
C1565 sg13cmos5l_a21oi_1_0.Y sg13cmos5l_dfrbpq_1_2.CLK 0.1806f
C1566 a_6372_14488# sg13cmos5l_xnor2_1_2.A 0.01799f
C1567 a_9737_14822# sg13cmos5l_tiehi_1.L_HI 0.01916f
C1568 sg13cmos5l_buf_1_10.X sg13cmos5l_buf_1_0.X 0.13688f
C1569 a_38720_10034# VDD 0.0583f
C1570 a_9861_15213# sg13cmos5l_dlygate4sd3_1_8.A 0.01043f
C1571 a_9658_14725# VDD 0.10119f
C1572 a_2890_15457# a_2916_15552# 0.24169f
C1573 a_3435_15356# a_4175_15311# 0.17382f
C1574 VDD a_16552_15996# 0.18144f
C1575 a_17604_14488# sg13cmos5l_dfrbpq_1_3.RESET_B 0.30415f
C1576 a_6540_13238# VDD 0.19533f
C1577 a_16068_14040# VDD 0.08143f
C1578 sg13cmos5l_buf_8_2.A sg13cmos5l_buf_1_10.X 0.38553f
C1579 a_11370_15532# sg13cmos5l_dlygate4sd3_1_8.A 0.09118f
C1580 sg13cmos5l_dfrbpq_1_6.RESET_B a_20774_14922# 0.07398f
C1581 a_24169_14508# a_24365_14508# 0.01485f
C1582 a_22508_15960# VDD 0.22831f
C1583 a_25956_14488# sg13cmos5l_dfrbpq_1_7.Q 0.03198f
C1584 sg13cmos5l_buf_8_2.X sg13cmos5l_o21ai_1_1.Y 0.26217f
C1585 sg13cmos5l_a21oi_1_2.A1 sg13cmos5l_or3_1_1.X 0.23534f
C1586 a_25094_15238# a_25206_15302# 0.3854f
C1587 sg13cmos5l_dfrbpq_1_2.D sg13cmos5l_nor2_1_0.B 0.11174f
C1588 a_22145_15424# a_22426_15202# 0.18796f
C1589 a_17994_14020# sg13cmos5l_or3_1_1.B 0.01534f
C1590 sg13cmos5l_dfrbpq_1_6.Q sg13cmos5l_dfrbpq_1_3.Q 0.18548f
C1591 sg13cmos5l_and2_1_1.X VDD 0.27664f
C1592 a_18021_14495# sg13cmos5l_buf_8_2.A 0.01317f
C1593 counter_value_o[7] VSS 2.33359f
C1594 counter_value_o[6] VSS 1.63261f
C1595 counter_value_o[5] VSS 1.92698f
C1596 counter_value_o[4] VSS 1.56945f
C1597 counter_value_o[3] VSS 1.53899f
C1598 counter_value_o[2] VSS 1.74775f
C1599 counter_value_o[1] VSS 1.5799f
C1600 counter_value_o[0] VSS 1.63892f
C1601 a_38720_3986# VSS 0.07631f ; **FLOATING
C1602 a_38536_3986# VSS 0.10768f ; **FLOATING
C1603 a_38720_10034# VSS 0.07628f ; **FLOATING
C1604 a_38536_10034# VSS 0.10768f ; **FLOATING
C1605 a_38720_13058# VSS 0.08763f ; **FLOATING
C1606 a_25109_12972# VSS 0.25522f
C1607 a_25203_13320# VSS 0.45994f
C1608 a_6575_13342# VSS 0.20137f
C1609 a_6280_13058# VSS 0.09809f ; **FLOATING
C1610 a_38720_13854# VSS 0.07452f ; **FLOATING
C1611 a_38536_13854# VSS 0.10767f ; **FLOATING
C1612 a_27826_13722# VSS 0.39632f
C1613 a_27313_13799# VSS 0.06782f
C1614 a_26374_13735# VSS 0.53262f
C1615 a_26436_13735# VSS 0.53884f
C1616 a_27609_14037# VSS 0.29831f
C1617 a_25956_13722# VSS 0.06121f
C1618 a_26505_14113# VSS 0.13109f
C1619 a_25862_13722# VSS 0.30589f
C1620 a_25037_14020# VSS 0.26318f
C1621 a_24704_13854# VSS 0.0401f ; **FLOATING
C1622 a_24520_13854# VSS 0.1039f ; **FLOATING
C1623 a_24841_13726# VSS 0.15095f
C1624 a_21549_14020# VSS 0.28251f
C1625 a_21460_14020# VSS 0.52082f
C1626 a_20968_13854# VSS 0.09008f ; **FLOATING
C1627 a_19232_13854# VSS 0.03773f ; **FLOATING
C1628 a_19048_13854# VSS 0.09994f ; **FLOATING
C1629 a_21251_13690# VSS 0.03834f
C1630 a_17233_13799# VSS 0.20929f
C1631 a_16356_13735# VSS 0.13271f
C1632 a_17529_14037# VSS 0.07696f
C1633 a_16425_14113# VSS 0.50217f
C1634 a_16068_14040# VSS 0.20049f
C1635 a_15782_13722# VSS 1.15951f
C1636 a_15680_13854# VSS 0.04657f ; **FLOATING
C1637 a_6080_13854# VSS 0.03878f ; **FLOATING
C1638 a_5896_13854# VSS 0.10286f ; **FLOATING
C1639 a_6286_13911# VSS 0.14189f
C1640 a_38720_14570# VSS 0.08673f ; **FLOATING
C1641 a_27417_14607# VSS 0.12686f
C1642 a_26313_14531# VSS 0.09521f
C1643 a_27634_14922# VSS 0.04455f
C1644 a_27121_14845# VSS 0.0678f
C1645 a_27472_14726# VSS 0.02568f
C1646 a_26244_14909# VSS 0.55965f
C1647 a_26182_14909# VSS 0.79375f
C1648 a_24263_14508# VSS 0.59707f
C1649 a_23736_14464# VSS 0.04886f
C1650 a_25764_14922# VSS 0.16376f
C1651 a_25670_14922# VSS 0.72012f
C1652 a_25094_14484# VSS 0.18968f
C1653 a_23552_14570# VSS 0.03863f ; **FLOATING
C1654 a_23368_14570# VSS 0.08476f ; **FLOATING
C1655 a_23638_14862# VSS 0.16918f
C1656 a_21417_14531# VSS 0.57652f
C1657 a_20376_14464# VSS 0.24207f
C1658 a_22225_14845# VSS 0.28476f
C1659 a_21348_14909# VSS 0.03666f
C1660 a_20868_14922# VSS 0.17329f
C1661 a_20774_14922# VSS 0.50797f
C1662 a_20278_14862# VSS 0.18479f
C1663 a_17961_14531# VSS 0.07346f
C1664 a_18769_14845# VSS 0.30331f
C1665 a_17892_14909# VSS 0.54013f
C1666 a_17830_14909# VSS 0.50346f
C1667 a_16955_14484# VSS 0.16646f
C1668 a_15338_14484# VSS 0.31827f
C1669 a_17412_14922# VSS 0.19118f
C1670 a_17057_14832# VSS 0.25488f
C1671 a_17318_14922# VSS 0.55406f
C1672 a_14344_14570# VSS 0.11656f ; **FLOATING
C1673 a_10016_14570# VSS 0.0411f ; **FLOATING
C1674 a_10618_14448# VSS 0.09765f
C1675 a_10222_14751# VSS 0.16058f
C1676 a_9536_14570# VSS 0.04987f ; **FLOATING
C1677 a_7833_14607# VSS 0.21642f
C1678 a_9658_14725# VSS 0.08137f
C1679 a_8779_14832# VSS 2.05795f
C1680 a_6729_14531# VSS 0.50345f
C1681 a_8050_14922# VSS 0.43618f
C1682 a_7537_14845# VSS 0.14418f
C1683 a_6660_14909# VSS 0.35245f
C1684 a_6598_14909# VSS 0.31578f
C1685 a_6180_14922# VSS 0.18831f
C1686 a_5707_14832# VSS 0.04721f
C1687 a_5504_14570# VSS 0.06581f ; **FLOATING
C1688 a_6086_14922# VSS 0.60611f
C1689 sg13cmos5l_dlygate4sd3_1_0.X VSS 0.04225f
C1690 a_3872_14570# VSS 0.06949f ; **FLOATING
C1691 a_2516_14484# VSS 0.22627f
C1692 a_2646_14842# VSS 0.0482f
C1693 a_2059_14832# VSS 0.62272f
C1694 a_1856_14570# VSS 0.06669f ; **FLOATING
C1695 a_1965_14832# VSS 0.07071f
C1696 a_38720_15366# VSS 0.08766f ; **FLOATING
C1697 a_27502_15423# VSS 0.16892f
C1698 a_24310_15230# VSS 1.57381f
C1699 a_24062_15242# VSS 0.06305f
C1700 a_23858_15242# VSS 0.01275f
C1701 a_23480_15242# VSS 0.09203f
C1702 a_23378_15242# VSS 0.04678f
C1703 a_25094_15238# VSS 0.18921f
C1704 sg13cmos5l_o21ai_1_2.Y VSS 0.11754f
C1705 a_24408_15552# VSS 0.41208f
C1706 a_23168_15366# VSS 0.05136f ; **FLOATING
C1707 a_21824_15366# VSS 0.04409f ; **FLOATING
C1708 a_20705_15260# VSS 0.09764f
C1709 a_20603_15532# VSS 0.32519f
C1710 a_20000_15366# VSS 0.03804f ; **FLOATING
C1711 a_19816_15366# VSS 0.08226f ; **FLOATING
C1712 a_21070_15423# VSS 0.03026f
C1713 sg13cmos5l_dlygate4sd3_1_9.X VSS 0.09206f
C1714 a_18665_15180# VSS 0.05051f
C1715 a_16175_15238# VSS 0.37281f
C1716 a_17238_15302# VSS 0.19906f
C1717 sg13cmos5l_a21oi_1_0.Y VSS 0.0238f
C1718 a_15870_15486# VSS 0.0567f
C1719 a_11752_15366# VSS 0.08325f ; **FLOATING
C1720 a_10609_15311# VSS 0.14761f
C1721 a_9670_15247# VSS 0.07864f
C1722 a_9732_15247# VSS 0.1153f
C1723 a_10905_15549# VSS 0.09938f
C1724 a_9252_15234# VSS 0.20127f
C1725 a_7829_15238# VSS 0.09487f
C1726 a_9801_15625# VSS 0.50347f
C1727 a_9158_15234# VSS 1.45711f
C1728 a_9418_15457# VSS 0.0195f
C1729 a_8582_15238# VSS 0.3273f
C1730 a_7058_15242# VSS 0.49023f
C1731 a_6578_15242# VSS 0.56482f
C1732 a_7923_15532# VSS 0.30095f
C1733 sg13cmos5l_nand4_1_0.Y VSS 0.03957f
C1734 a_5600_15366# VSS 0.04738f ; **FLOATING
C1735 a_5886_15486# VSS 0.0851f
C1736 a_4081_15311# VSS 0.14662f
C1737 a_3142_15247# VSS 0.97322f
C1738 a_3204_15247# VSS 0.72225f
C1739 a_3273_15625# VSS 0.02173f
C1740 a_2630_15234# VSS 0.4784f
C1741 sg13cmos5l_and2_1_0.X VSS 0.09449f
C1742 a_2528_15366# VSS 0.06282f ; **FLOATING
C1743 a_2890_15457# VSS 0.09289f
C1744 a_37192_16082# VSS 0.09909f ; **FLOATING
C1745 a_37484_15960# VSS 0.01239f
C1746 a_32200_16082# VSS 0.09676f ; **FLOATING
C1747 a_27296_16082# VSS 0.05227f ; **FLOATING
C1748 a_24923_15996# VSS 0.22259f
C1749 a_26170_16237# VSS 0.08239f
C1750 a_25025_16344# VSS 0.25926f
C1751 sg13cmos5l_dlygate4sd3_1_17.A VSS 0.15997f
C1752 a_26633_16334# VSS 0.07084f
C1753 a_25786_15960# VSS 0.41618f
C1754 a_25390_16263# VSS 0.06506f
C1755 a_22304_16082# VSS 0.04037f ; **FLOATING
C1756 a_21946_16237# VSS 0.05753f
C1757 a_20960_16082# VSS 0.06776f ; **FLOATING
C1758 a_17165_16020# VSS 0.1776f
C1759 sg13cmos5l_dfrbpq_1_6.D VSS 0.18416f
C1760 a_22025_16334# VSS 0.04998f
C1761 a_18454_16374# VSS 0.15119f
C1762 a_16969_16020# VSS 0.10779f
C1763 sg13cmos5l_inv_1_0.Y VSS 0.2253f
C1764 a_12232_16082# VSS 0.09383f ; **FLOATING
C1765 sg13cmos5l_dlygate4sd3_1_1.A VSS 0.09828f
C1766 a_7240_16082# VSS 0.09487f ; **FLOATING
C1767 a_3008_16082# VSS 0.03902f ; **FLOATING
C1768 a_2824_16082# VSS 0.07953f ; **FLOATING
C1769 a_3130_16237# VSS 0.09764f
C1770 a_2248_16082# VSS 0.10237f ; **FLOATING
C1771 VSS.t7 VSS 0.29772f
C1772 VSS.t4 VSS 5.47241f
C1773 VSS.t302 VSS 0.16724f
C1774 VSS.t2909 VSS 0.01995f
C1775 VSS.t2924 VSS 0.17545f
C1776 VSS.t2929 VSS 0.06052f
C1777 VSS.t2944 VSS 0.03687f
C1778 VSS.t2964 VSS 0.04589f
C1779 VSS.t2682 VSS 0.17563f
C1780 VSS.t2689 VSS 0.03253f
C1781 VSS.t2695 VSS 0.45397f
C1782 VSS.t2700 VSS 0.23969f
C1783 VSS.t2699 VSS 0.30286f
C1784 VSS.t2707 VSS 0.11233f
C1785 VSS.t3021 VSS 0.03664f
C1786 VSS.t3016 VSS 0.03516f
C1787 VSS.t3019 VSS 0.03664f
C1788 VSS.t3014 VSS 0.03516f
C1789 VSS.t2999 VSS 0.14658f
C1790 VSS.t2994 VSS 0.06341f
C1791 VSS.t2988 VSS 0.03026f
C1792 VSS.t2989 VSS 0.04523f
C1793 VSS.t2978 VSS 0.14918p
C1794 VSS.t2979 VSS 0.14918p
C1795 VSS.t3044 VSS 0.17977f
C1796 VSS.t3139 VSS 0.14412f
C1797 VSS.t2719 VSS 0.01244f
C1798 VSS.t2720 VSS 0.01244f
C1799 VSS.t2728 VSS 0.43125f
C1800 VSS.t2736 VSS 0.01055f
C1801 VSS.t2735 VSS 0.01055f
C1802 VSS.t2739 VSS 0.21471f
C1803 VSS.t2745 VSS 0.0598f
C1804 VSS.t2744 VSS 0.0598f
C1805 VSS.t1167 VSS 0.03142f
C1806 VSS.t2227 VSS 0.02295f
C1807 VSS.t2221 VSS 0.098f
C1808 VSS.t2222 VSS 0.098f
C1809 VSS.t2247 VSS 0.22698f
C1810 VSS.t2252 VSS 0.3776f
C1811 VSS.t2254 VSS 0.3776f
C1812 VSS.t2262 VSS 0.0348f
C1813 VSS.t2267 VSS 0.57558f
C1814 VSS.t2277 VSS 0.10324f
C1815 VSS.t2276 VSS 0.01657f
C1816 VSS.t2281 VSS 0.14106f
C1817 VSS.t2282 VSS 0.14106f
C1818 VSS.t2291 VSS 0.22939f
C1819 VSS.t2292 VSS 0.26542f
C1820 VSS.t2297 VSS 0.2012f
C1821 VSS.t2301 VSS 0.12036f
C1822 VSS.t2302 VSS 0.12036f
C1823 VSS.t2307 VSS 0.16676f
C1824 VSS.t2317 VSS 0.49836f
C1825 VSS.t2322 VSS 0.26541f
C1826 VSS.t2327 VSS 0.52719f
C1827 VSS.t2332 VSS 0.12129f
C1828 VSS.t2337 VSS 0.44145f
C1829 VSS.t2336 VSS 0.44145f
C1830 VSS.t2342 VSS 0.25173f
C1831 VSS.t2357 VSS 0.12872f
C1832 VSS.t2362 VSS 0.25174f
C1833 VSS.t2377 VSS 0.24918f
C1834 VSS.t2402 VSS 0.06771f
C1835 VSS.t2407 VSS 0.12276f
C1836 VSS.t2412 VSS 0.07206f
C1837 VSS.t2417 VSS 0.01038f
C1838 VSS.t2416 VSS 0.01038f
C1839 VSS.t2422 VSS 0.06925f
C1840 VSS.t2427 VSS 0.05073f
C1841 VSS.t2437 VSS 0.13625f
C1842 VSS.t2447 VSS 0.03463f
C1843 VSS.t2457 VSS 0.19927f
C1844 VSS.t2462 VSS 0.05336f
C1845 VSS.t2467 VSS 0.10848f
C1846 VSS.t2464 VSS 0.05336f
C1847 VSS.t2466 VSS 0.10848f
C1848 VSS.t2477 VSS 0.07787f
C1849 VSS.t2476 VSS 0.07787f
C1850 VSS.t2482 VSS 0.27378f
C1851 VSS.t2491 VSS 0.04219f
C1852 VSS.t2492 VSS 0.05959f
C1853 VSS.t2497 VSS 0.04172f
C1854 VSS.t2494 VSS 0.0174f
C1855 VSS.t2429 VSS 0.05073f
C1856 VSS.t2329 VSS 0.02552f
C1857 VSS.t2279 VSS 0.08667f
C1858 VSS.t2269 VSS 0.17661f
C1859 VSS.t1453 VSS 0.63743f
C1860 VSS.t1458 VSS 0.19197f
C1861 VSS.t1463 VSS 0.28211f
C1862 VSS.t1468 VSS 0.08206f
C1863 VSS.t1473 VSS 0.06103f
C1864 VSS.t1478 VSS 0.07204f
C1865 VSS.t1483 VSS 0.28211f
C1866 VSS.t1493 VSS 0.20053f
C1867 VSS.t1503 VSS 0.08773f
C1868 VSS.t1523 VSS 0.78225f
C1869 VSS.t1528 VSS 0.02111f
C1870 VSS.t1920 VSS 0.13296f
C1871 VSS.t1919 VSS 0.13296f
C1872 VSS.t1912 VSS 0.1061f
C1873 VSS.t1907 VSS 0.11995f
C1874 VSS.t1910 VSS 0.1061f
C1875 VSS.t1902 VSS 0.14098f
C1876 VSS.t1905 VSS 0.11995f
C1877 VSS.t1900 VSS 0.14098f
C1878 VSS.t1892 VSS 1.52005f
C1879 VSS.t1890 VSS 1.52005f
C1880 VSS.t1874 VSS 0.03386f
C1881 VSS.t1875 VSS 0.03386f
C1882 VSS.t1869 VSS 0.0317f
C1883 VSS.t1870 VSS 0.0317f
C1884 VSS.t1859 VSS 0.17341f
C1885 VSS.t1860 VSS 0.17341f
C1886 VSS.t1855 VSS 0.10324f
C1887 VSS.t1850 VSS 0.32028f
C1888 VSS.t1830 VSS 0.04202f
C1889 VSS.t1935 VSS 0.0888f
C1890 VSS.t1940 VSS 0.04195f
C1891 VSS.t1950 VSS 0.0443f
C1892 VSS.t1955 VSS 0.22939f
C1893 VSS.t1959 VSS 0.01001f
C1894 VSS.t1960 VSS 0.01001f
C1895 VSS.t1965 VSS 0.03942f
C1896 VSS.t1975 VSS 0.01771f
C1897 VSS.t1980 VSS 0.12504f
C1898 VSS.t1990 VSS 0.12093f
C1899 VSS.t1593 VSS 0.50367f
C1900 VSS.t1578 VSS 0.11899f
C1901 VSS.t1573 VSS 0.03848f
C1902 VSS.t1563 VSS 0.02994f
C1903 VSS.t1557 VSS 0.19097f
C1904 VSS.t1558 VSS 0.86215f
C1905 VSS.t1543 VSS 0.11959f
C1906 VSS.t1595 VSS 0.35526f
C1907 VSS.t1597 VSS 0.11942f
C1908 VSS.t1598 VSS 0.11942f
C1909 VSS.t1613 VSS 0.01971f
C1910 VSS.t1618 VSS 0.1554f
C1911 VSS.t1628 VSS 0.27388f
C1912 VSS.t1638 VSS 0.05899f
C1913 VSS.t1648 VSS 0.11685f
C1914 VSS.t1653 VSS 0.07033f
C1915 VSS.t1658 VSS 0.20769f
C1916 VSS.t1657 VSS 0.08182f
C1917 VSS.t1663 VSS 0.01944f
C1918 VSS.t1668 VSS 0.21696f
C1919 VSS.t1673 VSS 0.25691f
C1920 VSS.t1683 VSS 0.07668f
C1921 VSS.t1693 VSS 0.08438f
C1922 VSS.t1698 VSS 0.19179f
C1923 VSS.t1708 VSS 0.05162f
C1924 VSS.t1712 VSS 0.02975f
C1925 VSS.t1713 VSS 0.02975f
C1926 VSS.t1004 VSS 0.10671f
C1927 VSS.t994 VSS 0.09974f
C1928 VSS.t983 VSS 0.02979f
C1929 VSS.t984 VSS 0.02979f
C1930 VSS.t974 VSS 0.06261f
C1931 VSS.t961 VSS 0.05181f
C1932 VSS.t959 VSS 0.05181f
C1933 VSS.t954 VSS 0.03542f
C1934 VSS.t948 VSS 0.04799f
C1935 VSS.t949 VSS 0.04799f
C1936 VSS.t944 VSS 0.05104f
C1937 VSS.t939 VSS 0.22936f
C1938 VSS.t933 VSS 0.03603f
C1939 VSS.t934 VSS 0.17669f
C1940 VSS.t914 VSS 0.21343f
C1941 VSS.t889 VSS 0.01475f
C1942 VSS.t883 VSS 0.03536f
C1943 VSS.t884 VSS 0.03536f
C1944 VSS.t869 VSS 0.18356f
C1945 VSS.t859 VSS 0.09599f
C1946 VSS.t849 VSS 0.29837p
C1947 VSS.t839 VSS 0.0696f
C1948 VSS.t833 VSS 0.05691f
C1949 VSS.t834 VSS 0.26304f
C1950 VSS.t811 VSS 0.06159f
C1951 VSS.t809 VSS 0.06159f
C1952 VSS.t799 VSS 0.03373f
C1953 VSS.t789 VSS 0.06676f
C1954 VSS.t783 VSS 0.27354f
C1955 VSS.t784 VSS 0.43719f
C1956 VSS.t779 VSS 0.11609f
C1957 VSS.t769 VSS 0.03408f
C1958 VSS.t854 VSS 0.25467f
C1959 VSS.t556 VSS 0.04725f
C1960 VSS.t566 VSS 0.21525f
C1961 VSS.t570 VSS 0.27342f
C1962 VSS.t679 VSS 0.27342f
C1963 VSS.t44 VSS 0.20049f
C1964 VSS.t93 VSS 0.3123f
C1965 VSS.t573 VSS 0.35549f
C1966 VSS.t704 VSS 0.03782f
C1967 VSS.t83 VSS 0.03834f
C1968 VSS.t341 VSS 0.05949f
C1969 VSS.t9 VSS 0.12232f
C1970 VSS.t3 VSS 0.66694f
C1971 VSS.t113 VSS 0.18968f
C1972 VSS.t3220 VSS 0.4583f
C1973 VSS.t58 VSS 1.46641f
C1974 VSS.t407 VSS 0.04604f
C1975 VSS.t406 VSS 0.04604f
C1976 VSS.t419 VSS 0.20178f
C1977 VSS.t422 VSS 0.08245f
C1978 VSS.t421 VSS 0.08245f
C1979 VSS.t425 VSS 0.33408f
C1980 VSS.t434 VSS 0.14106f
C1981 VSS.t433 VSS 0.14106f
C1982 VSS.t437 VSS 0.05338f
C1983 VSS.t369 VSS 0.11596f
C1984 VSS.t231 VSS 0.04333f
C1985 VSS.t346 VSS 0.02098f
C1986 VSS.t163 VSS 0.15287f
C1987 VSS.t89 VSS 0.53349f
C1988 VSS.t323 VSS 0.08338f
C1989 VSS.t11 VSS 0.62967f
C1990 VSS.t38 VSS 0.52065f
C1991 VSS.t506 VSS 0.10502f
C1992 VSS.t41 VSS 0.8005f
C1993 VSS.t134 VSS 0.64105f
C1994 VSS.t136 VSS 0.02525f
C1995 VSS.t34 VSS 0.30151f
C1996 VSS.t1 VSS 0.06244f
C1997 VSS.t193 VSS 0.55463f
C1998 VSS.t76 VSS 0.65427f
C1999 VSS.t25 VSS 0.37156f
C2000 VSS.t121 VSS 0.48365f
C2001 VSS.t16 VSS 3.21827f
C2002 VSS.t171 VSS 0.4511f
C2003 VSS.t157 VSS 0.20865f
C2004 VSS.t179 VSS 0.29411f
C2005 VSS.t138 VSS 0.06284f
C2006 VSS.t399 VSS 0.06284f
C2007 VSS.t176 VSS 0.21698f
C2008 VSS.t3261 VSS 0.03386f
C2009 VSS.t47 VSS 0.44774f
C2010 VSS.t655 VSS 0.08634f
C2011 VSS.t521 VSS 0.19534f
C2012 VSS.t520 VSS 0.0238f
C2013 VSS.t526 VSS 0.06046f
C2014 VSS.t536 VSS 0.02215f
C2015 VSS.t541 VSS 0.01802f
C2016 VSS.t543 VSS 0.01802f
C2017 VSS.t523 VSS 0.17154f
C2018 VSS.t60 VSS 0.78513f
C2019 VSS.t243 VSS 0.0722f
C2020 VSS.t724 VSS 0.42696f
C2021 VSS.t723 VSS 0.40992f
C2022 VSS.t728 VSS 0.76856f
C2023 VSS.t617 VSS 0.07207f
C2024 VSS.t620 VSS 0.20188f
C2025 VSS.t623 VSS 0.28101f
C2026 VSS.t626 VSS 0.0238f
C2027 VSS.t629 VSS 0.0238f
C2028 VSS.t996 VSS 0.09974f
C2029 VSS.t1009 VSS 0.04005f
C2030 VSS.t1013 VSS 0.04501f
C2031 VSS.t1014 VSS 0.04501f
C2032 VSS.t1024 VSS 0.23946f
C2033 VSS.t1034 VSS 0.2162f
C2034 VSS.t1039 VSS 0.18907f
C2035 VSS.t1300 VSS 0.19736f
C2036 VSS.t1291 VSS 0.0159f
C2037 VSS.t1276 VSS 0.02133f
C2038 VSS.t1275 VSS 0.02133f
C2039 VSS.t1273 VSS 0.04169f
C2040 VSS.t1272 VSS 0.04169f
C2041 VSS.t1270 VSS 0.06847f
C2042 VSS.t1267 VSS 0.05009f
C2043 VSS.t1263 VSS 0.16724f
C2044 VSS.t1262 VSS 0.16724f
C2045 VSS.t1245 VSS 0.04215f
C2046 VSS.t1241 VSS 0.20637f
C2047 VSS.t1240 VSS 0.20637f
C2048 VSS.t1227 VSS 0.09962f
C2049 VSS.t1216 VSS 0.11638f
C2050 VSS.t1215 VSS 0.11638f
C2051 VSS.t1199 VSS 0.0321f
C2052 VSS.t1198 VSS 0.0786f
C2053 VSS.t1197 VSS 0.04651f
C2054 VSS.t1195 VSS 0.18317f
C2055 VSS.t1194 VSS 0.22896f
C2056 VSS.t1192 VSS 0.14894f
C2057 VSS.t1180 VSS 0.14413f
C2058 VSS.t1177 VSS 0.86786f
C2059 VSS.t1175 VSS 0.25677f
C2060 VSS.t1169 VSS 0.0931f
C2061 VSS.t1422 VSS 0.13887f
C2062 VSS.t1303 VSS 0.11248f
C2063 VSS.t1302 VSS 0.02581f
C2064 VSS.t1425 VSS 0.25174f
C2065 VSS.t1306 VSS 0.25174f
C2066 VSS.t1314 VSS 0.07835f
C2067 VSS.t1312 VSS 0.06088f
C2068 VSS.t1315 VSS 0.07835f
C2069 VSS.t1318 VSS 0.1862f
C2070 VSS.t1317 VSS 0.16935f
C2071 VSS.t1301 VSS 0.08667f
C2072 VSS.t2070 VSS 0.08526f
C2073 VSS.t2060 VSS 0.08623f
C2074 VSS.t2045 VSS 0.07071f
C2075 VSS.t2020 VSS 0.43393f
C2076 VSS.t2007 VSS 0.09598f
C2077 VSS.t2010 VSS 0.06283f
C2078 VSS.t2004 VSS 0.02101f
C2079 VSS.t2005 VSS 0.117f
C2080 VSS.t1999 VSS 0.03687f
C2081 VSS.t2000 VSS 0.03687f
C2082 VSS.t2064 VSS 0.04311f
C2083 VSS.t2065 VSS 0.04311f
C2084 VSS.t2075 VSS 0.28197f
C2085 VSS.t2089 VSS 0.02669f
C2086 VSS.t2090 VSS 0.02669f
C2087 VSS.t2105 VSS 0.02111f
C2088 VSS.t2107 VSS 0.02111f
C2089 VSS.t1678 VSS 0.08907f
C2090 VSS.t1620 VSS 0.02568f
C2091 VSS.t1995 VSS 0.59675p
C2092 VSS.t2616 VSS 0.01049f
C2093 VSS.t2615 VSS 0.01049f
C2094 VSS.t2618 VSS 0.0238f
C2095 VSS.t2621 VSS 0.03603f
C2096 VSS.t2622 VSS 0.03603f
C2097 VSS.t2625 VSS 0.01239f
C2098 VSS.t2629 VSS 0.03687f
C2099 VSS.t2642 VSS 0.04333f
C2100 VSS.t2640 VSS 0.04333f
C2101 VSS.t2648 VSS 0.06747f
C2102 VSS.t2649 VSS 0.13881f
C2103 VSS.t2650 VSS 0.13881f
C2104 VSS.t2654 VSS 0.29777f
C2105 VSS.t2655 VSS 0.29777f
C2106 VSS.t2663 VSS 0.01924f
C2107 VSS.t2754 VSS 0.11915f
C2108 VSS.t2762 VSS 0.01768f
C2109 VSS.t2763 VSS 0.16871f
C2110 VSS.t2766 VSS 0.14021f
C2111 VSS.t2769 VSS 0.06319f
.ends
