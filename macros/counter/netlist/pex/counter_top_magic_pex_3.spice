* PEX produced on Wed Aug 26 09:48:10 AM CEST 2026 using /foss/tools/sak/sak-pex.sh with m=3 and s=1 (extresist threshold=10000 mOhm, minres=1000 mOhm, mindelay=1 ps)
* NGSPICE file created from counter_top_pex.ext - technology: ihp-sg13cmos5l

.subckt counter_top_pex VDD VSS clock_i reset_n_i enable_i counter_value_o[0]
+ counter_value_o[1] counter_value_o[2] counter_value_o[3] counter_value_o[4]
+ counter_value_o[5] counter_value_o[6] counter_value_o[7]
X0 VDD VSS.t924 VDD VDD sg13_lv_pmos ad=0.19p pd=1.38u as=3.19196n ps=0.01242 w=1u l=1u
X1 VDD enable_i a_1192_3900# VDD sg13_lv_pmos ad=0.2114p pd=1.54u as=0.2856p ps=2.36u w=0.84u l=0.13u
X2 VDD VSS.t2668 VDD VDD sg13_lv_pmos ad=0.19p pd=1.38u as=0 ps=0 w=1u l=1u
X3 VSS.t41 a_4432_15454# a_4081_15311# VSS.t68 sg13_lv_nmos ad=79.8f pd=0.8u as=0.1428p ps=1.52u w=0.42u l=0.13u
X4 VDD VSS.t1761 VDD VDD sg13_lv_pmos ad=0.34p pd=2.68u as=0 ps=0 w=1u l=1u
X5 VSS.t2049 VDD VSS.t2051 VSS.t2050 sg13_lv_nmos ad=79.8f pd=0.8u as=0 ps=0 w=0.42u l=1u
X6 VDD sg13cmos5l_and2_1_2.B a_8685_14832# VDD sg13_lv_pmos ad=0.1918p pd=1.5u as=0.1596p ps=1.22u w=0.84u l=0.13u
X7 VDD VSS.t630 VDD VDD sg13_lv_pmos ad=0.34p pd=2.68u as=0 ps=0 w=1u l=1u
X8 VSS.t1612 VDD VSS.t1614 VSS.t1613 sg13_lv_nmos ad=79.8f pd=0.8u as=0 ps=0 w=0.42u l=1u
X9 VSS.t3134 VDD VSS.t3136 VSS.t3135 sg13_lv_nmos ad=79.8f pd=0.8u as=0 ps=0 w=0.42u l=1u
X10 VDD VSS.t1208 VDD VDD sg13_lv_pmos ad=0.34p pd=2.68u as=0 ps=0 w=1u l=1u
X11 VSS.t2004 VDD VSS.t2003 VSS.t2002 sg13_lv_nmos ad=0.1428p pd=1.52u as=0 ps=0 w=0.42u l=1u
X12 VDD VSS.t861 VDD VDD sg13_lv_pmos ad=0.34p pd=2.68u as=0 ps=0 w=1u l=1u
X13 VSS.t2678 VDD VSS.t2679 VSS.t199 sg13_lv_nmos ad=79.8f pd=0.8u as=0 ps=0 w=0.42u l=1u
X14 VSS.t1350 VDD VSS.t1349 VSS.t248 sg13_lv_nmos ad=0.1428p pd=1.52u as=0 ps=0 w=0.42u l=1u
X15 VDD VSS.t2450 VDD VDD sg13_lv_pmos ad=0.34p pd=2.68u as=0 ps=0 w=1u l=1u
X16 VDD VSS.t2108 VDD VDD sg13_lv_pmos ad=0.34p pd=2.68u as=0 ps=0 w=1u l=1u
X17 VDD VSS.t1883 VDD VDD sg13_lv_pmos ad=0.34p pd=2.68u as=0 ps=0 w=1u l=1u
X18 VDD VSS.t2679 VDD VDD sg13_lv_pmos ad=0.34p pd=2.68u as=0 ps=0 w=1u l=1u
X19 VSS.t982 VDD VSS.t981 VSS.t980 sg13_lv_nmos ad=0.1428p pd=1.52u as=0 ps=0 w=0.42u l=1u
X20 VDD VSS.t597 VDD VDD sg13_lv_pmos ad=0.34p pd=2.68u as=0 ps=0 w=1u l=1u
X21 VSS.t1027 VDD VSS.t1026 VSS.t1025 sg13_lv_nmos ad=0.1428p pd=1.52u as=0 ps=0 w=0.42u l=1u
X22 VDD VSS.t1217 VDD VDD sg13_lv_pmos ad=0.34p pd=2.68u as=0 ps=0 w=1u l=1u
X23 a_27500_15960# sg13cmos5l_dfrbpq_1_6.Q VSS.t118 VSS.t3219 sg13_lv_nmos ad=0.187p pd=1.78u as=0.14875p ps=1.16u w=0.55u l=0.13u
X24 VDD VSS.t1079 VDD VDD sg13_lv_pmos ad=0.19p pd=1.38u as=0 ps=0 w=1u l=1u
X25 VDD VSS.t1327 VDD VDD sg13_lv_pmos ad=0.19p pd=1.38u as=0 ps=0 w=1u l=1u
X26 VDD a_27407_13799# a_27664_13942# VDD sg13_lv_pmos ad=2.42015p pd=15.68u as=79.8f ps=0.8u w=0.42u l=0.13u
X27 VDD VSS.t891 VDD VDD sg13_lv_pmos ad=0.34p pd=2.68u as=0 ps=0 w=1u l=1u
X28 VSS.t2733 VDD VSS.t2732 VSS.t199 sg13_lv_nmos ad=0.1428p pd=1.52u as=0 ps=0 w=0.42u l=1u
X29 VDD sg13cmos5l_xnor2_1_2.A sg13cmos5l_nand4_1_0.Y VDD sg13_lv_pmos ad=0.2128p pd=1.5u as=0.2128p ps=1.5u w=1.12u l=0.13u
X30 VSS.t2536 VDD VSS.t2538 VSS.t2537 sg13_lv_nmos ad=79.8f pd=0.8u as=0 ps=0 w=0.42u l=1u
X31 a_19450_15202# sg13cmos5l_dfrbpq_1_3.Q VSS.t123 VSS.t87 sg13_lv_nmos ad=0.1428p pd=1.52u as=79.8f ps=0.8u w=0.42u l=0.13u
X32 VDD VSS.t679 VDD VDD sg13_lv_pmos ad=0.19p pd=1.38u as=0 ps=0 w=1u l=1u
X33 VDD VSS.t1604 VDD VDD sg13_lv_pmos ad=0.19p pd=1.38u as=0 ps=0 w=1u l=1u
X34 VDD VSS.t3068 VDD VDD sg13_lv_pmos ad=0.34p pd=2.68u as=0 ps=0 w=1u l=1u
X35 VSS.t2801 VDD VSS.t2800 VSS.t199 sg13_lv_nmos ad=0.1428p pd=1.52u as=0 ps=0 w=0.42u l=1u
X36 VDD VSS.t1938 VDD VDD sg13_lv_pmos ad=0.34p pd=2.68u as=0 ps=0 w=1u l=1u
X37 a_26436_13735# a_26148_14040# a_26374_13735# VSS.t126 sg13_lv_nmos ad=0.1428p pd=1.52u as=37.8f ps=0.6u w=0.42u l=0.13u
X38 VSS.t947 VDD VSS.t949 VSS.t948 sg13_lv_nmos ad=79.8f pd=0.8u as=0 ps=0 w=0.42u l=1u
X39 VSS.t2034 VDD VSS.t2036 VSS.t2035 sg13_lv_nmos ad=79.8f pd=0.8u as=0 ps=0 w=0.42u l=1u
X40 VDD VSS.t1609 VDD VDD sg13_lv_pmos ad=0.19p pd=1.38u as=0 ps=0 w=1u l=1u
X41 VSS.t1364 VDD VSS.t1363 VSS.t248 sg13_lv_nmos ad=0.1428p pd=1.52u as=0 ps=0 w=0.42u l=1u
X42 VSS.t2670 VDD VSS.t2671 VSS.t199 sg13_lv_nmos ad=79.8f pd=0.8u as=0 ps=0 w=0.42u l=1u
X43 VDD VSS.t954 VDD VDD sg13_lv_pmos ad=0.19p pd=1.38u as=0 ps=0 w=1u l=1u
X44 VSS.t997 VDD VSS.t996 VSS.t995 sg13_lv_nmos ad=0.1428p pd=1.52u as=0 ps=0 w=0.42u l=1u
X45 VSS.t2406 VDD VSS.t2408 VSS.t2407 sg13_lv_nmos ad=79.8f pd=0.8u as=0 ps=0 w=0.42u l=1u
X46 VSS.t1954 VDD VSS.t1953 VSS.t1952 sg13_lv_nmos ad=0.1428p pd=1.52u as=0 ps=0 w=0.42u l=1u
X47 VDD VSS.t1951 VDD VDD sg13_lv_pmos ad=0.19p pd=1.38u as=0 ps=0 w=1u l=1u
X48 VSS.t822 VDD VSS.t824 VSS.t823 sg13_lv_nmos ad=79.8f pd=0.8u as=0 ps=0 w=0.42u l=1u
X49 VDD VSS.t477 VDD VDD sg13_lv_pmos ad=0.34p pd=2.68u as=0 ps=0 w=1u l=1u
X50 VDD VSS.t881 VDD VDD sg13_lv_pmos ad=0.34p pd=2.68u as=0 ps=0 w=1u l=1u
X51 VDD VSS.t2076 VDD VDD sg13_lv_pmos ad=0.19p pd=1.38u as=0 ps=0 w=1u l=1u
X52 a_17412_14922# sg13cmos5l_dfrbpq_1_3.D a_17318_14922# VSS.t115 sg13_lv_nmos ad=60.89999f pd=0.71u as=0.1428p ps=1.52u w=0.42u l=0.13u
X53 VSS.t1497 VDD VSS.t1496 VSS.t1495 sg13_lv_nmos ad=0.1428p pd=1.52u as=0 ps=0 w=0.42u l=1u
X54 VDD VSS.t1307 VDD VDD sg13_lv_pmos ad=0.34p pd=2.68u as=0 ps=0 w=1u l=1u
X55 VDD VSS.t3183 VDD VDD sg13_lv_pmos ad=0.34p pd=2.68u as=0 ps=0 w=1u l=1u
X56 VSS.t2687 VDD VSS.t2686 VSS.t199 sg13_lv_nmos ad=0.1428p pd=1.52u as=0 ps=0 w=0.42u l=1u
X57 VDD a_25774_15423# sg13cmos5l_dfrbpq_1_7.D VDD sg13_lv_pmos ad=0.2254p pd=1.53u as=0.4256p ps=3u w=1.12u l=0.13u
X58 VDD VSS.t733 VDD VDD sg13_lv_pmos ad=0.19p pd=1.38u as=0 ps=0 w=1u l=1u
X59 VSS.t1057 VDD VSS.t1059 VSS.t1058 sg13_lv_nmos ad=79.8f pd=0.8u as=0 ps=0 w=0.42u l=1u
X60 VSS.t2748 VDD VSS.t2749 VSS.t199 sg13_lv_nmos ad=79.8f pd=0.8u as=0 ps=0 w=0.42u l=1u
X61 VDD VSS.t1759 VDD VDD sg13_lv_pmos ad=0.19p pd=1.38u as=0 ps=0 w=1u l=1u
X62 VDD a_18021_14495# a_18123_14495# VDD sg13_lv_pmos ad=2.42015p pd=15.68u as=0.3864p ps=2.93u w=1.12u l=0.13u
X63 VDD a_22319_14845# a_22986_14484# VDD sg13_lv_pmos ad=0.2128p pd=1.5u as=0.3864p ps=2.93u w=1.12u l=0.13u
X64 VSS.t917 VDD VSS.t916 VSS.t915 sg13_lv_nmos ad=0.1428p pd=1.52u as=0 ps=0 w=0.42u l=1u
X65 VDD VSS.t1589 VDD VDD sg13_lv_pmos ad=0.19p pd=1.38u as=0 ps=0 w=1u l=1u
X66 VSS.t433 VDD VSS.t432 VSS.t431 sg13_lv_nmos ad=0.1428p pd=1.52u as=0 ps=0 w=0.42u l=1u
X67 VDD VSS.t635 VDD VDD sg13_lv_pmos ad=0.34p pd=2.68u as=0 ps=0 w=1u l=1u
X68 VSS.t1251 VDD VSS.t1252 VSS.t248 sg13_lv_nmos ad=79.8f pd=0.8u as=0 ps=0 w=0.42u l=1u
X69 VDD VSS.t1345 VDD VDD sg13_lv_pmos ad=0.19p pd=1.38u as=0 ps=0 w=1u l=1u
X70 VDD VSS.t339 VDD VDD sg13_lv_pmos ad=0.34p pd=2.68u as=0 ps=0 w=1u l=1u
X71 VSS.t2700 VDD VSS.t2700 VSS.t199 sg13_lv_nmos ad=0.1428p pd=1.52u as=0 ps=0 w=0.42u l=1u
X72 VDD VSS.t2503 VDD VDD sg13_lv_pmos ad=0.19p pd=1.38u as=0 ps=0 w=1u l=1u
X73 VDD sg13cmos5l_dlygate4sd3_1_4.X a_17165_16020# VDD sg13_lv_pmos ad=0.3822p pd=1.84u as=0.1575p ps=1.315u w=1u l=0.13u
X74 VSS.t1989 VDD VSS.t1988 VSS.t1987 sg13_lv_nmos ad=0.1428p pd=1.52u as=0 ps=0 w=0.42u l=1u
X75 VSS.t3074 VDD VSS.t3073 VSS.t3072 sg13_lv_nmos ad=0.1428p pd=1.52u as=0 ps=0 w=0.42u l=1u
X76 VSS.t328 VDD VSS.t328 VSS.t330 sg13_lv_nmos ad=0.1428p pd=1.52u as=0 ps=0 w=0.42u l=1u
X77 VDD VSS.t2290 VDD VDD sg13_lv_pmos ad=0.34p pd=2.68u as=0 ps=0 w=1u l=1u
X78 VDD VSS.t844 VDD VDD sg13_lv_pmos ad=0.19p pd=1.38u as=0 ps=0 w=1u l=1u
X79 VDD VSS.t1554 VDD VDD sg13_lv_pmos ad=0.19p pd=1.38u as=0 ps=0 w=1u l=1u
X80 VDD VSS.t2463 VDD VDD sg13_lv_pmos ad=0.19p pd=1.38u as=0 ps=0 w=1u l=1u
X81 VSS.t2521 VDD VSS.t2523 VSS.t2522 sg13_lv_nmos ad=79.8f pd=0.8u as=0 ps=0 w=0.42u l=1u
X82 VSS.t454 VDD VSS.t455 VSS.t19 sg13_lv_nmos ad=79.8f pd=0.8u as=0 ps=0 w=0.42u l=1u
X83 VDD VSS.t39 VDD VDD sg13_lv_pmos ad=0.34p pd=2.68u as=0 ps=0 w=1u l=1u
X84 VDD VSS.t555 VDD VDD sg13_lv_pmos ad=0.34p pd=2.68u as=0 ps=0 w=1u l=1u
X85 VSS.t1027 VDD VSS.t1026 VSS.t1025 sg13_lv_nmos ad=0.1428p pd=1.52u as=0 ps=0 w=0.42u l=1u
X86 VSS.t1899 VDD VSS.t1898 VSS.t1897 sg13_lv_nmos ad=0.1428p pd=1.52u as=0 ps=0 w=0.42u l=1u
X87 VDD VSS.t597 VDD VDD sg13_lv_pmos ad=0.34p pd=2.68u as=0 ps=0 w=1u l=1u
X88 VSS.t1687 VDD VSS.t1689 VSS.t1688 sg13_lv_nmos ad=79.8f pd=0.8u as=0 ps=0 w=0.42u l=1u
X89 VSS.t2069 VDD VSS.t2071 VSS.t2070 sg13_lv_nmos ad=79.8f pd=0.8u as=0 ps=0 w=0.42u l=1u
X90 VSS.t1234 VDD VSS.t1235 VSS.t248 sg13_lv_nmos ad=79.8f pd=0.8u as=0 ps=0 w=0.42u l=1u
X91 VDD VSS.t1998 VDD VDD sg13_lv_pmos ad=0.34p pd=2.68u as=0 ps=0 w=1u l=1u
X92 VSS.t21 a_26633_16334# a_26554_16237# VSS.t38 sg13_lv_nmos ad=7.70437p pd=50.66u as=0.27427p ps=2.28u w=0.795u l=0.13u
X93 VDD VSS.t1354 VDD VDD sg13_lv_pmos ad=0.19p pd=1.38u as=0 ps=0 w=1u l=1u
X94 sg13cmos5l_dfrbpq_1_2.D sg13cmos5l_a21oi_1_3.B1 VSS.t90 VSS.t89 sg13_lv_nmos ad=0.1406p pd=1.12u as=0.2516p ps=2.16u w=0.74u l=0.13u
X95 a_2516_14484# a_2490_14447# sg13cmos5l_xor2_1_0.X VDD sg13_lv_pmos ad=0.2128p pd=1.5u as=0.3808p ps=2.92u w=1.12u l=0.13u
X96 VSS.t2724 VDD VSS.t2724 VSS.t199 sg13_lv_nmos ad=0.1428p pd=1.52u as=0 ps=0 w=0.42u l=1u
X97 VDD VSS.t485 VDD VDD sg13_lv_pmos ad=0.19p pd=1.38u as=0 ps=0 w=1u l=1u
X98 VSS.t947 VDD VSS.t949 VSS.t948 sg13_lv_nmos ad=79.8f pd=0.8u as=0 ps=0 w=0.42u l=1u
X99 VDD VSS.t936 VDD VDD sg13_lv_pmos ad=0.34p pd=2.68u as=0 ps=0 w=1u l=1u
X100 VDD VSS.t1766 VDD VDD sg13_lv_pmos ad=0.34p pd=2.68u as=0 ps=0 w=1u l=1u
X101 VDD VSS.t373 VDD VDD sg13_lv_pmos ad=0.19p pd=1.38u as=0 ps=0 w=1u l=1u
X102 VSS.t1617 VDD VSS.t1619 VSS.t1618 sg13_lv_nmos ad=79.8f pd=0.8u as=0 ps=0 w=0.42u l=1u
X103 VSS.t3139 VDD VSS.t3141 VSS.t3140 sg13_lv_nmos ad=79.8f pd=0.8u as=0 ps=0 w=0.42u l=1u
X104 VDD VSS.t620 VDD VDD sg13_lv_pmos ad=0.34p pd=2.68u as=0 ps=0 w=1u l=1u
X105 VSS.t655 VDD VSS.t652 VSS.t654 sg13_lv_nmos ad=0.1428p pd=1.52u as=0 ps=0 w=0.42u l=1u
X106 VDD VSS.t1061 VDD VDD sg13_lv_pmos ad=0.34p pd=2.68u as=0 ps=0 w=1u l=1u
X107 VDD a_3130_16237# sg13cmos5l_dfrbpq_1_0.RESET_B VDD sg13_lv_pmos ad=2.8961p pd=18.25u as=0.3927p ps=2.99u w=1.155u l=0.13u
X108 VSS.t667 VDD VSS.t667 VSS.t798 sg13_lv_nmos ad=0.1428p pd=1.52u as=0 ps=0 w=0.42u l=1u
X109 VSS.t2391 VDD VSS.t2393 VSS.t2392 sg13_lv_nmos ad=79.8f pd=0.8u as=0 ps=0 w=0.42u l=1u
X110 VDD VSS.t2455 VDD VDD sg13_lv_pmos ad=0.34p pd=2.68u as=0 ps=0 w=1u l=1u
X111 VSS.t822 VDD VSS.t824 VSS.t823 sg13_lv_nmos ad=79.8f pd=0.8u as=0 ps=0 w=0.42u l=1u
X112 VDD VSS.t811 VDD VDD sg13_lv_pmos ad=0.34p pd=2.68u as=0 ps=0 w=1u l=1u
X113 VDD VSS.t999 VDD VDD sg13_lv_pmos ad=0.19p pd=1.38u as=0 ps=0 w=1u l=1u
X114 VDD VSS.t2113 VDD VDD sg13_lv_pmos ad=0.34p pd=2.68u as=0 ps=0 w=1u l=1u
X115 VSS.t578 VDD VSS.t580 VSS.t579 sg13_lv_nmos ad=79.8f pd=0.8u as=0 ps=0 w=0.42u l=1u
X116 VDD VSS.t414 VDD VDD sg13_lv_pmos ad=0.34p pd=2.68u as=0 ps=0 w=1u l=1u
X117 VDD sg13cmos5l_dlygate4sd3_1_0.X a_5613_14832# VDD sg13_lv_pmos ad=0.1918p pd=1.5u as=0.1596p ps=1.22u w=0.84u l=0.13u
X118 VDD VSS.t50 VDD VDD sg13_lv_pmos ad=0.19p pd=1.38u as=0 ps=0 w=1u l=1u
X119 VDD VSS.t1275 VDD VDD sg13_lv_pmos ad=0.19p pd=1.38u as=0 ps=0 w=1u l=1u
X120 VDD VSS.t2777 VDD VDD sg13_lv_pmos ad=0.19p pd=1.38u as=0 ps=0 w=1u l=1u
X121 VSS.t2476 VDD VSS.t2475 VSS.t2474 sg13_lv_nmos ad=0.1428p pd=1.52u as=0 ps=0 w=0.42u l=1u
X122 VSS.t2089 VDD VSS.t2091 VSS.t2090 sg13_lv_nmos ad=79.8f pd=0.8u as=0 ps=0 w=0.42u l=1u
X123 sg13cmos5l_a21oi_1_0.A2 a_16969_16020# VSS.t197 VSS.t3269 sg13_lv_nmos ad=0.2516p pd=2.16u as=0.13395p ps=1.12u w=0.74u l=0.13u
X124 VSS.t917 VDD VSS.t916 VSS.t915 sg13_lv_nmos ad=0.1428p pd=1.52u as=0 ps=0 w=0.42u l=1u
X125 VSS.t1211 VDD VSS.t1212 VSS.t248 sg13_lv_nmos ad=79.8f pd=0.8u as=0 ps=0 w=0.42u l=1u
X126 VDD VSS.t2156 VDD VDD sg13_lv_pmos ad=0.19p pd=1.38u as=0 ps=0 w=1u l=1u
X127 VSS.t472 VDD VSS.t473 VSS.t19 sg13_lv_nmos ad=79.8f pd=0.8u as=0 ps=0 w=0.42u l=1u
X128 VDD VSS.t465 VDD VDD sg13_lv_pmos ad=0.34p pd=2.68u as=0 ps=0 w=1u l=1u
X129 VSS.t2716 VDD VSS.t2715 VSS.t199 sg13_lv_nmos ad=0.1428p pd=1.52u as=0 ps=0 w=0.42u l=1u
X130 VDD VSS.t45 VDD VDD sg13_lv_pmos ad=0.19p pd=1.38u as=0 ps=0 w=1u l=1u
X131 VSS.t962 VDD VSS.t961 VSS.t960 sg13_lv_nmos ad=0.1428p pd=1.52u as=0 ps=0 w=0.42u l=1u
X132 VSS.t2541 VDD VSS.t2543 VSS.t2542 sg13_lv_nmos ad=79.8f pd=0.8u as=0 ps=0 w=0.42u l=1u
X133 a_27407_13799# a_26565_13701# a_26148_14040# VDD sg13_lv_pmos ad=0.2048p pd=1.63u as=0.34p ps=2.68u w=1u l=0.13u
X134 VDD VSS.t3038 VDD VDD sg13_lv_pmos ad=0.34p pd=2.68u as=0 ps=0 w=1u l=1u
X135 VDD VSS.t1943 VDD VDD sg13_lv_pmos ad=0.34p pd=2.68u as=0 ps=0 w=1u l=1u
X136 VSS.t65 a_22319_14845# a_22986_14484# VSS.t0 sg13_lv_nmos ad=0.1406p pd=1.12u as=0.2516p ps=2.16u w=0.74u l=0.13u
X137 VDD VSS.t1574 VDD VDD sg13_lv_pmos ad=0.19p pd=1.38u as=0 ps=0 w=1u l=1u
X138 VDD VSS.t1751 VDD VDD sg13_lv_pmos ad=0.34p pd=2.68u as=0 ps=0 w=1u l=1u
X139 VSS.t2039 VDD VSS.t2041 VSS.t2040 sg13_lv_nmos ad=79.8f pd=0.8u as=0 ps=0 w=0.42u l=1u
X140 VDD VSS.t318 VDD VDD sg13_lv_pmos ad=0.19p pd=1.38u as=0 ps=0 w=1u l=1u
X141 VDD VSS.t1614 VDD VDD sg13_lv_pmos ad=0.19p pd=1.38u as=0 ps=0 w=1u l=1u
X142 VSS.t2691 VDD VSS.t2691 VSS.t199 sg13_lv_nmos ad=0.1428p pd=1.52u as=0 ps=0 w=0.42u l=1u
X143 VSS.t568 VDD VSS.t567 VSS.t566 sg13_lv_nmos ad=0.1428p pd=1.52u as=0 ps=0 w=0.42u l=1u
X144 VDD VSS.t1259 VDD VDD sg13_lv_pmos ad=0.34p pd=2.68u as=0 ps=0 w=1u l=1u
X145 VDD VSS.t2742 VDD VDD sg13_lv_pmos ad=0.19p pd=1.38u as=0 ps=0 w=1u l=1u
X146 VDD VSS.t966 VDD VDD sg13_lv_pmos ad=0.34p pd=2.68u as=0 ps=0 w=1u l=1u
X147 a_17892_14909# a_17604_14488# a_17830_14909# VSS.t93 sg13_lv_nmos ad=0.1428p pd=1.52u as=37.8f ps=0.6u w=0.42u l=0.13u
X148 VDD VSS.t555 VDD VDD sg13_lv_pmos ad=0.34p pd=2.68u as=0 ps=0 w=1u l=1u
X149 VSS.t1296 VDD VSS.t1297 VSS.t248 sg13_lv_nmos ad=79.8f pd=0.8u as=0 ps=0 w=0.42u l=1u
X150 VDD VSS.t2275 VDD VDD sg13_lv_pmos ad=0.34p pd=2.68u as=0 ps=0 w=1u l=1u
X151 VSS.t2336 VDD VSS.t2338 VSS.t2337 sg13_lv_nmos ad=79.8f pd=0.8u as=0 ps=0 w=0.42u l=1u
X152 VSS.t1884 VDD VSS.t1883 VSS.t1882 sg13_lv_nmos ad=0.1428p pd=1.52u as=0 ps=0 w=0.42u l=1u
X153 a_16425_14113# a_16068_14040# VDD VDD sg13_lv_pmos ad=63f pd=0.72u as=0.1563p ps=1.22u w=0.42u l=0.13u
X154 VSS.t2690 VDD VSS.t2688 VSS.t199 sg13_lv_nmos ad=0.1428p pd=1.52u as=0 ps=0 w=0.42u l=1u
X155 VSS.t1301 VDD VSS.t1302 VSS.t248 sg13_lv_nmos ad=79.8f pd=0.8u as=0 ps=0 w=0.42u l=1u
X156 VSS.t2783 VDD VSS.t2784 VSS.t199 sg13_lv_nmos ad=79.8f pd=0.8u as=0 ps=0 w=0.42u l=1u
X157 VDD a_17584_13942# a_17529_14037# VDD sg13_lv_pmos ad=2.42015p pd=15.68u as=93.45f ps=0.865u w=0.42u l=0.13u
X158 VSS.t1627 VDD VSS.t1626 VSS.t1625 sg13_lv_nmos ad=0.1428p pd=1.52u as=0 ps=0 w=0.42u l=1u
X159 VDD VSS.t3106 VDD VDD sg13_lv_pmos ad=0.19p pd=1.38u as=0 ps=0 w=1u l=1u
X160 VSS.t2376 VDD VSS.t2378 VSS.t2377 sg13_lv_nmos ad=79.8f pd=0.8u as=0 ps=0 w=0.42u l=1u
X161 VDD VSS.t2318 VDD VDD sg13_lv_pmos ad=0.19p pd=1.38u as=0 ps=0 w=1u l=1u
X162 VDD VSS.t981 VDD VDD sg13_lv_pmos ad=0.34p pd=2.68u as=0 ps=0 w=1u l=1u
X163 VDD VSS.t1282 VDD VDD sg13_lv_pmos ad=0.34p pd=2.68u as=0 ps=0 w=1u l=1u
X164 VDD VSS.t2784 VDD VDD sg13_lv_pmos ad=0.34p pd=2.68u as=0 ps=0 w=1u l=1u
X165 VSS.t1602 VDD VSS.t1604 VSS.t1603 sg13_lv_nmos ad=79.8f pd=0.8u as=0 ps=0 w=0.42u l=1u
X166 VDD VSS.t1238 VDD VDD sg13_lv_pmos ad=0.19p pd=1.38u as=0 ps=0 w=1u l=1u
X167 a_9252_15234# sg13cmos5l_and2_1_2.X a_9158_15234# VSS.t3277 sg13_lv_nmos ad=60.89999f pd=0.71u as=0.1428p ps=1.52u w=0.42u l=0.13u
X168 a_17806_15423# a_17921_15424# VDD VDD sg13_lv_pmos ad=0.34p pd=2.68u as=0.2254p ps=1.53u w=1u l=0.5u
X169 VSS.t1994 VDD VSS.t1993 VSS.t1992 sg13_lv_nmos ad=0.1428p pd=1.52u as=0 ps=0 w=0.42u l=1u
X170 VSS.t493 VDD VSS.t492 VSS.t19 sg13_lv_nmos ad=0.1428p pd=1.52u as=0 ps=0 w=0.42u l=1u
X171 VSS.t623 VDD VSS.t623 VSS.t750 sg13_lv_nmos ad=79.8f pd=0.8u as=0 ps=0 w=0.42u l=1u
X172 VDD VSS.t1044 VDD VDD sg13_lv_pmos ad=0.19p pd=1.38u as=0 ps=0 w=1u l=1u
X173 VSS.t1446 VDD VSS.t1311 VSS.t248 sg13_lv_nmos ad=79.8f pd=0.8u as=0 ps=0 w=0.42u l=1u
X174 VDD VSS.t1621 VDD VDD sg13_lv_pmos ad=0.34p pd=2.68u as=0 ps=0 w=1u l=1u
X175 VDD VSS.t2468 VDD VDD sg13_lv_pmos ad=0.19p pd=1.38u as=0 ps=0 w=1u l=1u
X176 VSS.t2526 VDD VSS.t2528 VSS.t2527 sg13_lv_nmos ad=79.8f pd=0.8u as=0 ps=0 w=0.42u l=1u
X177 VDD VSS.t658 VDD VDD sg13_lv_pmos ad=0.19p pd=1.38u as=0 ps=0 w=1u l=1u
X178 VSS.t1692 VDD VSS.t1694 VSS.t1693 sg13_lv_nmos ad=79.8f pd=0.8u as=0 ps=0 w=0.42u l=1u
X179 VSS.t2074 VDD VSS.t2076 VSS.t2075 sg13_lv_nmos ad=79.8f pd=0.8u as=0 ps=0 w=0.42u l=1u
X180 VSS.t1077 VDD VSS.t1079 VSS.t1078 sg13_lv_nmos ad=79.8f pd=0.8u as=0 ps=0 w=0.42u l=1u
X181 VDD VSS.t339 VDD VDD sg13_lv_pmos ad=0.19p pd=1.38u as=0 ps=0 w=1u l=1u
X182 VSS.t962 VDD VSS.t961 VSS.t960 sg13_lv_nmos ad=0.1428p pd=1.52u as=0 ps=0 w=0.42u l=1u
X183 VDD VSS.t1968 VDD VDD sg13_lv_pmos ad=0.34p pd=2.68u as=0 ps=0 w=1u l=1u
X184 VDD VSS.t944 VDD VDD sg13_lv_pmos ad=0.19p pd=1.38u as=0 ps=0 w=1u l=1u
X185 VDD VSS.t3091 VDD VDD sg13_lv_pmos ad=0.19p pd=1.38u as=0 ps=0 w=1u l=1u
X186 VDD VSS.t2303 VDD VDD sg13_lv_pmos ad=0.19p pd=1.38u as=0 ps=0 w=1u l=1u
X187 VDD VSS.t2141 VDD VDD sg13_lv_pmos ad=0.19p pd=1.38u as=0 ps=0 w=1u l=1u
X188 VSS.t26 a_4078_14751# sg13cmos5l_xor2_1_0.B VSS.t183 sg13_lv_nmos ad=0.1426p pd=1.16u as=0.2516p ps=2.16u w=0.74u l=0.13u
X189 VSS.t2706 VDD VSS.t2706 VSS.t199 sg13_lv_nmos ad=0.1428p pd=1.52u as=0 ps=0 w=0.42u l=1u
X190 a_12010_15202# sg13cmos5l_buf_8_2.A VDD VDD sg13_lv_pmos ad=0.2128p pd=1.5u as=0.2128p ps=1.5u w=1.12u l=0.13u
X191 VDD sg13cmos5l_buf_8_2.A a_19323_13726# VDD sg13_lv_pmos ad=0.2128p pd=1.5u as=0.3808p ps=2.92u w=1.12u l=0.13u
X192 VDD VSS.t2093 VDD VDD sg13_lv_pmos ad=0.34p pd=2.68u as=0 ps=0 w=1u l=1u
X193 VDD VSS.t1220 VDD VDD sg13_lv_pmos ad=0.34p pd=2.68u as=0 ps=0 w=1u l=1u
X194 VDD VSS.t1928 VDD VDD sg13_lv_pmos ad=0.34p pd=2.68u as=0 ps=0 w=1u l=1u
X195 VDD VSS.t456 VDD VDD sg13_lv_pmos ad=0.34p pd=2.68u as=0 ps=0 w=1u l=1u
X196 VDD VSS.t1736 VDD VDD sg13_lv_pmos ad=0.34p pd=2.68u as=0 ps=0 w=1u l=1u
X197 VSS.t2321 VDD VSS.t2323 VSS.t2322 sg13_lv_nmos ad=79.8f pd=0.8u as=0 ps=0 w=0.42u l=1u
X198 VSS.t2024 VDD VSS.t2026 VSS.t2025 sg13_lv_nmos ad=79.8f pd=0.8u as=0 ps=0 w=0.42u l=1u
X199 VSS.t487 VDD VSS.t486 VSS.t19 sg13_lv_nmos ad=0.1428p pd=1.52u as=0 ps=0 w=0.42u l=1u
X200 VDD VSS.t555 VDD VDD sg13_lv_pmos ad=0.19p pd=1.38u as=0 ps=0 w=1u l=1u
X201 VSS.t1587 VDD VSS.t1589 VSS.t1588 sg13_lv_nmos ad=79.8f pd=0.8u as=0 ps=0 w=0.42u l=1u
X202 VSS.t3109 VDD VSS.t3111 VSS.t3110 sg13_lv_nmos ad=79.8f pd=0.8u as=0 ps=0 w=0.42u l=1u
X203 VDD VSS.t1286 VDD VDD sg13_lv_pmos ad=0.34p pd=2.68u as=0 ps=0 w=1u l=1u
X204 VSS.t1278 VDD VSS.t1279 VSS.t248 sg13_lv_nmos ad=79.8f pd=0.8u as=0 ps=0 w=0.42u l=1u
X205 VDD VSS.t1599 VDD VDD sg13_lv_pmos ad=0.19p pd=1.38u as=0 ps=0 w=1u l=1u
X206 a_10905_15549# a_9963_15356# a_10703_15311# VDD sg13_lv_pmos ad=93.45f pd=0.865u as=0.2048p ps=1.63u w=0.42u l=0.13u
X207 VDD sg13cmos5l_xnor2_1_2.A a_6714_12972# VDD sg13_lv_pmos ad=0.2891p pd=1.695u as=0.1428p ps=1.375u w=1.12u l=0.13u
X208 VDD VSS.t819 VDD VDD sg13_lv_pmos ad=0.19p pd=1.38u as=0 ps=0 w=1u l=1u
X209 VSS.t2396 VDD VSS.t2398 VSS.t2397 sg13_lv_nmos ad=79.8f pd=0.8u as=0 ps=0 w=0.42u l=1u
X210 VDD VSS.t2460 VDD VDD sg13_lv_pmos ad=0.34p pd=2.68u as=0 ps=0 w=1u l=1u
X211 VSS.t300 a_12010_15202# sg13cmos5l_dfrbpq_1_2.CLK VSS.t302 sg13_lv_nmos ad=0.1406p pd=1.12u as=0.1406p ps=1.12u w=0.74u l=0.13u
X212 a_22426_15202# sg13cmos5l_dfrbpq_1_6.Q VSS.t135 VSS.t48 sg13_lv_nmos ad=0.1428p pd=1.52u as=79.8f ps=0.8u w=0.42u l=0.13u
X213 sg13cmos5l_a21oi_1_0.Y sg13cmos5l_a21oi_1_3.B1 VSS.t13 VSS.t84 sg13_lv_nmos ad=0.1406p pd=1.12u as=0.2516p ps=2.16u w=0.74u l=0.13u
X214 VDD VSS.t2669 VDD VDD sg13_lv_pmos ad=0.34p pd=2.68u as=0 ps=0 w=1u l=1u
X215 VDD sg13cmos5l_o21ai_1_2.B1 sg13cmos5l_or3_1_1.C VDD sg13_lv_pmos ad=0.3808p pd=2.92u as=0.2128p ps=1.5u w=1.12u l=0.13u
X216 a_19120_14726# sg13cmos5l_dfrbpq_1_3.RESET_B VDD VDD sg13_lv_pmos ad=79.8f pd=0.8u as=2.42015p ps=15.68u w=0.42u l=0.13u
X217 a_23480_15242# sg13cmos5l_dfrbpq_1_3.Q a_23378_15242# VSS.t48 sg13_lv_nmos ad=0.1406p pd=1.12u as=0.1406p ps=1.12u w=0.74u l=0.13u
X218 VDD VSS.t1228 VDD VDD sg13_lv_pmos ad=0.34p pd=2.68u as=0 ps=0 w=1u l=1u
X219 VSS.t1328 VDD VSS.t1329 VSS.t248 sg13_lv_nmos ad=79.8f pd=0.8u as=0 ps=0 w=0.42u l=1u
X220 VSS.t2681 VDD VSS.t2679 VSS.t199 sg13_lv_nmos ad=0.1428p pd=1.52u as=0 ps=0 w=0.42u l=1u
X221 VSS.t352 VDD VSS.t351 VSS.t350 sg13_lv_nmos ad=0.1428p pd=1.52u as=0 ps=0 w=0.42u l=1u
X222 VDD a_21562_15960# a_21281_16262# VDD sg13_lv_pmos ad=0.1523p pd=1.38u as=0.34p ps=2.68u w=1u l=0.5u
X223 VDD sg13cmos5l_o21ai_1_2.Y a_24824_15238# VDD sg13_lv_pmos ad=0.1523p pd=1.38u as=0.1428p ps=1.52u w=0.42u l=0.13u
X224 VDD a_18863_14845# a_19530_14484# VDD sg13_lv_pmos ad=0.2128p pd=1.5u as=0.3864p ps=2.93u w=1.12u l=0.13u
X225 VDD VSS.t889 VDD VDD sg13_lv_pmos ad=0.19p pd=1.38u as=0 ps=0 w=1u l=1u
X226 VDD VSS.t1314 VDD VDD sg13_lv_pmos ad=0.19p pd=1.38u as=0 ps=0 w=1u l=1u
X227 VDD VSS.t2814 VDD VDD sg13_lv_pmos ad=0.19p pd=1.38u as=0 ps=0 w=1u l=1u
X228 VDD VSS.t2126 VDD VDD sg13_lv_pmos ad=0.19p pd=1.38u as=0 ps=0 w=1u l=1u
X229 a_20603_15532# sg13cmos5l_a21oi_1_3.B1 sg13cmos5l_a21oi_1_1.Y VDD sg13_lv_pmos ad=0.2128p pd=1.5u as=0.3808p ps=2.92u w=1.12u l=0.13u
X230 VSS.t2718 VDD VSS.t2718 VSS.t199 sg13_lv_nmos ad=0.1428p pd=1.52u as=0 ps=0 w=0.42u l=1u
X231 VSS.t2541 VDD VSS.t2540 VSS.t2539 sg13_lv_nmos ad=0.1428p pd=1.52u as=0 ps=0 w=0.42u l=1u
X232 VSS.t2361 VDD VSS.t2363 VSS.t2362 sg13_lv_nmos ad=79.8f pd=0.8u as=0 ps=0 w=0.42u l=1u
X233 VDD VSS.t3043 VDD VDD sg13_lv_pmos ad=0.34p pd=2.68u as=0 ps=0 w=1u l=1u
X234 VSS.t2786 VDD VSS.t2784 VSS.t199 sg13_lv_nmos ad=0.1428p pd=1.52u as=0 ps=0 w=0.42u l=1u
X235 sg13cmos5l_dfrbpq_1_2.CLK a_12010_15202# VDD VDD sg13_lv_pmos ad=0.2128p pd=1.5u as=0.2128p ps=1.5u w=1.12u l=0.13u
X236 VDD VSS.t1913 VDD VDD sg13_lv_pmos ad=0.34p pd=2.68u as=0 ps=0 w=1u l=1u
X237 VSS.t454 VDD VSS.t453 VSS.t19 sg13_lv_nmos ad=0.1428p pd=1.52u as=0 ps=0 w=0.42u l=1u
X238 VDD VSS.t974 VDD VDD sg13_lv_pmos ad=0.19p pd=1.38u as=0 ps=0 w=1u l=1u
X239 VSS.t1767 VDD VSS.t1766 VSS.t1765 sg13_lv_nmos ad=0.1428p pd=1.52u as=0 ps=0 w=0.42u l=1u
X240 VDD VSS.t1619 VDD VDD sg13_lv_pmos ad=0.19p pd=1.38u as=0 ps=0 w=1u l=1u
X241 VDD VSS.t2493 VDD VDD sg13_lv_pmos ad=0.19p pd=1.38u as=0 ps=0 w=1u l=1u
X242 VSS.t3064 VDD VSS.t3063 VSS.t3062 sg13_lv_nmos ad=0.1428p pd=1.52u as=0 ps=0 w=0.42u l=1u
X243 VDD a_15579_14854# sg13cmos5l_buf_8_2.A VDD sg13_lv_pmos ad=0.3864p pd=2.93u as=0.2128p ps=1.5u w=1.12u l=0.13u
X244 VDD VSS.t334 VDD VDD sg13_lv_pmos ad=0.34p pd=2.68u as=0 ps=0 w=1u l=1u
X245 VSS.t122 a_22508_15960# counter_value_o[4] VSS.t128 sg13_lv_nmos ad=0.14875p pd=1.16u as=0.2886p ps=2.26u w=0.74u l=0.13u
X246 VSS.t297 a_12010_15202# sg13cmos5l_dfrbpq_1_2.CLK VSS.t296 sg13_lv_nmos ad=0.1406p pd=1.12u as=0.1406p ps=1.12u w=0.74u l=0.13u
X247 VDD VSS.t464 VDD VDD sg13_lv_pmos ad=0.19p pd=1.38u as=0 ps=0 w=1u l=1u
X248 VDD VSS.t2776 VDD VDD sg13_lv_pmos ad=0.19p pd=1.38u as=0 ps=0 w=1u l=1u
X249 VSS.t2511 VDD VSS.t2513 VSS.t2512 sg13_lv_nmos ad=79.8f pd=0.8u as=0 ps=0 w=0.42u l=1u
X250 VSS.t1077 VDD VSS.t1079 VSS.t1078 sg13_lv_nmos ad=79.8f pd=0.8u as=0 ps=0 w=0.42u l=1u
X251 VDD VSS.t1319 VDD VDD sg13_lv_pmos ad=0.34p pd=2.68u as=0 ps=0 w=1u l=1u
X252 VDD VSS.t744 VDD VDD sg13_lv_pmos ad=0.19p pd=1.38u as=0 ps=0 w=1u l=1u
X253 VSS.t2672 VDD VSS.t2672 VSS.t199 sg13_lv_nmos ad=0.1428p pd=1.52u as=0 ps=0 w=0.42u l=1u
X254 VSS.t1269 VDD VSS.t1268 VSS.t248 sg13_lv_nmos ad=0.1428p pd=1.52u as=0 ps=0 w=0.42u l=1u
X255 VDD VSS.t2548 VDD VDD sg13_lv_pmos ad=0.19p pd=1.38u as=0 ps=0 w=1u l=1u
X256 VDD VSS.t1953 VDD VDD sg13_lv_pmos ad=0.34p pd=2.68u as=0 ps=0 w=1u l=1u
X257 VSS.t578 VDD VSS.t580 VSS.t579 sg13_lv_nmos ad=79.8f pd=0.8u as=0 ps=0 w=0.42u l=1u
X258 VSS.t937 VDD VSS.t936 VSS.t935 sg13_lv_nmos ad=0.1428p pd=1.52u as=0 ps=0 w=0.42u l=1u
X259 VSS.t2381 VDD VSS.t2383 VSS.t2382 sg13_lv_nmos ad=79.8f pd=0.8u as=0 ps=0 w=0.42u l=1u
X260 VDD VSS.t2288 VDD VDD sg13_lv_pmos ad=0.19p pd=1.38u as=0 ps=0 w=1u l=1u
X261 VDD sg13cmos5l_dlygate4sd3_1_17.A a_24824_14525# VDD sg13_lv_pmos ad=0.1523p pd=1.38u as=0.1428p ps=1.52u w=0.42u l=0.13u
X262 VSS.t1262 VDD VSS.t1263 VSS.t248 sg13_lv_nmos ad=79.8f pd=0.8u as=0 ps=0 w=0.42u l=1u
X263 VSS.t2154 VDD VSS.t2156 VSS.t2155 sg13_lv_nmos ad=79.8f pd=0.8u as=0 ps=0 w=0.42u l=1u
X264 VDD VSS.t2078 VDD VDD sg13_lv_pmos ad=0.34p pd=2.68u as=0 ps=0 w=1u l=1u
X265 VDD VSS.t555 VDD VDD sg13_lv_pmos ad=0.19p pd=1.38u as=0 ps=0 w=1u l=1u
X266 VDD VSS.t1357 VDD VDD sg13_lv_pmos ad=0.19p pd=1.38u as=0 ps=0 w=1u l=1u
X267 VDD a_19450_15202# a_19169_15424# VDD sg13_lv_pmos ad=0.1523p pd=1.38u as=0.34p ps=2.68u w=1u l=0.5u
X268 a_26373_14495# sg13cmos5l_buf_8_2.X VSS.t19 VSS.t106 sg13_lv_nmos ad=0.2516p pd=2.16u as=3.8707p ps=25.555u w=0.74u l=0.13u
X269 VSS.t1752 VDD VSS.t1751 VSS.t1750 sg13_lv_nmos ad=0.1428p pd=1.52u as=0 ps=0 w=0.42u l=1u
X270 a_26170_15202# sg13cmos5l_a21oi_1_3.Y VSS.t108 VSS.t3274 sg13_lv_nmos ad=0.1428p pd=1.52u as=79.8f ps=0.8u w=0.42u l=0.13u
X271 VDD VSS.t1761 VDD VDD sg13_lv_pmos ad=0.34p pd=2.68u as=0 ps=0 w=1u l=1u
X272 VDD VSS.t328 VDD VDD sg13_lv_pmos ad=0.34p pd=2.68u as=0 ps=0 w=1u l=1u
X273 VSS.t812 VDD VSS.t811 VSS.t810 sg13_lv_nmos ad=0.1428p pd=1.52u as=0 ps=0 w=0.42u l=1u
X274 VSS.t997 VDD VSS.t999 VSS.t998 sg13_lv_nmos ad=79.8f pd=0.8u as=0 ps=0 w=0.42u l=1u
X275 VSS.t276 sg13cmos5l_or3_1_2.B a_24310_15230# VSS.t48 sg13_lv_nmos ad=0.1406p pd=1.12u as=0.2516p ps=2.16u w=0.74u l=0.15u
X276 VDD VSS.t2445 VDD VDD sg13_lv_pmos ad=0.34p pd=2.68u as=0 ps=0 w=1u l=1u
X277 a_16042_13945# a_16485_13701# a_15782_13722# VSS.t3293 sg13_lv_nmos ad=79.8f pd=0.8u as=0.1296p ps=1.52u w=0.42u l=0.13u
X278 VDD VSS.t1591 VDD VDD sg13_lv_pmos ad=0.34p pd=2.68u as=0 ps=0 w=1u l=1u
X279 VSS.t2496 VDD VSS.t2498 VSS.t2497 sg13_lv_nmos ad=79.8f pd=0.8u as=0 ps=0 w=0.42u l=1u
X280 VSS.t472 VDD VSS.t471 VSS.t19 sg13_lv_nmos ad=0.1428p pd=1.52u as=0 ps=0 w=0.42u l=1u
X281 VDD VSS.t618 VDD VDD sg13_lv_pmos ad=0.34p pd=2.68u as=0 ps=0 w=1u l=1u
X282 VSS.t1662 VDD VSS.t1664 VSS.t1663 sg13_lv_nmos ad=79.8f pd=0.8u as=0 ps=0 w=0.42u l=1u
X283 VSS.t376 VDD VSS.t378 VSS.t377 sg13_lv_nmos ad=79.8f pd=0.8u as=0 ps=0 w=0.42u l=1u
X284 VDD VSS.t421 VDD VDD sg13_lv_pmos ad=0.19p pd=1.38u as=0 ps=0 w=1u l=1u
X285 VDD VSS.t1204 VDD VDD sg13_lv_pmos ad=0.34p pd=2.68u as=0 ps=0 w=1u l=1u
X286 VDD VSS.t1973 VDD VDD sg13_lv_pmos ad=0.34p pd=2.68u as=0 ps=0 w=1u l=1u
X287 a_17710_16263# a_17825_16262# VDD VDD sg13_lv_pmos ad=0.34p pd=2.68u as=0.2254p ps=1.53u w=1u l=0.5u
X288 a_19120_14726# a_18863_14845# a_19282_14922# VSS.t52 sg13_lv_nmos ad=0.1428p pd=1.52u as=37.8f ps=0.6u w=0.42u l=0.13u
X289 VSS.t1244 VDD VSS.t1244 VSS.t248 sg13_lv_nmos ad=0.1428p pd=1.52u as=0 ps=0 w=0.42u l=1u
X290 VDD VSS.t1305 VDD VDD sg13_lv_pmos ad=0.19p pd=1.38u as=0 ps=0 w=1u l=1u
X291 VDD VSS.t2806 VDD VDD sg13_lv_pmos ad=0.19p pd=1.38u as=0 ps=0 w=1u l=1u
X292 VSS.t123 a_18863_14845# a_19530_14484# VSS.t52 sg13_lv_nmos ad=0.1406p pd=1.12u as=0.2516p ps=2.16u w=0.74u l=0.13u
X293 VDD VSS.t1337 VDD VDD sg13_lv_pmos ad=0.34p pd=2.68u as=0 ps=0 w=1u l=1u
X294 VSS.t2710 VDD VSS.t2709 VSS.t199 sg13_lv_nmos ad=0.1428p pd=1.52u as=0 ps=0 w=0.42u l=1u
X295 VSS.t2526 VDD VSS.t2525 VSS.t2524 sg13_lv_nmos ad=0.1428p pd=1.52u as=0 ps=0 w=0.42u l=1u
X296 VSS.t2139 VDD VSS.t2141 VSS.t2140 sg13_lv_nmos ad=79.8f pd=0.8u as=0 ps=0 w=0.42u l=1u
X297 VDD VSS.t41 VDD VDD sg13_lv_pmos ad=0.34p pd=2.68u as=0 ps=0 w=1u l=1u
X298 VSS.t667 VDD VSS.t664 VSS.t666 sg13_lv_nmos ad=0.1428p pd=1.52u as=0 ps=0 w=0.42u l=1u
X299 VDD VSS.t1081 VDD VDD sg13_lv_pmos ad=0.34p pd=2.68u as=0 ps=0 w=1u l=1u
X300 VSS.t1287 VDD VSS.t1286 VSS.t248 sg13_lv_nmos ad=0.1428p pd=1.52u as=0 ps=0 w=0.42u l=1u
X301 VSS.t2326 VDD VSS.t2328 VSS.t2327 sg13_lv_nmos ad=79.8f pd=0.8u as=0 ps=0 w=0.42u l=1u
X302 VSS.t2029 VDD VSS.t2031 VSS.t2030 sg13_lv_nmos ad=79.8f pd=0.8u as=0 ps=0 w=0.42u l=1u
X303 VSS.t421 VDD VSS.t418 VSS.t420 sg13_lv_nmos ad=0.1428p pd=1.52u as=0 ps=0 w=0.42u l=1u
X304 VSS.t481 VDD VSS.t480 VSS.t19 sg13_lv_nmos ad=0.1428p pd=1.52u as=0 ps=0 w=0.42u l=1u
X305 VSS.t3114 VDD VSS.t3116 VSS.t3115 sg13_lv_nmos ad=79.8f pd=0.8u as=0 ps=0 w=0.42u l=1u
X306 VSS.t967 VDD VSS.t966 VSS.t965 sg13_lv_nmos ad=0.1428p pd=1.52u as=0 ps=0 w=0.42u l=1u
X307 VDD VSS.t1604 VDD VDD sg13_lv_pmos ad=0.19p pd=1.38u as=0 ps=0 w=1u l=1u
X308 VDD VSS.t1019 VDD VDD sg13_lv_pmos ad=0.19p pd=1.38u as=0 ps=0 w=1u l=1u
X309 VDD VSS.t1659 VDD VDD sg13_lv_pmos ad=0.19p pd=1.38u as=0 ps=0 w=1u l=1u
X310 VSS.t448 VDD VSS.t39 VSS.t19 sg13_lv_nmos ad=0.1428p pd=1.52u as=0 ps=0 w=0.42u l=1u
X311 VSS.t2401 VDD VSS.t2403 VSS.t2402 sg13_lv_nmos ad=79.8f pd=0.8u as=0 ps=0 w=0.42u l=1u
X312 VDD VSS.t323 VDD VDD sg13_lv_pmos ad=0.19p pd=1.38u as=0 ps=0 w=1u l=1u
X313 a_27034_15202# sg13cmos5l_dfrbpq_1_7.Q VDD VDD sg13_lv_pmos ad=0.1428p pd=1.52u as=0.1523p ps=1.38u w=0.42u l=0.13u
X314 VSS.t2708 VDD VSS.t2706 VSS.t199 sg13_lv_nmos ad=0.1428p pd=1.52u as=0 ps=0 w=0.42u l=1u
X315 VDD VSS.t2430 VDD VDD sg13_lv_pmos ad=0.34p pd=2.68u as=0 ps=0 w=1u l=1u
X316 VDD VSS.t643 VDD VDD sg13_lv_pmos ad=0.19p pd=1.38u as=0 ps=0 w=1u l=1u
X317 VDD VSS.t56 VDD VDD sg13_lv_pmos ad=0.19p pd=1.38u as=0 ps=0 w=1u l=1u
X318 VDD VSS.t1941 VDD VDD sg13_lv_pmos ad=0.19p pd=1.38u as=0 ps=0 w=1u l=1u
X319 VDD VSS.t2768 VDD VDD sg13_lv_pmos ad=0.19p pd=1.38u as=0 ps=0 w=1u l=1u
X320 VSS.t1622 VDD VSS.t1621 VSS.t1620 sg13_lv_nmos ad=0.1428p pd=1.52u as=0 ps=0 w=0.42u l=1u
X321 VSS.t3144 VDD VSS.t3143 VSS.t3142 sg13_lv_nmos ad=0.1428p pd=1.52u as=0 ps=0 w=0.42u l=1u
X322 VDD VSS.t2348 VDD VDD sg13_lv_pmos ad=0.19p pd=1.38u as=0 ps=0 w=1u l=1u
X323 VSS.t13 a_18202_15202# a_17921_15424# VSS.t221 sg13_lv_nmos ad=79.8f pd=0.8u as=0.1428p ps=1.52u w=0.42u l=0.5u
X324 VDD VSS.t2743 VDD VDD sg13_lv_pmos ad=0.34p pd=2.68u as=0 ps=0 w=1u l=1u
X325 a_25390_16263# a_25505_16262# VDD VDD sg13_lv_pmos ad=0.34p pd=2.68u as=0.2254p ps=1.53u w=1u l=0.5u
X326 VSS.t484 VDD VSS.t485 VSS.t19 sg13_lv_nmos ad=79.8f pd=0.8u as=0 ps=0 w=0.42u l=1u
X327 VDD VSS.t477 VDD VDD sg13_lv_pmos ad=0.34p pd=2.68u as=0 ps=0 w=1u l=1u
X328 VDD VSS.t894 VDD VDD sg13_lv_pmos ad=0.19p pd=1.38u as=0 ps=0 w=1u l=1u
X329 VSS.t937 VDD VSS.t936 VSS.t935 sg13_lv_nmos ad=0.1428p pd=1.52u as=0 ps=0 w=0.42u l=1u
X330 VDD VSS.t2533 VDD VDD sg13_lv_pmos ad=0.19p pd=1.38u as=0 ps=0 w=1u l=1u
X331 VDD VSS.t1317 VDD VDD sg13_lv_pmos ad=0.19p pd=1.38u as=0 ps=0 w=1u l=1u
X332 VSS.t1617 VDD VSS.t1616 VSS.t1615 sg13_lv_nmos ad=0.1428p pd=1.52u as=0 ps=0 w=0.42u l=1u
X333 VDD VSS.t2817 VDD VDD sg13_lv_pmos ad=0.19p pd=1.38u as=0 ps=0 w=1u l=1u
X334 VDD VSS.t2131 VDD VDD sg13_lv_pmos ad=0.19p pd=1.38u as=0 ps=0 w=1u l=1u
X335 VDD VSS.t2485 VDD VDD sg13_lv_pmos ad=0.34p pd=2.68u as=0 ps=0 w=1u l=1u
X336 VSS.t2546 VDD VSS.t2545 VSS.t2544 sg13_lv_nmos ad=0.1428p pd=1.52u as=0 ps=0 w=0.42u l=1u
X337 VSS.t2366 VDD VSS.t2368 VSS.t2367 sg13_lv_nmos ad=79.8f pd=0.8u as=0 ps=0 w=0.42u l=1u
X338 VDD VSS.t3048 VDD VDD sg13_lv_pmos ad=0.34p pd=2.68u as=0 ps=0 w=1u l=1u
X339 VSS.t625 VDD VSS.t627 VSS.t626 sg13_lv_nmos ad=79.8f pd=0.8u as=0 ps=0 w=0.42u l=1u
X340 VSS.t2094 VDD VSS.t2093 VSS.t2092 sg13_lv_nmos ad=0.1428p pd=1.52u as=0 ps=0 w=0.42u l=1u
X341 VDD VSS.t1271 VDD VDD sg13_lv_pmos ad=0.34p pd=2.68u as=0 ps=0 w=1u l=1u
X342 VDD VSS.t2091 VDD VDD sg13_lv_pmos ad=0.19p pd=1.38u as=0 ps=0 w=1u l=1u
X343 VSS.t812 VDD VSS.t811 VSS.t810 sg13_lv_nmos ad=0.1428p pd=1.52u as=0 ps=0 w=0.42u l=1u
X344 VSS.t997 VDD VSS.t999 VSS.t998 sg13_lv_nmos ad=79.8f pd=0.8u as=0 ps=0 w=0.42u l=1u
X345 VDD VSS.t1589 VDD VDD sg13_lv_pmos ad=0.19p pd=1.38u as=0 ps=0 w=1u l=1u
X346 VDD VSS.t1644 VDD VDD sg13_lv_pmos ad=0.19p pd=1.38u as=0 ps=0 w=1u l=1u
X347 VDD a_8218_13690# a_7937_13912# VDD sg13_lv_pmos ad=0.1523p pd=1.38u as=0.34p ps=2.68u w=1u l=0.5u
X348 sg13cmos5l_dfrbpq_1_2.Q a_17994_14020# VDD VDD sg13_lv_pmos ad=0.3808p pd=2.92u as=0.2128p ps=1.5u w=1.12u l=0.13u
X349 VDD VSS.t215 VDD VDD sg13_lv_pmos ad=0.34p pd=2.68u as=0 ps=0 w=1u l=1u
X350 VDD VSS.t926 VDD VDD sg13_lv_pmos ad=0.34p pd=2.68u as=0 ps=0 w=1u l=1u
X351 VDD VSS.t2705 VDD VDD sg13_lv_pmos ad=0.19p pd=1.38u as=0 ps=0 w=1u l=1u
X352 VDD VSS.t2778 VDD VDD sg13_lv_pmos ad=0.19p pd=1.38u as=0 ps=0 w=1u l=1u
X353 VSS.t2044 VDD VSS.t2043 VSS.t2042 sg13_lv_nmos ad=0.1428p pd=1.52u as=0 ps=0 w=0.42u l=1u
X354 VDD VSS.t41 VDD VDD sg13_lv_pmos ad=0.34p pd=2.68u as=0 ps=0 w=1u l=1u
X355 a_23960_15242# sg13cmos5l_dfrbpq_1_3.Q a_23858_15242# VSS.t48 sg13_lv_nmos ad=0.1406p pd=1.12u as=0.1406p ps=1.12u w=0.74u l=0.13u
X356 VSS.t3129 VDD VSS.t3128 VSS.t3127 sg13_lv_nmos ad=0.1428p pd=1.52u as=0 ps=0 w=0.42u l=1u
X357 VSS.t2341 VDD VSS.t2340 VSS.t2339 sg13_lv_nmos ad=0.1428p pd=1.52u as=0 ps=0 w=0.42u l=1u
X358 VDD VSS.t364 VDD VDD sg13_lv_pmos ad=0.19p pd=1.38u as=0 ps=0 w=1u l=1u
X359 a_7680_15549# sg13cmos5l_dlygate4sd3_1_8.X VDD VDD sg13_lv_pmos ad=0.1596p pd=1.22u as=0.4536p ps=2.76u w=0.84u l=0.13u
X360 VSS.t466 VDD VSS.t465 VSS.t19 sg13_lv_nmos ad=0.1428p pd=1.52u as=0 ps=0 w=0.42u l=1u
X361 VSS.t2675 VDD VSS.t2674 VSS.t199 sg13_lv_nmos ad=0.1428p pd=1.52u as=0 ps=0 w=0.42u l=1u
X362 a_24923_15996# sg13cmos5l_or3_1_1.X VDD VDD sg13_lv_pmos ad=0.3808p pd=2.92u as=0.2128p ps=1.5u w=1.12u l=0.13u
X363 VDD sg13cmos5l_xnor2_1_0.Y a_8312_15238# VDD sg13_lv_pmos ad=0.1523p pd=1.38u as=0.1428p ps=1.52u w=0.42u l=0.13u
X364 VSS.t2770 VDD VSS.t2771 VSS.t199 sg13_lv_nmos ad=79.8f pd=0.8u as=0 ps=0 w=0.42u l=1u
X365 VDD VSS.t2518 VDD VDD sg13_lv_pmos ad=0.19p pd=1.38u as=0 ps=0 w=1u l=1u
X366 VDD VSS.t661 VDD VDD sg13_lv_pmos ad=0.19p pd=1.38u as=0 ps=0 w=1u l=1u
X367 VDD VSS.t1958 VDD VDD sg13_lv_pmos ad=0.34p pd=2.68u as=0 ps=0 w=1u l=1u
X368 VDD VSS.t2293 VDD VDD sg13_lv_pmos ad=0.19p pd=1.38u as=0 ps=0 w=1u l=1u
X369 VDD VSS.t3081 VDD VDD sg13_lv_pmos ad=0.19p pd=1.38u as=0 ps=0 w=1u l=1u
X370 VSS.t2124 VDD VSS.t2126 VSS.t2125 sg13_lv_nmos ad=79.8f pd=0.8u as=0 ps=0 w=0.42u l=1u
X371 VDD VSS.t440 VDD VDD sg13_lv_pmos ad=0.19p pd=1.38u as=0 ps=0 w=1u l=1u
X372 a_20868_14922# sg13cmos5l_dfrbpq_1_6.D a_20774_14922# VSS.t52 sg13_lv_nmos ad=60.89999f pd=0.71u as=0.1428p ps=1.52u w=0.42u l=0.13u
X373 VDD VSS.t2083 VDD VDD sg13_lv_pmos ad=0.34p pd=2.68u as=0 ps=0 w=1u l=1u
X374 VSS.t1345 VDD VSS.t1475 VSS.t248 sg13_lv_nmos ad=0.1428p pd=1.52u as=0 ps=0 w=0.42u l=1u
X375 VSS.t403 VDD VSS.t403 VSS.t406 sg13_lv_nmos ad=79.8f pd=0.8u as=0 ps=0 w=0.42u l=1u
X376 VDD VSS.t582 VDD VDD sg13_lv_pmos ad=0.34p pd=2.68u as=0 ps=0 w=1u l=1u
X377 VSS.t967 VDD VSS.t966 VSS.t965 sg13_lv_nmos ad=0.1428p pd=1.52u as=0 ps=0 w=0.42u l=1u
X378 VDD sg13cmos5l_dlygate4sd3_1_1.A sg13cmos5l_nand3_1_0.Y VDD sg13_lv_pmos ad=0.2128p pd=1.5u as=0.2128p ps=1.5u w=1.12u l=0.13u
X379 VSS.t3099 VDD VSS.t3101 VSS.t3100 sg13_lv_nmos ad=79.8f pd=0.8u as=0 ps=0 w=0.42u l=1u
X380 VSS.t2311 VDD VSS.t2313 VSS.t2312 sg13_lv_nmos ad=79.8f pd=0.8u as=0 ps=0 w=0.42u l=1u
X381 a_21562_15960# sg13cmos5l_a21oi_1_1.Y VSS.t56 VSS.t211 sg13_lv_nmos ad=0.1428p pd=1.52u as=79.8f ps=0.8u w=0.42u l=0.13u
X382 VDD VSS.t1766 VDD VDD sg13_lv_pmos ad=0.34p pd=2.68u as=0 ps=0 w=1u l=1u
X383 VDD a_21477_14495# a_21579_14495# VDD sg13_lv_pmos ad=2.42015p pd=15.68u as=0.3864p ps=2.93u w=1.12u l=0.13u
X384 VSS.t1672 VDD VSS.t1674 VSS.t1673 sg13_lv_nmos ad=79.8f pd=0.8u as=0 ps=0 w=0.42u l=1u
X385 VSS.t2386 VDD VSS.t2388 VSS.t2387 sg13_lv_nmos ad=79.8f pd=0.8u as=0 ps=0 w=0.42u l=1u
X386 a_17830_14909# sg13cmos5l_dfrbpq_1_3.RESET_B VSS.t13 VSS.t112 sg13_lv_nmos ad=37.8f pd=0.6u as=0.1701p ps=1.65u w=0.42u l=0.13u
X387 VDD VSS.t670 VDD VDD sg13_lv_pmos ad=0.19p pd=1.38u as=0 ps=0 w=1u l=1u
X388 VDD VSS.t1596 VDD VDD sg13_lv_pmos ad=0.34p pd=2.68u as=0 ps=0 w=1u l=1u
X389 VSS.t1667 VDD VSS.t1669 VSS.t1668 sg13_lv_nmos ad=79.8f pd=0.8u as=0 ps=0 w=0.42u l=1u
X390 VDD VSS.t2736 VDD VDD sg13_lv_pmos ad=0.34p pd=2.68u as=0 ps=0 w=1u l=1u
X391 VDD VSS.t2510 VDD VDD sg13_lv_pmos ad=0.34p pd=2.68u as=0 ps=0 w=1u l=1u
X392 VSS.t887 VDD VSS.t889 VSS.t888 sg13_lv_nmos ad=79.8f pd=0.8u as=0 ps=0 w=0.42u l=1u
X393 VSS.t2780 VDD VSS.t2781 VSS.t199 sg13_lv_nmos ad=79.8f pd=0.8u as=0 ps=0 w=0.42u l=1u
X394 VDD VSS.t1207 VDD VDD sg13_lv_pmos ad=0.34p pd=2.68u as=0 ps=0 w=1u l=1u
X395 a_26565_13701# sg13cmos5l_buf_8_2.X VSS.t105 VSS.t104 sg13_lv_nmos ad=0.2516p pd=2.16u as=15.38618p ps=0.10091m w=0.74u l=0.13u
X396 VDD VSS.t1308 VDD VDD sg13_lv_pmos ad=0.19p pd=1.38u as=0 ps=0 w=1u l=1u
X397 VDD VSS.t2809 VDD VDD sg13_lv_pmos ad=0.19p pd=1.38u as=0 ps=0 w=1u l=1u
X398 VDD VSS.t2116 VDD VDD sg13_lv_pmos ad=0.19p pd=1.38u as=0 ps=0 w=1u l=1u
X399 VDD VSS.t2470 VDD VDD sg13_lv_pmos ad=0.34p pd=2.68u as=0 ps=0 w=1u l=1u
X400 VSS.t2531 VDD VSS.t2530 VSS.t2529 sg13_lv_nmos ad=0.1428p pd=1.52u as=0 ps=0 w=0.42u l=1u
X401 VDD VSS.t2781 VDD VDD sg13_lv_pmos ad=0.34p pd=2.68u as=0 ps=0 w=1u l=1u
X402 VSS.t90 a_15579_14854# sg13cmos5l_buf_8_2.A VSS.t155 sg13_lv_nmos ad=0.1406p pd=1.12u as=0.1406p ps=1.12u w=0.74u l=0.13u
X403 VDD VSS.t17 VDD VDD sg13_lv_pmos ad=0.19p pd=1.38u as=0 ps=0 w=1u l=1u
X404 VSS.t1697 VDD VSS.t1696 VSS.t1695 sg13_lv_nmos ad=0.1428p pd=1.52u as=0 ps=0 w=0.42u l=1u
X405 VDD VSS.t3033 VDD VDD sg13_lv_pmos ad=0.34p pd=2.68u as=0 ps=0 w=1u l=1u
X406 sg13cmos5l_o21ai_1_3.Y sg13cmos5l_or3_1_1.C a_24408_15552# VDD sg13_lv_pmos ad=0.2128p pd=1.5u as=0.2128p ps=1.5u w=1.12u l=0.15u
X407 VDD sg13cmos5l_inv_1_0.Y a_16140_15424# VDD sg13_lv_pmos ad=0.4536p pd=2.76u as=0.1596p ps=1.22u w=0.84u l=0.13u
X408 a_27664_13942# a_27407_13799# a_27826_13722# VSS.t184 sg13_lv_nmos ad=0.1428p pd=1.52u as=37.8f ps=0.6u w=0.42u l=0.13u
X409 VDD VSS.t1986 VDD VDD sg13_lv_pmos ad=0.19p pd=1.38u as=0 ps=0 w=1u l=1u
X410 a_17584_13942# sg13cmos5l_dfrbpq_1_2.RESET_B VDD VDD sg13_lv_pmos ad=79.8f pd=0.8u as=2.42015p ps=15.68u w=0.42u l=0.13u
X411 VDD VSS.t1574 VDD VDD sg13_lv_pmos ad=0.19p pd=1.38u as=0 ps=0 w=1u l=1u
X412 VDD VSS.t1751 VDD VDD sg13_lv_pmos ad=0.34p pd=2.68u as=0 ps=0 w=1u l=1u
X413 VDD VSS.t649 VDD VDD sg13_lv_pmos ad=0.34p pd=2.68u as=0 ps=0 w=1u l=1u
X414 VSS.t2371 VDD VSS.t2373 VSS.t2372 sg13_lv_nmos ad=79.8f pd=0.8u as=0 ps=0 w=0.42u l=1u
X415 VDD a_25786_15960# a_25505_16262# VDD sg13_lv_pmos ad=0.1523p pd=1.38u as=0.34p ps=2.68u w=1u l=0.5u
X416 VSS.t1218 VDD VSS.t1219 VSS.t248 sg13_lv_nmos ad=79.8f pd=0.8u as=0 ps=0 w=0.42u l=1u
X417 VDD VSS.t2696 VDD VDD sg13_lv_pmos ad=0.19p pd=1.38u as=0 ps=0 w=1u l=1u
X418 VSS.t1592 VDD VSS.t1591 VSS.t1590 sg13_lv_nmos ad=0.1428p pd=1.52u as=0 ps=0 w=0.42u l=1u
X419 VSS.t3114 VDD VSS.t3113 VSS.t3112 sg13_lv_nmos ad=0.1428p pd=1.52u as=0 ps=0 w=0.42u l=1u
X420 VSS.t2326 VDD VSS.t2325 VSS.t2324 sg13_lv_nmos ad=0.1428p pd=1.52u as=0 ps=0 w=0.42u l=1u
X421 VDD VSS.t2353 VDD VDD sg13_lv_pmos ad=0.19p pd=1.38u as=0 ps=0 w=1u l=1u
X422 VSS.t2667 VDD VSS.t200 VSS.t199 sg13_lv_nmos ad=0.1428p pd=1.52u as=0 ps=0 w=0.42u l=1u
X423 a_21466_15202# sg13cmos5l_o21ai_1_1.Y VSS.t174 VSS.t175 sg13_lv_nmos ad=0.1428p pd=1.52u as=79.8f ps=0.8u w=0.42u l=0.13u
X424 VDD VSS.t2801 VDD VDD sg13_lv_pmos ad=0.19p pd=1.38u as=0 ps=0 w=1u l=1u
X425 VDD VSS.t2136 VDD VDD sg13_lv_pmos ad=0.19p pd=1.38u as=0 ps=0 w=1u l=1u
X426 a_3209_16334# a_3333_16033# VDD VDD sg13_lv_pmos ad=0.2442p pd=2.06u as=2.8961p ps=18.25u w=0.66u l=0.13u
X427 VDD VSS.t548 VDD VDD sg13_lv_pmos ad=0.34p pd=2.68u as=0 ps=0 w=1u l=1u
X428 VDD VSS.t846 VDD VDD sg13_lv_pmos ad=0.34p pd=2.68u as=0 ps=0 w=1u l=1u
X429 VSS.t1272 VDD VSS.t1271 VSS.t248 sg13_lv_nmos ad=0.1428p pd=1.52u as=0 ps=0 w=0.42u l=1u
X430 VSS.t90 a_15579_14854# sg13cmos5l_buf_8_2.A VSS.t151 sg13_lv_nmos ad=0.1406p pd=1.12u as=0.1406p ps=1.12u w=0.74u l=0.13u
X431 VSS.t613 VDD VSS.t615 VSS.t614 sg13_lv_nmos ad=79.8f pd=0.8u as=0 ps=0 w=0.42u l=1u
X432 VDD VSS.t582 VDD VDD sg13_lv_pmos ad=0.34p pd=2.68u as=0 ps=0 w=1u l=1u
X433 VSS.t1682 VDD VSS.t1681 VSS.t1680 sg13_lv_nmos ad=0.1428p pd=1.52u as=0 ps=0 w=0.42u l=1u
X434 VSS.t1226 VDD VSS.t1227 VSS.t248 sg13_lv_nmos ad=79.8f pd=0.8u as=0 ps=0 w=0.42u l=1u
X435 VSS.t90 VDD VSS.t90 VSS.t444 sg13_lv_nmos ad=0.1428p pd=1.52u as=0 ps=0 w=0.42u l=1u
X436 VSS.t19 a_15671_15315# a_15671_15315# VSS.t57 sg13_lv_nmos ad=4.11262p pd=27.15u as=0.111p ps=1.34u w=0.3u l=0.13u
X437 VDD a_25094_14484# a_25206_14508# VDD sg13_lv_pmos ad=0.2254p pd=1.53u as=0.34p ps=2.68u w=1u l=0.5u
X438 VSS.t2551 VDD VSS.t2550 VSS.t2549 sg13_lv_nmos ad=0.1428p pd=1.52u as=0 ps=0 w=0.42u l=1u
X439 VSS.t1230 VDD VSS.t1231 VSS.t248 sg13_lv_nmos ad=79.8f pd=0.8u as=0 ps=0 w=0.42u l=1u
X440 VSS.t1657 VDD VSS.t1659 VSS.t1658 sg13_lv_nmos ad=79.8f pd=0.8u as=0 ps=0 w=0.42u l=1u
X441 VDD VSS.t2333 VDD VDD sg13_lv_pmos ad=0.19p pd=1.38u as=0 ps=0 w=1u l=1u
X442 a_19054_15423# a_19169_15424# VDD VDD sg13_lv_pmos ad=0.34p pd=2.68u as=0.2254p ps=1.53u w=1u l=0.5u
X443 VDD VSS.t1931 VDD VDD sg13_lv_pmos ad=0.19p pd=1.38u as=0 ps=0 w=1u l=1u
X444 VDD VSS.t2763 VDD VDD sg13_lv_pmos ad=0.19p pd=1.38u as=0 ps=0 w=1u l=1u
X445 VSS.t2049 VDD VSS.t2048 VSS.t2047 sg13_lv_nmos ad=0.1428p pd=1.52u as=0 ps=0 w=0.42u l=1u
X446 VDD VSS.t446 VDD VDD sg13_lv_pmos ad=0.34p pd=2.68u as=0 ps=0 w=1u l=1u
X447 VSS.t1612 VDD VSS.t1611 VSS.t1610 sg13_lv_nmos ad=0.1428p pd=1.52u as=0 ps=0 w=0.42u l=1u
X448 VSS.t3134 VDD VSS.t3133 VSS.t3132 sg13_lv_nmos ad=0.1428p pd=1.52u as=0 ps=0 w=0.42u l=1u
X449 VSS.t887 VDD VSS.t889 VSS.t888 sg13_lv_nmos ad=79.8f pd=0.8u as=0 ps=0 w=0.42u l=1u
X450 VDD VSS.t1621 VDD VDD sg13_lv_pmos ad=0.34p pd=2.68u as=0 ps=0 w=1u l=1u
X451 VSS.t1652 VDD VSS.t1654 VSS.t1653 sg13_lv_nmos ad=79.8f pd=0.8u as=0 ps=0 w=0.42u l=1u
X452 VDD VSS.t2495 VDD VDD sg13_lv_pmos ad=0.34p pd=2.68u as=0 ps=0 w=1u l=1u
X453 VDD VSS.t450 VDD VDD sg13_lv_pmos ad=0.34p pd=2.68u as=0 ps=0 w=1u l=1u
X454 VSS.t2772 VDD VSS.t2773 VSS.t199 sg13_lv_nmos ad=79.8f pd=0.8u as=0 ps=0 w=0.42u l=1u
X455 VDD VSS.t2523 VDD VDD sg13_lv_pmos ad=0.19p pd=1.38u as=0 ps=0 w=1u l=1u
X456 VDD VSS.t1963 VDD VDD sg13_lv_pmos ad=0.34p pd=2.68u as=0 ps=0 w=1u l=1u
X457 VSS.t2356 VDD VSS.t2358 VSS.t2357 sg13_lv_nmos ad=79.8f pd=0.8u as=0 ps=0 w=0.42u l=1u
X458 VDD VSS.t2298 VDD VDD sg13_lv_pmos ad=0.19p pd=1.38u as=0 ps=0 w=1u l=1u
X459 a_9801_15625# a_9444_15552# VDD VDD sg13_lv_pmos ad=63f pd=0.72u as=0.1563p ps=1.22u w=0.42u l=0.13u
X460 VDD VSS.t1001 VDD VDD sg13_lv_pmos ad=0.34p pd=2.68u as=0 ps=0 w=1u l=1u
X461 VDD VSS.t3086 VDD VDD sg13_lv_pmos ad=0.19p pd=1.38u as=0 ps=0 w=1u l=1u
X462 VSS.t2129 VDD VSS.t2131 VSS.t2130 sg13_lv_nmos ad=79.8f pd=0.8u as=0 ps=0 w=0.42u l=1u
X463 VSS.t583 VDD VSS.t582 VSS.t581 sg13_lv_nmos ad=0.1428p pd=1.52u as=0 ps=0 w=0.42u l=1u
X464 VDD VSS.t17 VDD VDD sg13_lv_pmos ad=0.19p pd=1.38u as=0 ps=0 w=1u l=1u
X465 VDD VSS.t1244 VDD VDD sg13_lv_pmos ad=0.19p pd=1.38u as=0 ps=0 w=1u l=1u
X466 VSS.t1317 VDD VSS.t1317 VSS.t248 sg13_lv_nmos ad=79.8f pd=0.8u as=0 ps=0 w=0.42u l=1u
X467 VDD VSS.t1270 VDD VDD sg13_lv_pmos ad=0.34p pd=2.68u as=0 ps=0 w=1u l=1u
X468 VDD VSS.t2773 VDD VDD sg13_lv_pmos ad=0.34p pd=2.68u as=0 ps=0 w=1u l=1u
X469 VDD a_25094_15238# a_25206_15302# VDD sg13_lv_pmos ad=0.2254p pd=1.53u as=0.34p ps=2.68u w=1u l=0.5u
X470 VDD VSS.t2148 VDD VDD sg13_lv_pmos ad=0.34p pd=2.68u as=0 ps=0 w=1u l=1u
X471 VDD VSS.t1971 VDD VDD sg13_lv_pmos ad=0.19p pd=1.38u as=0 ps=0 w=1u l=1u
X472 VDD VSS.t456 VDD VDD sg13_lv_pmos ad=0.34p pd=2.68u as=0 ps=0 w=1u l=1u
X473 VDD VSS.t1736 VDD VDD sg13_lv_pmos ad=0.34p pd=2.68u as=0 ps=0 w=1u l=1u
X474 VSS.t2536 VDD VSS.t2535 VSS.t2534 sg13_lv_nmos ad=0.1428p pd=1.52u as=0 ps=0 w=0.42u l=1u
X475 VSS.t484 VDD VSS.t483 VSS.t19 sg13_lv_nmos ad=0.1428p pd=1.52u as=0 ps=0 w=0.42u l=1u
X476 VSS.t1642 VDD VSS.t1644 VSS.t1643 sg13_lv_nmos ad=79.8f pd=0.8u as=0 ps=0 w=0.42u l=1u
X477 VSS.t3164 VDD VSS.t3166 VSS.t3165 sg13_lv_nmos ad=79.8f pd=0.8u as=0 ps=0 w=0.42u l=1u
X478 VDD VSS.t9 VDD VDD sg13_lv_pmos ad=0.34p pd=2.68u as=0 ps=0 w=1u l=1u
X479 VDD VSS.t1601 VDD VDD sg13_lv_pmos ad=0.34p pd=2.68u as=0 ps=0 w=1u l=1u
X480 VSS.t2819 VDD VSS.t2820 VSS.t199 sg13_lv_nmos ad=79.8f pd=0.8u as=0 ps=0 w=0.42u l=1u
X481 VDD a_21946_16237# sg13cmos5l_dfrbpq_1_6.RESET_B VDD sg13_lv_pmos ad=2.8961p pd=18.25u as=0.3927p ps=2.99u w=1.155u l=0.13u
X482 VDD a_12010_15202# sg13cmos5l_dfrbpq_1_2.CLK VDD sg13_lv_pmos ad=0.2128p pd=1.5u as=0.2128p ps=1.5u w=1.12u l=0.13u
X483 VDD VSS.t1016 VDD VDD sg13_lv_pmos ad=0.34p pd=2.68u as=0 ps=0 w=1u l=1u
X484 VDD VSS.t2738 VDD VDD sg13_lv_pmos ad=0.34p pd=2.68u as=0 ps=0 w=1u l=1u
X485 VDD VSS.t2515 VDD VDD sg13_lv_pmos ad=0.34p pd=2.68u as=0 ps=0 w=1u l=1u
X486 VDD VSS.t548 VDD VDD sg13_lv_pmos ad=0.34p pd=2.68u as=0 ps=0 w=1u l=1u
X487 VDD VSS.t1311 VDD VDD sg13_lv_pmos ad=0.19p pd=1.38u as=0 ps=0 w=1u l=1u
X488 VDD VSS.t2121 VDD VDD sg13_lv_pmos ad=0.19p pd=1.38u as=0 ps=0 w=1u l=1u
X489 VSS.t105 VDD VSS.t17 VSS.t563 sg13_lv_nmos ad=79.8f pd=0.8u as=0 ps=0 w=0.42u l=1u
X490 VSS.t679 VDD VSS.t676 VSS.t678 sg13_lv_nmos ad=0.1428p pd=1.52u as=0 ps=0 w=0.42u l=1u
X491 VDD VSS.t2792 VDD VDD sg13_lv_pmos ad=0.19p pd=1.38u as=0 ps=0 w=1u l=1u
X492 VDD VSS.t2475 VDD VDD sg13_lv_pmos ad=0.34p pd=2.68u as=0 ps=0 w=1u l=1u
X493 VSS.t2501 VDD VSS.t2500 VSS.t2499 sg13_lv_nmos ad=0.1428p pd=1.52u as=0 ps=0 w=0.42u l=1u
X494 VSS.t17 a_6286_13911# sg13cmos5l_dlygate4sd3_1_0.X VSS.t70 sg13_lv_nmos ad=0.1426p pd=1.16u as=0.2516p ps=2.16u w=0.74u l=0.13u
X495 VSS.t1299 VDD VSS.t1298 VSS.t248 sg13_lv_nmos ad=0.1428p pd=1.52u as=0 ps=0 w=0.42u l=1u
X496 VSS.t323 VDD VSS.t323 VSS.t326 sg13_lv_nmos ad=79.8f pd=0.8u as=0 ps=0 w=0.42u l=1u
X497 VSS.t2994 VDD VSS.t2996 VSS.t2995 sg13_lv_nmos ad=79.8f pd=0.8u as=0 ps=0 w=0.42u l=1u
X498 VSS.t2084 VDD VSS.t2083 VSS.t2082 sg13_lv_nmos ad=0.1428p pd=1.52u as=0 ps=0 w=0.42u l=1u
X499 VSS.t1292 VDD VSS.t1293 VSS.t248 sg13_lv_nmos ad=79.8f pd=0.8u as=0 ps=0 w=0.42u l=1u
X500 VSS.t1667 VDD VSS.t1666 VSS.t1665 sg13_lv_nmos ad=0.1428p pd=1.52u as=0 ps=0 w=0.42u l=1u
X501 VDD VSS.t125 VDD VDD sg13_lv_pmos ad=0.34p pd=2.68u as=0 ps=0 w=1u l=1u
X502 a_26638_15423# a_26753_15424# VDD VDD sg13_lv_pmos ad=0.34p pd=2.68u as=0.2254p ps=1.53u w=1u l=0.5u
X503 VDD VSS.t839 VDD VDD sg13_lv_pmos ad=0.19p pd=1.38u as=0 ps=0 w=1u l=1u
X504 VDD VSS.t2310 VDD VDD sg13_lv_pmos ad=0.34p pd=2.68u as=0 ps=0 w=1u l=1u
X505 VDD VSS.t646 VDD VDD sg13_lv_pmos ad=0.19p pd=1.38u as=0 ps=0 w=1u l=1u
X506 VDD VSS.t1634 VDD VDD sg13_lv_pmos ad=0.19p pd=1.38u as=0 ps=0 w=1u l=1u
X507 VDD VSS.t3098 VDD VDD sg13_lv_pmos ad=0.34p pd=2.68u as=0 ps=0 w=1u l=1u
X508 VSS.t640 VDD VSS.t640 VSS.t780 sg13_lv_nmos ad=0.1428p pd=1.52u as=0 ps=0 w=0.42u l=1u
X509 VDD VSS.t1276 VDD VDD sg13_lv_pmos ad=0.19p pd=1.38u as=0 ps=0 w=1u l=1u
X510 VSS.t1335 VDD VSS.t1335 VSS.t248 sg13_lv_nmos ad=79.8f pd=0.8u as=0 ps=0 w=0.42u l=1u
X511 VDD a_26170_15202# a_25889_15424# VDD sg13_lv_pmos ad=0.1523p pd=1.38u as=0.34p ps=2.68u w=1u l=0.5u
X512 VDD VSS.t1916 VDD VDD sg13_lv_pmos ad=0.19p pd=1.38u as=0 ps=0 w=1u l=1u
X513 VDD VSS.t2699 VDD VDD sg13_lv_pmos ad=0.19p pd=1.38u as=0 ps=0 w=1u l=1u
X514 VDD VSS.t2755 VDD VDD sg13_lv_pmos ad=0.19p pd=1.38u as=0 ps=0 w=1u l=1u
X515 VSS.t2034 VDD VSS.t2033 VSS.t2032 sg13_lv_nmos ad=0.1428p pd=1.52u as=0 ps=0 w=0.42u l=1u
X516 VDD a_12010_15202# sg13cmos5l_dfrbpq_1_2.CLK VDD sg13_lv_pmos ad=0.2128p pd=1.5u as=0.2128p ps=1.5u w=1.12u l=0.13u
X517 a_6789_14495# sg13cmos5l_dfrbpq_1_2.CLK VSS.t19 VSS.t218 sg13_lv_nmos ad=0.2516p pd=2.16u as=3.8707p ps=25.555u w=0.74u l=0.13u
X518 VSS.t1597 VDD VSS.t1596 VSS.t1595 sg13_lv_nmos ad=0.1428p pd=1.52u as=0 ps=0 w=0.42u l=1u
X519 VSS.t3119 VDD VSS.t3118 VSS.t3117 sg13_lv_nmos ad=0.1428p pd=1.52u as=0 ps=0 w=0.42u l=1u
X520 VSS.t2331 VDD VSS.t2330 VSS.t2329 sg13_lv_nmos ad=0.1428p pd=1.52u as=0 ps=0 w=0.42u l=1u
X521 VSS.t433 VDD VSS.t435 VSS.t434 sg13_lv_nmos ad=79.8f pd=0.8u as=0 ps=0 w=0.42u l=1u
X522 VDD VSS.t1239 VDD VDD sg13_lv_pmos ad=0.34p pd=2.68u as=0 ps=0 w=1u l=1u
X523 VDD VSS.t625 VDD VDD sg13_lv_pmos ad=0.34p pd=2.68u as=0 ps=0 w=1u l=1u
X524 VSS.t2406 VDD VSS.t2405 VSS.t2404 sg13_lv_nmos ad=0.1428p pd=1.52u as=0 ps=0 w=0.42u l=1u
X525 VDD VSS.t1204 VDD VDD sg13_lv_pmos ad=0.19p pd=1.38u as=0 ps=0 w=1u l=1u
X526 VDD VSS.t2803 VDD VDD sg13_lv_pmos ad=0.19p pd=1.38u as=0 ps=0 w=1u l=1u
X527 VDD VSS.t2508 VDD VDD sg13_lv_pmos ad=0.19p pd=1.38u as=0 ps=0 w=1u l=1u
X528 VDD VSS.t2106 VDD VDD sg13_lv_pmos ad=0.19p pd=1.38u as=0 ps=0 w=1u l=1u
X529 sg13cmos5l_buf_8_2.A a_15579_14854# VDD VDD sg13_lv_pmos ad=0.2128p pd=1.5u as=0.2128p ps=1.5u w=1.12u l=0.13u
X530 VSS.t1 sg13cmos5l_dlygate4sd3_1_17.A a_24824_14525# VSS.t0 sg13_lv_nmos ad=79.8f pd=0.8u as=0.1428p ps=1.52u w=0.42u l=0.13u
X531 VDD VSS.t1046 VDD VDD sg13_lv_pmos ad=0.34p pd=2.68u as=0 ps=0 w=1u l=1u
X532 VDD VSS.t1302 VDD VDD sg13_lv_pmos ad=0.19p pd=1.38u as=0 ps=0 w=1u l=1u
X533 VSS.t2521 VDD VSS.t2520 VSS.t2519 sg13_lv_nmos ad=0.1428p pd=1.52u as=0 ps=0 w=0.42u l=1u
X534 VSS.t2341 VDD VSS.t2343 VSS.t2342 sg13_lv_nmos ad=79.8f pd=0.8u as=0 ps=0 w=0.42u l=1u
X535 a_22576_14726# sg13cmos5l_dfrbpq_1_6.RESET_B VDD VDD sg13_lv_pmos ad=79.8f pd=0.8u as=2.42015p ps=15.68u w=0.42u l=0.13u
X536 VDD VSS.t854 VDD VDD sg13_lv_pmos ad=0.19p pd=1.38u as=0 ps=0 w=1u l=1u
X537 VDD VSS.t2283 VDD VDD sg13_lv_pmos ad=0.19p pd=1.38u as=0 ps=0 w=1u l=1u
X538 a_27609_14037# a_26667_13844# a_27407_13799# VDD sg13_lv_pmos ad=93.45f pd=0.865u as=0.2048p ps=1.63u w=0.42u l=0.13u
X539 VSS.t2817 VDD VSS.t2818 VSS.t199 sg13_lv_nmos ad=79.8f pd=0.8u as=0 ps=0 w=0.42u l=1u
X540 VSS.t19 a_26373_14495# a_26475_14495# VSS.t224 sg13_lv_nmos ad=4.11262p pd=27.15u as=0.2516p ps=2.16u w=0.74u l=0.13u
X541 VSS.t1687 VDD VSS.t1686 VSS.t1685 sg13_lv_nmos ad=0.1428p pd=1.52u as=0 ps=0 w=0.42u l=1u
X542 VDD VSS.t2378 VDD VDD sg13_lv_pmos ad=0.19p pd=1.38u as=0 ps=0 w=1u l=1u
X543 VSS.t367 VDD VSS.t263 VSS.t368 sg13_lv_nmos ad=79.8f pd=0.8u as=0 ps=0 w=0.42u l=1u
X544 VDD sg13cmos5l_dfrbpq_1_1.RESET_B a_6086_14922# VDD sg13_lv_pmos ad=0.36237p pd=2.605u as=79.8f ps=0.8u w=0.42u l=0.13u
X545 VDD VSS.t92 VDD VDD sg13_lv_pmos ad=0.34p pd=2.68u as=0 ps=0 w=1u l=1u
X546 VSS.t1082 VDD VSS.t1081 VSS.t1080 sg13_lv_nmos ad=0.1428p pd=1.52u as=0 ps=0 w=0.42u l=1u
X547 VDD VSS.t1317 VDD VDD sg13_lv_pmos ad=0.34p pd=2.68u as=0 ps=0 w=1u l=1u
X548 VDD VSS.t2818 VDD VDD sg13_lv_pmos ad=0.34p pd=2.68u as=0 ps=0 w=1u l=1u
X549 VDD VSS.t2133 VDD VDD sg13_lv_pmos ad=0.34p pd=2.68u as=0 ps=0 w=1u l=1u
X550 VDD a_37484_15960# counter_value_o[7] VDD sg13_lv_pmos ad=0.2114p pd=1.54u as=0.42p ps=2.99u w=1.12u l=0.13u
X551 a_20774_14922# a_21579_14495# a_21034_14452# VDD sg13_lv_pmos ad=0.1428p pd=1.52u as=79.8f ps=0.8u w=0.42u l=0.13u
X552 VSS.t1478 VDD VSS.t1350 VSS.t248 sg13_lv_nmos ad=79.8f pd=0.8u as=0 ps=0 w=0.42u l=1u
X553 VSS.t1984 VDD VSS.t1986 VSS.t1985 sg13_lv_nmos ad=79.8f pd=0.8u as=0 ps=0 w=0.42u l=1u
X554 VDD VSS.t590 VDD VDD sg13_lv_pmos ad=0.19p pd=1.38u as=0 ps=0 w=1u l=1u
X555 VDD VSS.t635 VDD VDD sg13_lv_pmos ad=0.34p pd=2.68u as=0 ps=0 w=1u l=1u
X556 VDD VSS.t2161 VDD VDD sg13_lv_pmos ad=0.19p pd=1.38u as=0 ps=0 w=1u l=1u
X557 VDD VSS.t1586 VDD VDD sg13_lv_pmos ad=0.34p pd=2.68u as=0 ps=0 w=1u l=1u
X558 VDD VSS.t1936 VDD VDD sg13_lv_pmos ad=0.19p pd=1.38u as=0 ps=0 w=1u l=1u
X559 VSS.t2928 VDD VSS.t2811 VSS.t199 sg13_lv_nmos ad=79.8f pd=0.8u as=0 ps=0 w=0.42u l=1u
X560 VDD VSS.t2766 VDD VDD sg13_lv_pmos ad=0.19p pd=1.38u as=0 ps=0 w=1u l=1u
X561 VSS.t478 VDD VSS.t477 VSS.t19 sg13_lv_nmos ad=0.1428p pd=1.52u as=0 ps=0 w=0.42u l=1u
X562 sg13cmos5l_dlygate4sd3_1_17.A sg13cmos5l_a21oi_1_3.B1 VSS.t86 VSS.t85 sg13_lv_nmos ad=0.1406p pd=1.12u as=0.2516p ps=2.16u w=0.74u l=0.13u
X563 VSS.t1269 VDD VSS.t1270 VSS.t248 sg13_lv_nmos ad=79.8f pd=0.8u as=0 ps=0 w=0.42u l=1u
X564 VDD VSS.t673 VDD VDD sg13_lv_pmos ad=0.19p pd=1.38u as=0 ps=0 w=1u l=1u
X565 VDD VSS.t664 VDD VDD sg13_lv_pmos ad=0.19p pd=1.38u as=0 ps=0 w=1u l=1u
X566 VDD VSS.t1591 VDD VDD sg13_lv_pmos ad=0.34p pd=2.68u as=0 ps=0 w=1u l=1u
X567 VDD VSS.t2528 VDD VDD sg13_lv_pmos ad=0.19p pd=1.38u as=0 ps=0 w=1u l=1u
X568 VSS.t165 sg13cmos5l_buf_1_0.X a_2490_14447# VSS.t283 sg13_lv_nmos ad=0.374p pd=2.46u as=0.17462p ps=1.185u w=0.55u l=0.13u
X569 VDD VSS.t1009 VDD VDD sg13_lv_pmos ad=0.19p pd=1.38u as=0 ps=0 w=1u l=1u
X570 VSS.t1717 VDD VSS.t1719 VSS.t1718 sg13_lv_nmos ad=79.8f pd=0.8u as=0 ps=0 w=0.42u l=1u
X571 VDD VSS.t2779 VDD VDD sg13_lv_pmos ad=0.34p pd=2.68u as=0 ps=0 w=1u l=1u
X572 VSS.t2134 VDD VSS.t2136 VSS.t2135 sg13_lv_nmos ad=79.8f pd=0.8u as=0 ps=0 w=0.42u l=1u
X573 VSS.t2809 VDD VSS.t2809 VSS.t199 sg13_lv_nmos ad=79.8f pd=0.8u as=0 ps=0 w=0.42u l=1u
X574 VSS.t892 VDD VSS.t894 VSS.t893 sg13_lv_nmos ad=79.8f pd=0.8u as=0 ps=0 w=0.42u l=1u
X575 VSS.t2979 VDD VSS.t2981 VSS.t2980 sg13_lv_nmos ad=79.8f pd=0.8u as=0 ps=0 w=0.42u l=1u
X576 a_2916_15552# a_3435_15356# a_4175_15311# VSS.t208 sg13_lv_nmos ad=0.3473p pd=2.71u as=0.12665p ps=1.145u w=0.74u l=0.13u
X577 VDD a_22030_15423# sg13cmos5l_or3_1_2.A VDD sg13_lv_pmos ad=0.2254p pd=1.53u as=0.4256p ps=3u w=1.12u l=0.13u
X578 VSS.t2019 VDD VSS.t2021 VSS.t2020 sg13_lv_nmos ad=79.8f pd=0.8u as=0 ps=0 w=0.42u l=1u
X579 VDD VSS.t1976 VDD VDD sg13_lv_pmos ad=0.19p pd=1.38u as=0 ps=0 w=1u l=1u
X580 VDD VSS.t2714 VDD VDD sg13_lv_pmos ad=0.19p pd=1.38u as=0 ps=0 w=1u l=1u
X581 VSS.t2391 VDD VSS.t2390 VSS.t2389 sg13_lv_nmos ad=0.1428p pd=1.52u as=0 ps=0 w=0.42u l=1u
X582 VDD VSS.t682 VDD VDD sg13_lv_pmos ad=0.19p pd=1.38u as=0 ps=0 w=1u l=1u
X583 VDD VSS.t3083 VDD VDD sg13_lv_pmos ad=0.34p pd=2.68u as=0 ps=0 w=1u l=1u
X584 VDD VSS.t2295 VDD VDD sg13_lv_pmos ad=0.34p pd=2.68u as=0 ps=0 w=1u l=1u
X585 VSS.t1647 VDD VSS.t1649 VSS.t1648 sg13_lv_nmos ad=79.8f pd=0.8u as=0 ps=0 w=0.42u l=1u
X586 VSS.t3169 VDD VSS.t3171 VSS.t3170 sg13_lv_nmos ad=79.8f pd=0.8u as=0 ps=0 w=0.42u l=1u
X587 VDD VSS.t2323 VDD VDD sg13_lv_pmos ad=0.19p pd=1.38u as=0 ps=0 w=1u l=1u
X588 a_4175_15311# a_3333_15213# a_2916_15552# VDD sg13_lv_pmos ad=0.2048p pd=1.63u as=0.34p ps=2.68u w=1u l=0.13u
X589 VSS.t613 VDD VSS.t615 VSS.t614 sg13_lv_nmos ad=79.8f pd=0.8u as=0 ps=0 w=0.42u l=1u
X590 VDD VSS.t1659 VDD VDD sg13_lv_pmos ad=0.19p pd=1.38u as=0 ps=0 w=1u l=1u
X591 a_7532_15960# sg13cmos5l_dlygate4sd3_1_1.A VDD VDD sg13_lv_pmos ad=0.2856p pd=2.36u as=0.2114p ps=1.54u w=0.84u l=0.13u
X592 VSS.t1252 VDD VSS.t1251 VSS.t248 sg13_lv_nmos ad=0.1428p pd=1.52u as=0 ps=0 w=0.42u l=1u
X593 a_26182_14909# sg13cmos5l_dfrbpq_1_7.RESET_B VSS.t108 VSS.t3299 sg13_lv_nmos ad=37.8f pd=0.6u as=0.1701p ps=1.65u w=0.42u l=0.13u
X594 VSS.t1547 VDD VSS.t1549 VSS.t1548 sg13_lv_nmos ad=79.8f pd=0.8u as=0 ps=0 w=0.42u l=1u
X595 VSS.t2456 VDD VSS.t2458 VSS.t2457 sg13_lv_nmos ad=79.8f pd=0.8u as=0 ps=0 w=0.42u l=1u
X596 VSS.t1929 VDD VSS.t1931 VSS.t1930 sg13_lv_nmos ad=79.8f pd=0.8u as=0 ps=0 w=0.42u l=1u
X597 VDD VSS.t627 VDD VDD sg13_lv_pmos ad=0.34p pd=2.68u as=0 ps=0 w=1u l=1u
X598 VDD VSS.t976 VDD VDD sg13_lv_pmos ad=0.34p pd=2.68u as=0 ps=0 w=1u l=1u
X599 VSS.t45 VDD VSS.t45 VSS.t411 sg13_lv_nmos ad=0.1428p pd=1.52u as=0 ps=0 w=0.42u l=1u
X600 VSS.t847 VDD VSS.t846 VSS.t845 sg13_lv_nmos ad=0.1428p pd=1.52u as=0 ps=0 w=0.42u l=1u
X601 VDD VSS.t1293 VDD VDD sg13_lv_pmos ad=0.19p pd=1.38u as=0 ps=0 w=1u l=1u
X602 VDD VSS.t1948 VDD VDD sg13_lv_pmos ad=0.34p pd=2.68u as=0 ps=0 w=1u l=1u
X603 VDD VSS.t2795 VDD VDD sg13_lv_pmos ad=0.19p pd=1.38u as=0 ps=0 w=1u l=1u
X604 VSS.t2740 VDD VSS.t2741 VSS.t199 sg13_lv_nmos ad=79.8f pd=0.8u as=0 ps=0 w=0.42u l=1u
X605 VDD VSS.t2772 VDD VDD sg13_lv_pmos ad=0.34p pd=2.68u as=0 ps=0 w=1u l=1u
X606 VSS.t2506 VDD VSS.t2505 VSS.t2504 sg13_lv_nmos ad=0.1428p pd=1.52u as=0 ps=0 w=0.42u l=1u
X607 a_17318_14922# a_18123_14495# a_17578_14452# VDD sg13_lv_pmos ad=0.1428p pd=1.52u as=79.8f ps=0.8u w=0.42u l=0.13u
X608 VSS.t481 VDD VSS.t482 VSS.t19 sg13_lv_nmos ad=79.8f pd=0.8u as=0 ps=0 w=0.42u l=1u
X609 VSS.t2964 VDD VSS.t2966 VSS.t2965 sg13_lv_nmos ad=79.8f pd=0.8u as=0 ps=0 w=0.42u l=1u
X610 VDD VSS.t1039 VDD VDD sg13_lv_pmos ad=0.19p pd=1.38u as=0 ps=0 w=1u l=1u
X611 VSS.t1082 VDD VSS.t1081 VSS.t1080 sg13_lv_nmos ad=0.1428p pd=1.52u as=0 ps=0 w=0.42u l=1u
X612 VSS.t1672 VDD VSS.t1671 VSS.t1670 sg13_lv_nmos ad=0.1428p pd=1.52u as=0 ps=0 w=0.42u l=1u
X613 VSS.t2783 VDD VSS.t2782 VSS.t199 sg13_lv_nmos ad=0.1428p pd=1.52u as=0 ps=0 w=0.42u l=1u
X614 VDD VSS.t2540 VDD VDD sg13_lv_pmos ad=0.34p pd=2.68u as=0 ps=0 w=1u l=1u
X615 VDD VSS.t2363 VDD VDD sg13_lv_pmos ad=0.19p pd=1.38u as=0 ps=0 w=1u l=1u
X616 VSS.t443 VDD VSS.t443 VSS.t442 sg13_lv_nmos ad=0.1428p pd=1.52u as=0 ps=0 w=0.42u l=1u
X617 VDD VSS.t2315 VDD VDD sg13_lv_pmos ad=0.34p pd=2.68u as=0 ps=0 w=1u l=1u
X618 a_16175_15238# a_16140_15424# sg13cmos5l_nor2_1_0.B VSS.t147 sg13_lv_nmos ad=0.1406p pd=1.12u as=0.2516p ps=2.16u w=0.74u l=0.13u
X619 VDD VSS.t590 VDD VDD sg13_lv_pmos ad=0.19p pd=1.38u as=0 ps=0 w=1u l=1u
X620 VDD VSS.t1639 VDD VDD sg13_lv_pmos ad=0.19p pd=1.38u as=0 ps=0 w=1u l=1u
X621 VDD VSS.t3103 VDD VDD sg13_lv_pmos ad=0.34p pd=2.68u as=0 ps=0 w=1u l=1u
X622 VSS.t2149 VDD VSS.t2148 VSS.t2147 sg13_lv_nmos ad=0.1428p pd=1.52u as=0 ps=0 w=0.42u l=1u
X623 VSS.t1969 VDD VSS.t1971 VSS.t1970 sg13_lv_nmos ad=79.8f pd=0.8u as=0 ps=0 w=0.42u l=1u
X624 VSS.t583 VDD VSS.t582 VSS.t581 sg13_lv_nmos ad=0.1428p pd=1.52u as=0 ps=0 w=0.42u l=1u
X625 VDD VSS.t2488 VDD VDD sg13_lv_pmos ad=0.19p pd=1.38u as=0 ps=0 w=1u l=1u
X626 VDD VSS.t2146 VDD VDD sg13_lv_pmos ad=0.19p pd=1.38u as=0 ps=0 w=1u l=1u
X627 VSS.t1228 VDD VSS.t1229 VSS.t248 sg13_lv_nmos ad=79.8f pd=0.8u as=0 ps=0 w=0.42u l=1u
X628 VSS.t1265 VDD VSS.t1264 VSS.t248 sg13_lv_nmos ad=0.1428p pd=1.52u as=0 ps=0 w=0.42u l=1u
X629 VDD VSS.t1644 VDD VDD sg13_lv_pmos ad=0.19p pd=1.38u as=0 ps=0 w=1u l=1u
X630 VDD VSS.t1921 VDD VDD sg13_lv_pmos ad=0.19p pd=1.38u as=0 ps=0 w=1u l=1u
X631 VDD VSS.t2702 VDD VDD sg13_lv_pmos ad=0.19p pd=1.38u as=0 ps=0 w=1u l=1u
X632 VDD VSS.t2757 VDD VDD sg13_lv_pmos ad=0.19p pd=1.38u as=0 ps=0 w=1u l=1u
X633 a_4175_15311# a_3333_15213# a_4081_15311# VSS.t243 sg13_lv_nmos ad=0.12665p pd=1.145u as=0.1428p ps=1.52u w=0.42u l=0.13u
X634 VDD VSS.t1358 VDD VDD sg13_lv_pmos ad=0.34p pd=2.68u as=0 ps=0 w=1u l=1u
X635 VSS.t1602 VDD VSS.t1601 VSS.t1600 sg13_lv_nmos ad=0.1428p pd=1.52u as=0 ps=0 w=0.42u l=1u
X636 VSS.t3124 VDD VSS.t3123 VSS.t3122 sg13_lv_nmos ad=0.1428p pd=1.52u as=0 ps=0 w=0.42u l=1u
X637 VSS.t2336 VDD VSS.t2335 VSS.t2334 sg13_lv_nmos ad=0.1428p pd=1.52u as=0 ps=0 w=0.42u l=1u
X638 VSS.t162 a_7888_14726# a_7537_14845# VSS.t171 sg13_lv_nmos ad=79.8f pd=0.8u as=0.1428p ps=1.52u w=0.42u l=0.13u
X639 VSS.t649 VDD VSS.t649 VSS.t650 sg13_lv_nmos ad=79.8f pd=0.8u as=0 ps=0 w=0.42u l=1u
X640 VSS.t1002 VDD VSS.t1001 VSS.t1000 sg13_lv_nmos ad=0.1428p pd=1.52u as=0 ps=0 w=0.42u l=1u
X641 VDD VSS.t2513 VDD VDD sg13_lv_pmos ad=0.19p pd=1.38u as=0 ps=0 w=1u l=1u
X642 VSS.t2376 VDD VSS.t2375 VSS.t2374 sg13_lv_nmos ad=0.1428p pd=1.52u as=0 ps=0 w=0.42u l=1u
X643 VSS.t892 VDD VSS.t894 VSS.t893 sg13_lv_nmos ad=79.8f pd=0.8u as=0 ps=0 w=0.42u l=1u
X644 VDD VSS.t866 VDD VDD sg13_lv_pmos ad=0.34p pd=2.68u as=0 ps=0 w=1u l=1u
X645 VSS.t2733 VDD VSS.t2734 VSS.t199 sg13_lv_nmos ad=79.8f pd=0.8u as=0 ps=0 w=0.42u l=1u
X646 VSS.t463 VDD VSS.t462 VSS.t19 sg13_lv_nmos ad=0.1428p pd=1.52u as=0 ps=0 w=0.42u l=1u
X647 VSS.t2119 VDD VSS.t2121 VSS.t2120 sg13_lv_nmos ad=79.8f pd=0.8u as=0 ps=0 w=0.42u l=1u
X648 VSS.t2801 VDD VSS.t2802 VSS.t199 sg13_lv_nmos ad=79.8f pd=0.8u as=0 ps=0 w=0.42u l=1u
X649 VDD VSS.t414 VDD VDD sg13_lv_pmos ad=0.19p pd=1.38u as=0 ps=0 w=1u l=1u
X650 a_27826_13722# sg13cmos5l_dfrbpq_1_5.RESET_B VSS.t36 VSS.t35 sg13_lv_nmos ad=37.8f pd=0.6u as=79.8f ps=0.8u w=0.42u l=0.13u
X651 VSS.t105 VDD VSS.t17 VSS.t563 sg13_lv_nmos ad=79.8f pd=0.8u as=0 ps=0 w=0.42u l=1u
X652 VDD VSS.t1320 VDD VDD sg13_lv_pmos ad=0.34p pd=2.68u as=0 ps=0 w=1u l=1u
X653 VDD VSS.t2138 VDD VDD sg13_lv_pmos ad=0.34p pd=2.68u as=0 ps=0 w=1u l=1u
X654 VDD VSS.t391 VDD VDD sg13_lv_pmos ad=0.19p pd=1.38u as=0 ps=0 w=1u l=1u
X655 VSS.t1212 VDD VSS.t1211 VSS.t248 sg13_lv_nmos ad=0.1428p pd=1.52u as=0 ps=0 w=0.42u l=1u
X656 VDD VSS.t2802 VDD VDD sg13_lv_pmos ad=0.34p pd=2.68u as=0 ps=0 w=1u l=1u
X657 VSS.t1989 VDD VSS.t1991 VSS.t1990 sg13_lv_nmos ad=79.8f pd=0.8u as=0 ps=0 w=0.42u l=1u
X658 VDD VSS.t929 VDD VDD sg13_lv_pmos ad=0.19p pd=1.38u as=0 ps=0 w=1u l=1u
X659 VSS.t1017 VDD VSS.t1016 VSS.t1015 sg13_lv_nmos ad=0.1428p pd=1.52u as=0 ps=0 w=0.42u l=1u
X660 VSS.t1632 VDD VSS.t1634 VSS.t1633 sg13_lv_nmos ad=79.8f pd=0.8u as=0 ps=0 w=0.42u l=1u
X661 VSS.t3154 VDD VSS.t3156 VSS.t3155 sg13_lv_nmos ad=79.8f pd=0.8u as=0 ps=0 w=0.42u l=1u
X662 VDD VSS.t2308 VDD VDD sg13_lv_pmos ad=0.19p pd=1.38u as=0 ps=0 w=1u l=1u
X663 sg13cmos5l_a21oi_1_3.A1 a_25206_15302# VSS.t108 VSS.t48 sg13_lv_nmos ad=0.2516p pd=2.16u as=0.1426p ps=1.16u w=0.74u l=0.13u
X664 VDD VSS.t2693 VDD VDD sg13_lv_pmos ad=0.19p pd=1.38u as=0 ps=0 w=1u l=1u
X665 VSS.t2024 VDD VSS.t2023 VSS.t2022 sg13_lv_nmos ad=0.1428p pd=1.52u as=0 ps=0 w=0.42u l=1u
X666 VSS.t3109 VDD VSS.t3108 VSS.t3107 sg13_lv_nmos ad=0.1428p pd=1.52u as=0 ps=0 w=0.42u l=1u
X667 VSS.t2321 VDD VSS.t2320 VSS.t2319 sg13_lv_nmos ad=0.1428p pd=1.52u as=0 ps=0 w=0.42u l=1u
X668 VSS.t1532 VDD VSS.t1534 VSS.t1533 sg13_lv_nmos ad=79.8f pd=0.8u as=0 ps=0 w=0.42u l=1u
X669 VSS.t2441 VDD VSS.t2443 VSS.t2442 sg13_lv_nmos ad=79.8f pd=0.8u as=0 ps=0 w=0.42u l=1u
X670 a_6729_14531# a_6372_14488# VDD VDD sg13_lv_pmos ad=63f pd=0.72u as=0.1563p ps=1.22u w=0.42u l=0.13u
X671 VDD VSS.t1596 VDD VDD sg13_lv_pmos ad=0.34p pd=2.68u as=0 ps=0 w=1u l=1u
X672 VSS.t19 a_27034_15202# a_26753_15424# VSS.t83 sg13_lv_nmos ad=79.8f pd=0.8u as=0.1428p ps=1.52u w=0.42u l=0.5u
X673 VDD VSS.t1651 VDD VDD sg13_lv_pmos ad=0.34p pd=2.68u as=0 ps=0 w=1u l=1u
X674 VSS.t2396 VDD VSS.t2395 VSS.t2394 sg13_lv_nmos ad=0.1428p pd=1.52u as=0 ps=0 w=0.42u l=1u
X675 VSS.t847 VDD VSS.t846 VSS.t845 sg13_lv_nmos ad=0.1428p pd=1.52u as=0 ps=0 w=0.42u l=1u
X676 VDD VSS.t1021 VDD VDD sg13_lv_pmos ad=0.34p pd=2.68u as=0 ps=0 w=1u l=1u
X677 VDD VSS.t2498 VDD VDD sg13_lv_pmos ad=0.19p pd=1.38u as=0 ps=0 w=1u l=1u
X678 VSS.t603 VDD VSS.t602 VSS.t601 sg13_lv_nmos ad=0.1428p pd=1.52u as=0 ps=0 w=0.42u l=1u
X679 VDD VSS.t1255 VDD VDD sg13_lv_pmos ad=0.19p pd=1.38u as=0 ps=0 w=1u l=1u
X680 VSS.t1722 VDD VSS.t1724 VSS.t1723 sg13_lv_nmos ad=79.8f pd=0.8u as=0 ps=0 w=0.42u l=1u
X681 VDD VSS.t1933 VDD VDD sg13_lv_pmos ad=0.34p pd=2.68u as=0 ps=0 w=1u l=1u
X682 VDD VSS.t2764 VDD VDD sg13_lv_pmos ad=0.34p pd=2.68u as=0 ps=0 w=1u l=1u
X683 VDD VSS.t959 VDD VDD sg13_lv_pmos ad=0.19p pd=1.38u as=0 ps=0 w=1u l=1u
X684 VSS.t2104 VDD VSS.t2106 VSS.t2105 sg13_lv_nmos ad=79.8f pd=0.8u as=0 ps=0 w=0.42u l=1u
X685 a_37484_15960# sg13cmos5l_dfrbpq_1_5.Q VSS.t47 VSS.t309 sg13_lv_nmos ad=0.187p pd=1.78u as=0.14875p ps=1.16u w=0.55u l=0.13u
X686 VDD VSS.t1341 VDD VDD sg13_lv_pmos ad=0.19p pd=1.38u as=0 ps=0 w=1u l=1u
X687 VSS.t2949 VDD VSS.t2951 VSS.t2950 sg13_lv_nmos ad=79.8f pd=0.8u as=0 ps=0 w=0.42u l=1u
X688 VDD a_26170_16237# sg13cmos5l_dfrbpq_1_7.RESET_B VDD sg13_lv_pmos ad=2.8961p pd=18.25u as=0.3927p ps=2.99u w=1.155u l=0.13u
X689 VSS.t1302 VDD VSS.t1301 VSS.t248 sg13_lv_nmos ad=0.1428p pd=1.52u as=0 ps=0 w=0.42u l=1u
X690 VSS.t1225 VDD VSS.t1224 VSS.t248 sg13_lv_nmos ad=0.1428p pd=1.52u as=0 ps=0 w=0.42u l=1u
X691 VDD VSS.t2525 VDD VDD sg13_lv_pmos ad=0.34p pd=2.68u as=0 ps=0 w=1u l=1u
X692 VDD sg13cmos5l_tiehi_1.L_HI a_9158_15234# VDD sg13_lv_pmos ad=0.36237p pd=2.605u as=79.8f ps=0.8u w=0.42u l=0.13u
X693 sg13cmos5l_and2_1_0.X a_1965_14832# VSS.t15 VSS.t229 sg13_lv_nmos ad=0.2516p pd=2.16u as=0.1331p ps=1.12u w=0.74u l=0.13u
X694 VDD VSS.t896 VDD VDD sg13_lv_pmos ad=0.34p pd=2.68u as=0 ps=0 w=1u l=1u
X695 VDD VSS.t2717 VDD VDD sg13_lv_pmos ad=0.19p pd=1.38u as=0 ps=0 w=1u l=1u
X696 VSS.t2361 VDD VSS.t2360 VSS.t2359 sg13_lv_nmos ad=0.1428p pd=1.52u as=0 ps=0 w=0.42u l=1u
X697 VDD VSS.t3088 VDD VDD sg13_lv_pmos ad=0.34p pd=2.68u as=0 ps=0 w=1u l=1u
X698 VDD VSS.t2300 VDD VDD sg13_lv_pmos ad=0.34p pd=2.68u as=0 ps=0 w=1u l=1u
X699 VDD VSS.t2328 VDD VDD sg13_lv_pmos ad=0.19p pd=1.38u as=0 ps=0 w=1u l=1u
X700 VSS.t2134 VDD VSS.t2133 VSS.t2132 sg13_lv_nmos ad=0.1428p pd=1.52u as=0 ps=0 w=0.42u l=1u
X701 a_27898_15202# sg13cmos5l_dfrbpq_1_5.Q VSS.t39 VSS.t19 sg13_lv_nmos ad=0.1428p pd=1.52u as=79.8f ps=0.8u w=0.42u l=0.13u
X702 VSS.t1517 VDD VSS.t1519 VSS.t1518 sg13_lv_nmos ad=79.8f pd=0.8u as=0 ps=0 w=0.42u l=1u
X703 VSS.t2426 VDD VSS.t2428 VSS.t2427 sg13_lv_nmos ad=79.8f pd=0.8u as=0 ps=0 w=0.42u l=1u
X704 VSS.t1934 VDD VSS.t1936 VSS.t1935 sg13_lv_nmos ad=79.8f pd=0.8u as=0 ps=0 w=0.42u l=1u
X705 a_26633_16334# a_26757_16033# VDD VDD sg13_lv_pmos ad=0.2442p pd=2.06u as=2.8961p ps=18.25u w=0.66u l=0.13u
X706 VDD VSS.t2490 VDD VDD sg13_lv_pmos ad=0.34p pd=2.68u as=0 ps=0 w=1u l=1u
X707 a_18863_14845# a_18021_14495# a_18769_14845# VSS.t52 sg13_lv_nmos ad=0.12665p pd=1.145u as=0.1428p ps=1.52u w=0.42u l=0.13u
X708 VSS.t1002 VDD VSS.t1001 VSS.t1000 sg13_lv_nmos ad=0.1428p pd=1.52u as=0 ps=0 w=0.42u l=1u
X709 a_3204_15247# a_2916_15552# a_3142_15247# VSS.t205 sg13_lv_nmos ad=0.1428p pd=1.52u as=37.8f ps=0.6u w=0.42u l=0.13u
X710 VSS.t1047 VDD VSS.t1046 VSS.t1045 sg13_lv_nmos ad=0.1428p pd=1.52u as=0 ps=0 w=0.42u l=1u
X711 VDD VSS.t2001 VDD VDD sg13_lv_pmos ad=0.19p pd=1.38u as=0 ps=0 w=1u l=1u
X712 VSS.t1311 VDD VSS.t1310 VSS.t248 sg13_lv_nmos ad=0.1428p pd=1.52u as=0 ps=0 w=0.42u l=1u
X713 a_10960_15454# sg13cmos5l_tiehi_1.L_HI VDD VDD sg13_lv_pmos ad=79.8f pd=0.8u as=2.8961p ps=18.25u w=0.42u l=0.13u
X714 VSS.t1884 VDD VSS.t1886 VSS.t1885 sg13_lv_nmos ad=79.8f pd=0.8u as=0 ps=0 w=0.42u l=1u
X715 VSS.t2969 VDD VSS.t2971 VSS.t2970 sg13_lv_nmos ad=79.8f pd=0.8u as=0 ps=0 w=0.42u l=1u
X716 VDD VSS.t366 VDD VDD sg13_lv_pmos ad=0.34p pd=2.68u as=0 ps=0 w=1u l=1u
X717 sg13cmos5l_nand4_1_0.Y sg13cmos5l_dlygate4sd3_1_8.X a_7262_15242# VSS.t244 sg13_lv_nmos ad=0.2516p pd=2.16u as=0.1406p ps=1.12u w=0.74u l=0.13u
X718 VSS.t1677 VDD VSS.t1676 VSS.t1675 sg13_lv_nmos ad=0.1428p pd=1.52u as=0 ps=0 w=0.42u l=1u
X719 VDD VSS.t2368 VDD VDD sg13_lv_pmos ad=0.19p pd=1.38u as=0 ps=0 w=1u l=1u
X720 VDD VSS.t652 VDD VDD sg13_lv_pmos ad=0.19p pd=1.38u as=0 ps=0 w=1u l=1u
X721 VDD VSS.t859 VDD VDD sg13_lv_pmos ad=0.19p pd=1.38u as=0 ps=0 w=1u l=1u
X722 VSS.t1017 VDD VSS.t1016 VSS.t1015 sg13_lv_nmos ad=0.1428p pd=1.52u as=0 ps=0 w=0.42u l=1u
X723 VSS.t1347 VDD VSS.t1347 VSS.t248 sg13_lv_nmos ad=79.8f pd=0.8u as=0 ps=0 w=0.42u l=1u
X724 VDD VSS.t1312 VDD VDD sg13_lv_pmos ad=0.34p pd=2.68u as=0 ps=0 w=1u l=1u
X725 VDD VSS.t2285 VDD VDD sg13_lv_pmos ad=0.34p pd=2.68u as=0 ps=0 w=1u l=1u
X726 VSS.t2154 VDD VSS.t2153 VSS.t2152 sg13_lv_nmos ad=0.1428p pd=1.52u as=0 ps=0 w=0.42u l=1u
X727 VSS.t1974 VDD VSS.t1976 VSS.t1975 sg13_lv_nmos ad=79.8f pd=0.8u as=0 ps=0 w=0.42u l=1u
X728 VDD VSS.t29 VDD VDD sg13_lv_pmos ad=0.19p pd=1.38u as=0 ps=0 w=1u l=1u
X729 VDD VSS.t2151 VDD VDD sg13_lv_pmos ad=0.19p pd=1.38u as=0 ps=0 w=1u l=1u
X730 VDD VSS.t2684 VDD VDD sg13_lv_pmos ad=0.19p pd=1.38u as=0 ps=0 w=1u l=1u
X731 VDD VSS.t489 VDD VDD sg13_lv_pmos ad=0.34p pd=2.68u as=0 ps=0 w=1u l=1u
X732 VSS.t3094 VDD VSS.t3093 VSS.t3092 sg13_lv_nmos ad=0.1428p pd=1.52u as=0 ps=0 w=0.42u l=1u
X733 VSS.t2306 VDD VSS.t2305 VSS.t2304 sg13_lv_nmos ad=0.1428p pd=1.52u as=0 ps=0 w=0.42u l=1u
X734 VDD VSS.t1216 VDD VDD sg13_lv_pmos ad=0.19p pd=1.38u as=0 ps=0 w=1u l=1u
X735 VDD VSS.t1066 VDD VDD sg13_lv_pmos ad=0.34p pd=2.68u as=0 ps=0 w=1u l=1u
X736 VDD VSS.t1636 VDD VDD sg13_lv_pmos ad=0.34p pd=2.68u as=0 ps=0 w=1u l=1u
X737 VDD VSS.t2793 VDD VDD sg13_lv_pmos ad=0.19p pd=1.38u as=0 ps=0 w=1u l=1u
X738 VSS.t2104 VDD VSS.t2103 VSS.t2102 sg13_lv_nmos ad=0.1428p pd=1.52u as=0 ps=0 w=0.42u l=1u
X739 VSS.t318 VDD VSS.t318 VSS.t320 sg13_lv_nmos ad=0.1428p pd=1.52u as=0 ps=0 w=0.42u l=1u
X740 VSS.t3009 VDD VSS.t3011 VSS.t3010 sg13_lv_nmos ad=79.8f pd=0.8u as=0 ps=0 w=0.42u l=1u
X741 VDD VSS.t2340 VDD VDD sg13_lv_pmos ad=0.34p pd=2.68u as=0 ps=0 w=1u l=1u
X742 VSS.t2381 VDD VSS.t2380 VSS.t2379 sg13_lv_nmos ad=0.1428p pd=1.52u as=0 ps=0 w=0.42u l=1u
X743 VSS.t2735 VDD VSS.t2736 VSS.t199 sg13_lv_nmos ad=79.8f pd=0.8u as=0 ps=0 w=0.42u l=1u
X744 VDD VSS.t450 VDD VDD sg13_lv_pmos ad=0.34p pd=2.68u as=0 ps=0 w=1u l=1u
X745 VDD VSS.t670 VDD VDD sg13_lv_pmos ad=0.34p pd=2.68u as=0 ps=0 w=1u l=1u
X746 VSS.t1707 VDD VSS.t1709 VSS.t1708 sg13_lv_nmos ad=79.8f pd=0.8u as=0 ps=0 w=0.42u l=1u
X747 VSS.t2803 VDD VSS.t2804 VSS.t199 sg13_lv_nmos ad=79.8f pd=0.8u as=0 ps=0 w=0.42u l=1u
X748 VSS.t1949 VDD VSS.t1948 VSS.t1947 sg13_lv_nmos ad=0.1428p pd=1.52u as=0 ps=0 w=0.42u l=1u
X749 VDD VSS.t826 VDD VDD sg13_lv_pmos ad=0.34p pd=2.68u as=0 ps=0 w=1u l=1u
X750 VDD VSS.t3076 VDD VDD sg13_lv_pmos ad=0.19p pd=1.38u as=0 ps=0 w=1u l=1u
X751 VDD VSS.t1946 VDD VDD sg13_lv_pmos ad=0.19p pd=1.38u as=0 ps=0 w=1u l=1u
X752 VSS.t19 a_3333_15213# a_3435_15356# VSS.t242 sg13_lv_nmos ad=4.11262p pd=27.15u as=0.2516p ps=2.16u w=0.74u l=0.13u
X753 VSS.t143 a_14261_15238# sg13cmos5l_or3_1_1.B VSS.t144 sg13_lv_nmos ad=0.1406p pd=1.12u as=0.1406p ps=1.12u w=0.74u l=0.13u
X754 VDD VSS.t102 VDD VDD sg13_lv_pmos ad=0.34p pd=2.68u as=0 ps=0 w=1u l=1u
X755 VSS.t1662 VDD VSS.t1661 VSS.t1660 sg13_lv_nmos ad=0.1428p pd=1.52u as=0 ps=0 w=0.42u l=1u
X756 VSS.t1329 VDD VSS.t1328 VSS.t248 sg13_lv_nmos ad=0.1428p pd=1.52u as=0 ps=0 w=0.42u l=1u
X757 VSS.t1361 VDD VSS.t1362 VSS.t248 sg13_lv_nmos ad=79.8f pd=0.8u as=0 ps=0 w=0.42u l=1u
X758 VDD VSS.t1303 VDD VDD sg13_lv_pmos ad=0.34p pd=2.68u as=0 ps=0 w=1u l=1u
X759 VDD VSS.t2804 VDD VDD sg13_lv_pmos ad=0.34p pd=2.68u as=0 ps=0 w=1u l=1u
X760 VDD VSS.t2108 VDD VDD sg13_lv_pmos ad=0.34p pd=2.68u as=0 ps=0 w=1u l=1u
X761 VSS.t440 VDD VSS.t440 VSS.t510 sg13_lv_nmos ad=0.1428p pd=1.52u as=0 ps=0 w=0.42u l=1u
X762 VSS.t1637 VDD VSS.t1639 VSS.t1638 sg13_lv_nmos ad=79.8f pd=0.8u as=0 ps=0 w=0.42u l=1u
X763 VDD VSS.t2313 VDD VDD sg13_lv_pmos ad=0.19p pd=1.38u as=0 ps=0 w=1u l=1u
X764 a_2890_15457# a_3333_15213# a_3273_15625# VDD sg13_lv_pmos ad=79.8f pd=0.8u as=63f ps=0.72u w=0.42u l=0.13u
X765 VSS.t143 VDD VSS.t90 VSS.t514 sg13_lv_nmos ad=0.1428p pd=1.52u as=0 ps=0 w=0.42u l=1u
X766 VDD VSS.t676 VDD VDD sg13_lv_pmos ad=0.19p pd=1.38u as=0 ps=0 w=1u l=1u
X767 VDD VSS.t879 VDD VDD sg13_lv_pmos ad=0.19p pd=1.38u as=0 ps=0 w=1u l=1u
X768 VSS.t1281 VDD VSS.t1282 VSS.t248 sg13_lv_nmos ad=79.8f pd=0.8u as=0 ps=0 w=0.42u l=1u
X769 VDD VSS.t1306 VDD VDD sg13_lv_pmos ad=0.19p pd=1.38u as=0 ps=0 w=1u l=1u
X770 VSS.t1502 VDD VSS.t1504 VSS.t1503 sg13_lv_nmos ad=79.8f pd=0.8u as=0 ps=0 w=0.42u l=1u
X771 VSS.t1919 VDD VSS.t1921 VSS.t1920 sg13_lv_nmos ad=79.8f pd=0.8u as=0 ps=0 w=0.42u l=1u
X772 VSS.t1047 VDD VSS.t1046 VSS.t1045 sg13_lv_nmos ad=0.1428p pd=1.52u as=0 ps=0 w=0.42u l=1u
X773 VDD VSS.t1601 VDD VDD sg13_lv_pmos ad=0.34p pd=2.68u as=0 ps=0 w=1u l=1u
X774 VDD VSS.t1656 VDD VDD sg13_lv_pmos ad=0.34p pd=2.68u as=0 ps=0 w=1u l=1u
X775 VSS.t1209 VDD VSS.t1210 VSS.t248 sg13_lv_nmos ad=79.8f pd=0.8u as=0 ps=0 w=0.42u l=1u
X776 VDD VSS.t1938 VDD VDD sg13_lv_pmos ad=0.34p pd=2.68u as=0 ps=0 w=1u l=1u
X777 VDD VSS.t2767 VDD VDD sg13_lv_pmos ad=0.34p pd=2.68u as=0 ps=0 w=1u l=1u
X778 VSS.t357 VDD VSS.t356 VSS.t355 sg13_lv_nmos ad=0.1428p pd=1.52u as=0 ps=0 w=0.42u l=1u
X779 VDD VSS.t334 VDD VDD sg13_lv_pmos ad=0.19p pd=1.38u as=0 ps=0 w=1u l=1u
X780 VSS.t1473 VDD VSS.t1341 VSS.t248 sg13_lv_nmos ad=0.1428p pd=1.52u as=0 ps=0 w=0.42u l=1u
X781 VSS.t2956 VDD VSS.t2954 VSS.t2955 sg13_lv_nmos ad=79.8f pd=0.8u as=0 ps=0 w=0.42u l=1u
X782 VSS.t679 VDD VSS.t679 VSS.t806 sg13_lv_nmos ad=0.1428p pd=1.52u as=0 ps=0 w=0.42u l=1u
X783 VDD VSS.t1951 VDD VDD sg13_lv_pmos ad=0.19p pd=1.38u as=0 ps=0 w=1u l=1u
X784 VSS.t2777 VDD VSS.t2777 VSS.t199 sg13_lv_nmos ad=0.1428p pd=1.52u as=0 ps=0 w=0.42u l=1u
X785 VDD VSS.t2530 VDD VDD sg13_lv_pmos ad=0.34p pd=2.68u as=0 ps=0 w=1u l=1u
X786 VDD VSS.t623 VDD VDD sg13_lv_pmos ad=0.34p pd=2.68u as=0 ps=0 w=1u l=1u
X787 VDD VSS.t2720 VDD VDD sg13_lv_pmos ad=0.19p pd=1.38u as=0 ps=0 w=1u l=1u
X788 VSS.t2366 VDD VSS.t2365 VSS.t2364 sg13_lv_nmos ad=0.1428p pd=1.52u as=0 ps=0 w=0.42u l=1u
X789 VSS.t736 VDD VSS.t9 VSS.t737 sg13_lv_nmos ad=79.8f pd=0.8u as=0 ps=0 w=0.42u l=1u
X790 VDD VSS.t831 VDD VDD sg13_lv_pmos ad=0.34p pd=2.68u as=0 ps=0 w=1u l=1u
X791 VSS.t1263 VDD VSS.t1262 VSS.t248 sg13_lv_nmos ad=0.1428p pd=1.52u as=0 ps=0 w=0.42u l=1u
X792 VSS.t2139 VDD VSS.t2138 VSS.t2137 sg13_lv_nmos ad=0.1428p pd=1.52u as=0 ps=0 w=0.42u l=1u
X793 a_3333_16033# a_3333_16033# VSS.t21 VSS.t250 sg13_lv_nmos ad=0.111p pd=1.34u as=7.70437p ps=50.66u w=0.3u l=0.13u
X794 VSS.t339 VDD VSS.t339 VSS.t341 sg13_lv_nmos ad=0.1428p pd=1.52u as=0 ps=0 w=0.42u l=1u
X795 VSS.t19 a_6789_14495# a_6891_14495# VSS.t79 sg13_lv_nmos ad=4.11262p pd=27.15u as=0.2516p ps=2.16u w=0.74u l=0.13u
X796 VSS.t598 VDD VSS.t600 VSS.t599 sg13_lv_nmos ad=79.8f pd=0.8u as=0 ps=0 w=0.42u l=1u
X797 VDD VSS.t655 VDD VDD sg13_lv_pmos ad=0.34p pd=2.68u as=0 ps=0 w=1u l=1u
X798 VSS.t6 a_10222_14751# sg13cmos5l_dlygate4sd3_1_8.X VSS.t239 sg13_lv_nmos ad=0.1426p pd=1.16u as=0.2516p ps=2.16u w=0.74u l=0.13u
X799 VDD VSS.t1634 VDD VDD sg13_lv_pmos ad=0.19p pd=1.38u as=0 ps=0 w=1u l=1u
X800 VDD a_21070_15423# sg13cmos5l_dlygate4sd3_1_9.X VDD sg13_lv_pmos ad=0.2254p pd=1.53u as=0.4256p ps=3u w=1.12u l=0.13u
X801 VDD VSS.t996 VDD VDD sg13_lv_pmos ad=0.34p pd=2.68u as=0 ps=0 w=1u l=1u
X802 VSS.t1522 VDD VSS.t1524 VSS.t1523 sg13_lv_nmos ad=79.8f pd=0.8u as=0 ps=0 w=0.42u l=1u
X803 VSS.t2431 VDD VSS.t2433 VSS.t2432 sg13_lv_nmos ad=79.8f pd=0.8u as=0 ps=0 w=0.42u l=1u
X804 VDD VSS.t45 VDD VDD sg13_lv_pmos ad=0.34p pd=2.68u as=0 ps=0 w=1u l=1u
X805 VSS.t867 VDD VSS.t866 VSS.t865 sg13_lv_nmos ad=0.1428p pd=1.52u as=0 ps=0 w=0.42u l=1u
X806 VDD VSS.t1223 VDD VDD sg13_lv_pmos ad=0.19p pd=1.38u as=0 ps=0 w=1u l=1u
X807 VDD VSS.t2006 VDD VDD sg13_lv_pmos ad=0.19p pd=1.38u as=0 ps=0 w=1u l=1u
X808 VSS.t1222 VDD VSS.t1223 VSS.t248 sg13_lv_nmos ad=79.8f pd=0.8u as=0 ps=0 w=0.42u l=1u
X809 VSS.t1652 VDD VSS.t1651 VSS.t1650 sg13_lv_nmos ad=0.1428p pd=1.52u as=0 ps=0 w=0.42u l=1u
X810 VSS.t3174 VDD VSS.t3173 VSS.t3172 sg13_lv_nmos ad=0.1428p pd=1.52u as=0 ps=0 w=0.42u l=1u
X811 VDD VSS.t2325 VDD VDD sg13_lv_pmos ad=0.34p pd=2.68u as=0 ps=0 w=1u l=1u
X812 VSS.t2728 VDD VSS.t2729 VSS.t199 sg13_lv_nmos ad=79.8f pd=0.8u as=0 ps=0 w=0.42u l=1u
X813 VSS.t623 a_19323_13726# sg13cmos5l_buf_8_2.X VSS.t3237 sg13_lv_nmos ad=0.2516p pd=2.16u as=0.1406p ps=1.12u w=0.74u l=0.13u
X814 a_9418_15457# a_9861_15213# a_9158_15234# VSS.t2 sg13_lv_nmos ad=79.8f pd=0.8u as=0.1296p ps=1.52u w=0.42u l=0.13u
X815 VSS.t1934 VDD VSS.t1933 VSS.t1932 sg13_lv_nmos ad=0.1428p pd=1.52u as=0 ps=0 w=0.42u l=1u
X816 VSS.t652 VDD VSS.t652 VSS.t653 sg13_lv_nmos ad=79.8f pd=0.8u as=0 ps=0 w=0.42u l=1u
X817 VDD VSS.t1059 VDD VDD sg13_lv_pmos ad=0.19p pd=1.38u as=0 ps=0 w=1u l=1u
X818 VSS.t1647 VDD VSS.t1646 VSS.t1645 sg13_lv_nmos ad=0.1428p pd=1.52u as=0 ps=0 w=0.42u l=1u
X819 VDD VSS.t399 VDD VDD sg13_lv_pmos ad=0.19p pd=1.38u as=0 ps=0 w=1u l=1u
X820 VSS.t603 VDD VSS.t602 VSS.t601 sg13_lv_nmos ad=0.1428p pd=1.52u as=0 ps=0 w=0.42u l=1u
X821 VDD VSS.t986 VDD VDD sg13_lv_pmos ad=0.34p pd=2.68u as=0 ps=0 w=1u l=1u
X822 VSS.t1277 VDD VSS.t1276 VSS.t248 sg13_lv_nmos ad=0.1428p pd=1.52u as=0 ps=0 w=0.42u l=1u
X823 VSS.t1562 VDD VSS.t1564 VSS.t1563 sg13_lv_nmos ad=79.8f pd=0.8u as=0 ps=0 w=0.42u l=1u
X824 VDD VSS.t3078 VDD VDD sg13_lv_pmos ad=0.34p pd=2.68u as=0 ps=0 w=1u l=1u
X825 VDD VSS.t2290 VDD VDD sg13_lv_pmos ad=0.34p pd=2.68u as=0 ps=0 w=1u l=1u
X826 VDD a_3333_15213# a_3435_15356# VDD sg13_lv_pmos ad=2.8961p pd=18.25u as=0.3864p ps=2.93u w=1.12u l=0.13u
X827 VDD sg13cmos5l_dfrbpq_1_2.RESET_B a_16042_13945# VDD sg13_lv_pmos ad=0.1563p pd=1.22u as=0.147p ps=1.54u w=0.42u l=0.13u
X828 VSS.t2726 VDD VSS.t2727 VSS.t199 sg13_lv_nmos ad=79.8f pd=0.8u as=0 ps=0 w=0.42u l=1u
X829 VDD VSS.t2463 VDD VDD sg13_lv_pmos ad=0.19p pd=1.38u as=0 ps=0 w=1u l=1u
X830 VDD VSS.t2691 VDD VDD sg13_lv_pmos ad=0.19p pd=1.38u as=0 ps=0 w=1u l=1u
X831 VDD VSS.t86 VDD VDD sg13_lv_pmos ad=0.19p pd=1.38u as=0 ps=0 w=1u l=1u
X832 VDD VSS.t1998 VDD VDD sg13_lv_pmos ad=0.34p pd=2.68u as=0 ps=0 w=1u l=1u
X833 VSS.t752 VDD VSS.t625 VSS.t753 sg13_lv_nmos ad=79.8f pd=0.8u as=0 ps=0 w=0.42u l=1u
X834 VSS.t1022 VDD VSS.t1021 VSS.t1020 sg13_lv_nmos ad=0.1428p pd=1.52u as=0 ps=0 w=0.42u l=1u
X835 VDD VSS.t1586 VDD VDD sg13_lv_pmos ad=0.34p pd=2.68u as=0 ps=0 w=1u l=1u
X836 VSS.t1205 VDD VSS.t1204 VSS.t248 sg13_lv_nmos ad=0.1428p pd=1.52u as=0 ps=0 w=0.42u l=1u
X837 VSS.t1313 VDD VSS.t1314 VSS.t248 sg13_lv_nmos ad=79.8f pd=0.8u as=0 ps=0 w=0.42u l=1u
X838 VDD VSS.t1641 VDD VDD sg13_lv_pmos ad=0.34p pd=2.68u as=0 ps=0 w=1u l=1u
X839 VSS.t475 VDD VSS.t474 VSS.t19 sg13_lv_nmos ad=0.1428p pd=1.52u as=0 ps=0 w=0.42u l=1u
X840 VSS.t3014 VDD VSS.t3016 VSS.t3015 sg13_lv_nmos ad=79.8f pd=0.8u as=0 ps=0 w=0.42u l=1u
X841 VSS.t2386 VDD VSS.t2385 VSS.t2384 sg13_lv_nmos ad=0.1428p pd=1.52u as=0 ps=0 w=0.42u l=1u
X842 VSS.t957 VDD VSS.t959 VSS.t958 sg13_lv_nmos ad=79.8f pd=0.8u as=0 ps=0 w=0.42u l=1u
X843 VSS.t2738 VDD VSS.t2739 VSS.t199 sg13_lv_nmos ad=79.8f pd=0.8u as=0 ps=0 w=0.42u l=1u
X844 a_21460_14020# sg13cmos5l_or3_1_2.A VDD VDD sg13_lv_pmos ad=0.1575p pd=1.315u as=0.3822p ps=1.84u w=1u l=0.13u
X845 VDD VSS.t1026 VDD VDD sg13_lv_pmos ad=0.34p pd=2.68u as=0 ps=0 w=1u l=1u
X846 VDD VSS.t2703 VDD VDD sg13_lv_pmos ad=0.34p pd=2.68u as=0 ps=0 w=1u l=1u
X847 VSS.t747 a_19323_13726# sg13cmos5l_buf_8_2.X VSS.t3233 sg13_lv_nmos ad=0.1406p pd=1.12u as=0.1406p ps=1.12u w=0.74u l=0.13u
X848 VSS.t2806 VDD VSS.t2807 VSS.t199 sg13_lv_nmos ad=79.8f pd=0.8u as=0 ps=0 w=0.42u l=1u
X849 VSS.t210 VDD VSS.t210 VSS.t702 sg13_lv_nmos ad=79.8f pd=0.8u as=0 ps=0 w=0.42u l=1u
X850 VDD VSS.t1257 VDD VDD sg13_lv_pmos ad=0.19p pd=1.38u as=0 ps=0 w=1u l=1u
X851 VDD a_12524_15960# counter_value_o[2] VDD sg13_lv_pmos ad=0.2114p pd=1.54u as=0.42p ps=2.99u w=1.12u l=0.13u
X852 VSS.t555 VDD VSS.t555 VSS.t557 sg13_lv_nmos ad=79.8f pd=0.8u as=0 ps=0 w=0.42u l=1u
X853 VSS.t633 VDD VSS.t635 VSS.t759 sg13_lv_nmos ad=79.8f pd=0.8u as=0 ps=0 w=0.42u l=1u
X854 VDD VSS.t949 VDD VDD sg13_lv_pmos ad=0.19p pd=1.38u as=0 ps=0 w=1u l=1u
X855 VDD VSS.t1306 VDD VDD sg13_lv_pmos ad=0.34p pd=2.68u as=0 ps=0 w=1u l=1u
X856 VDD VSS.t2711 VDD VDD sg13_lv_pmos ad=0.19p pd=1.38u as=0 ps=0 w=1u l=1u
X857 VDD VSS.t2807 VDD VDD sg13_lv_pmos ad=0.34p pd=2.68u as=0 ps=0 w=1u l=1u
X858 VSS.t2351 VDD VSS.t2350 VSS.t2349 sg13_lv_nmos ad=0.1428p pd=1.52u as=0 ps=0 w=0.42u l=1u
X859 VDD VSS.t2113 VDD VDD sg13_lv_pmos ad=0.34p pd=2.68u as=0 ps=0 w=1u l=1u
X860 VSS.t1290 VDD VSS.t1289 VSS.t248 sg13_lv_nmos ad=0.1428p pd=1.52u as=0 ps=0 w=0.42u l=1u
X861 VSS.t1964 VDD VSS.t1966 VSS.t1965 sg13_lv_nmos ad=79.8f pd=0.8u as=0 ps=0 w=0.42u l=1u
X862 VSS.t318 VDD VSS.t318 VSS.t319 sg13_lv_nmos ad=79.8f pd=0.8u as=0 ps=0 w=0.42u l=1u
X863 sg13cmos5l_o21ai_1_2.A2 sg13cmos5l_dfrbpq_1_2.Q VDD VDD sg13_lv_pmos ad=0.2128p pd=1.5u as=0.3808p ps=2.92u w=1.12u l=0.13u
X864 VDD VSS.t2682 VDD VDD sg13_lv_pmos ad=0.19p pd=1.38u as=0 ps=0 w=1u l=1u
X865 VSS.t1904 VDD VSS.t1903 VSS.t1902 sg13_lv_nmos ad=0.1428p pd=1.52u as=0 ps=0 w=0.42u l=1u
X866 VSS.t41 a_4474_14448# a_4193_14750# VSS.t40 sg13_lv_nmos ad=79.8f pd=0.8u as=0.1428p ps=1.52u w=0.42u l=0.5u
X867 a_24263_14508# sg13cmos5l_o21ai_1_2.A2 a_24169_14508# VDD sg13_lv_pmos ad=0.19p pd=1.38u as=0.34p ps=2.68u w=1u l=0.13u
X868 a_21060_14488# a_21034_14452# VDD VDD sg13_lv_pmos ad=0.34p pd=2.68u as=0.36237p ps=2.605u w=1u l=0.13u
X869 VSS.t1507 VDD VSS.t1509 VSS.t1508 sg13_lv_nmos ad=79.8f pd=0.8u as=0 ps=0 w=0.42u l=1u
X870 VSS.t867 VDD VSS.t866 VSS.t865 sg13_lv_nmos ad=0.1428p pd=1.52u as=0 ps=0 w=0.42u l=1u
X871 VSS.t1295 VDD VSS.t1294 VSS.t248 sg13_lv_nmos ad=0.1428p pd=1.52u as=0 ps=0 w=0.42u l=1u
X872 VSS.t2693 VDD VSS.t2694 VSS.t199 sg13_lv_nmos ad=79.8f pd=0.8u as=0 ps=0 w=0.42u l=1u
X873 VSS.t2416 VDD VSS.t2418 VSS.t2417 sg13_lv_nmos ad=79.8f pd=0.8u as=0 ps=0 w=0.42u l=1u
X874 VDD VSS.t824 VDD VDD sg13_lv_pmos ad=0.19p pd=1.38u as=0 ps=0 w=1u l=1u
X875 VDD VSS.t1266 VDD VDD sg13_lv_pmos ad=0.19p pd=1.38u as=0 ps=0 w=1u l=1u
X876 VDD VSS.t2941 VDD VDD sg13_lv_pmos ad=0.19p pd=1.38u as=0 ps=0 w=1u l=1u
X877 VDD VSS.t1991 VDD VDD sg13_lv_pmos ad=0.19p pd=1.38u as=0 ps=0 w=1u l=1u
X878 VSS.t90 sg13cmos5l_or3_1_2.B a_16175_15238# VSS.t3239 sg13_lv_nmos ad=0.1898p pd=1.36u as=0.1406p ps=1.12u w=0.74u l=0.13u
X879 VSS.t620 VDD VSS.t620 VSS.t621 sg13_lv_nmos ad=79.8f pd=0.8u as=0 ps=0 w=0.42u l=1u
X880 VDD VSS.t1943 VDD VDD sg13_lv_pmos ad=0.34p pd=2.68u as=0 ps=0 w=1u l=1u
X881 VDD VSS.t2769 VDD VDD sg13_lv_pmos ad=0.34p pd=2.68u as=0 ps=0 w=1u l=1u
X882 VSS.t2816 VDD VSS.t2815 VSS.t199 sg13_lv_nmos ad=0.1428p pd=1.52u as=0 ps=0 w=0.42u l=1u
X883 VDD VSS.t2694 VDD VDD sg13_lv_pmos ad=0.34p pd=2.68u as=0 ps=0 w=1u l=1u
X884 VSS.t300 VDD VSS.t305 VSS.t509 sg13_lv_nmos ad=79.8f pd=0.8u as=0 ps=0 w=0.42u l=1u
X885 sg13cmos5l_buf_1_10.X a_1192_9948# VSS.t249 VSS.t248 sg13_lv_nmos ad=0.2886p pd=2.26u as=0.14875p ps=1.16u w=0.74u l=0.13u
X886 VDD VSS.t1230 VDD VDD sg13_lv_pmos ad=0.34p pd=2.68u as=0 ps=0 w=1u l=1u
X887 VSS.t2959 VDD VSS.t2961 VSS.t2960 sg13_lv_nmos ad=79.8f pd=0.8u as=0 ps=0 w=0.42u l=1u
X888 sg13cmos5l_dfrbpq_1_5.Q a_28074_14020# VSS.t102 VSS.t101 sg13_lv_nmos ad=0.2516p pd=2.16u as=0.1406p ps=1.12u w=0.74u l=0.13u
X889 VDD VSS.t916 VDD VDD sg13_lv_pmos ad=0.34p pd=2.68u as=0 ps=0 w=1u l=1u
X890 VSS.t1392 VDD VSS.t1235 VSS.t248 sg13_lv_nmos ad=0.1428p pd=1.52u as=0 ps=0 w=0.42u l=1u
X891 VDD VSS.t2500 VDD VDD sg13_lv_pmos ad=0.34p pd=2.68u as=0 ps=0 w=1u l=1u
X892 sg13cmos5l_or3_1_2.B a_16168_15996# VDD VDD sg13_lv_pmos ad=0.42p pd=2.99u as=0.2114p ps=1.54u w=1.12u l=0.13u
X893 VDD VSS.t1031 VDD VDD sg13_lv_pmos ad=0.34p pd=2.68u as=0 ps=0 w=1u l=1u
X894 VDD VSS.t2723 VDD VDD sg13_lv_pmos ad=0.19p pd=1.38u as=0 ps=0 w=1u l=1u
X895 VSS.t2745 VDD VSS.t2745 VSS.t199 sg13_lv_nmos ad=0.1428p pd=1.52u as=0 ps=0 w=0.42u l=1u
X896 VSS.t2371 VDD VSS.t2370 VSS.t2369 sg13_lv_nmos ad=0.1428p pd=1.52u as=0 ps=0 w=0.42u l=1u
X897 VDD VSS.t2275 VDD VDD sg13_lv_pmos ad=0.34p pd=2.68u as=0 ps=0 w=1u l=1u
X898 VSS.t1727 VDD VSS.t1726 VSS.t1725 sg13_lv_nmos ad=0.1428p pd=1.52u as=0 ps=0 w=0.42u l=1u
X899 VSS.t2109 VDD VSS.t2108 VSS.t2107 sg13_lv_nmos ad=0.1428p pd=1.52u as=0 ps=0 w=0.42u l=1u
X900 VDD a_7680_15549# sg13cmos5l_xnor2_1_0.Y VDD sg13_lv_pmos ad=0.3808p pd=2.92u as=0.2408p ps=1.55u w=1.12u l=0.13u
X901 VDD VSS.t1629 VDD VDD sg13_lv_pmos ad=0.19p pd=1.38u as=0 ps=0 w=1u l=1u
X902 VSS.t2814 VDD VSS.t2813 VSS.t199 sg13_lv_nmos ad=0.1428p pd=1.52u as=0 ps=0 w=0.42u l=1u
X903 VSS.t2717 VDD VSS.t2718 VSS.t199 sg13_lv_nmos ad=79.8f pd=0.8u as=0 ps=0 w=0.42u l=1u
X904 VDD VSS.t1639 VDD VDD sg13_lv_pmos ad=0.19p pd=1.38u as=0 ps=0 w=1u l=1u
X905 VSS.t21 a_3209_16334# a_3130_16237# VSS.t20 sg13_lv_nmos ad=7.70437p pd=50.66u as=0.27427p ps=2.28u w=0.795u l=0.13u
X906 VSS.t1022 VDD VSS.t1021 VSS.t1020 sg13_lv_nmos ad=0.1428p pd=1.52u as=0 ps=0 w=0.42u l=1u
X907 VSS.t1067 VDD VSS.t1066 VSS.t1065 sg13_lv_nmos ad=0.1428p pd=1.52u as=0 ps=0 w=0.42u l=1u
X908 VSS.t957 VDD VSS.t959 VSS.t958 sg13_lv_nmos ad=79.8f pd=0.8u as=0 ps=0 w=0.42u l=1u
X909 VDD VSS.t1248 VDD VDD sg13_lv_pmos ad=0.34p pd=2.68u as=0 ps=0 w=1u l=1u
X910 VSS.t1470 VDD VSS.t1341 VSS.t248 sg13_lv_nmos ad=79.8f pd=0.8u as=0 ps=0 w=0.42u l=1u
X911 VDD VSS.t1226 VDD VDD sg13_lv_pmos ad=0.19p pd=1.38u as=0 ps=0 w=1u l=1u
X912 VDD VSS.t2787 VDD VDD sg13_lv_pmos ad=0.19p pd=1.38u as=0 ps=0 w=1u l=1u
X913 VDD VSS.t2011 VDD VDD sg13_lv_pmos ad=0.19p pd=1.38u as=0 ps=0 w=1u l=1u
X914 VSS.t1657 VDD VSS.t1656 VSS.t1655 sg13_lv_nmos ad=0.1428p pd=1.52u as=0 ps=0 w=0.42u l=1u
X915 VSS.t3179 VDD VSS.t3178 VSS.t3177 sg13_lv_nmos ad=0.1428p pd=1.52u as=0 ps=0 w=0.42u l=1u
X916 VDD VSS.t2330 VDD VDD sg13_lv_pmos ad=0.34p pd=2.68u as=0 ps=0 w=1u l=1u
X917 a_27215_14845# a_26373_14495# a_27121_14845# VSS.t19 sg13_lv_nmos ad=0.12665p pd=1.145u as=0.1428p ps=1.52u w=0.42u l=0.13u
X918 VSS.t2730 VDD VSS.t2731 VSS.t199 sg13_lv_nmos ad=79.8f pd=0.8u as=0 ps=0 w=0.42u l=1u
X919 VDD VSS.t1071 VDD VDD sg13_lv_pmos ad=0.34p pd=2.68u as=0 ps=0 w=1u l=1u
X920 VSS.t1939 VDD VSS.t1938 VSS.t1937 sg13_lv_nmos ad=0.1428p pd=1.52u as=0 ps=0 w=0.42u l=1u
X921 VDD VSS.t655 VDD VDD sg13_lv_pmos ad=0.19p pd=1.38u as=0 ps=0 w=1u l=1u
X922 VSS.t2944 VDD VSS.t2946 VSS.t2945 sg13_lv_nmos ad=79.8f pd=0.8u as=0 ps=0 w=0.42u l=1u
X923 VSS.t2798 VDD VSS.t2799 VSS.t199 sg13_lv_nmos ad=79.8f pd=0.8u as=0 ps=0 w=0.42u l=1u
X924 VDD VSS.t1285 VDD VDD sg13_lv_pmos ad=0.19p pd=1.38u as=0 ps=0 w=1u l=1u
X925 VSS.t1359 VDD VSS.t1360 VSS.t248 sg13_lv_nmos ad=79.8f pd=0.8u as=0 ps=0 w=0.42u l=1u
X926 VDD VSS.t2343 VDD VDD sg13_lv_pmos ad=0.19p pd=1.38u as=0 ps=0 w=1u l=1u
X927 VSS.t381 VDD VSS.t380 VSS.t379 sg13_lv_nmos ad=0.1428p pd=1.52u as=0 ps=0 w=0.42u l=1u
X928 VDD VSS.t994 VDD VDD sg13_lv_pmos ad=0.19p pd=1.38u as=0 ps=0 w=1u l=1u
X929 VDD sg13cmos5l_dfrbpq_1_2.Q a_16552_15996# VDD sg13_lv_pmos ad=0.2114p pd=1.54u as=0.2856p ps=2.36u w=0.84u l=0.13u
X930 VDD VSS.t1297 VDD VDD sg13_lv_pmos ad=0.34p pd=2.68u as=0 ps=0 w=1u l=1u
X931 VSS.t1567 VDD VSS.t1569 VSS.t1568 sg13_lv_nmos ad=79.8f pd=0.8u as=0 ps=0 w=0.42u l=1u
X932 VDD VSS.t2799 VDD VDD sg13_lv_pmos ad=0.34p pd=2.68u as=0 ps=0 w=1u l=1u
X933 VSS.t2729 VDD VSS.t2730 VSS.t199 sg13_lv_nmos ad=79.8f pd=0.8u as=0 ps=0 w=0.42u l=1u
X934 VDD VSS.t2468 VDD VDD sg13_lv_pmos ad=0.19p pd=1.38u as=0 ps=0 w=1u l=1u
X935 VSS.t2129 VDD VSS.t2128 VSS.t2127 sg13_lv_nmos ad=0.1428p pd=1.52u as=0 ps=0 w=0.42u l=1u
X936 VSS.t1949 VDD VSS.t1951 VSS.t1950 sg13_lv_nmos ad=79.8f pd=0.8u as=0 ps=0 w=0.42u l=1u
X937 VSS.t877 VDD VSS.t879 VSS.t878 sg13_lv_nmos ad=79.8f pd=0.8u as=0 ps=0 w=0.42u l=1u
X938 VDD VSS.t2673 VDD VDD sg13_lv_pmos ad=0.19p pd=1.38u as=0 ps=0 w=1u l=1u
X939 VSS.t1889 VDD VSS.t1888 VSS.t1887 sg13_lv_nmos ad=0.1428p pd=1.52u as=0 ps=0 w=0.42u l=1u
X940 a_21417_14531# a_21060_14488# VDD VDD sg13_lv_pmos ad=63f pd=0.72u as=0.1563p ps=1.22u w=0.42u l=0.13u
X941 VSS.t1364 VDD VSS.t1365 VSS.t248 sg13_lv_nmos ad=79.8f pd=0.8u as=0 ps=0 w=0.42u l=1u
X942 VSS.t2974 VDD VSS.t2973 VSS.t2972 sg13_lv_nmos ad=0.1428p pd=1.52u as=0 ps=0 w=0.42u l=1u
X943 VDD VSS.t1354 VDD VDD sg13_lv_pmos ad=0.34p pd=2.68u as=0 ps=0 w=1u l=1u
X944 VDD VSS.t1086 VDD VDD sg13_lv_pmos ad=0.34p pd=2.68u as=0 ps=0 w=1u l=1u
X945 VDD VSS.t2730 VDD VDD sg13_lv_pmos ad=0.34p pd=2.68u as=0 ps=0 w=1u l=1u
X946 VDD VSS.t1968 VDD VDD sg13_lv_pmos ad=0.34p pd=2.68u as=0 ps=0 w=1u l=1u
X947 a_3204_15247# a_3435_15356# a_2890_15457# VSS.t207 sg13_lv_nmos ad=0.2373p pd=1.97u as=79.8f ps=0.8u w=0.42u l=0.13u
X948 VDD VSS.t2153 VDD VDD sg13_lv_pmos ad=0.34p pd=2.68u as=0 ps=0 w=1u l=1u
X949 a_3142_15247# sg13cmos5l_dfrbpq_1_0.RESET_B VSS.t165 VSS.t194 sg13_lv_nmos ad=37.8f pd=0.6u as=0.1701p ps=1.65u w=0.42u l=0.13u
X950 VSS.t598 VDD VSS.t600 VSS.t599 sg13_lv_nmos ad=79.8f pd=0.8u as=0 ps=0 w=0.42u l=1u
X951 VDD VSS.t1651 VDD VDD sg13_lv_pmos ad=0.34p pd=2.68u as=0 ps=0 w=1u l=1u
X952 VDD VSS.t1928 VDD VDD sg13_lv_pmos ad=0.34p pd=2.68u as=0 ps=0 w=1u l=1u
X953 VDD VSS.t2761 VDD VDD sg13_lv_pmos ad=0.34p pd=2.68u as=0 ps=0 w=1u l=1u
X954 VSS.t210 a_8218_13690# a_7937_13912# VSS.t209 sg13_lv_nmos ad=79.8f pd=0.8u as=0.1428p ps=1.52u w=0.42u l=0.5u
X955 VSS.t2789 VDD VSS.t2790 VSS.t199 sg13_lv_nmos ad=79.8f pd=0.8u as=0 ps=0 w=0.42u l=1u
X956 VDD VSS.t961 VDD VDD sg13_lv_pmos ad=0.34p pd=2.68u as=0 ps=0 w=1u l=1u
X957 VSS.t90 clock_i a_15579_14854# VSS.t3249 sg13_lv_nmos ad=0.1406p pd=1.12u as=0.2553p ps=2.17u w=0.74u l=0.13u
X958 VSS.t2738 VDD VSS.t2737 VSS.t199 sg13_lv_nmos ad=0.1428p pd=1.52u as=0 ps=0 w=0.42u l=1u
X959 VSS.t2356 VDD VSS.t2355 VSS.t2354 sg13_lv_nmos ad=0.1428p pd=1.52u as=0 ps=0 w=0.42u l=1u
X960 VDD VSS.t334 VDD VDD sg13_lv_pmos ad=0.19p pd=1.38u as=0 ps=0 w=1u l=1u
X961 VDD sg13cmos5l_dfrbpq_1_1.RESET_B a_6346_14452# VDD sg13_lv_pmos ad=0.1563p pd=1.22u as=0.147p ps=1.54u w=0.42u l=0.13u
X962 VDD VSS.t567 VDD VDD sg13_lv_pmos ad=0.34p pd=2.68u as=0 ps=0 w=1u l=1u
X963 VSS.t2806 VDD VSS.t2805 VSS.t199 sg13_lv_nmos ad=0.1428p pd=1.52u as=0 ps=0 w=0.42u l=1u
X964 VSS.t2079 VDD VSS.t2081 VSS.t2080 sg13_lv_nmos ad=79.8f pd=0.8u as=0 ps=0 w=0.42u l=1u
X965 VSS.t1067 VDD VSS.t1066 VSS.t1065 sg13_lv_nmos ad=0.1428p pd=1.52u as=0 ps=0 w=0.42u l=1u
X966 VSS.t1512 VDD VSS.t1514 VSS.t1513 sg13_lv_nmos ad=79.8f pd=0.8u as=0 ps=0 w=0.42u l=1u
X967 VDD VSS.t2390 VDD VDD sg13_lv_pmos ad=0.34p pd=2.68u as=0 ps=0 w=1u l=1u
X968 VSS.t2696 VDD VSS.t2697 VSS.t199 sg13_lv_nmos ad=79.8f pd=0.8u as=0 ps=0 w=0.42u l=1u
X969 VSS.t2421 VDD VSS.t2423 VSS.t2422 sg13_lv_nmos ad=79.8f pd=0.8u as=0 ps=0 w=0.42u l=1u
X970 VSS.t451 VDD VSS.t450 VSS.t19 sg13_lv_nmos ad=0.1428p pd=1.52u as=0 ps=0 w=0.42u l=1u
X971 a_6575_13342# a_6540_13238# sg13cmos5l_dlygate4sd3_1_0.A VSS.t169 sg13_lv_nmos ad=0.1406p pd=1.12u as=0.2516p ps=2.16u w=0.74u l=0.13u
X972 VDD VSS.t1631 VDD VDD sg13_lv_pmos ad=0.34p pd=2.68u as=0 ps=0 w=1u l=1u
X973 VSS.t1999 VDD VSS.t1998 VSS.t1997 sg13_lv_nmos ad=0.1428p pd=1.52u as=0 ps=0 w=0.42u l=1u
X974 VDD VSS.t1218 VDD VDD sg13_lv_pmos ad=0.19p pd=1.38u as=0 ps=0 w=1u l=1u
X975 VDD VSS.t1996 VDD VDD sg13_lv_pmos ad=0.19p pd=1.38u as=0 ps=0 w=1u l=1u
X976 VSS.t1256 VDD VSS.t1408 VSS.t248 sg13_lv_nmos ad=0.1428p pd=1.52u as=0 ps=0 w=0.42u l=1u
X977 VSS.t1642 VDD VSS.t1641 VSS.t1640 sg13_lv_nmos ad=0.1428p pd=1.52u as=0 ps=0 w=0.42u l=1u
X978 sg13cmos5l_o21ai_1_1.Y sg13cmos5l_or3_1_2.C a_20376_14464# VDD sg13_lv_pmos ad=0.2128p pd=1.5u as=0.2128p ps=1.5u w=1.12u l=0.15u
X979 VDD VSS.t1913 VDD VDD sg13_lv_pmos ad=0.34p pd=2.68u as=0 ps=0 w=1u l=1u
X980 VDD VSS.t1349 VDD VDD sg13_lv_pmos ad=0.34p pd=2.68u as=0 ps=0 w=1u l=1u
X981 VDD VSS.t2697 VDD VDD sg13_lv_pmos ad=0.34p pd=2.68u as=0 ps=0 w=1u l=1u
X982 VDD VSS.t2753 VDD VDD sg13_lv_pmos ad=0.34p pd=2.68u as=0 ps=0 w=1u l=1u
X983 a_12524_15960# sg13cmos5l_dlygate4sd3_1_8.A VSS.t125 VSS.t3264 sg13_lv_nmos ad=0.187p pd=1.78u as=0.14875p ps=1.16u w=0.55u l=0.13u
X984 VDD VSS.t1329 VDD VDD sg13_lv_pmos ad=0.19p pd=1.38u as=0 ps=0 w=1u l=1u
X985 VDD VSS.t2709 VDD VDD sg13_lv_pmos ad=0.19p pd=1.38u as=0 ps=0 w=1u l=1u
X986 VSS.t987 VDD VSS.t986 VSS.t985 sg13_lv_nmos ad=0.1428p pd=1.52u as=0 ps=0 w=0.42u l=1u
X987 VDD VSS.t2505 VDD VDD sg13_lv_pmos ad=0.34p pd=2.68u as=0 ps=0 w=1u l=1u
X988 VSS.t877 VDD VSS.t879 VSS.t878 sg13_lv_nmos ad=79.8f pd=0.8u as=0 ps=0 w=0.42u l=1u
X989 VSS.t1275 VDD VSS.t1274 VSS.t248 sg13_lv_nmos ad=0.1428p pd=1.52u as=0 ps=0 w=0.42u l=1u
X990 sg13cmos5l_or3_1_1.C sg13cmos5l_dfrbpq_1_2.Q VDD VDD sg13_lv_pmos ad=0.2128p pd=1.5u as=0.3808p ps=2.92u w=1.12u l=0.13u
X991 a_24408_15552# sg13cmos5l_or3_1_2.B VDD VDD sg13_lv_pmos ad=0.2128p pd=1.5u as=0.3808p ps=2.92u w=1.12u l=0.15u
X992 VDD VSS.t667 VDD VDD sg13_lv_pmos ad=0.34p pd=2.68u as=0 ps=0 w=1u l=1u
X993 VSS.t1732 VDD VSS.t1731 VSS.t1730 sg13_lv_nmos ad=0.1428p pd=1.52u as=0 ps=0 w=0.42u l=1u
X994 VSS.t2720 VDD VSS.t2721 VSS.t199 sg13_lv_nmos ad=79.8f pd=0.8u as=0 ps=0 w=0.42u l=1u
X995 VSS.t2114 VDD VSS.t2113 VSS.t2112 sg13_lv_nmos ad=0.1428p pd=1.52u as=0 ps=0 w=0.42u l=1u
X996 VSS.t19 a_27502_15423# sg13cmos5l_or3_1_1.A VSS.t19 sg13_lv_nmos ad=0.1426p pd=1.16u as=0.2516p ps=2.16u w=0.74u l=0.13u
X997 VSS.t2817 VDD VSS.t2816 VSS.t199 sg13_lv_nmos ad=0.1428p pd=1.52u as=0 ps=0 w=0.42u l=1u
X998 VSS.t47 VDD VSS.t47 VSS.t429 sg13_lv_nmos ad=79.8f pd=0.8u as=0 ps=0 w=0.42u l=1u
X999 a_7058_15242# sg13cmos5l_xor2_1_0.B VSS.t162 VSS.t161 sg13_lv_nmos ad=0.1406p pd=1.12u as=0.2516p ps=2.16u w=0.74u l=0.13u
X1000 VSS.t1497 VDD VSS.t1499 VSS.t1498 sg13_lv_nmos ad=79.8f pd=0.8u as=0 ps=0 w=0.42u l=1u
X1001 VDD VSS.t2548 VDD VDD sg13_lv_pmos ad=0.19p pd=1.38u as=0 ps=0 w=1u l=1u
X1002 VDD VSS.t414 VDD VDD sg13_lv_pmos ad=0.34p pd=2.68u as=0 ps=0 w=1u l=1u
X1003 VSS.t555 VDD VSS.t555 VSS.t557 sg13_lv_nmos ad=79.8f pd=0.8u as=0 ps=0 w=0.42u l=1u
X1004 VSS.t1203 VDD VSS.t249 VSS.t248 sg13_lv_nmos ad=0.1428p pd=1.52u as=0 ps=0 w=0.42u l=1u
X1005 VDD VSS.t1953 VDD VDD sg13_lv_pmos ad=0.34p pd=2.68u as=0 ps=0 w=1u l=1u
X1006 VDD VSS.t2859 VDD VDD sg13_lv_pmos ad=0.34p pd=2.68u as=0 ps=0 w=1u l=1u
X1007 VDD VSS.t489 VDD VDD sg13_lv_pmos ad=0.34p pd=2.68u as=0 ps=0 w=1u l=1u
X1008 a_25862_13722# sg13cmos5l_dfrbpq_1_5.D VDD VDD sg13_lv_pmos ad=79.8f pd=0.8u as=0.1428p ps=1.52u w=0.42u l=0.13u
X1009 VSS.t1311 VDD VSS.t1312 VSS.t248 sg13_lv_nmos ad=79.8f pd=0.8u as=0 ps=0 w=0.42u l=1u
X1010 VSS.t1233 VDD VSS.t1234 VSS.t248 sg13_lv_nmos ad=79.8f pd=0.8u as=0 ps=0 w=0.42u l=1u
X1011 VDD VSS.t1981 VDD VDD sg13_lv_pmos ad=0.19p pd=1.38u as=0 ps=0 w=1u l=1u
X1012 a_7822_13911# a_7937_13912# VDD VDD sg13_lv_pmos ad=0.34p pd=2.68u as=0.2254p ps=1.53u w=1u l=0.5u
X1013 VDD VSS.t1209 VDD VDD sg13_lv_pmos ad=0.19p pd=1.38u as=0 ps=0 w=1u l=1u
X1014 VDD VSS.t2335 VDD VDD sg13_lv_pmos ad=0.34p pd=2.68u as=0 ps=0 w=1u l=1u
X1015 a_6286_13911# a_6401_13912# VDD VDD sg13_lv_pmos ad=0.34p pd=2.68u as=0.2254p ps=1.53u w=1u l=0.5u
X1016 VSS.t664 VDD VSS.t664 VSS.t665 sg13_lv_nmos ad=79.8f pd=0.8u as=0 ps=0 w=0.42u l=1u
X1017 VDD VSS.t1079 VDD VDD sg13_lv_pmos ad=0.19p pd=1.38u as=0 ps=0 w=1u l=1u
X1018 VDD VSS.t1636 VDD VDD sg13_lv_pmos ad=0.34p pd=2.68u as=0 ps=0 w=1u l=1u
X1019 a_26249_16334# a_26373_16033# VDD VDD sg13_lv_pmos ad=0.2442p pd=2.06u as=2.8961p ps=18.25u w=0.66u l=0.13u
X1020 VSS.t1527 VDD VSS.t1526 VSS.t1525 sg13_lv_nmos ad=0.1428p pd=1.52u as=0 ps=0 w=0.42u l=1u
X1021 VSS.t1944 VDD VSS.t1943 VSS.t1942 sg13_lv_nmos ad=0.1428p pd=1.52u as=0 ps=0 w=0.42u l=1u
X1022 VSS.t418 VDD VSS.t418 VSS.t419 sg13_lv_nmos ad=79.8f pd=0.8u as=0 ps=0 w=0.42u l=1u
X1023 VSS.t478 VDD VSS.t479 VSS.t19 sg13_lv_nmos ad=79.8f pd=0.8u as=0 ps=0 w=0.42u l=1u
X1024 VDD VSS.t3071 VDD VDD sg13_lv_pmos ad=0.19p pd=1.38u as=0 ps=0 w=1u l=1u
X1025 VSS.t2705 VDD VSS.t2704 VSS.t199 sg13_lv_nmos ad=0.1428p pd=1.52u as=0 ps=0 w=0.42u l=1u
X1026 VSS.t2436 VDD VSS.t2435 VSS.t2434 sg13_lv_nmos ad=0.1428p pd=1.52u as=0 ps=0 w=0.42u l=1u
X1027 a_12010_15202# sg13cmos5l_buf_8_2.A VSS.t440 VSS.t3285 sg13_lv_nmos ad=0.2553p pd=2.17u as=0.1406p ps=1.12u w=0.74u l=0.13u
X1028 VSS.t727 VDD VSS.t59 VSS.t726 sg13_lv_nmos ad=0.1428p pd=1.52u as=0 ps=0 w=0.42u l=1u
X1029 VSS.t2764 VDD VSS.t2765 VSS.t199 sg13_lv_nmos ad=79.8f pd=0.8u as=0 ps=0 w=0.42u l=1u
X1030 VDD a_14261_15238# sg13cmos5l_or3_1_1.B VDD sg13_lv_pmos ad=0.2128p pd=1.5u as=0.2128p ps=1.5u w=1.12u l=0.13u
X1031 VDD VSS.t1006 VDD VDD sg13_lv_pmos ad=0.34p pd=2.68u as=0 ps=0 w=1u l=1u
X1032 VSS.t31 VDD VSS.t31 VSS.t332 sg13_lv_nmos ad=79.8f pd=0.8u as=0 ps=0 w=0.42u l=1u
X1033 VSS.t588 VDD VSS.t587 VSS.t586 sg13_lv_nmos ad=0.1428p pd=1.52u as=0 ps=0 w=0.42u l=1u
X1034 VDD VSS.t1494 VDD VDD sg13_lv_pmos ad=0.19p pd=1.38u as=0 ps=0 w=1u l=1u
X1035 VDD VSS.t318 VDD VDD sg13_lv_pmos ad=0.34p pd=2.68u as=0 ps=0 w=1u l=1u
X1036 a_9737_14822# a_9861_14521# VDD VDD sg13_lv_pmos ad=0.2442p pd=2.06u as=2.42015p ps=15.68u w=0.66u l=0.13u
X1037 a_17604_14488# a_17578_14452# VDD VDD sg13_lv_pmos ad=0.34p pd=2.68u as=0.36237p ps=2.605u w=1u l=0.13u
X1038 VDD VSS.t567 VDD VDD sg13_lv_pmos ad=0.34p pd=2.68u as=0 ps=0 w=1u l=1u
X1039 VDD VSS.t2676 VDD VDD sg13_lv_pmos ad=0.19p pd=1.38u as=0 ps=0 w=1u l=1u
X1040 sg13cmos5l_dfrbpq_1_3.D a_17238_15302# VDD VDD sg13_lv_pmos ad=0.4256p pd=3u as=0.2254p ps=1.53u w=1.12u l=0.13u
X1041 VDD a_27472_14726# a_27417_14607# VDD sg13_lv_pmos ad=2.42015p pd=15.68u as=93.45f ps=0.865u w=0.42u l=0.13u
X1042 a_19323_13726# sg13cmos5l_buf_8_2.A VSS.t742 VSS.t3287 sg13_lv_nmos ad=0.1406p pd=1.12u as=0.1406p ps=1.12u w=0.74u l=0.13u
X1043 VSS.t2979 VDD VSS.t2978 VSS.t2977 sg13_lv_nmos ad=0.1428p pd=1.52u as=0 ps=0 w=0.42u l=1u
X1044 VSS.t761 VDD VSS.t637 VSS.t762 sg13_lv_nmos ad=79.8f pd=0.8u as=0 ps=0 w=0.42u l=1u
X1045 VDD VSS.t1335 VDD VDD sg13_lv_pmos ad=0.34p pd=2.68u as=0 ps=0 w=1u l=1u
X1046 VSS.t1627 VDD VSS.t1629 VSS.t1628 sg13_lv_nmos ad=79.8f pd=0.8u as=0 ps=0 w=0.42u l=1u
X1047 VSS.t3149 VDD VSS.t3151 VSS.t3150 sg13_lv_nmos ad=79.8f pd=0.8u as=0 ps=0 w=0.42u l=1u
X1048 VSS.t1293 VDD VSS.t1292 VSS.t248 sg13_lv_nmos ad=0.1428p pd=1.52u as=0 ps=0 w=0.42u l=1u
X1049 VSS.t1217 VDD VSS.t1216 VSS.t248 sg13_lv_nmos ad=0.1428p pd=1.52u as=0 ps=0 w=0.42u l=1u
X1050 VSS.t2019 VDD VSS.t2018 VSS.t2017 sg13_lv_nmos ad=0.1428p pd=1.52u as=0 ps=0 w=0.42u l=1u
X1051 VDD VSS.t881 VDD VDD sg13_lv_pmos ad=0.34p pd=2.68u as=0 ps=0 w=1u l=1u
X1052 VSS.t1325 VDD VSS.t1326 VSS.t248 sg13_lv_nmos ad=79.8f pd=0.8u as=0 ps=0 w=0.42u l=1u
X1053 VSS.t2687 VDD VSS.t2688 VSS.t199 sg13_lv_nmos ad=79.8f pd=0.8u as=0 ps=0 w=0.42u l=1u
X1054 VDD VSS.t1973 VDD VDD sg13_lv_pmos ad=0.34p pd=2.68u as=0 ps=0 w=1u l=1u
X1055 VDD VSS.t2158 VDD VDD sg13_lv_pmos ad=0.34p pd=2.68u as=0 ps=0 w=1u l=1u
X1056 VSS.t2551 VDD VSS.t2553 VSS.t2552 sg13_lv_nmos ad=79.8f pd=0.8u as=0 ps=0 w=0.42u l=1u
X1057 VDD VSS.t1656 VDD VDD sg13_lv_pmos ad=0.34p pd=2.68u as=0 ps=0 w=1u l=1u
X1058 VDD VSS.t2688 VDD VDD sg13_lv_pmos ad=0.34p pd=2.68u as=0 ps=0 w=1u l=1u
X1059 sg13cmos5l_buf_8_2.A a_15579_14854# VDD VDD sg13_lv_pmos ad=0.2128p pd=1.5u as=0.2128p ps=1.5u w=1.12u l=0.13u
X1060 VSS.t776 VDD VSS.t102 VSS.t777 sg13_lv_nmos ad=79.8f pd=0.8u as=0 ps=0 w=0.42u l=1u
X1061 VSS.t1929 VDD VSS.t1928 VSS.t1927 sg13_lv_nmos ad=0.1428p pd=1.52u as=0 ps=0 w=0.42u l=1u
X1062 VSS.t987 VDD VSS.t986 VSS.t985 sg13_lv_nmos ad=0.1428p pd=1.52u as=0 ps=0 w=0.42u l=1u
X1063 counter_value_o[3] a_16552_15996# VSS.t197 VSS.t258 sg13_lv_nmos ad=0.2886p pd=2.26u as=0.14875p ps=1.16u w=0.74u l=0.13u
X1064 a_26757_16033# a_26757_16033# VSS.t21 VSS.t3221 sg13_lv_nmos ad=0.111p pd=1.34u as=7.70437p ps=50.66u w=0.3u l=0.13u
X1065 VDD VSS.t2797 VDD VDD sg13_lv_pmos ad=0.34p pd=2.68u as=0 ps=0 w=1u l=1u
X1066 VSS.t2740 VDD VSS.t2740 VSS.t199 sg13_lv_nmos ad=0.1428p pd=1.52u as=0 ps=0 w=0.42u l=1u
X1067 VDD VSS.t623 VDD VDD sg13_lv_pmos ad=0.19p pd=1.38u as=0 ps=0 w=1u l=1u
X1068 VSS.t254 VDD VSS.t254 VSS.t564 sg13_lv_nmos ad=0.1428p pd=1.52u as=0 ps=0 w=0.42u l=1u
X1069 VSS.t747 VDD VSS.t747 VSS.t746 sg13_lv_nmos ad=0.1428p pd=1.52u as=0 ps=0 w=0.42u l=1u
X1070 VSS.t2809 VDD VSS.t2808 VSS.t199 sg13_lv_nmos ad=0.1428p pd=1.52u as=0 ps=0 w=0.42u l=1u
X1071 VSS.t2084 VDD VSS.t2086 VSS.t2085 sg13_lv_nmos ad=79.8f pd=0.8u as=0 ps=0 w=0.42u l=1u
X1072 VDD VSS.t351 VDD VDD sg13_lv_pmos ad=0.34p pd=2.68u as=0 ps=0 w=1u l=1u
X1073 VDD VSS.t1036 VDD VDD sg13_lv_pmos ad=0.34p pd=2.68u as=0 ps=0 w=1u l=1u
X1074 VSS.t1443 VDD VSS.t1306 VSS.t248 sg13_lv_nmos ad=0.1428p pd=1.52u as=0 ps=0 w=0.42u l=1u
X1075 VDD VSS.t1243 VDD VDD sg13_lv_pmos ad=0.19p pd=1.38u as=0 ps=0 w=1u l=1u
X1076 VDD VSS.t2749 VDD VDD sg13_lv_pmos ad=0.19p pd=1.38u as=0 ps=0 w=1u l=1u
X1077 VSS.t2421 VDD VSS.t2420 VSS.t2419 sg13_lv_nmos ad=0.1428p pd=1.52u as=0 ps=0 w=0.42u l=1u
X1078 VDD VSS.t844 VDD VDD sg13_lv_pmos ad=0.19p pd=1.38u as=0 ps=0 w=1u l=1u
X1079 VDD VSS.t2360 VDD VDD sg13_lv_pmos ad=0.34p pd=2.68u as=0 ps=0 w=1u l=1u
X1080 VDD VSS.t2533 VDD VDD sg13_lv_pmos ad=0.19p pd=1.38u as=0 ps=0 w=1u l=1u
X1081 VDD VSS.t652 VDD VDD sg13_lv_pmos ad=0.34p pd=2.68u as=0 ps=0 w=1u l=1u
X1082 VDD VSS.t1279 VDD VDD sg13_lv_pmos ad=0.19p pd=1.38u as=0 ps=0 w=1u l=1u
X1083 VSS.t371 VDD VSS.t370 VSS.t369 sg13_lv_nmos ad=0.1428p pd=1.52u as=0 ps=0 w=0.42u l=1u
X1084 VDD VSS.t2485 VDD VDD sg13_lv_pmos ad=0.34p pd=2.68u as=0 ps=0 w=1u l=1u
X1085 VDD VSS.t1966 VDD VDD sg13_lv_pmos ad=0.19p pd=1.38u as=0 ps=0 w=1u l=1u
X1086 VSS.t1969 VDD VSS.t1968 VSS.t1967 sg13_lv_nmos ad=0.1428p pd=1.52u as=0 ps=0 w=0.42u l=1u
X1087 VDD VSS.t2143 VDD VDD sg13_lv_pmos ad=0.34p pd=2.68u as=0 ps=0 w=1u l=1u
X1088 VDD VSS.t506 VDD VDD sg13_lv_pmos ad=0.34p pd=2.68u as=0 ps=0 w=1u l=1u
X1089 VDD VSS.t2320 VDD VDD sg13_lv_pmos ad=0.34p pd=2.68u as=0 ps=0 w=1u l=1u
X1090 VSS.t1072 VDD VSS.t1071 VSS.t1070 sg13_lv_nmos ad=0.1428p pd=1.52u as=0 ps=0 w=0.42u l=1u
X1091 VDD VSS.t2700 VDD VDD sg13_lv_pmos ad=0.34p pd=2.68u as=0 ps=0 w=1u l=1u
X1092 VDD VSS.t580 VDD VDD sg13_lv_pmos ad=0.19p pd=1.38u as=0 ps=0 w=1u l=1u
X1093 VSS.t1473 VDD VSS.t1344 VSS.t248 sg13_lv_nmos ad=79.8f pd=0.8u as=0 ps=0 w=0.42u l=1u
X1094 VDD VSS.t2091 VDD VDD sg13_lv_pmos ad=0.19p pd=1.38u as=0 ps=0 w=1u l=1u
X1095 a_17063_16020# sg13cmos5l_or3_1_2.B a_16969_16020# VDD sg13_lv_pmos ad=0.19p pd=1.38u as=0.34p ps=2.68u w=1u l=0.13u
X1096 VDD sg13cmos5l_dlygate4sd3_1_4.X sg13cmos5l_dlygate4sd3_1_5.A VDD sg13_lv_pmos ad=0.3808p pd=2.92u as=0.2128p ps=1.5u w=1.12u l=0.15u
X1097 VSS.t123 a_19450_15202# a_19169_15424# VSS.t87 sg13_lv_nmos ad=79.8f pd=0.8u as=0.1428p ps=1.52u w=0.42u l=0.5u
X1098 VDD VSS.t936 VDD VDD sg13_lv_pmos ad=0.34p pd=2.68u as=0 ps=0 w=1u l=1u
X1099 VDD VSS.t1207 VDD VDD sg13_lv_pmos ad=0.19p pd=1.38u as=0 ps=0 w=1u l=1u
X1100 VSS.t41 a_4175_15311# a_4842_15532# VSS.t67 sg13_lv_nmos ad=0.1406p pd=1.12u as=0.2516p ps=2.16u w=0.74u l=0.13u
X1101 sg13cmos5l_xnor2_1_0.Y sg13cmos5l_nand3_1_0.Y a_7923_15532# VDD sg13_lv_pmos ad=0.2408p pd=1.55u as=0.1428p ps=1.375u w=1.12u l=0.13u
X1102 VDD VSS.t914 VDD VDD sg13_lv_pmos ad=0.19p pd=1.38u as=0 ps=0 w=1u l=1u
X1103 VSS.t2696 VDD VSS.t2694 VSS.t199 sg13_lv_nmos ad=0.1428p pd=1.52u as=0 ps=0 w=0.42u l=1u
X1104 VDD VSS.t2712 VDD VDD sg13_lv_pmos ad=0.19p pd=1.38u as=0 ps=0 w=1u l=1u
X1105 VSS.t2755 VDD VSS.t2756 VSS.t199 sg13_lv_nmos ad=79.8f pd=0.8u as=0 ps=0 w=0.42u l=1u
X1106 VDD a_8582_15238# a_8694_15302# VDD sg13_lv_pmos ad=0.2254p pd=1.53u as=0.34p ps=2.68u w=1u l=0.5u
X1107 VDD VSS.t2943 VDD VDD sg13_lv_pmos ad=0.34p pd=2.68u as=0 ps=0 w=1u l=1u
X1108 VDD sg13cmos5l_xor2_1_0.X a_1965_14832# VDD sg13_lv_pmos ad=0.1918p pd=1.5u as=0.1596p ps=1.22u w=0.84u l=0.13u
X1109 VSS.t652 VDD VSS.t655 VSS.t789 sg13_lv_nmos ad=79.8f pd=0.8u as=0 ps=0 w=0.42u l=1u
X1110 a_17318_14922# sg13cmos5l_dfrbpq_1_3.D VDD VDD sg13_lv_pmos ad=79.8f pd=0.8u as=0.1428p ps=1.52u w=0.42u l=0.13u
X1111 VDD VSS.t811 VDD VDD sg13_lv_pmos ad=0.34p pd=2.68u as=0 ps=0 w=1u l=1u
X1112 VDD VSS.t999 VDD VDD sg13_lv_pmos ad=0.19p pd=1.38u as=0 ps=0 w=1u l=1u
X1113 VSS.t2964 VDD VSS.t2963 VSS.t2962 sg13_lv_nmos ad=0.1428p pd=1.52u as=0 ps=0 w=0.42u l=1u
X1114 VSS.t1087 VDD VSS.t1086 VSS.t1085 sg13_lv_nmos ad=0.1428p pd=1.52u as=0 ps=0 w=0.42u l=1u
X1115 VSS.t1352 VDD VSS.t1353 VSS.t248 sg13_lv_nmos ad=79.8f pd=0.8u as=0 ps=0 w=0.42u l=1u
X1116 VDD VSS.t2518 VDD VDD sg13_lv_pmos ad=0.19p pd=1.38u as=0 ps=0 w=1u l=1u
X1117 VSS.t197 a_17710_16263# sg13cmos5l_a21oi_1_0.A1 VSS.t3263 sg13_lv_nmos ad=0.1426p pd=1.16u as=0.2516p ps=2.16u w=0.74u l=0.13u
X1118 VSS.t108 a_25094_14484# a_25206_14508# VSS.t0 sg13_lv_nmos ad=0.1426p pd=1.16u as=0.1428p ps=1.52u w=0.42u l=0.5u
X1119 sg13cmos5l_or3_1_1.X a_24841_13726# VSS.t77 VSS.t76 sg13_lv_nmos ad=0.2516p pd=2.16u as=0.13395p ps=1.12u w=0.74u l=0.13u
X1120 VDD VSS.t1958 VDD VDD sg13_lv_pmos ad=0.34p pd=2.68u as=0 ps=0 w=1u l=1u
X1121 VDD VSS.t2724 VDD VDD sg13_lv_pmos ad=0.34p pd=2.68u as=0 ps=0 w=1u l=1u
X1122 sg13cmos5l_dfrbpq_1_2.D sg13cmos5l_nor2_1_0.B a_15338_14484# VDD sg13_lv_pmos ad=0.3808p pd=2.92u as=0.1176p ps=1.33u w=1.12u l=0.13u
X1123 VSS.t503 VDD VSS.t6 VSS.t502 sg13_lv_nmos ad=0.1428p pd=1.52u as=0 ps=0 w=0.42u l=1u
X1124 VDD VSS.t1212 VDD VDD sg13_lv_pmos ad=0.19p pd=1.38u as=0 ps=0 w=1u l=1u
X1125 a_25109_12972# sg13cmos5l_a21oi_1_3.A1 VDD VDD sg13_lv_pmos ad=0.2128p pd=1.5u as=0.2128p ps=1.5u w=1.12u l=0.13u
X1126 VSS.t1632 VDD VSS.t1631 VSS.t1630 sg13_lv_nmos ad=0.1428p pd=1.52u as=0 ps=0 w=0.42u l=1u
X1127 VSS.t3154 VDD VSS.t3153 VSS.t3152 sg13_lv_nmos ad=0.1428p pd=1.52u as=0 ps=0 w=0.42u l=1u
X1128 VDD VSS.t2305 VDD VDD sg13_lv_pmos ad=0.34p pd=2.68u as=0 ps=0 w=1u l=1u
X1129 VSS.t2536 VDD VSS.t2538 VSS.t2537 sg13_lv_nmos ad=79.8f pd=0.8u as=0 ps=0 w=0.42u l=1u
X1130 VDD VSS.t555 VDD VDD sg13_lv_pmos ad=0.34p pd=2.68u as=0 ps=0 w=1u l=1u
X1131 VDD VSS.t1641 VDD VDD sg13_lv_pmos ad=0.34p pd=2.68u as=0 ps=0 w=1u l=1u
X1132 VSS.t744 a_19323_13726# sg13cmos5l_buf_8_2.X VSS.t3231 sg13_lv_nmos ad=0.1406p pd=1.12u as=0.1406p ps=1.12u w=0.74u l=0.13u
X1133 VDD VSS.t1297 VDD VDD sg13_lv_pmos ad=0.19p pd=1.38u as=0 ps=0 w=1u l=1u
X1134 VSS.t1532 VDD VSS.t1531 VSS.t1530 sg13_lv_nmos ad=0.1428p pd=1.52u as=0 ps=0 w=0.42u l=1u
X1135 VSS.t2441 VDD VSS.t2440 VSS.t2439 sg13_lv_nmos ad=0.1428p pd=1.52u as=0 ps=0 w=0.42u l=1u
X1136 VSS.t1914 VDD VSS.t1913 VSS.t1912 sg13_lv_nmos ad=0.1428p pd=1.52u as=0 ps=0 w=0.42u l=1u
X1137 VSS.t1702 VDD VSS.t1704 VSS.t1703 sg13_lv_nmos ad=79.8f pd=0.8u as=0 ps=0 w=0.42u l=1u
X1138 VSS.t1246 VDD VSS.t1247 VSS.t248 sg13_lv_nmos ad=79.8f pd=0.8u as=0 ps=0 w=0.42u l=1u
X1139 VDD VSS.t2013 VDD VDD sg13_lv_pmos ad=0.34p pd=2.68u as=0 ps=0 w=1u l=1u
X1140 VDD VSS.t2788 VDD VDD sg13_lv_pmos ad=0.34p pd=2.68u as=0 ps=0 w=1u l=1u
X1141 VSS.t2406 VDD VSS.t2408 VSS.t2407 sg13_lv_nmos ad=79.8f pd=0.8u as=0 ps=0 w=0.42u l=1u
X1142 VDD VSS.t3136 VDD VDD sg13_lv_pmos ad=0.19p pd=1.38u as=0 ps=0 w=1u l=1u
X1143 a_16485_13701# sg13cmos5l_dfrbpq_1_2.CLK VDD VDD sg13_lv_pmos ad=0.4088p pd=2.97u as=2.3367p ps=15.135u w=1.12u l=0.13u
X1144 VDD VSS.t966 VDD VDD sg13_lv_pmos ad=0.34p pd=2.68u as=0 ps=0 w=1u l=1u
X1145 VSS.t2714 VDD VSS.t2715 VSS.t199 sg13_lv_nmos ad=79.8f pd=0.8u as=0 ps=0 w=0.42u l=1u
X1146 VDD VSS.t2679 VDD VDD sg13_lv_pmos ad=0.19p pd=1.38u as=0 ps=0 w=1u l=1u
X1147 VDD VSS.t378 VDD VDD sg13_lv_pmos ad=0.19p pd=1.38u as=0 ps=0 w=1u l=1u
X1148 VSS.t1334 VDD VSS.t1333 VSS.t248 sg13_lv_nmos ad=0.1428p pd=1.52u as=0 ps=0 w=0.42u l=1u
X1149 VSS.t2949 VDD VSS.t2948 VSS.t2947 sg13_lv_nmos ad=0.1428p pd=1.52u as=0 ps=0 w=0.42u l=1u
X1150 VDD a_4474_14448# a_4193_14750# VDD sg13_lv_pmos ad=0.1523p pd=1.38u as=0.34p ps=2.68u w=1u l=0.5u
X1151 VDD VSS.t1338 VDD VDD sg13_lv_pmos ad=0.34p pd=2.68u as=0 ps=0 w=1u l=1u
X1152 VDD VSS.t2345 VDD VDD sg13_lv_pmos ad=0.34p pd=2.68u as=0 ps=0 w=1u l=1u
X1153 VDD VSS.t2715 VDD VDD sg13_lv_pmos ad=0.34p pd=2.68u as=0 ps=0 w=1u l=1u
X1154 VDD sg13cmos5l_buf_1_0.X a_2942_14484# VDD sg13_lv_pmos ad=0.36p pd=2.72u as=0.1225p ps=1.245u w=1u l=0.13u
X1155 a_6540_13238# sg13cmos5l_xnor2_1_2.B VDD VDD sg13_lv_pmos ad=0.1596p pd=1.22u as=0.2891p ps=1.695u w=0.84u l=0.13u
X1156 VSS.t1072 VDD VSS.t1071 VSS.t1070 sg13_lv_nmos ad=0.1428p pd=1.52u as=0 ps=0 w=0.42u l=1u
X1157 VDD VSS.t2470 VDD VDD sg13_lv_pmos ad=0.34p pd=2.68u as=0 ps=0 w=1u l=1u
X1158 VDD VSS.t646 VDD VDD sg13_lv_pmos ad=0.34p pd=2.68u as=0 ps=0 w=1u l=1u
X1159 VDD VSS.t2128 VDD VDD sg13_lv_pmos ad=0.34p pd=2.68u as=0 ps=0 w=1u l=1u
X1160 VDD VSS.t580 VDD VDD sg13_lv_pmos ad=0.19p pd=1.38u as=0 ps=0 w=1u l=1u
X1161 VDD VSS.t2691 VDD VDD sg13_lv_pmos ad=0.34p pd=2.68u as=0 ps=0 w=1u l=1u
X1162 VDD VSS.t981 VDD VDD sg13_lv_pmos ad=0.34p pd=2.68u as=0 ps=0 w=1u l=1u
X1163 a_21034_14452# a_21477_14495# a_20774_14922# VSS.t94 sg13_lv_nmos ad=79.8f pd=0.8u as=0.1296p ps=1.52u w=0.42u l=0.13u
X1164 VDD VSS.t2800 VDD VDD sg13_lv_pmos ad=0.34p pd=2.68u as=0 ps=0 w=1u l=1u
X1165 VDD VSS.t1219 VDD VDD sg13_lv_pmos ad=0.34p pd=2.68u as=0 ps=0 w=1u l=1u
X1166 VSS.t2743 VDD VSS.t2742 VSS.t199 sg13_lv_nmos ad=0.1428p pd=1.52u as=0 ps=0 w=0.42u l=1u
X1167 VSS.t1492 VDD VSS.t1494 VSS.t1493 sg13_lv_nmos ad=79.8f pd=0.8u as=0 ps=0 w=0.42u l=1u
X1168 VSS.t1087 VDD VSS.t1086 VSS.t1085 sg13_lv_nmos ad=0.1428p pd=1.52u as=0 ps=0 w=0.42u l=1u
X1169 sg13cmos5l_a21oi_1_3.A2 a_24169_14508# VSS.t3278 VSS.t0 sg13_lv_nmos ad=0.2516p pd=2.16u as=0.13395p ps=1.12u w=0.74u l=0.13u
X1170 VDD VSS.t1044 VDD VDD sg13_lv_pmos ad=0.19p pd=1.38u as=0 ps=0 w=1u l=1u
X1171 VSS.t992 VDD VSS.t994 VSS.t993 sg13_lv_nmos ad=79.8f pd=0.8u as=0 ps=0 w=0.42u l=1u
X1172 VDD reset_n_i a_1192_9948# VDD sg13_lv_pmos ad=0.2114p pd=1.54u as=0.2856p ps=2.36u w=0.84u l=0.13u
X1173 VDD VSS.t1624 VDD VDD sg13_lv_pmos ad=0.19p pd=1.38u as=0 ps=0 w=1u l=1u
X1174 VSS.t2792 VDD VSS.t2790 VSS.t199 sg13_lv_nmos ad=0.1428p pd=1.52u as=0 ps=0 w=0.42u l=1u
X1175 VSS.t2054 VDD VSS.t2056 VSS.t2055 sg13_lv_nmos ad=79.8f pd=0.8u as=0 ps=0 w=0.42u l=1u
X1176 VSS.t457 VDD VSS.t458 VSS.t19 sg13_lv_nmos ad=79.8f pd=0.8u as=0 ps=0 w=0.42u l=1u
X1177 VDD VSS.t2365 VDD VDD sg13_lv_pmos ad=0.34p pd=2.68u as=0 ps=0 w=1u l=1u
X1178 a_16969_16020# sg13cmos5l_inv_1_0.Y VSS.t197 VSS.t3257 sg13_lv_nmos ad=0.198p pd=1.27u as=0.1045p ps=0.93u w=0.55u l=0.13u
X1179 VDD VSS.t399 VDD VDD sg13_lv_pmos ad=0.34p pd=2.68u as=0 ps=0 w=1u l=1u
X1180 VSS.t588 VDD VSS.t587 VSS.t586 sg13_lv_nmos ad=0.1428p pd=1.52u as=0 ps=0 w=0.42u l=1u
X1181 VDD VSS.t1629 VDD VDD sg13_lv_pmos ad=0.19p pd=1.38u as=0 ps=0 w=1u l=1u
X1182 VDD VSS.t143 VDD VDD sg13_lv_pmos ad=0.34p pd=2.68u as=0 ps=0 w=1u l=1u
X1183 VSS.t1974 VDD VSS.t1973 VSS.t1972 sg13_lv_nmos ad=0.1428p pd=1.52u as=0 ps=0 w=0.42u l=1u
X1184 a_25774_15423# a_25889_15424# VDD VDD sg13_lv_pmos ad=0.34p pd=2.68u as=0.2254p ps=1.53u w=1u l=0.5u
X1185 VDD VSS.t1361 VDD VDD sg13_lv_pmos ad=0.34p pd=2.68u as=0 ps=0 w=1u l=1u
X1186 VDD VSS.t2686 VDD VDD sg13_lv_pmos ad=0.34p pd=2.68u as=0 ps=0 w=1u l=1u
X1187 VDD VSS.t555 VDD VDD sg13_lv_pmos ad=0.34p pd=2.68u as=0 ps=0 w=1u l=1u
X1188 a_18552_15976# sg13cmos5l_inv_1_0.Y VDD VDD sg13_lv_pmos ad=0.2128p pd=1.5u as=0.3808p ps=2.92u w=1.12u l=0.15u
X1189 VSS.t403 VDD VSS.t403 VSS.t404 sg13_lv_nmos ad=79.8f pd=0.8u as=0 ps=0 w=0.42u l=1u
X1190 VSS.t1712 VDD VSS.t1711 VSS.t1710 sg13_lv_nmos ad=0.1428p pd=1.52u as=0 ps=0 w=0.42u l=1u
X1191 VSS.t1517 VDD VSS.t1516 VSS.t1515 sg13_lv_nmos ad=0.1428p pd=1.52u as=0 ps=0 w=0.42u l=1u
X1192 VSS.t2426 VDD VSS.t2425 VSS.t2424 sg13_lv_nmos ad=0.1428p pd=1.52u as=0 ps=0 w=0.42u l=1u
X1193 VSS.t2699 VDD VSS.t2698 VSS.t199 sg13_lv_nmos ad=0.1428p pd=1.52u as=0 ps=0 w=0.42u l=1u
X1194 VDD VSS.t114 VDD VDD sg13_lv_pmos ad=0.19p pd=1.38u as=0 ps=0 w=1u l=1u
X1195 VSS.t2758 VDD VSS.t2759 VSS.t199 sg13_lv_nmos ad=79.8f pd=0.8u as=0 ps=0 w=0.42u l=1u
X1196 VSS.t3009 VDD VSS.t3008 VSS.t3007 sg13_lv_nmos ad=0.1428p pd=1.52u as=0 ps=0 w=0.42u l=1u
X1197 a_22319_14845# a_21477_14495# a_21060_14488# VDD sg13_lv_pmos ad=0.2048p pd=1.63u as=0.34p ps=2.68u w=1u l=0.13u
X1198 VSS.t2391 VDD VSS.t2393 VSS.t2392 sg13_lv_nmos ad=79.8f pd=0.8u as=0 ps=0 w=0.42u l=1u
X1199 VDD VSS.t3121 VDD VDD sg13_lv_pmos ad=0.19p pd=1.38u as=0 ps=0 w=1u l=1u
X1200 VDD VSS.t2333 VDD VDD sg13_lv_pmos ad=0.19p pd=1.38u as=0 ps=0 w=1u l=1u
X1201 a_24062_15242# sg13cmos5l_dfrbpq_1_6.Q a_23960_15242# VSS.t48 sg13_lv_nmos ad=0.1406p pd=1.12u as=0.1406p ps=1.12u w=0.74u l=0.13u
X1202 VSS.t1707 VDD VSS.t1706 VSS.t1705 sg13_lv_nmos ad=0.1428p pd=1.52u as=0 ps=0 w=0.42u l=1u
X1203 VDD VSS.t1014 VDD VDD sg13_lv_pmos ad=0.19p pd=1.38u as=0 ps=0 w=1u l=1u
X1204 VDD VSS.t3073 VDD VDD sg13_lv_pmos ad=0.34p pd=2.68u as=0 ps=0 w=1u l=1u
X1205 VSS.t2803 VDD VSS.t2803 VSS.t199 sg13_lv_nmos ad=0.1428p pd=1.52u as=0 ps=0 w=0.42u l=1u
X1206 VSS.t2705 VDD VSS.t2706 VSS.t199 sg13_lv_nmos ad=79.8f pd=0.8u as=0 ps=0 w=0.42u l=1u
X1207 VDD VSS.t2671 VDD VDD sg13_lv_pmos ad=0.19p pd=1.38u as=0 ps=0 w=1u l=1u
X1208 a_8779_14832# sg13cmos5l_buf_1_10.X a_8685_14832# VSS.t190 sg13_lv_nmos ad=0.1216p pd=1.02u as=0.2176p ps=1.96u w=0.64u l=0.13u
X1209 VDD VSS.t1250 VDD VDD sg13_lv_pmos ad=0.19p pd=1.38u as=0 ps=0 w=1u l=1u
X1210 VDD VSS.t1330 VDD VDD sg13_lv_pmos ad=0.34p pd=2.68u as=0 ps=0 w=1u l=1u
X1211 VDD VSS.t2523 VDD VDD sg13_lv_pmos ad=0.19p pd=1.38u as=0 ps=0 w=1u l=1u
X1212 VDD VSS.t2706 VDD VDD sg13_lv_pmos ad=0.34p pd=2.68u as=0 ps=0 w=1u l=1u
X1213 VSS.t2009 VDD VSS.t2008 VSS.t2007 sg13_lv_nmos ad=0.1428p pd=1.52u as=0 ps=0 w=0.42u l=1u
X1214 VDD VSS.t1963 VDD VDD sg13_lv_pmos ad=0.34p pd=2.68u as=0 ps=0 w=1u l=1u
X1215 a_15579_14854# clock_i VSS.t90 VSS.t3250 sg13_lv_nmos ad=0.1406p pd=1.12u as=0.1406p ps=1.12u w=0.74u l=0.13u
X1216 VSS.t23 sg13cmos5l_dfrbpq_1_6.RESET_B a_20868_14922# VSS.t3290 sg13_lv_nmos ad=0.1626p pd=1.415u as=60.89999f ps=0.71u w=0.42u l=0.13u
X1217 VSS.t555 VDD VSS.t555 VSS.t558 sg13_lv_nmos ad=0.1428p pd=1.52u as=0 ps=0 w=0.42u l=1u
X1218 a_17578_14452# a_18021_14495# a_17318_14922# VSS.t231 sg13_lv_nmos ad=79.8f pd=0.8u as=0.1296p ps=1.52u w=0.42u l=0.13u
X1219 VSS.t2541 VDD VSS.t2543 VSS.t2542 sg13_lv_nmos ad=79.8f pd=0.8u as=0 ps=0 w=0.42u l=1u
X1220 a_25956_14488# a_25930_14452# VSS.t108 VSS.t226 sg13_lv_nmos ad=0.2516p pd=2.16u as=0.1626p ps=1.415u w=0.74u l=0.13u
X1221 VSS.t490 VDD VSS.t491 VSS.t19 sg13_lv_nmos ad=79.8f pd=0.8u as=0 ps=0 w=0.42u l=1u
X1222 VDD VSS.t889 VDD VDD sg13_lv_pmos ad=0.19p pd=1.38u as=0 ps=0 w=1u l=1u
X1223 VDD VSS.t2483 VDD VDD sg13_lv_pmos ad=0.19p pd=1.38u as=0 ps=0 w=1u l=1u
X1224 VSS.t1286 VDD VSS.t1285 VSS.t248 sg13_lv_nmos ad=0.1428p pd=1.52u as=0 ps=0 w=0.42u l=1u
X1225 VSS.t1502 VDD VSS.t1501 VSS.t1500 sg13_lv_nmos ad=0.1428p pd=1.52u as=0 ps=0 w=0.42u l=1u
X1226 VSS.t118 VDD VSS.t118 VSS.t396 sg13_lv_nmos ad=0.1428p pd=1.52u as=0 ps=0 w=0.42u l=1u
X1227 VDD VSS.t323 VDD VDD sg13_lv_pmos ad=0.34p pd=2.68u as=0 ps=0 w=1u l=1u
X1228 a_6372_14488# a_6891_14495# a_7631_14845# VSS.t120 sg13_lv_nmos ad=0.3473p pd=2.71u as=0.12665p ps=1.145u w=0.74u l=0.13u
X1229 VSS.t2750 VDD VSS.t2751 VSS.t199 sg13_lv_nmos ad=79.8f pd=0.8u as=0 ps=0 w=0.42u l=1u
X1230 VDD VSS.t26 VDD VDD sg13_lv_pmos ad=0.19p pd=1.38u as=0 ps=0 w=1u l=1u
X1231 a_20278_14862# sg13cmos5l_or3_1_2.C VSS.t88 VSS.t52 sg13_lv_nmos ad=0.1406p pd=1.12u as=0.1406p ps=1.12u w=0.74u l=0.15u
X1232 a_27634_14922# sg13cmos5l_dfrbpq_1_7.RESET_B VSS.t19 VSS.t19 sg13_lv_nmos ad=37.8f pd=0.6u as=79.8f ps=0.8u w=0.42u l=0.13u
X1233 VSS.t17 sg13cmos5l_xnor2_1_2.B a_6575_13342# VSS.t3260 sg13_lv_nmos ad=0.1898p pd=1.36u as=0.1406p ps=1.12u w=0.74u l=0.13u
X1234 VDD VSS.t1210 VDD VDD sg13_lv_pmos ad=0.34p pd=2.68u as=0 ps=0 w=1u l=1u
X1235 VDD VSS.t1983 VDD VDD sg13_lv_pmos ad=0.34p pd=2.68u as=0 ps=0 w=1u l=1u
X1236 VSS.t102 VDD VSS.t640 VSS.t779 sg13_lv_nmos ad=79.8f pd=0.8u as=0 ps=0 w=0.42u l=1u
X1237 VDD VSS.t1268 VDD VDD sg13_lv_pmos ad=0.34p pd=2.68u as=0 ps=0 w=1u l=1u
X1238 VDD VSS.t3141 VDD VDD sg13_lv_pmos ad=0.19p pd=1.38u as=0 ps=0 w=1u l=1u
X1239 VSS.t992 VDD VSS.t994 VSS.t993 sg13_lv_nmos ad=79.8f pd=0.8u as=0 ps=0 w=0.42u l=1u
X1240 VSS.t1037 VDD VSS.t1036 VSS.t1035 sg13_lv_nmos ad=0.1428p pd=1.52u as=0 ps=0 w=0.42u l=1u
X1241 VSS.t2954 VDD VSS.t2953 VSS.t2952 sg13_lv_nmos ad=0.1428p pd=1.52u as=0 ps=0 w=0.42u l=1u
X1242 VSS.t490 VDD VSS.t489 VSS.t19 sg13_lv_nmos ad=0.1428p pd=1.52u as=0 ps=0 w=0.42u l=1u
X1243 a_7888_14726# a_7631_14845# a_8050_14922# VSS.t3281 sg13_lv_nmos ad=0.1428p pd=1.52u as=37.8f ps=0.6u w=0.42u l=0.13u
X1244 VSS.t1385 VDD VSS.t1227 VSS.t248 sg13_lv_nmos ad=0.1428p pd=1.52u as=0 ps=0 w=0.42u l=1u
X1245 VSS.t3124 VDD VSS.t3126 VSS.t3125 sg13_lv_nmos ad=79.8f pd=0.8u as=0 ps=0 w=0.42u l=1u
X1246 VSS.t2336 VDD VSS.t2338 VSS.t2337 sg13_lv_nmos ad=79.8f pd=0.8u as=0 ps=0 w=0.42u l=1u
X1247 VSS.t19 a_18665_15180# a_18586_15455# VSS.t18 sg13_lv_nmos ad=4.11262p pd=27.15u as=0.27427p ps=2.28u w=0.795u l=0.13u
X1248 VDD VSS.t476 VDD VDD sg13_lv_pmos ad=0.19p pd=1.38u as=0 ps=0 w=1u l=1u
X1249 VDD VSS.t2350 VDD VDD sg13_lv_pmos ad=0.34p pd=2.68u as=0 ps=0 w=1u l=1u
X1250 VDD VSS.t1496 VDD VDD sg13_lv_pmos ad=0.34p pd=2.68u as=0 ps=0 w=1u l=1u
X1251 VDD a_10703_15311# a_11370_15532# VDD sg13_lv_pmos ad=0.2128p pd=1.5u as=0.3864p ps=2.93u w=1.12u l=0.13u
X1252 VSS.t440 sg13cmos5l_buf_8_2.A a_12010_15202# VSS.t3284 sg13_lv_nmos ad=0.1406p pd=1.12u as=0.1406p ps=1.12u w=0.74u l=0.13u
X1253 VSS.t2411 VDD VSS.t2413 VSS.t2412 sg13_lv_nmos ad=79.8f pd=0.8u as=0 ps=0 w=0.42u l=1u
X1254 VDD VSS.t2475 VDD VDD sg13_lv_pmos ad=0.34p pd=2.68u as=0 ps=0 w=1u l=1u
X1255 VSS.t1959 VDD VSS.t1958 VSS.t1957 sg13_lv_nmos ad=0.1428p pd=1.52u as=0 ps=0 w=0.42u l=1u
X1256 VSS.t2734 VDD VSS.t2733 VSS.t199 sg13_lv_nmos ad=0.1428p pd=1.52u as=0 ps=0 w=0.42u l=1u
X1257 VDD VSS.t2677 VDD VDD sg13_lv_pmos ad=0.34p pd=2.68u as=0 ps=0 w=1u l=1u
X1258 VSS.t630 VDD VSS.t630 VSS.t631 sg13_lv_nmos ad=0.1428p pd=1.52u as=0 ps=0 w=0.42u l=1u
X1259 VDD VSS.t1631 VDD VDD sg13_lv_pmos ad=0.34p pd=2.68u as=0 ps=0 w=1u l=1u
X1260 VSS.t389 VDD VSS.t388 VSS.t387 sg13_lv_nmos ad=0.1428p pd=1.52u as=0 ps=0 w=0.42u l=1u
X1261 a_25862_13722# a_26667_13844# a_26122_13945# VDD sg13_lv_pmos ad=0.1428p pd=1.52u as=79.8f ps=0.8u w=0.42u l=0.13u
X1262 VSS.t912 VDD VSS.t914 VSS.t913 sg13_lv_nmos ad=79.8f pd=0.8u as=0 ps=0 w=0.42u l=1u
X1263 VDD VSS.t2051 VDD VDD sg13_lv_pmos ad=0.19p pd=1.38u as=0 ps=0 w=1u l=1u
X1264 VSS.t3 VDD VSS.t3 VSS.t2 sg13_lv_nmos ad=0.1428p pd=1.52u as=0 ps=0 w=0.42u l=1u
X1265 VDD VSS.t300 VDD VDD sg13_lv_pmos ad=0.34p pd=2.68u as=0 ps=0 w=1u l=1u
X1266 VDD VSS.t1221 VDD VDD sg13_lv_pmos ad=0.34p pd=2.68u as=0 ps=0 w=1u l=1u
X1267 VDD VSS.t1323 VDD VDD sg13_lv_pmos ad=0.19p pd=1.38u as=0 ps=0 w=1u l=1u
X1268 VDD a_27664_13942# a_27609_14037# VDD sg13_lv_pmos ad=2.42015p pd=15.68u as=93.45f ps=0.865u w=0.42u l=0.13u
X1269 VSS.t2728 VDD VSS.t2727 VSS.t199 sg13_lv_nmos ad=0.1428p pd=1.52u as=0 ps=0 w=0.42u l=1u
X1270 VDD VSS.t1056 VDD VDD sg13_lv_pmos ad=0.34p pd=2.68u as=0 ps=0 w=1u l=1u
X1271 VDD VSS.t3058 VDD VDD sg13_lv_pmos ad=0.34p pd=2.68u as=0 ps=0 w=1u l=1u
X1272 VSS.t2795 VDD VSS.t2794 VSS.t199 sg13_lv_nmos ad=0.1428p pd=1.52u as=0 ps=0 w=0.42u l=1u
X1273 VSS.t2059 VDD VSS.t2061 VSS.t2060 sg13_lv_nmos ad=79.8f pd=0.8u as=0 ps=0 w=0.42u l=1u
X1274 VSS.t9 a_17327_13799# a_17994_14020# VSS.t8 sg13_lv_nmos ad=0.1406p pd=1.12u as=0.2516p ps=2.16u w=0.74u l=0.13u
X1275 VSS.t3144 VDD VSS.t3146 VSS.t3145 sg13_lv_nmos ad=79.8f pd=0.8u as=0 ps=0 w=0.42u l=1u
X1276 sg13cmos5l_and2_1_2.B a_8694_15302# VSS.t3 VSS.t54 sg13_lv_nmos ad=0.2516p pd=2.16u as=0.1426p ps=1.16u w=0.74u l=0.13u
X1277 VDD VSS.t664 VDD VDD sg13_lv_pmos ad=0.34p pd=2.68u as=0 ps=0 w=1u l=1u
X1278 VDD VSS.t2508 VDD VDD sg13_lv_pmos ad=0.19p pd=1.38u as=0 ps=0 w=1u l=1u
X1279 VSS.t1362 VDD VSS.t1361 VSS.t248 sg13_lv_nmos ad=0.1428p pd=1.52u as=0 ps=0 w=0.42u l=1u
X1280 VDD VSS.t1689 VDD VDD sg13_lv_pmos ad=0.19p pd=1.38u as=0 ps=0 w=1u l=1u
X1281 VSS.t1562 VDD VSS.t1561 VSS.t1560 sg13_lv_nmos ad=0.1428p pd=1.52u as=0 ps=0 w=0.42u l=1u
X1282 VSS.t1979 VDD VSS.t1978 VSS.t1977 sg13_lv_nmos ad=0.1428p pd=1.52u as=0 ps=0 w=0.42u l=1u
X1283 VSS.t767 VDD VSS.t34 VSS.t766 sg13_lv_nmos ad=0.1428p pd=1.52u as=0 ps=0 w=0.42u l=1u
X1284 VDD VSS.t2688 VDD VDD sg13_lv_pmos ad=0.34p pd=2.68u as=0 ps=0 w=1u l=1u
X1285 VSS.t21 a_22025_16334# a_21946_16237# VSS.t212 sg13_lv_nmos ad=7.70437p pd=50.66u as=0.27427p ps=2.28u w=0.795u l=0.13u
X1286 VSS.t1355 VDD VSS.t1356 VSS.t248 sg13_lv_nmos ad=79.8f pd=0.8u as=0 ps=0 w=0.42u l=1u
X1287 VDD VSS.t2784 VDD VDD sg13_lv_pmos ad=0.19p pd=1.38u as=0 ps=0 w=1u l=1u
X1288 VSS.t2089 VDD VSS.t2088 VSS.t2087 sg13_lv_nmos ad=0.1428p pd=1.52u as=0 ps=0 w=0.42u l=1u
X1289 VSS.t45 VDD VSS.t45 VSS.t409 sg13_lv_nmos ad=0.1428p pd=1.52u as=0 ps=0 w=0.42u l=1u
X1290 VSS.t882 VDD VSS.t881 VSS.t880 sg13_lv_nmos ad=0.1428p pd=1.52u as=0 ps=0 w=0.42u l=1u
X1291 VDD VSS.t934 VDD VDD sg13_lv_pmos ad=0.19p pd=1.38u as=0 ps=0 w=1u l=1u
X1292 VDD VSS.t2378 VDD VDD sg13_lv_pmos ad=0.19p pd=1.38u as=0 ps=0 w=1u l=1u
X1293 VDD VSS.t2036 VDD VDD sg13_lv_pmos ad=0.19p pd=1.38u as=0 ps=0 w=1u l=1u
X1294 VDD a_27215_14845# a_27882_14484# VDD sg13_lv_pmos ad=0.2128p pd=1.5u as=0.3864p ps=2.93u w=1.12u l=0.13u
X1295 VSS.t2702 VDD VSS.t2700 VSS.t199 sg13_lv_nmos ad=0.1428p pd=1.52u as=0 ps=0 w=0.42u l=1u
X1296 VSS.t287 a_2540_15960# counter_value_o[0] VSS.t3275 sg13_lv_nmos ad=0.14875p pd=1.16u as=0.2886p ps=2.26u w=0.74u l=0.13u
X1297 a_12010_15202# sg13cmos5l_buf_8_2.A VDD VDD sg13_lv_pmos ad=0.3808p pd=2.92u as=0.2128p ps=1.5u w=1.12u l=0.13u
X1298 VSS.t664 VDD VSS.t667 VSS.t797 sg13_lv_nmos ad=79.8f pd=0.8u as=0 ps=0 w=0.42u l=1u
X1299 VSS.t2396 VDD VSS.t2398 VSS.t2397 sg13_lv_nmos ad=79.8f pd=0.8u as=0 ps=0 w=0.42u l=1u
X1300 VDD VSS.t2161 VDD VDD sg13_lv_pmos ad=0.19p pd=1.38u as=0 ps=0 w=1u l=1u
X1301 a_25670_14922# a_26475_14495# a_25930_14452# VDD sg13_lv_pmos ad=0.1428p pd=1.52u as=79.8f ps=0.8u w=0.42u l=0.13u
X1302 VDD a_19323_13726# sg13cmos5l_buf_8_2.X VDD sg13_lv_pmos ad=0.3864p pd=2.93u as=0.2128p ps=1.5u w=1.12u l=0.13u
X1303 VSS.t1037 VDD VSS.t1036 VSS.t1035 sg13_lv_nmos ad=0.1428p pd=1.52u as=0 ps=0 w=0.42u l=1u
X1304 VDD VSS.t1019 VDD VDD sg13_lv_pmos ad=0.19p pd=1.38u as=0 ps=0 w=1u l=1u
X1305 VSS.t200 enable_i a_1192_3900# VSS.t199 sg13_lv_nmos ad=0.14875p pd=1.16u as=0.187p ps=1.78u w=0.55u l=0.13u
X1306 VSS.t1249 VDD VSS.t1250 VSS.t248 sg13_lv_nmos ad=79.8f pd=0.8u as=0 ps=0 w=0.42u l=1u
X1307 VDD VSS.t1494 VDD VDD sg13_lv_pmos ad=0.19p pd=1.38u as=0 ps=0 w=1u l=1u
X1308 VSS.t313 VDD VSS.t312 VSS.t311 sg13_lv_nmos ad=0.1428p pd=1.52u as=0 ps=0 w=0.42u l=1u
X1309 VSS.t114 VDD VSS.t41 VSS.t438 sg13_lv_nmos ad=0.1428p pd=1.52u as=0 ps=0 w=0.42u l=1u
X1310 VSS.t2939 VDD VSS.t2938 VSS.t2937 sg13_lv_nmos ad=0.1428p pd=1.52u as=0 ps=0 w=0.42u l=1u
X1311 VDD VSS.t414 VDD VDD sg13_lv_pmos ad=0.19p pd=1.38u as=0 ps=0 w=1u l=1u
X1312 sg13cmos5l_dfrbpq_1_5.D a_25206_14508# VDD VDD sg13_lv_pmos ad=0.4256p pd=3u as=0.2254p ps=1.53u w=1.12u l=0.13u
X1313 VDD sg13cmos5l_or3_1_1.A a_25037_14020# VDD sg13_lv_pmos ad=0.3822p pd=1.84u as=0.1575p ps=1.315u w=1u l=0.13u
X1314 VDD VSS.t1333 VDD VDD sg13_lv_pmos ad=0.34p pd=2.68u as=0 ps=0 w=1u l=1u
X1315 VDD VSS.t2528 VDD VDD sg13_lv_pmos ad=0.19p pd=1.38u as=0 ps=0 w=1u l=1u
X1316 VSS.t3278 sg13cmos5l_o21ai_1_2.B1 a_24169_14508# VSS.t0 sg13_lv_nmos ad=0.13395p pd=1.12u as=0.198p ps=1.27u w=0.55u l=0.13u
X1317 VDD VSS.t627 VDD VDD sg13_lv_pmos ad=0.19p pd=1.38u as=0 ps=0 w=1u l=1u
X1318 VDD VSS.t2709 VDD VDD sg13_lv_pmos ad=0.34p pd=2.68u as=0 ps=0 w=1u l=1u
X1319 VSS.t13 sg13cmos5l_a21oi_1_0.A2 a_17057_14832# VSS.t3238 sg13_lv_nmos ad=0.2516p pd=2.16u as=0.1406p ps=1.12u w=0.74u l=0.13u
X1320 VSS.t1512 VDD VSS.t1511 VSS.t1510 sg13_lv_nmos ad=0.1428p pd=1.52u as=0 ps=0 w=0.42u l=1u
X1321 VSS.t842 VDD VSS.t844 VSS.t843 sg13_lv_nmos ad=79.8f pd=0.8u as=0 ps=0 w=0.42u l=1u
X1322 VSS.t2074 VDD VSS.t2073 VSS.t2072 sg13_lv_nmos ad=0.1428p pd=1.52u as=0 ps=0 w=0.42u l=1u
X1323 a_4594_15234# sg13cmos5l_dfrbpq_1_0.RESET_B VSS.t41 VSS.t193 sg13_lv_nmos ad=37.8f pd=0.6u as=79.8f ps=0.8u w=0.42u l=0.13u
X1324 VSS.t13 a_17806_15423# sg13cmos5l_inv_1_0.A VSS.t235 sg13_lv_nmos ad=0.1426p pd=1.16u as=0.2516p ps=2.16u w=0.74u l=0.13u
X1325 a_5707_14832# sg13cmos5l_buf_1_10.X a_5613_14832# VSS.t189 sg13_lv_nmos ad=0.1216p pd=1.02u as=0.2176p ps=1.96u w=0.64u l=0.13u
X1326 VSS.t912 VDD VSS.t914 VSS.t913 sg13_lv_nmos ad=79.8f pd=0.8u as=0 ps=0 w=0.42u l=1u
X1327 VDD VSS.t901 VDD VDD sg13_lv_pmos ad=0.34p pd=2.68u as=0 ps=0 w=1u l=1u
X1328 sg13cmos5l_and2_1_2.X a_8685_14832# VDD VDD sg13_lv_pmos ad=0.3808p pd=2.92u as=0.1918p ps=1.5u w=1.12u l=0.13u
X1329 VSS.t1507 VDD VSS.t1506 VSS.t1505 sg13_lv_nmos ad=0.1428p pd=1.52u as=0 ps=0 w=0.42u l=1u
X1330 VSS.t2416 VDD VSS.t2415 VSS.t2414 sg13_lv_nmos ad=0.1428p pd=1.52u as=0 ps=0 w=0.42u l=1u
X1331 a_6598_14909# sg13cmos5l_dfrbpq_1_1.RESET_B VSS.t114 VSS.t3224 sg13_lv_nmos ad=37.8f pd=0.6u as=0.1701p ps=1.65u w=0.42u l=0.13u
X1332 VSS.t646 VDD VSS.t646 VSS.t784 sg13_lv_nmos ad=0.1428p pd=1.52u as=0 ps=0 w=0.42u l=1u
X1333 VSS.t1677 VDD VSS.t1679 VSS.t1678 sg13_lv_nmos ad=79.8f pd=0.8u as=0 ps=0 w=0.42u l=1u
X1334 VSS.t2693 VDD VSS.t2692 VSS.t199 sg13_lv_nmos ad=0.1428p pd=1.52u as=0 ps=0 w=0.42u l=1u
X1335 VDD VSS.t47 VDD VDD sg13_lv_pmos ad=0.19p pd=1.38u as=0 ps=0 w=1u l=1u
X1336 VDD VSS.t1373 VDD VDD sg13_lv_pmos ad=0.34p pd=2.68u as=0 ps=0 w=1u l=1u
X1337 VDD VSS.t1988 VDD VDD sg13_lv_pmos ad=0.34p pd=2.68u as=0 ps=0 w=1u l=1u
X1338 a_9444_15552# a_9418_15457# VDD VDD sg13_lv_pmos ad=0.34p pd=2.68u as=0.36237p ps=2.605u w=1u l=0.13u
X1339 VSS.t108 a_26170_15202# a_25889_15424# VSS.t182 sg13_lv_nmos ad=79.8f pd=0.8u as=0.1428p ps=1.52u w=0.42u l=0.5u
X1340 VDD VSS.t3111 VDD VDD sg13_lv_pmos ad=0.19p pd=1.38u as=0 ps=0 w=1u l=1u
X1341 VDD VSS.t2323 VDD VDD sg13_lv_pmos ad=0.19p pd=1.38u as=0 ps=0 w=1u l=1u
X1342 VDD a_19323_13726# sg13cmos5l_buf_8_2.X VDD sg13_lv_pmos ad=0.2128p pd=1.5u as=0.2128p ps=1.5u w=1.12u l=0.13u
X1343 VDD VSS.t964 VDD VDD sg13_lv_pmos ad=0.19p pd=1.38u as=0 ps=0 w=1u l=1u
X1344 VSS.t1223 VDD VSS.t1222 VSS.t248 sg13_lv_nmos ad=0.1428p pd=1.52u as=0 ps=0 w=0.42u l=1u
X1345 VSS.t3129 VDD VSS.t3131 VSS.t3130 sg13_lv_nmos ad=79.8f pd=0.8u as=0 ps=0 w=0.42u l=1u
X1346 VSS.t2044 VDD VSS.t2046 VSS.t2045 sg13_lv_nmos ad=79.8f pd=0.8u as=0 ps=0 w=0.42u l=1u
X1347 VSS.t2769 VDD VSS.t2768 VSS.t199 sg13_lv_nmos ad=0.1428p pd=1.52u as=0 ps=0 w=0.42u l=1u
X1348 VDD VSS.t2355 VDD VDD sg13_lv_pmos ad=0.34p pd=2.68u as=0 ps=0 w=1u l=1u
X1349 VDD VSS.t1674 VDD VDD sg13_lv_pmos ad=0.19p pd=1.38u as=0 ps=0 w=1u l=1u
X1350 VSS.t882 VDD VSS.t881 VSS.t880 sg13_lv_nmos ad=0.1428p pd=1.52u as=0 ps=0 w=0.42u l=1u
X1351 VDD VSS.t864 VDD VDD sg13_lv_pmos ad=0.19p pd=1.38u as=0 ps=0 w=1u l=1u
X1352 VSS.t1964 VDD VSS.t1963 VSS.t1962 sg13_lv_nmos ad=0.1428p pd=1.52u as=0 ps=0 w=0.42u l=1u
X1353 sg13cmos5l_nand4_1_0.Y sg13cmos5l_buf_1_0.X VDD VDD sg13_lv_pmos ad=0.2128p pd=1.5u as=0.2128p ps=1.5u w=1.12u l=0.13u
X1354 a_6578_15242# sg13cmos5l_dlygate4sd3_1_3.A VSS.t114 VSS.t288 sg13_lv_nmos ad=0.1406p pd=1.12u as=0.2886p ps=2.26u w=0.74u l=0.13u
X1355 VSS.t460 VDD VSS.t461 VSS.t19 sg13_lv_nmos ad=79.8f pd=0.8u as=0 ps=0 w=0.42u l=1u
X1356 VDD VSS.t1626 VDD VDD sg13_lv_pmos ad=0.34p pd=2.68u as=0 ps=0 w=1u l=1u
X1357 VSS.t2717 VDD VSS.t2716 VSS.t199 sg13_lv_nmos ad=0.1428p pd=1.52u as=0 ps=0 w=0.42u l=1u
X1358 VDD VSS.t2679 VDD VDD sg13_lv_pmos ad=0.34p pd=2.68u as=0 ps=0 w=1u l=1u
X1359 VDD a_18106_15960# a_17825_16262# VDD sg13_lv_pmos ad=0.1523p pd=1.38u as=0.34p ps=2.68u w=1u l=0.5u
X1360 VDD VSS.t399 VDD VDD sg13_lv_pmos ad=0.34p pd=2.68u as=0 ps=0 w=1u l=1u
X1361 VDD VSS.t979 VDD VDD sg13_lv_pmos ad=0.19p pd=1.38u as=0 ps=0 w=1u l=1u
X1362 a_18863_14845# a_18021_14495# a_17604_14488# VDD sg13_lv_pmos ad=0.2048p pd=1.63u as=0.34p ps=2.68u w=1u l=0.13u
X1363 VSS.t1271 VDD VSS.t1270 VSS.t248 sg13_lv_nmos ad=0.1428p pd=1.52u as=0 ps=0 w=0.42u l=1u
X1364 VDD VSS.t2540 VDD VDD sg13_lv_pmos ad=0.34p pd=2.68u as=0 ps=0 w=1u l=1u
X1365 VDD VSS.t2363 VDD VDD sg13_lv_pmos ad=0.19p pd=1.38u as=0 ps=0 w=1u l=1u
X1366 VSS.t1697 VDD VSS.t1699 VSS.t1698 sg13_lv_nmos ad=79.8f pd=0.8u as=0 ps=0 w=0.42u l=1u
X1367 VSS.t555 VDD VSS.t555 VSS.t558 sg13_lv_nmos ad=0.1428p pd=1.52u as=0 ps=0 w=0.42u l=1u
X1368 VSS.t39 a_27215_14845# a_27882_14484# VSS.t19 sg13_lv_nmos ad=0.1406p pd=1.12u as=0.2516p ps=2.16u w=0.74u l=0.13u
X1369 VDD VSS.t2784 VDD VDD sg13_lv_pmos ad=0.34p pd=2.68u as=0 ps=0 w=1u l=1u
X1370 VSS.t1314 VDD VSS.t1313 VSS.t248 sg13_lv_nmos ad=0.1428p pd=1.52u as=0 ps=0 w=0.42u l=1u
X1371 VDD VSS.t1326 VDD VDD sg13_lv_pmos ad=0.19p pd=1.38u as=0 ps=0 w=1u l=1u
X1372 VDD VSS.t2146 VDD VDD sg13_lv_pmos ad=0.19p pd=1.38u as=0 ps=0 w=1u l=1u
X1373 VSS.t254 VDD VSS.t50 VSS.t565 sg13_lv_nmos ad=79.8f pd=0.8u as=0 ps=0 w=0.42u l=1u
X1374 VSS.t655 VDD VSS.t655 VSS.t656 sg13_lv_nmos ad=79.8f pd=0.8u as=0 ps=0 w=0.42u l=1u
X1375 sg13cmos5l_a21oi_1_3.Y sg13cmos5l_a21oi_1_3.B1 a_25109_12972# VDD sg13_lv_pmos ad=0.3808p pd=2.92u as=0.2128p ps=1.5u w=1.12u l=0.13u
X1376 VSS.t1012 VDD VSS.t1014 VSS.t1013 sg13_lv_nmos ad=79.8f pd=0.8u as=0 ps=0 w=0.42u l=1u
X1377 a_26373_16033# a_26373_16033# VSS.t21 VSS.t228 sg13_lv_nmos ad=0.111p pd=1.34u as=7.70437p ps=50.66u w=0.3u l=0.13u
X1378 a_4377_15549# a_3435_15356# a_4175_15311# VDD sg13_lv_pmos ad=93.45f pd=0.865u as=0.2048p ps=1.63u w=0.42u l=0.13u
X1379 VSS.t469 VDD VSS.t470 VSS.t19 sg13_lv_nmos ad=79.8f pd=0.8u as=0 ps=0 w=0.42u l=1u
X1380 VDD VSS.t3063 VDD VDD sg13_lv_pmos ad=0.34p pd=2.68u as=0 ps=0 w=1u l=1u
X1381 VSS.t2276 VDD VSS.t2278 VSS.t2277 sg13_lv_nmos ad=79.8f pd=0.8u as=0 ps=0 w=0.42u l=1u
X1382 VDD VSS.t2513 VDD VDD sg13_lv_pmos ad=0.19p pd=1.38u as=0 ps=0 w=1u l=1u
X1383 VSS.t842 VDD VSS.t844 VSS.t843 sg13_lv_nmos ad=79.8f pd=0.8u as=0 ps=0 w=0.42u l=1u
X1384 VDD VSS.t1694 VDD VDD sg13_lv_pmos ad=0.19p pd=1.38u as=0 ps=0 w=1u l=1u
X1385 VSS.t334 VDD VSS.t31 VSS.t333 sg13_lv_nmos ad=0.1428p pd=1.52u as=0 ps=0 w=0.42u l=1u
X1386 VDD VSS.t297 VDD VDD sg13_lv_pmos ad=0.19p pd=1.38u as=0 ps=0 w=1u l=1u
X1387 VSS.t1497 VDD VSS.t1496 VSS.t1495 sg13_lv_nmos ad=0.1428p pd=1.52u as=0 ps=0 w=0.42u l=1u
X1388 a_7680_15549# sg13cmos5l_nand3_1_0.Y a_7643_15280# VSS.t3252 sg13_lv_nmos ad=0.2176p pd=1.96u as=78.39999f ps=0.885u w=0.64u l=0.13u
X1389 sg13cmos5l_dfrbpq_1_6.Q a_22986_14484# VDD VDD sg13_lv_pmos ad=0.3808p pd=2.92u as=0.2128p ps=1.5u w=1.12u l=0.13u
X1390 VSS.t1323 VDD VSS.t1322 VSS.t248 sg13_lv_nmos ad=0.1428p pd=1.52u as=0 ps=0 w=0.42u l=1u
X1391 VDD VSS.t2672 VDD VDD sg13_lv_pmos ad=0.34p pd=2.68u as=0 ps=0 w=1u l=1u
X1392 VDD VSS.t1247 VDD VDD sg13_lv_pmos ad=0.34p pd=2.68u as=0 ps=0 w=1u l=1u
X1393 VSS.t2059 VDD VSS.t2058 VSS.t2057 sg13_lv_nmos ad=0.1428p pd=1.52u as=0 ps=0 w=0.42u l=1u
X1394 VSS.t1492 VDD VSS.t1491 VSS.t1490 sg13_lv_nmos ad=0.1428p pd=1.52u as=0 ps=0 w=0.42u l=1u
X1395 VDD VSS.t1219 VDD VDD sg13_lv_pmos ad=0.19p pd=1.38u as=0 ps=0 w=1u l=1u
X1396 VSS.t2684 VDD VSS.t2683 VSS.t199 sg13_lv_nmos ad=0.1428p pd=1.52u as=0 ps=0 w=0.42u l=1u
X1397 VSS.t323 VDD VSS.t318 VSS.t322 sg13_lv_nmos ad=0.1428p pd=1.52u as=0 ps=0 w=0.42u l=1u
X1398 sg13cmos5l_dfrbpq_1_3.D a_17238_15302# VSS.t13 VSS.t238 sg13_lv_nmos ad=0.2516p pd=2.16u as=0.1426p ps=1.16u w=0.74u l=0.13u
X1399 VSS.t1328 VDD VSS.t1327 VSS.t248 sg13_lv_nmos ad=0.1428p pd=1.52u as=0 ps=0 w=0.42u l=1u
X1400 VSS.t2745 VDD VSS.t2746 VSS.t199 sg13_lv_nmos ad=79.8f pd=0.8u as=0 ps=0 w=0.42u l=1u
X1401 VSS.t2401 VDD VSS.t2403 VSS.t2402 sg13_lv_nmos ad=79.8f pd=0.8u as=0 ps=0 w=0.42u l=1u
X1402 VDD VSS.t3096 VDD VDD sg13_lv_pmos ad=0.19p pd=1.38u as=0 ps=0 w=1u l=1u
X1403 VSS.t2496 VDD VSS.t2495 VSS.t2494 sg13_lv_nmos ad=0.1428p pd=1.52u as=0 ps=0 w=0.42u l=1u
X1404 VDD VSS.t2308 VDD VDD sg13_lv_pmos ad=0.19p pd=1.38u as=0 ps=0 w=1u l=1u
X1405 a_9444_15552# a_9418_15457# VSS.t3 VSS.t2 sg13_lv_nmos ad=0.2516p pd=2.16u as=0.1626p ps=1.415u w=0.74u l=0.13u
X1406 VSS.t92 VDD VSS.t34 VSS.t765 sg13_lv_nmos ad=79.8f pd=0.8u as=0 ps=0 w=0.42u l=1u
X1407 VDD VSS.t640 VDD VDD sg13_lv_pmos ad=0.34p pd=2.68u as=0 ps=0 w=1u l=1u
X1408 VSS.t446 VDD VSS.t65 VSS.t48 sg13_lv_nmos ad=0.1428p pd=1.52u as=0 ps=0 w=0.42u l=1u
X1409 sg13cmos5l_a21oi_1_3.B1 sg13cmos5l_buf_1_10.X VSS.t143 VSS.t191 sg13_lv_nmos ad=0.2516p pd=2.16u as=0.2516p ps=2.16u w=0.74u l=0.13u
X1410 VSS.t2761 VDD VSS.t2760 VSS.t199 sg13_lv_nmos ad=0.1428p pd=1.52u as=0 ps=0 w=0.42u l=1u
X1411 VDD VSS.t615 VDD VDD sg13_lv_pmos ad=0.19p pd=1.38u as=0 ps=0 w=1u l=1u
X1412 VSS.t1042 VDD VSS.t1044 VSS.t1043 sg13_lv_nmos ad=79.8f pd=0.8u as=0 ps=0 w=0.42u l=1u
X1413 VDD VSS.t2498 VDD VDD sg13_lv_pmos ad=0.19p pd=1.38u as=0 ps=0 w=1u l=1u
X1414 VSS.t90 sg13cmos5l_nor2_1_0.B sg13cmos5l_dfrbpq_1_2.D VSS.t129 sg13_lv_nmos ad=0.2516p pd=2.16u as=0.1406p ps=1.12u w=0.74u l=0.13u
X1415 VDD VSS.t1227 VDD VDD sg13_lv_pmos ad=0.19p pd=1.38u as=0 ps=0 w=1u l=1u
X1416 VDD sg13cmos5l_xor2_1_0.B a_2516_14484# VDD sg13_lv_pmos ad=0.2128p pd=1.5u as=0.2128p ps=1.5u w=1.12u l=0.13u
X1417 a_20774_14922# sg13cmos5l_dfrbpq_1_6.D VDD VDD sg13_lv_pmos ad=79.8f pd=0.8u as=0.1428p ps=1.52u w=0.42u l=0.13u
X1418 VSS.t1687 VDD VSS.t1689 VSS.t1688 sg13_lv_nmos ad=79.8f pd=0.8u as=0 ps=0 w=0.42u l=1u
X1419 VSS.t3209 VDD VSS.t3211 VSS.t3210 sg13_lv_nmos ad=79.8f pd=0.8u as=0 ps=0 w=0.42u l=1u
X1420 VDD VSS.t1611 VDD VDD sg13_lv_pmos ad=0.34p pd=2.68u as=0 ps=0 w=1u l=1u
X1421 VSS.t2079 VDD VSS.t2078 VSS.t2077 sg13_lv_nmos ad=0.1428p pd=1.52u as=0 ps=0 w=0.42u l=1u
X1422 a_17327_13799# a_16485_13701# a_17233_13799# VSS.t3295 sg13_lv_nmos ad=0.12665p pd=1.145u as=0.1428p ps=1.52u w=0.42u l=0.13u
X1423 VDD VSS.t118 VDD VDD sg13_lv_pmos ad=0.34p pd=2.68u as=0 ps=0 w=1u l=1u
X1424 VDD VSS.t2525 VDD VDD sg13_lv_pmos ad=0.34p pd=2.68u as=0 ps=0 w=1u l=1u
X1425 VDD VSS.t846 VDD VDD sg13_lv_pmos ad=0.34p pd=2.68u as=0 ps=0 w=1u l=1u
X1426 VSS.t1682 VDD VSS.t1684 VSS.t1683 sg13_lv_nmos ad=79.8f pd=0.8u as=0 ps=0 w=0.42u l=1u
X1427 VSS.t1341 VDD VSS.t1340 VSS.t248 sg13_lv_nmos ad=0.1428p pd=1.52u as=0 ps=0 w=0.42u l=1u
X1428 VDD VSS.t2553 VDD VDD sg13_lv_pmos ad=0.19p pd=1.38u as=0 ps=0 w=1u l=1u
X1429 VSS.t1012 VDD VSS.t1014 VSS.t1013 sg13_lv_nmos ad=79.8f pd=0.8u as=0 ps=0 w=0.42u l=1u
X1430 VDD VSS.t1216 VDD VDD sg13_lv_pmos ad=0.34p pd=2.68u as=0 ps=0 w=1u l=1u
X1431 VDD VSS.t1993 VDD VDD sg13_lv_pmos ad=0.34p pd=2.68u as=0 ps=0 w=1u l=1u
X1432 VSS.t56 a_21562_15960# a_21281_16262# VSS.t75 sg13_lv_nmos ad=79.8f pd=0.8u as=0.1428p ps=1.52u w=0.42u l=0.5u
X1433 VSS.t394 VDD VSS.t393 VSS.t392 sg13_lv_nmos ad=0.1428p pd=1.52u as=0 ps=0 w=0.42u l=1u
X1434 a_2490_14447# sg13cmos5l_xor2_1_0.B VSS.t165 VSS.t164 sg13_lv_nmos ad=0.17462p pd=1.185u as=0.15245p ps=1.17u w=0.55u l=0.13u
X1435 VDD VSS.t3116 VDD VDD sg13_lv_pmos ad=0.19p pd=1.38u as=0 ps=0 w=1u l=1u
X1436 VDD VSS.t2328 VDD VDD sg13_lv_pmos ad=0.19p pd=1.38u as=0 ps=0 w=1u l=1u
X1437 VSS.t2159 VDD VSS.t2161 VSS.t2160 sg13_lv_nmos ad=79.8f pd=0.8u as=0 ps=0 w=0.42u l=1u
X1438 VSS.t362 VDD VSS.t361 VSS.t360 sg13_lv_nmos ad=0.1428p pd=1.52u as=0 ps=0 w=0.42u l=1u
X1439 sg13cmos5l_and2_1_1.X a_5613_14832# VDD VDD sg13_lv_pmos ad=0.3808p pd=2.92u as=0.1918p ps=1.5u w=1.12u l=0.13u
X1440 VDD VSS.t488 VDD VDD sg13_lv_pmos ad=0.19p pd=1.38u as=0 ps=0 w=1u l=1u
X1441 VDD VSS.t899 VDD VDD sg13_lv_pmos ad=0.19p pd=1.38u as=0 ps=0 w=1u l=1u
X1442 VSS.t2753 VDD VSS.t2752 VSS.t199 sg13_lv_nmos ad=0.1428p pd=1.52u as=0 ps=0 w=0.42u l=1u
X1443 VSS.t118 a_27500_15960# counter_value_o[5] VSS.t117 sg13_lv_nmos ad=0.14875p pd=1.16u as=0.2886p ps=2.26u w=0.74u l=0.13u
X1444 VDD VSS.t1064 VDD VDD sg13_lv_pmos ad=0.19p pd=1.38u as=0 ps=0 w=1u l=1u
X1445 VDD VSS.t1317 VDD VDD sg13_lv_pmos ad=0.19p pd=1.38u as=0 ps=0 w=1u l=1u
X1446 VDD VSS.t1624 VDD VDD sg13_lv_pmos ad=0.19p pd=1.38u as=0 ps=0 w=1u l=1u
X1447 VDD VSS.t2001 VDD VDD sg13_lv_pmos ad=0.19p pd=1.38u as=0 ps=0 w=1u l=1u
X1448 VDD VSS.t3143 VDD VDD sg13_lv_pmos ad=0.34p pd=2.68u as=0 ps=0 w=1u l=1u
X1449 VSS.t3194 VDD VSS.t3196 VSS.t3195 sg13_lv_nmos ad=79.8f pd=0.8u as=0 ps=0 w=0.42u l=1u
X1450 VSS.t2109 VDD VSS.t2111 VSS.t2110 sg13_lv_nmos ad=79.8f pd=0.8u as=0 ps=0 w=0.42u l=1u
X1451 VSS.t2720 VDD VSS.t2718 VSS.t199 sg13_lv_nmos ad=0.1428p pd=1.52u as=0 ps=0 w=0.42u l=1u
X1452 a_4432_15454# a_4175_15311# a_4594_15234# VSS.t66 sg13_lv_nmos ad=0.1428p pd=1.52u as=37.8f ps=0.6u w=0.42u l=0.13u
X1453 VSS.t932 VDD VSS.t934 VSS.t933 sg13_lv_nmos ad=79.8f pd=0.8u as=0 ps=0 w=0.42u l=1u
X1454 sg13cmos5l_dfrbpq_1_6.Q a_22986_14484# VSS.t65 VSS.t0 sg13_lv_nmos ad=0.2516p pd=2.16u as=0.1406p ps=1.12u w=0.74u l=0.13u
X1455 a_6202_15238# sg13cmos5l_dlygate4sd3_1_3.A VSS.t114 VSS.t284 sg13_lv_nmos ad=0.1406p pd=1.12u as=0.2516p ps=2.16u w=0.74u l=0.13u
X1456 a_7829_15238# sg13cmos5l_nand3_1_0.Y VSS.t162 VSS.t3253 sg13_lv_nmos ad=0.1406p pd=1.12u as=0.1898p ps=1.36u w=0.74u l=0.13u
X1457 VSS.t6 a_10618_14448# a_10337_14750# VSS.t3268 sg13_lv_nmos ad=79.8f pd=0.8u as=0.1428p ps=1.52u w=0.42u l=0.5u
X1458 VDD VSS.t1001 VDD VDD sg13_lv_pmos ad=0.34p pd=2.68u as=0 ps=0 w=1u l=1u
X1459 VDD VSS.t2368 VDD VDD sg13_lv_pmos ad=0.19p pd=1.38u as=0 ps=0 w=1u l=1u
X1460 VSS.t2029 VDD VSS.t2028 VSS.t2027 sg13_lv_nmos ad=0.1428p pd=1.52u as=0 ps=0 w=0.42u l=1u
X1461 VDD VSS.t2026 VDD VDD sg13_lv_pmos ad=0.19p pd=1.38u as=0 ps=0 w=1u l=1u
X1462 VDD sg13cmos5l_or3_1_2.A sg13cmos5l_o21ai_1_1.Y VDD sg13_lv_pmos ad=0.3808p pd=2.92u as=0.2128p ps=1.5u w=1.12u l=0.15u
X1463 VSS.t1355 VDD VSS.t1354 VSS.t248 sg13_lv_nmos ad=0.1428p pd=1.52u as=0 ps=0 w=0.42u l=1u
X1464 a_2630_15234# sg13cmos5l_and2_1_0.X VDD VDD sg13_lv_pmos ad=79.8f pd=0.8u as=0.1428p ps=1.52u w=0.42u l=0.13u
X1465 VSS.t2386 VDD VSS.t2388 VSS.t2387 sg13_lv_nmos ad=79.8f pd=0.8u as=0 ps=0 w=0.42u l=1u
X1466 VDD VSS.t2151 VDD VDD sg13_lv_pmos ad=0.19p pd=1.38u as=0 ps=0 w=1u l=1u
X1467 a_6372_14488# a_6346_14452# VSS.t114 VSS.t113 sg13_lv_nmos ad=0.2516p pd=2.16u as=0.1626p ps=1.415u w=0.74u l=0.13u
X1468 VDD VSS.t468 VDD VDD sg13_lv_pmos ad=0.34p pd=2.68u as=0 ps=0 w=1u l=1u
X1469 VSS.t1939 VDD VSS.t1941 VSS.t1940 sg13_lv_nmos ad=79.8f pd=0.8u as=0 ps=0 w=0.42u l=1u
X1470 VSS.t2787 VDD VSS.t2789 VSS.t199 sg13_lv_nmos ad=79.8f pd=0.8u as=0 ps=0 w=0.42u l=1u
X1471 VDD VSS.t676 VDD VDD sg13_lv_pmos ad=0.34p pd=2.68u as=0 ps=0 w=1u l=1u
X1472 VDD VSS.t1298 VDD VDD sg13_lv_pmos ad=0.34p pd=2.68u as=0 ps=0 w=1u l=1u
X1473 VSS.t21 a_26249_16334# a_26170_16237# VSS.t3272 sg13_lv_nmos ad=7.70437p pd=50.66u as=0.27427p ps=2.28u w=0.795u l=0.13u
X1474 VDD VSS.t399 VDD VDD sg13_lv_pmos ad=0.19p pd=1.38u as=0 ps=0 w=1u l=1u
X1475 VDD VSS.t615 VDD VDD sg13_lv_pmos ad=0.19p pd=1.38u as=0 ps=0 w=1u l=1u
X1476 VSS.t1042 VDD VSS.t1044 VSS.t1043 sg13_lv_nmos ad=79.8f pd=0.8u as=0 ps=0 w=0.42u l=1u
X1477 a_8050_14922# sg13cmos5l_dfrbpq_1_1.RESET_B VSS.t162 VSS.t3223 sg13_lv_nmos ad=37.8f pd=0.6u as=79.8f ps=0.8u w=0.42u l=0.13u
X1478 VDD VSS.t1016 VDD VDD sg13_lv_pmos ad=0.34p pd=2.68u as=0 ps=0 w=1u l=1u
X1479 VDD VSS.t1664 VDD VDD sg13_lv_pmos ad=0.19p pd=1.38u as=0 ps=0 w=1u l=1u
X1480 VDD VSS.t3128 VDD VDD sg13_lv_pmos ad=0.34p pd=2.68u as=0 ps=0 w=1u l=1u
X1481 VDD VSS.t2340 VDD VDD sg13_lv_pmos ad=0.34p pd=2.68u as=0 ps=0 w=1u l=1u
X1482 VSS.t902 VDD VSS.t901 VSS.t900 sg13_lv_nmos ad=0.1428p pd=1.52u as=0 ps=0 w=0.42u l=1u
X1483 VSS.t1397 VDD VSS.t1243 VSS.t248 sg13_lv_nmos ad=79.8f pd=0.8u as=0 ps=0 w=0.42u l=1u
X1484 VDD VSS.t2674 VDD VDD sg13_lv_pmos ad=0.34p pd=2.68u as=0 ps=0 w=1u l=1u
X1485 VDD VSS.t1335 VDD VDD sg13_lv_pmos ad=0.19p pd=1.38u as=0 ps=0 w=1u l=1u
X1486 VDD VSS.t1946 VDD VDD sg13_lv_pmos ad=0.19p pd=1.38u as=0 ps=0 w=1u l=1u
X1487 VDD VSS.t2771 VDD VDD sg13_lv_pmos ad=0.19p pd=1.38u as=0 ps=0 w=1u l=1u
X1488 VSS.t2064 VDD VSS.t2063 VSS.t2062 sg13_lv_nmos ad=0.1428p pd=1.52u as=0 ps=0 w=0.42u l=1u
X1489 VSS.t1627 VDD VSS.t1626 VSS.t1625 sg13_lv_nmos ad=0.1428p pd=1.52u as=0 ps=0 w=0.42u l=1u
X1490 VSS.t3149 VDD VSS.t3148 VSS.t3147 sg13_lv_nmos ad=0.1428p pd=1.52u as=0 ps=0 w=0.42u l=1u
X1491 VSS.t676 VDD VSS.t679 VSS.t805 sg13_lv_nmos ad=79.8f pd=0.8u as=0 ps=0 w=0.42u l=1u
X1492 VDD VSS.t2538 VDD VDD sg13_lv_pmos ad=0.19p pd=1.38u as=0 ps=0 w=1u l=1u
X1493 sg13cmos5l_dlygate4sd3_1_8.A a_11370_15532# VDD VDD sg13_lv_pmos ad=0.3808p pd=2.92u as=0.2128p ps=1.5u w=1.12u l=0.13u
X1494 sg13cmos5l_a21oi_1_1.Y sg13cmos5l_a21oi_1_3.B1 VSS.t88 VSS.t87 sg13_lv_nmos ad=0.1406p pd=1.12u as=0.2516p ps=2.16u w=0.74u l=0.13u
X1495 VSS.t962 VDD VSS.t964 VSS.t963 sg13_lv_nmos ad=79.8f pd=0.8u as=0 ps=0 w=0.42u l=1u
X1496 VDD VSS.t1978 VDD VDD sg13_lv_pmos ad=0.34p pd=2.68u as=0 ps=0 w=1u l=1u
X1497 VDD VSS.t829 VDD VDD sg13_lv_pmos ad=0.19p pd=1.38u as=0 ps=0 w=1u l=1u
X1498 VDD VSS.t3101 VDD VDD sg13_lv_pmos ad=0.19p pd=1.38u as=0 ps=0 w=1u l=1u
X1499 VSS.t2371 VDD VSS.t2373 VSS.t2372 sg13_lv_nmos ad=79.8f pd=0.8u as=0 ps=0 w=0.42u l=1u
X1500 VDD VSS.t2313 VDD VDD sg13_lv_pmos ad=0.19p pd=1.38u as=0 ps=0 w=1u l=1u
X1501 VSS.t339 VDD VSS.t339 VSS.t340 sg13_lv_nmos ad=79.8f pd=0.8u as=0 ps=0 w=0.42u l=1u
X1502 VSS.t1762 VDD VSS.t1764 VSS.t1763 sg13_lv_nmos ad=79.8f pd=0.8u as=0 ps=0 w=0.42u l=1u
X1503 VSS.t2144 VDD VSS.t2146 VSS.t2145 sg13_lv_nmos ad=79.8f pd=0.8u as=0 ps=0 w=0.42u l=1u
X1504 VDD VSS.t47 VDD VDD sg13_lv_pmos ad=0.19p pd=1.38u as=0 ps=0 w=1u l=1u
X1505 VSS.t862 VDD VSS.t864 VSS.t863 sg13_lv_nmos ad=79.8f pd=0.8u as=0 ps=0 w=0.42u l=1u
X1506 VSS.t2014 VDD VSS.t2016 VSS.t2015 sg13_lv_nmos ad=79.8f pd=0.8u as=0 ps=0 w=0.42u l=1u
X1507 VDD VSS.t476 VDD VDD sg13_lv_pmos ad=0.19p pd=1.38u as=0 ps=0 w=1u l=1u
X1508 VSS.t932 VDD VSS.t934 VSS.t933 sg13_lv_nmos ad=79.8f pd=0.8u as=0 ps=0 w=0.42u l=1u
X1509 VDD VSS.t921 VDD VDD sg13_lv_pmos ad=0.34p pd=2.68u as=0 ps=0 w=1u l=1u
X1510 VSS.t1692 VDD VSS.t1694 VSS.t1693 sg13_lv_nmos ad=79.8f pd=0.8u as=0 ps=0 w=0.42u l=1u
X1511 a_19323_13726# sg13cmos5l_buf_8_2.A VDD VDD sg13_lv_pmos ad=0.2128p pd=1.5u as=0.2128p ps=1.5u w=1.12u l=0.13u
X1512 VSS.t977 VDD VSS.t979 VSS.t978 sg13_lv_nmos ad=79.8f pd=0.8u as=0 ps=0 w=0.42u l=1u
X1513 VDD VSS.t1616 VDD VDD sg13_lv_pmos ad=0.34p pd=2.68u as=0 ps=0 w=1u l=1u
X1514 VDD VSS.t1496 VDD VDD sg13_lv_pmos ad=0.34p pd=2.68u as=0 ps=0 w=1u l=1u
X1515 VSS.t3179 VDD VSS.t3181 VSS.t3180 sg13_lv_nmos ad=79.8f pd=0.8u as=0 ps=0 w=0.42u l=1u
X1516 VSS.t2711 VDD VSS.t2710 VSS.t199 sg13_lv_nmos ad=0.1428p pd=1.52u as=0 ps=0 w=0.42u l=1u
X1517 VDD sg13cmos5l_buf_8_2.A a_12010_15202# VDD sg13_lv_pmos ad=0.2128p pd=1.5u as=0.2128p ps=1.5u w=1.12u l=0.13u
X1518 VSS.t623 VDD VSS.t623 VSS.t622 sg13_lv_nmos ad=0.1428p pd=1.52u as=0 ps=0 w=0.42u l=1u
X1519 VDD VSS.t1046 VDD VDD sg13_lv_pmos ad=0.34p pd=2.68u as=0 ps=0 w=1u l=1u
X1520 VSS.t2296 VDD VSS.t2295 VSS.t2294 sg13_lv_nmos ad=0.1428p pd=1.52u as=0 ps=0 w=0.42u l=1u
X1521 VDD a_22426_15202# a_22145_15424# VDD sg13_lv_pmos ad=0.1523p pd=1.38u as=0.34p ps=2.68u w=1u l=0.5u
X1522 VSS.t658 VDD VSS.t658 VSS.t792 sg13_lv_nmos ad=0.1428p pd=1.52u as=0 ps=0 w=0.42u l=1u
X1523 VDD VSS.t2530 VDD VDD sg13_lv_pmos ad=0.34p pd=2.68u as=0 ps=0 w=1u l=1u
X1524 a_22508_15960# sg13cmos5l_dfrbpq_1_3.Q VDD VDD sg13_lv_pmos ad=0.2856p pd=2.36u as=0.2114p ps=1.54u w=0.84u l=0.13u
X1525 VDD VSS.t984 VDD VDD sg13_lv_pmos ad=0.19p pd=1.38u as=0 ps=0 w=1u l=1u
X1526 VDD VSS.t1270 VDD VDD sg13_lv_pmos ad=0.19p pd=1.38u as=0 ps=0 w=1u l=1u
X1527 VSS.t1234 VDD VSS.t1233 VSS.t248 sg13_lv_nmos ad=0.1428p pd=1.52u as=0 ps=0 w=0.42u l=1u
X1528 VSS.t1274 VDD VSS.t1275 VSS.t248 sg13_lv_nmos ad=79.8f pd=0.8u as=0 ps=0 w=0.42u l=1u
X1529 sg13cmos5l_dfrbpq_1_2.CLK a_12010_15202# VSS.t300 VSS.t303 sg13_lv_nmos ad=0.1406p pd=1.12u as=0.1406p ps=1.12u w=0.74u l=0.13u
X1530 VDD VSS.t92 VDD VDD sg13_lv_pmos ad=0.34p pd=2.68u as=0 ps=0 w=1u l=1u
X1531 VDD VSS.t1320 VDD VDD sg13_lv_pmos ad=0.19p pd=1.38u as=0 ps=0 w=1u l=1u
X1532 VDD VSS.t2820 VDD VDD sg13_lv_pmos ad=0.19p pd=1.38u as=0 ps=0 w=1u l=1u
X1533 VSS.t1747 VDD VSS.t1749 VSS.t1748 sg13_lv_nmos ad=79.8f pd=0.8u as=0 ps=0 w=0.42u l=1u
X1534 VSS.t2551 VDD VSS.t2550 VSS.t2549 sg13_lv_nmos ad=0.1428p pd=1.52u as=0 ps=0 w=0.42u l=1u
X1535 VSS.t1924 VDD VSS.t1926 VSS.t1925 sg13_lv_nmos ad=79.8f pd=0.8u as=0 ps=0 w=0.42u l=1u
X1536 VDD VSS.t122 VDD VDD sg13_lv_pmos ad=0.34p pd=2.68u as=0 ps=0 w=1u l=1u
X1537 VDD a_18863_14845# a_19120_14726# VDD sg13_lv_pmos ad=2.42015p pd=15.68u as=79.8f ps=0.8u w=0.42u l=0.13u
X1538 VSS.t1239 VDD VSS.t1238 VSS.t248 sg13_lv_nmos ad=0.1428p pd=1.52u as=0 ps=0 w=0.42u l=1u
X1539 VSS.t403 VDD VSS.t403 VSS.t405 sg13_lv_nmos ad=0.1428p pd=1.52u as=0 ps=0 w=0.42u l=1u
X1540 a_20218_15238# sg13cmos5l_dfrbpq_1_2.Q VSS.t270 VSS.t87 sg13_lv_nmos ad=0.1406p pd=1.12u as=0.2516p ps=2.16u w=0.74u l=0.13u
X1541 sg13cmos5l_o21ai_1_2.A2 sg13cmos5l_dfrbpq_1_6.Q a_23480_15242# VSS.t48 sg13_lv_nmos ad=0.2516p pd=2.16u as=0.1406p ps=1.12u w=0.74u l=0.13u
X1542 a_15338_14484# sg13cmos5l_a21oi_1_3.B1 VDD VDD sg13_lv_pmos ad=0.1176p pd=1.33u as=0.4032p ps=2.96u w=1.12u l=0.13u
X1543 VSS.t2755 VDD VSS.t2755 VSS.t199 sg13_lv_nmos ad=0.1428p pd=1.52u as=0 ps=0 w=0.42u l=1u
X1544 VDD VSS.t449 VDD VDD sg13_lv_pmos ad=0.19p pd=1.38u as=0 ps=0 w=1u l=1u
X1545 VSS.t902 VDD VSS.t901 VSS.t900 sg13_lv_nmos ad=0.1428p pd=1.52u as=0 ps=0 w=0.42u l=1u
X1546 VSS.t1017 VDD VSS.t1019 VSS.t1018 sg13_lv_nmos ad=79.8f pd=0.8u as=0 ps=0 w=0.42u l=1u
X1547 VDD VSS.t2006 VDD VDD sg13_lv_pmos ad=0.19p pd=1.38u as=0 ps=0 w=1u l=1u
X1548 sg13cmos5l_dlygate4sd3_1_5.A sg13cmos5l_dlygate4sd3_1_4.X a_18454_16374# VSS.t272 sg13_lv_nmos ad=0.2516p pd=2.16u as=0.1406p ps=1.12u w=0.74u l=0.15u
X1549 VSS.t463 VDD VSS.t464 VSS.t19 sg13_lv_nmos ad=79.8f pd=0.8u as=0 ps=0 w=0.42u l=1u
X1550 VDD VSS.t3113 VDD VDD sg13_lv_pmos ad=0.34p pd=2.68u as=0 ps=0 w=1u l=1u
X1551 VDD VSS.t2325 VDD VDD sg13_lv_pmos ad=0.34p pd=2.68u as=0 ps=0 w=1u l=1u
X1552 VDD sg13cmos5l_dlygate4sd3_1_9.X a_20603_15532# VDD sg13_lv_pmos ad=0.2128p pd=1.5u as=0.2128p ps=1.5u w=1.12u l=0.13u
X1553 VDD VSS.t1649 VDD VDD sg13_lv_pmos ad=0.19p pd=1.38u as=0 ps=0 w=1u l=1u
X1554 VSS.t2114 VDD VSS.t2116 VSS.t2115 sg13_lv_nmos ad=79.8f pd=0.8u as=0 ps=0 w=0.42u l=1u
X1555 VSS.t2723 VDD VSS.t2722 VSS.t199 sg13_lv_nmos ad=0.1428p pd=1.52u as=0 ps=0 w=0.42u l=1u
X1556 VDD VSS.t1689 VDD VDD sg13_lv_pmos ad=0.19p pd=1.38u as=0 ps=0 w=1u l=1u
X1557 VDD VSS.t200 VDD VDD sg13_lv_pmos ad=0.34p pd=2.68u as=0 ps=0 w=1u l=1u
X1558 a_20376_14464# sg13cmos5l_or3_1_2.B VDD VDD sg13_lv_pmos ad=0.2128p pd=1.5u as=0.3808p ps=2.92u w=1.12u l=0.15u
X1559 sg13cmos5l_dfrbpq_1_5.D a_25206_14508# VSS.t108 VSS.t0 sg13_lv_nmos ad=0.2516p pd=2.16u as=0.1426p ps=1.16u w=0.74u l=0.13u
X1560 VDD VSS.t1251 VDD VDD sg13_lv_pmos ad=0.34p pd=2.68u as=0 ps=0 w=1u l=1u
X1561 VDD VSS.t2031 VDD VDD sg13_lv_pmos ad=0.19p pd=1.38u as=0 ps=0 w=1u l=1u
X1562 VSS.t962 VDD VSS.t964 VSS.t963 sg13_lv_nmos ad=79.8f pd=0.8u as=0 ps=0 w=0.42u l=1u
X1563 VDD VSS.t951 VDD VDD sg13_lv_pmos ad=0.34p pd=2.68u as=0 ps=0 w=1u l=1u
X1564 VSS.t1326 VDD VSS.t1325 VSS.t248 sg13_lv_nmos ad=0.1428p pd=1.52u as=0 ps=0 w=0.42u l=1u
X1565 VSS.t550 VDD VSS.t550 VSS.t551 sg13_lv_nmos ad=0.1428p pd=1.52u as=0 ps=0 w=0.42u l=1u
X1566 VSS.t1287 VDD VSS.t1288 VSS.t248 sg13_lv_nmos ad=79.8f pd=0.8u as=0 ps=0 w=0.42u l=1u
X1567 VDD VSS.t2811 VDD VDD sg13_lv_pmos ad=0.19p pd=1.38u as=0 ps=0 w=1u l=1u
X1568 VSS.t2536 VDD VSS.t2535 VSS.t2534 sg13_lv_nmos ad=0.1428p pd=1.52u as=0 ps=0 w=0.42u l=1u
X1569 VDD VSS.t403 VDD VDD sg13_lv_pmos ad=0.34p pd=2.68u as=0 ps=0 w=1u l=1u
X1570 sg13cmos5l_dfrbpq_1_2.CLK a_12010_15202# VSS.t297 VSS.t298 sg13_lv_nmos ad=0.1406p pd=1.12u as=0.1406p ps=1.12u w=0.74u l=0.13u
X1571 VSS.t1909 VDD VSS.t1911 VSS.t1910 sg13_lv_nmos ad=79.8f pd=0.8u as=0 ps=0 w=0.42u l=1u
X1572 VDD a_27407_13799# a_28074_14020# VDD sg13_lv_pmos ad=0.2128p pd=1.5u as=0.3864p ps=2.93u w=1.12u l=0.13u
X1573 VSS.t1702 VDD VSS.t1701 VSS.t1700 sg13_lv_nmos ad=0.1428p pd=1.52u as=0 ps=0 w=0.42u l=1u
X1574 VSS.t862 VDD VSS.t864 VSS.t863 sg13_lv_nmos ad=79.8f pd=0.8u as=0 ps=0 w=0.42u l=1u
X1575 VDD VSS.t2393 VDD VDD sg13_lv_pmos ad=0.19p pd=1.38u as=0 ps=0 w=1u l=1u
X1576 VSS.t767 VDD VSS.t769 VSS.t768 sg13_lv_nmos ad=79.8f pd=0.8u as=0 ps=0 w=0.42u l=1u
X1577 VDD VSS.t1327 VDD VDD sg13_lv_pmos ad=0.34p pd=2.68u as=0 ps=0 w=1u l=1u
X1578 VDD VSS.t1669 VDD VDD sg13_lv_pmos ad=0.19p pd=1.38u as=0 ps=0 w=1u l=1u
X1579 VSS.t977 VDD VSS.t979 VSS.t978 sg13_lv_nmos ad=79.8f pd=0.8u as=0 ps=0 w=0.42u l=1u
X1580 VSS.t1999 VDD VSS.t2001 VSS.t2000 sg13_lv_nmos ad=79.8f pd=0.8u as=0 ps=0 w=0.42u l=1u
X1581 sg13cmos5l_a21oi_1_0.A2 a_16969_16020# VDD VDD sg13_lv_pmos ad=0.3808p pd=2.92u as=0.3822p ps=1.84u w=1.12u l=0.13u
X1582 VDD VSS.t2773 VDD VDD sg13_lv_pmos ad=0.19p pd=1.38u as=0 ps=0 w=1u l=1u
X1583 VSS.t2069 VDD VSS.t2068 VSS.t2067 sg13_lv_nmos ad=0.1428p pd=1.52u as=0 ps=0 w=0.42u l=1u
X1584 VDD VSS.t467 VDD VDD sg13_lv_pmos ad=0.19p pd=1.38u as=0 ps=0 w=1u l=1u
X1585 VDD VSS.t1229 VDD VDD sg13_lv_pmos ad=0.19p pd=1.38u as=0 ps=0 w=1u l=1u
X1586 VSS.t2281 VDD VSS.t2280 VSS.t2279 sg13_lv_nmos ad=0.1428p pd=1.52u as=0 ps=0 w=0.42u l=1u
X1587 VDD VSS.t1696 VDD VDD sg13_lv_pmos ad=0.34p pd=2.68u as=0 ps=0 w=1u l=1u
X1588 VSS.t2829 VDD VSS.t2678 VSS.t199 sg13_lv_nmos ad=79.8f pd=0.8u as=0 ps=0 w=0.42u l=1u
X1589 VDD VSS.t1029 VDD VDD sg13_lv_pmos ad=0.19p pd=1.38u as=0 ps=0 w=1u l=1u
X1590 VDD VSS.t2543 VDD VDD sg13_lv_pmos ad=0.19p pd=1.38u as=0 ps=0 w=1u l=1u
X1591 VSS.t73 a_19054_15423# sg13cmos5l_dlygate4sd3_1_4.X VSS.t87 sg13_lv_nmos ad=0.1426p pd=1.16u as=0.2516p ps=2.16u w=0.74u l=0.13u
X1592 a_16356_13735# a_16587_13844# a_16042_13945# VSS.t140 sg13_lv_nmos ad=0.2373p pd=1.97u as=79.8f ps=0.8u w=0.42u l=0.13u
X1593 VDD a_19323_13726# sg13cmos5l_buf_8_2.X VDD sg13_lv_pmos ad=0.2128p pd=1.5u as=0.2128p ps=1.5u w=1.12u l=0.13u
X1594 VDD VSS.t649 VDD VDD sg13_lv_pmos ad=0.19p pd=1.38u as=0 ps=0 w=1u l=1u
X1595 VSS.t1732 VDD VSS.t1734 VSS.t1733 sg13_lv_nmos ad=79.8f pd=0.8u as=0 ps=0 w=0.42u l=1u
X1596 VSS.t2149 VDD VSS.t2151 VSS.t2150 sg13_lv_nmos ad=79.8f pd=0.8u as=0 ps=0 w=0.42u l=1u
X1597 a_16294_13735# sg13cmos5l_dfrbpq_1_2.RESET_B VSS.t59 VSS.t60 sg13_lv_nmos ad=37.8f pd=0.6u as=0.1701p ps=1.65u w=0.42u l=0.13u
X1598 a_25956_13722# sg13cmos5l_dfrbpq_1_5.D a_25862_13722# VSS.t178 sg13_lv_nmos ad=60.89999f pd=0.71u as=0.1428p ps=1.52u w=0.42u l=0.13u
X1599 VSS.t897 VDD VSS.t899 VSS.t898 sg13_lv_nmos ad=79.8f pd=0.8u as=0 ps=0 w=0.42u l=1u
X1600 VSS.t1017 VDD VSS.t1019 VSS.t1018 sg13_lv_nmos ad=79.8f pd=0.8u as=0 ps=0 w=0.42u l=1u
X1601 VDD VSS.t2043 VDD VDD sg13_lv_pmos ad=0.34p pd=2.68u as=0 ps=0 w=1u l=1u
X1602 VSS.t573 VDD VSS.t572 VSS.t571 sg13_lv_nmos ad=0.1428p pd=1.52u as=0 ps=0 w=0.42u l=1u
X1603 VSS.t1062 VDD VSS.t1064 VSS.t1063 sg13_lv_nmos ad=79.8f pd=0.8u as=0 ps=0 w=0.42u l=1u
X1604 VDD VSS.t3166 VDD VDD sg13_lv_pmos ad=0.19p pd=1.38u as=0 ps=0 w=1u l=1u
X1605 sg13cmos5l_nor2_1_0.B a_16140_15424# VDD VDD sg13_lv_pmos ad=0.2408p pd=1.55u as=0.3808p ps=2.92u w=1.12u l=0.13u
X1606 VSS.t2748 VDD VSS.t2747 VSS.t199 sg13_lv_nmos ad=0.1428p pd=1.52u as=0 ps=0 w=0.42u l=1u
X1607 VSS.t497 VDD VSS.t165 VSS.t496 sg13_lv_nmos ad=0.1428p pd=1.52u as=0 ps=0 w=0.42u l=1u
X1608 VDD VSS.t2741 VDD VDD sg13_lv_pmos ad=0.19p pd=1.38u as=0 ps=0 w=1u l=1u
X1609 VDD VSS.t1991 VDD VDD sg13_lv_pmos ad=0.19p pd=1.38u as=0 ps=0 w=1u l=1u
X1610 VSS.t2406 VDD VSS.t2405 VSS.t2404 sg13_lv_nmos ad=0.1428p pd=1.52u as=0 ps=0 w=0.42u l=1u
X1611 VSS.t2099 VDD VSS.t2101 VSS.t2100 sg13_lv_nmos ad=79.8f pd=0.8u as=0 ps=0 w=0.42u l=1u
X1612 VSS.t1662 VDD VSS.t1664 VSS.t1663 sg13_lv_nmos ad=79.8f pd=0.8u as=0 ps=0 w=0.42u l=1u
X1613 VSS.t3184 VDD VSS.t3186 VSS.t3185 sg13_lv_nmos ad=79.8f pd=0.8u as=0 ps=0 w=0.42u l=1u
X1614 VSS.t2714 VDD VSS.t2712 VSS.t199 sg13_lv_nmos ad=0.1428p pd=1.52u as=0 ps=0 w=0.42u l=1u
X1615 VDD VSS.t2338 VDD VDD sg13_lv_pmos ad=0.19p pd=1.38u as=0 ps=0 w=1u l=1u
X1616 VDD VSS.t1211 VDD VDD sg13_lv_pmos ad=0.34p pd=2.68u as=0 ps=0 w=1u l=1u
X1617 VDD VSS.t1674 VDD VDD sg13_lv_pmos ad=0.19p pd=1.38u as=0 ps=0 w=1u l=1u
X1618 VSS.t2054 VDD VSS.t2053 VSS.t2052 sg13_lv_nmos ad=0.1428p pd=1.52u as=0 ps=0 w=0.42u l=1u
X1619 VSS.t11 a_25786_15960# a_25505_16262# VSS.t168 sg13_lv_nmos ad=79.8f pd=0.8u as=0.1428p ps=1.52u w=0.42u l=0.5u
X1620 VDD VSS.t866 VDD VDD sg13_lv_pmos ad=0.34p pd=2.68u as=0 ps=0 w=1u l=1u
X1621 VDD VSS.t1626 VDD VDD sg13_lv_pmos ad=0.34p pd=2.68u as=0 ps=0 w=1u l=1u
X1622 VSS.t2471 VDD VSS.t2473 VSS.t2472 sg13_lv_nmos ad=79.8f pd=0.8u as=0 ps=0 w=0.42u l=1u
X1623 VSS.t1944 VDD VSS.t1946 VSS.t1945 sg13_lv_nmos ad=79.8f pd=0.8u as=0 ps=0 w=0.42u l=1u
X1624 VSS.t1353 VDD VSS.t1352 VSS.t248 sg13_lv_nmos ad=0.1428p pd=1.52u as=0 ps=0 w=0.42u l=1u
X1625 VDD VSS.t1681 VDD VDD sg13_lv_pmos ad=0.34p pd=2.68u as=0 ps=0 w=1u l=1u
X1626 VDD VSS.t2500 VDD VDD sg13_lv_pmos ad=0.34p pd=2.68u as=0 ps=0 w=1u l=1u
X1627 a_8218_13690# sg13cmos5l_dlygate4sd3_1_1.A VSS.t210 VSS.t3229 sg13_lv_nmos ad=0.1428p pd=1.52u as=79.8f ps=0.8u w=0.42u l=0.13u
X1628 VSS.t13 a_17126_15238# a_17238_15302# VSS.t72 sg13_lv_nmos ad=0.1426p pd=1.16u as=0.1428p ps=1.52u w=0.42u l=0.5u
X1629 a_16042_13945# a_16485_13701# a_16425_14113# VDD sg13_lv_pmos ad=79.8f pd=0.8u as=63f ps=0.72u w=0.42u l=0.13u
X1630 VDD VSS.t919 VDD VDD sg13_lv_pmos ad=0.19p pd=1.38u as=0 ps=0 w=1u l=1u
X1631 VSS.t1358 VDD VSS.t1357 VSS.t248 sg13_lv_nmos ad=0.1428p pd=1.52u as=0 ps=0 w=0.42u l=1u
X1632 VDD VSS.t602 VDD VDD sg13_lv_pmos ad=0.34p pd=2.68u as=0 ps=0 w=1u l=1u
X1633 VSS.t1894 VDD VSS.t1896 VSS.t1895 sg13_lv_nmos ad=79.8f pd=0.8u as=0 ps=0 w=0.42u l=1u
X1634 VDD VSS.t1359 VDD VDD sg13_lv_pmos ad=0.19p pd=1.38u as=0 ps=0 w=1u l=1u
X1635 VSS.t2758 VDD VSS.t2757 VSS.t199 sg13_lv_nmos ad=0.1428p pd=1.52u as=0 ps=0 w=0.42u l=1u
X1636 VSS.t370 sg13cmos5l_inv_1_0.Y a_18454_16374# VSS.t3256 sg13_lv_nmos ad=0.1406p pd=1.12u as=0.2516p ps=2.16u w=0.74u l=0.15u
X1637 VDD VSS.t47 VDD VDD sg13_lv_pmos ad=0.34p pd=2.68u as=0 ps=0 w=1u l=1u
X1638 VSS.t655 VDD VSS.t658 VSS.t791 sg13_lv_nmos ad=79.8f pd=0.8u as=0 ps=0 w=0.42u l=1u
X1639 VDD VSS.t2734 VDD VDD sg13_lv_pmos ad=0.19p pd=1.38u as=0 ps=0 w=1u l=1u
X1640 VDD VSS.t2011 VDD VDD sg13_lv_pmos ad=0.19p pd=1.38u as=0 ps=0 w=1u l=1u
X1641 VDD VSS.t3118 VDD VDD sg13_lv_pmos ad=0.34p pd=2.68u as=0 ps=0 w=1u l=1u
X1642 VDD VSS.t2330 VDD VDD sg13_lv_pmos ad=0.34p pd=2.68u as=0 ps=0 w=1u l=1u
X1643 VDD VSS.t1654 VDD VDD sg13_lv_pmos ad=0.19p pd=1.38u as=0 ps=0 w=1u l=1u
X1644 VSS.t1240 VDD VSS.t1241 VSS.t248 sg13_lv_nmos ad=79.8f pd=0.8u as=0 ps=0 w=0.42u l=1u
X1645 VDD VSS.t1021 VDD VDD sg13_lv_pmos ad=0.34p pd=2.68u as=0 ps=0 w=1u l=1u
X1646 VDD VSS.t1694 VDD VDD sg13_lv_pmos ad=0.19p pd=1.38u as=0 ps=0 w=1u l=1u
X1647 VDD VSS.t15 VDD VDD sg13_lv_pmos ad=0.34p pd=2.68u as=0 ps=0 w=1u l=1u
X1648 VSS.t19 a_26638_15423# sg13cmos5l_o21ai_1_2.B1 VSS.t99 sg13_lv_nmos ad=0.1426p pd=1.16u as=0.2516p ps=2.16u w=0.74u l=0.13u
X1649 VDD VSS.t959 VDD VDD sg13_lv_pmos ad=0.19p pd=1.38u as=0 ps=0 w=1u l=1u
X1650 VSS.t1617 VDD VSS.t1616 VSS.t1615 sg13_lv_nmos ad=0.1428p pd=1.52u as=0 ps=0 w=0.42u l=1u
X1651 VSS.t3139 VDD VSS.t3138 VSS.t3137 sg13_lv_nmos ad=0.1428p pd=1.52u as=0 ps=0 w=0.42u l=1u
X1652 VDD VSS.t2343 VDD VDD sg13_lv_pmos ad=0.19p pd=1.38u as=0 ps=0 w=1u l=1u
X1653 VSS.t2669 VDD VSS.t2670 VSS.t199 sg13_lv_nmos ad=79.8f pd=0.8u as=0 ps=0 w=0.42u l=1u
X1654 VSS.t827 VDD VSS.t829 VSS.t828 sg13_lv_nmos ad=79.8f pd=0.8u as=0 ps=0 w=0.42u l=1u
X1655 VDD VSS.t2818 VDD VDD sg13_lv_pmos ad=0.19p pd=1.38u as=0 ps=0 w=1u l=1u
X1656 VDD VSS.t31 VDD VDD sg13_lv_pmos ad=0.34p pd=2.68u as=0 ps=0 w=1u l=1u
X1657 sg13cmos5l_dlygate4sd3_1_5.A sg13cmos5l_or3_1_2.B a_18552_15976# VDD sg13_lv_pmos ad=0.2128p pd=1.5u as=0.2128p ps=1.5u w=1.12u l=0.15u
X1658 VDD VSS.t3 VDD VDD sg13_lv_pmos ad=0.34p pd=2.68u as=0 ps=0 w=1u l=1u
X1659 VDD VSS.t679 VDD VDD sg13_lv_pmos ad=0.34p pd=2.68u as=0 ps=0 w=1u l=1u
X1660 VSS.t897 VDD VSS.t899 VSS.t898 sg13_lv_nmos ad=79.8f pd=0.8u as=0 ps=0 w=0.42u l=1u
X1661 VDD VSS.t886 VDD VDD sg13_lv_pmos ad=0.34p pd=2.68u as=0 ps=0 w=1u l=1u
X1662 VSS.t1914 VDD VSS.t1916 VSS.t1915 sg13_lv_nmos ad=79.8f pd=0.8u as=0 ps=0 w=0.42u l=1u
X1663 VSS.t1062 VDD VSS.t1064 VSS.t1063 sg13_lv_nmos ad=79.8f pd=0.8u as=0 ps=0 w=0.42u l=1u
X1664 VDD VSS.t1310 VDD VDD sg13_lv_pmos ad=0.34p pd=2.68u as=0 ps=0 w=1u l=1u
X1665 VSS.t640 VDD VSS.t102 VSS.t639 sg13_lv_nmos ad=0.1428p pd=1.52u as=0 ps=0 w=0.42u l=1u
X1666 VDD VSS.t9 VDD VDD sg13_lv_pmos ad=0.19p pd=1.38u as=0 ps=0 w=1u l=1u
X1667 VSS.t2456 VDD VSS.t2458 VSS.t2457 sg13_lv_nmos ad=79.8f pd=0.8u as=0 ps=0 w=0.42u l=1u
X1668 VDD VSS.t2028 VDD VDD sg13_lv_pmos ad=0.34p pd=2.68u as=0 ps=0 w=1u l=1u
X1669 VDD sg13cmos5l_nand3_1_0.Y a_7680_15549# VDD sg13_lv_pmos ad=0.2891p pd=1.695u as=0.1596p ps=1.22u w=0.84u l=0.13u
X1670 VDD VSS.t2398 VDD VDD sg13_lv_pmos ad=0.19p pd=1.38u as=0 ps=0 w=1u l=1u
X1671 VSS.t448 VDD VSS.t449 VSS.t19 sg13_lv_nmos ad=79.8f pd=0.8u as=0 ps=0 w=0.42u l=1u
X1672 VSS.t922 VDD VSS.t921 VSS.t920 sg13_lv_nmos ad=0.1428p pd=1.52u as=0 ps=0 w=0.42u l=1u
X1673 VDD VSS.t2153 VDD VDD sg13_lv_pmos ad=0.34p pd=2.68u as=0 ps=0 w=1u l=1u
X1674 VSS.t1406 VDD VSS.t1254 VSS.t248 sg13_lv_nmos ad=79.8f pd=0.8u as=0 ps=0 w=0.42u l=1u
X1675 VSS.t2004 VDD VSS.t2006 VSS.t2005 sg13_lv_nmos ad=79.8f pd=0.8u as=0 ps=0 w=0.42u l=1u
X1676 VDD VSS.t1347 VDD VDD sg13_lv_pmos ad=0.19p pd=1.38u as=0 ps=0 w=1u l=1u
X1677 VSS.t2039 VDD VSS.t2038 VSS.t2037 sg13_lv_nmos ad=0.1428p pd=1.52u as=0 ps=0 w=0.42u l=1u
X1678 VSS.t676 VDD VSS.t676 VSS.t677 sg13_lv_nmos ad=79.8f pd=0.8u as=0 ps=0 w=0.42u l=1u
X1679 sg13cmos5l_nand3_1_0.Y sg13cmos5l_buf_1_0.X VDD VDD sg13_lv_pmos ad=0.3808p pd=2.92u as=0.2128p ps=1.5u w=1.12u l=0.13u
X1680 VSS.t1378 VDD VSS.t1219 VSS.t248 sg13_lv_nmos ad=0.1428p pd=1.52u as=0 ps=0 w=0.42u l=1u
X1681 VSS.t982 VDD VSS.t984 VSS.t983 sg13_lv_nmos ad=79.8f pd=0.8u as=0 ps=0 w=0.42u l=1u
X1682 VDD VSS.t1611 VDD VDD sg13_lv_pmos ad=0.34p pd=2.68u as=0 ps=0 w=1u l=1u
X1683 VSS.t13 sg13cmos5l_a21oi_1_0.Y a_16856_15238# VSS.t12 sg13_lv_nmos ad=79.8f pd=0.8u as=0.1428p ps=1.52u w=0.42u l=0.13u
X1684 VSS.t620 VDD VSS.t620 VSS.t740 sg13_lv_nmos ad=0.1428p pd=1.52u as=0 ps=0 w=0.42u l=1u
X1685 VDD VSS.t849 VDD VDD sg13_lv_pmos ad=0.19p pd=1.38u as=0 ps=0 w=1u l=1u
X1686 VDD VSS.t1666 VDD VDD sg13_lv_pmos ad=0.34p pd=2.68u as=0 ps=0 w=1u l=1u
X1687 VSS.t3039 VDD VSS.t3041 VSS.t3040 sg13_lv_nmos ad=79.8f pd=0.8u as=0 ps=0 w=0.42u l=1u
X1688 VSS.t2411 VDD VSS.t2410 VSS.t2409 sg13_lv_nmos ad=0.1428p pd=1.52u as=0 ps=0 w=0.42u l=1u
X1689 VSS.t1954 VDD VSS.t1956 VSS.t1955 sg13_lv_nmos ad=79.8f pd=0.8u as=0 ps=0 w=0.42u l=1u
X1690 VDD VSS.t2981 VDD VDD sg13_lv_pmos ad=0.19p pd=1.38u as=0 ps=0 w=1u l=1u
X1691 a_22030_15423# a_22145_15424# VDD VDD sg13_lv_pmos ad=0.34p pd=2.68u as=0.2254p ps=1.53u w=1u l=0.5u
X1692 VDD VSS.t602 VDD VDD sg13_lv_pmos ad=0.34p pd=2.68u as=0 ps=0 w=1u l=1u
X1693 VSS.t1737 VDD VSS.t1739 VSS.t1738 sg13_lv_nmos ad=79.8f pd=0.8u as=0 ps=0 w=0.42u l=1u
X1694 a_18106_15960# sg13cmos5l_dlygate4sd3_1_5.A VDD VDD sg13_lv_pmos ad=0.1428p pd=1.52u as=0.1523p ps=1.38u w=0.42u l=0.13u
X1695 VSS.t2820 VDD VSS.t2821 VSS.t199 sg13_lv_nmos ad=79.8f pd=0.8u as=0 ps=0 w=0.42u l=1u
X1696 VDD VSS.t2390 VDD VDD sg13_lv_pmos ad=0.34p pd=2.68u as=0 ps=0 w=1u l=1u
X1697 VDD VSS.t2048 VDD VDD sg13_lv_pmos ad=0.34p pd=2.68u as=0 ps=0 w=1u l=1u
X1698 sg13cmos5l_o21ai_1_1.Y sg13cmos5l_or3_1_2.A a_20278_14862# VSS.t52 sg13_lv_nmos ad=0.2516p pd=2.16u as=0.1406p ps=1.12u w=0.74u l=0.15u
X1699 VDD VSS.t1350 VDD VDD sg13_lv_pmos ad=0.19p pd=1.38u as=0 ps=0 w=1u l=1u
X1700 VSS.t550 VDD VSS.t550 VSS.t551 sg13_lv_nmos ad=0.1428p pd=1.52u as=0 ps=0 w=0.42u l=1u
X1701 VSS.t2750 VDD VSS.t2750 VSS.t199 sg13_lv_nmos ad=0.1428p pd=1.52u as=0 ps=0 w=0.42u l=1u
X1702 VSS.t1305 VDD VSS.t1304 VSS.t248 sg13_lv_nmos ad=0.1428p pd=1.52u as=0 ps=0 w=0.42u l=1u
X1703 VDD VSS.t2726 VDD VDD sg13_lv_pmos ad=0.19p pd=1.38u as=0 ps=0 w=1u l=1u
X1704 VDD VSS.t1996 VDD VDD sg13_lv_pmos ad=0.19p pd=1.38u as=0 ps=0 w=1u l=1u
X1705 VDD VSS.t488 VDD VDD sg13_lv_pmos ad=0.19p pd=1.38u as=0 ps=0 w=1u l=1u
X1706 VDD VSS.t1328 VDD VDD sg13_lv_pmos ad=0.34p pd=2.68u as=0 ps=0 w=1u l=1u
X1707 VSS.t2376 VDD VSS.t2375 VSS.t2374 sg13_lv_nmos ad=0.1428p pd=1.52u as=0 ps=0 w=0.42u l=1u
X1708 VDD sg13cmos5l_a21oi_1_0.A1 a_16955_14484# VDD sg13_lv_pmos ad=0.2128p pd=1.5u as=0.2128p ps=1.5u w=1.12u l=0.13u
X1709 VDD VSS.t625 VDD VDD sg13_lv_pmos ad=0.19p pd=1.38u as=0 ps=0 w=1u l=1u
X1710 VSS.t658 VDD VSS.t655 VSS.t657 sg13_lv_nmos ad=0.1428p pd=1.52u as=0 ps=0 w=0.42u l=1u
X1711 VDD VSS.t1066 VDD VDD sg13_lv_pmos ad=0.34p pd=2.68u as=0 ps=0 w=1u l=1u
X1712 VSS.t1667 VDD VSS.t1669 VSS.t1668 sg13_lv_nmos ad=79.8f pd=0.8u as=0 ps=0 w=0.42u l=1u
X1713 VSS.t3189 VDD VSS.t3191 VSS.t3190 sg13_lv_nmos ad=79.8f pd=0.8u as=0 ps=0 w=0.42u l=1u
X1714 sg13cmos5l_buf_8_2.A a_15579_14854# VSS.t90 VSS.t156 sg13_lv_nmos ad=0.1406p pd=1.12u as=0.1406p ps=1.12u w=0.74u l=0.13u
X1715 VSS.t45 VDD VSS.t45 VSS.t412 sg13_lv_nmos ad=0.1428p pd=1.52u as=0 ps=0 w=0.42u l=1u
X1716 VDD VSS.t452 VDD VDD sg13_lv_pmos ad=0.19p pd=1.38u as=0 ps=0 w=1u l=1u
X1717 VSS.t952 VDD VSS.t951 VSS.t950 sg13_lv_nmos ad=0.1428p pd=1.52u as=0 ps=0 w=0.42u l=1u
X1718 VSS.t2476 VDD VSS.t2478 VSS.t2477 sg13_lv_nmos ad=79.8f pd=0.8u as=0 ps=0 w=0.42u l=1u
X1719 a_17126_15238# a_16856_15238# VDD VDD sg13_lv_pmos ad=0.34p pd=2.68u as=0.1523p ps=1.38u w=1u l=0.5u
X1720 VSS.t827 VDD VSS.t829 VSS.t828 sg13_lv_nmos ad=79.8f pd=0.8u as=0 ps=0 w=0.42u l=1u
X1721 VDD VSS.t1004 VDD VDD sg13_lv_pmos ad=0.19p pd=1.38u as=0 ps=0 w=1u l=1u
X1722 VDD VSS.t1282 VDD VDD sg13_lv_pmos ad=0.19p pd=1.38u as=0 ps=0 w=1u l=1u
X1723 VSS.t2749 VDD VSS.t2748 VSS.t199 sg13_lv_nmos ad=0.1428p pd=1.52u as=0 ps=0 w=0.42u l=1u
X1724 VDD VSS.t2505 VDD VDD sg13_lv_pmos ad=0.34p pd=2.68u as=0 ps=0 w=1u l=1u
X1725 VSS.t376 VDD VSS.t375 VSS.t374 sg13_lv_nmos ad=0.1428p pd=1.52u as=0 ps=0 w=0.42u l=1u
X1726 sg13cmos5l_xnor2_1_2.B sg13cmos5l_dlygate4sd3_1_3.A VDD VDD sg13_lv_pmos ad=0.2128p pd=1.5u as=0.3808p ps=2.92u w=1.12u l=0.13u
X1727 VDD a_10618_14448# a_10337_14750# VDD sg13_lv_pmos ad=0.1523p pd=1.38u as=0.34p ps=2.68u w=1u l=0.5u
X1728 VDD a_17327_13799# a_17584_13942# VDD sg13_lv_pmos ad=2.42015p pd=15.68u as=79.8f ps=0.8u w=0.42u l=0.13u
X1729 VSS.t1697 VDD VSS.t1696 VSS.t1695 sg13_lv_nmos ad=0.1428p pd=1.52u as=0 ps=0 w=0.42u l=1u
X1730 VDD VSS.t2966 VDD VDD sg13_lv_pmos ad=0.19p pd=1.38u as=0 ps=0 w=1u l=1u
X1731 VDD VSS.t2809 VDD VDD sg13_lv_pmos ad=0.19p pd=1.38u as=0 ps=0 w=1u l=1u
X1732 VDD VSS.t210 VDD VDD sg13_lv_pmos ad=0.19p pd=1.38u as=0 ps=0 w=1u l=1u
X1733 VDD a_21466_15202# a_21185_15424# VDD sg13_lv_pmos ad=0.1523p pd=1.38u as=0.34p ps=2.68u w=1u l=0.5u
X1734 a_16356_13735# a_16068_14040# a_16294_13735# VSS.t307 sg13_lv_nmos ad=0.1428p pd=1.52u as=37.8f ps=0.6u w=0.42u l=0.13u
X1735 VSS.t50 VDD VSS.t254 VSS.t699 sg13_lv_nmos ad=0.1428p pd=1.52u as=0 ps=0 w=0.42u l=1u
X1736 VDD VSS.t2782 VDD VDD sg13_lv_pmos ad=0.34p pd=2.68u as=0 ps=0 w=1u l=1u
X1737 VSS.t550 VDD VSS.t550 VSS.t553 sg13_lv_nmos ad=0.1428p pd=1.52u as=0 ps=0 w=0.42u l=1u
X1738 VSS.t630 VDD VSS.t627 VSS.t756 sg13_lv_nmos ad=0.1428p pd=1.52u as=0 ps=0 w=0.42u l=1u
X1739 VDD VSS.t635 VDD VDD sg13_lv_pmos ad=0.19p pd=1.38u as=0 ps=0 w=1u l=1u
X1740 VSS.t2984 VDD VSS.t2986 VSS.t2985 sg13_lv_nmos ad=79.8f pd=0.8u as=0 ps=0 w=0.42u l=1u
X1741 VSS.t1899 VDD VSS.t1901 VSS.t1900 sg13_lv_nmos ad=79.8f pd=0.8u as=0 ps=0 w=0.42u l=1u
X1742 VDD VSS.t1210 VDD VDD sg13_lv_pmos ad=0.19p pd=1.38u as=0 ps=0 w=1u l=1u
X1743 VDD VSS.t1362 VDD VDD sg13_lv_pmos ad=0.19p pd=1.38u as=0 ps=0 w=1u l=1u
X1744 VSS.t1692 VDD VSS.t1691 VSS.t1690 sg13_lv_nmos ad=0.1428p pd=1.52u as=0 ps=0 w=0.42u l=1u
X1745 VSS.t475 VDD VSS.t476 VSS.t19 sg13_lv_nmos ad=79.8f pd=0.8u as=0 ps=0 w=0.42u l=1u
X1746 VDD VSS.t468 VDD VDD sg13_lv_pmos ad=0.34p pd=2.68u as=0 ps=0 w=1u l=1u
X1747 VDD VSS.t879 VDD VDD sg13_lv_pmos ad=0.19p pd=1.38u as=0 ps=0 w=1u l=1u
X1748 VSS.t922 VDD VSS.t921 VSS.t920 sg13_lv_nmos ad=0.1428p pd=1.52u as=0 ps=0 w=0.42u l=1u
X1749 VSS.t1454 VDD VSS.t1317 VSS.t248 sg13_lv_nmos ad=0.1428p pd=1.52u as=0 ps=0 w=0.42u l=1u
X1750 VDD VSS.t2383 VDD VDD sg13_lv_pmos ad=0.19p pd=1.38u as=0 ps=0 w=1u l=1u
X1751 VSS.t2441 VDD VSS.t2443 VSS.t2442 sg13_lv_nmos ad=79.8f pd=0.8u as=0 ps=0 w=0.42u l=1u
X1752 VDD VSS.t2736 VDD VDD sg13_lv_pmos ad=0.19p pd=1.38u as=0 ps=0 w=1u l=1u
X1753 VDD VSS.t1981 VDD VDD sg13_lv_pmos ad=0.19p pd=1.38u as=0 ps=0 w=1u l=1u
X1754 VDD VSS.t3123 VDD VDD sg13_lv_pmos ad=0.34p pd=2.68u as=0 ps=0 w=1u l=1u
X1755 VSS.t2396 VDD VSS.t2395 VSS.t2394 sg13_lv_nmos ad=0.1428p pd=1.52u as=0 ps=0 w=0.42u l=1u
X1756 VDD VSS.t2335 VDD VDD sg13_lv_pmos ad=0.34p pd=2.68u as=0 ps=0 w=1u l=1u
X1757 VDD VSS.t771 VDD VDD sg13_lv_pmos ad=0.34p pd=2.68u as=0 ps=0 w=1u l=1u
X1758 VDD VSS.t1664 VDD VDD sg13_lv_pmos ad=0.19p pd=1.38u as=0 ps=0 w=1u l=1u
X1759 VSS.t573 VDD VSS.t572 VSS.t571 sg13_lv_nmos ad=0.1428p pd=1.52u as=0 ps=0 w=0.42u l=1u
X1760 VDD VSS.t1262 VDD VDD sg13_lv_pmos ad=0.34p pd=2.68u as=0 ps=0 w=1u l=1u
X1761 VDD a_7888_14726# a_7833_14607# VDD sg13_lv_pmos ad=2.42015p pd=15.68u as=93.45f ps=0.865u w=0.42u l=0.13u
X1762 sg13cmos5l_buf_8_2.A a_15579_14854# VSS.t90 VSS.t152 sg13_lv_nmos ad=0.1406p pd=1.12u as=0.1406p ps=1.12u w=0.74u l=0.13u
X1763 VSS.t982 VDD VSS.t984 VSS.t983 sg13_lv_nmos ad=79.8f pd=0.8u as=0 ps=0 w=0.42u l=1u
X1764 VDD VSS.t1719 VDD VDD sg13_lv_pmos ad=0.19p pd=1.38u as=0 ps=0 w=1u l=1u
X1765 VSS.t47 VDD VSS.t47 VSS.t21 sg13_lv_nmos ad=0.1428p pd=1.52u as=0 ps=0 w=0.42u l=1u
X1766 VSS.t105 VDD VSS.t105 VSS.t560 sg13_lv_nmos ad=0.1428p pd=1.52u as=0 ps=0 w=0.42u l=1u
X1767 VDD VSS.t600 VDD VDD sg13_lv_pmos ad=0.19p pd=1.38u as=0 ps=0 w=1u l=1u
X1768 VSS.t1027 VDD VSS.t1029 VSS.t1028 sg13_lv_nmos ad=79.8f pd=0.8u as=0 ps=0 w=0.42u l=1u
X1769 VDD VSS.t1240 VDD VDD sg13_lv_pmos ad=0.19p pd=1.38u as=0 ps=0 w=1u l=1u
X1770 VDD VSS.t2802 VDD VDD sg13_lv_pmos ad=0.19p pd=1.38u as=0 ps=0 w=1u l=1u
X1771 VSS.t2119 VDD VSS.t2118 VSS.t2117 sg13_lv_nmos ad=0.1428p pd=1.52u as=0 ps=0 w=0.42u l=1u
X1772 VDD VSS.t315 VDD VDD sg13_lv_pmos ad=0.19p pd=1.38u as=0 ps=0 w=1u l=1u
X1773 VSS.t1682 VDD VSS.t1681 VSS.t1680 sg13_lv_nmos ad=0.1428p pd=1.52u as=0 ps=0 w=0.42u l=1u
X1774 VSS.t3204 VDD VSS.t3203 VSS.t3202 sg13_lv_nmos ad=0.1428p pd=1.52u as=0 ps=0 w=0.42u l=1u
X1775 VSS.t3024 VDD VSS.t3026 VSS.t3025 sg13_lv_nmos ad=79.8f pd=0.8u as=0 ps=0 w=0.42u l=1u
X1776 a_6346_14452# a_6789_14495# a_6729_14531# VDD sg13_lv_pmos ad=79.8f pd=0.8u as=63f ps=0.72u w=0.42u l=0.13u
X1777 VSS.t2743 VDD VSS.t2744 VSS.t199 sg13_lv_nmos ad=79.8f pd=0.8u as=0 ps=0 w=0.42u l=1u
X1778 VDD VSS.t349 VDD VDD sg13_lv_pmos ad=0.19p pd=1.38u as=0 ps=0 w=1u l=1u
X1779 VDD VSS.t1034 VDD VDD sg13_lv_pmos ad=0.19p pd=1.38u as=0 ps=0 w=1u l=1u
X1780 VSS.t2811 VDD VSS.t2812 VSS.t199 sg13_lv_nmos ad=79.8f pd=0.8u as=0 ps=0 w=0.42u l=1u
X1781 VSS.t457 VDD VSS.t456 VSS.t19 sg13_lv_nmos ad=0.1428p pd=1.52u as=0 ps=0 w=0.42u l=1u
X1782 VDD VSS.t831 VDD VDD sg13_lv_pmos ad=0.34p pd=2.68u as=0 ps=0 w=1u l=1u
X1783 VDD VSS.t2033 VDD VDD sg13_lv_pmos ad=0.34p pd=2.68u as=0 ps=0 w=1u l=1u
X1784 VSS.t640 VDD VSS.t643 VSS.t781 sg13_lv_nmos ad=79.8f pd=0.8u as=0 ps=0 w=0.42u l=1u
X1785 VDD VSS.t3156 VDD VDD sg13_lv_pmos ad=0.19p pd=1.38u as=0 ps=0 w=1u l=1u
X1786 VDD VSS.t2403 VDD VDD sg13_lv_pmos ad=0.19p pd=1.38u as=0 ps=0 w=1u l=1u
X1787 VSS.t2426 VDD VSS.t2428 VSS.t2427 sg13_lv_nmos ad=79.8f pd=0.8u as=0 ps=0 w=0.42u l=1u
X1788 VDD VSS.t2158 VDD VDD sg13_lv_pmos ad=0.34p pd=2.68u as=0 ps=0 w=1u l=1u
X1789 VSS.t1592 VDD VSS.t1594 VSS.t1593 sg13_lv_nmos ad=79.8f pd=0.8u as=0 ps=0 w=0.42u l=1u
X1790 VDD VSS.t2812 VDD VDD sg13_lv_pmos ad=0.34p pd=2.68u as=0 ps=0 w=1u l=1u
X1791 VSS.t2009 VDD VSS.t2011 VSS.t2010 sg13_lv_nmos ad=79.8f pd=0.8u as=0 ps=0 w=0.42u l=1u
X1792 VSS.t443 VDD VSS.t440 VSS.t512 sg13_lv_nmos ad=0.1428p pd=1.52u as=0 ps=0 w=0.42u l=1u
X1793 VSS.t2741 VDD VSS.t2742 VSS.t199 sg13_lv_nmos ad=79.8f pd=0.8u as=0 ps=0 w=0.42u l=1u
X1794 VSS.t1652 VDD VSS.t1654 VSS.t1653 sg13_lv_nmos ad=79.8f pd=0.8u as=0 ps=0 w=0.42u l=1u
X1795 VSS.t3174 VDD VSS.t3176 VSS.t3175 sg13_lv_nmos ad=79.8f pd=0.8u as=0 ps=0 w=0.42u l=1u
X1796 VDD VSS.t479 VDD VDD sg13_lv_pmos ad=0.19p pd=1.38u as=0 ps=0 w=1u l=1u
X1797 VSS.t952 VDD VSS.t951 VSS.t950 sg13_lv_nmos ad=0.1428p pd=1.52u as=0 ps=0 w=0.42u l=1u
X1798 VSS.t1467 VDD VSS.t1335 VSS.t248 sg13_lv_nmos ad=0.1428p pd=1.52u as=0 ps=0 w=0.42u l=1u
X1799 a_26244_14909# a_25956_14488# a_26182_14909# VSS.t227 sg13_lv_nmos ad=0.1428p pd=1.52u as=37.8f ps=0.6u w=0.42u l=0.13u
X1800 VDD VSS.t1049 VDD VDD sg13_lv_pmos ad=0.19p pd=1.38u as=0 ps=0 w=1u l=1u
X1801 VDD VSS.t1308 VDD VDD sg13_lv_pmos ad=0.19p pd=1.38u as=0 ps=0 w=1u l=1u
X1802 VSS.t47 VDD VSS.t47 VSS.t427 sg13_lv_nmos ad=0.1428p pd=1.52u as=0 ps=0 w=0.42u l=1u
X1803 VDD VSS.t1616 VDD VDD sg13_lv_pmos ad=0.34p pd=2.68u as=0 ps=0 w=1u l=1u
X1804 a_19450_15202# sg13cmos5l_dfrbpq_1_3.Q VDD VDD sg13_lv_pmos ad=0.1428p pd=1.52u as=0.1523p ps=1.38u w=0.42u l=0.13u
X1805 VDD VSS.t1671 VDD VDD sg13_lv_pmos ad=0.34p pd=2.68u as=0 ps=0 w=1u l=1u
X1806 VSS.t3044 VDD VSS.t3046 VSS.t3045 sg13_lv_nmos ad=79.8f pd=0.8u as=0 ps=0 w=0.42u l=1u
X1807 VSS.t1959 VDD VSS.t1961 VSS.t1960 sg13_lv_nmos ad=79.8f pd=0.8u as=0 ps=0 w=0.42u l=1u
X1808 a_20603_15532# sg13cmos5l_or3_1_2.X VDD VDD sg13_lv_pmos ad=0.3808p pd=2.92u as=0.2128p ps=1.5u w=1.12u l=0.13u
X1809 VDD VSS.t2951 VDD VDD sg13_lv_pmos ad=0.19p pd=1.38u as=0 ps=0 w=1u l=1u
X1810 VSS.t1356 VDD VSS.t1355 VSS.t248 sg13_lv_nmos ad=0.1428p pd=1.52u as=0 ps=0 w=0.42u l=1u
X1811 VSS.t1742 VDD VSS.t1744 VSS.t1743 sg13_lv_nmos ad=79.8f pd=0.8u as=0 ps=0 w=0.42u l=1u
X1812 VDD VSS.t2774 VDD VDD sg13_lv_pmos ad=0.34p pd=2.68u as=0 ps=0 w=1u l=1u
X1813 sg13cmos5l_dfrbpq_1_2.CLK a_12010_15202# VDD VDD sg13_lv_pmos ad=0.2128p pd=1.5u as=0.2128p ps=1.5u w=1.12u l=0.13u
X1814 VDD VSS.t440 VDD VDD sg13_lv_pmos ad=0.34p pd=2.68u as=0 ps=0 w=1u l=1u
X1815 VSS.t88 sg13cmos5l_or3_1_2.B a_20278_14862# VSS.t52 sg13_lv_nmos ad=0.1406p pd=1.12u as=0.2516p ps=2.16u w=0.74u l=0.15u
X1816 VDD VSS.t986 VDD VDD sg13_lv_pmos ad=0.34p pd=2.68u as=0 ps=0 w=1u l=1u
X1817 VDD VSS.t339 VDD VDD sg13_lv_pmos ad=0.19p pd=1.38u as=0 ps=0 w=1u l=1u
X1818 VDD VSS.t2360 VDD VDD sg13_lv_pmos ad=0.34p pd=2.68u as=0 ps=0 w=1u l=1u
X1819 VDD VSS.t1353 VDD VDD sg13_lv_pmos ad=0.19p pd=1.38u as=0 ps=0 w=1u l=1u
X1820 VDD VSS.t2545 VDD VDD sg13_lv_pmos ad=0.34p pd=2.68u as=0 ps=0 w=1u l=1u
X1821 VDD VSS.t1324 VDD VDD sg13_lv_pmos ad=0.34p pd=2.68u as=0 ps=0 w=1u l=1u
X1822 VDD VSS.t2729 VDD VDD sg13_lv_pmos ad=0.19p pd=1.38u as=0 ps=0 w=1u l=1u
X1823 VDD VSS.t2143 VDD VDD sg13_lv_pmos ad=0.34p pd=2.68u as=0 ps=0 w=1u l=1u
X1824 VDD VSS.t1966 VDD VDD sg13_lv_pmos ad=0.19p pd=1.38u as=0 ps=0 w=1u l=1u
X1825 sg13cmos5l_or3_1_2.C sg13cmos5l_dfrbpq_1_2.Q VDD VDD sg13_lv_pmos ad=0.2128p pd=1.5u as=0.3808p ps=2.92u w=1.12u l=0.13u
X1826 VSS.t2381 VDD VSS.t2380 VSS.t2379 sg13_lv_nmos ad=0.1428p pd=1.52u as=0 ps=0 w=0.42u l=1u
X1827 VDD VSS.t2320 VDD VDD sg13_lv_pmos ad=0.34p pd=2.68u as=0 ps=0 w=1u l=1u
X1828 VDD VSS.t459 VDD VDD sg13_lv_pmos ad=0.34p pd=2.68u as=0 ps=0 w=1u l=1u
X1829 VDD VSS.t3108 VDD VDD sg13_lv_pmos ad=0.34p pd=2.68u as=0 ps=0 w=1u l=1u
X1830 VDD VSS.t555 VDD VDD sg13_lv_pmos ad=0.19p pd=1.38u as=0 ps=0 w=1u l=1u
X1831 VSS.t3159 VDD VSS.t3161 VSS.t3160 sg13_lv_nmos ad=79.8f pd=0.8u as=0 ps=0 w=0.42u l=1u
X1832 VDD VSS.t449 VDD VDD sg13_lv_pmos ad=0.19p pd=1.38u as=0 ps=0 w=1u l=1u
X1833 VDD VSS.t1289 VDD VDD sg13_lv_pmos ad=0.34p pd=2.68u as=0 ps=0 w=1u l=1u
X1834 VDD VSS.t600 VDD VDD sg13_lv_pmos ad=0.19p pd=1.38u as=0 ps=0 w=1u l=1u
X1835 VSS.t1027 VDD VSS.t1029 VSS.t1028 sg13_lv_nmos ad=79.8f pd=0.8u as=0 ps=0 w=0.42u l=1u
X1836 VSS.t1365 VDD VSS.t1364 VSS.t248 sg13_lv_nmos ad=0.1428p pd=1.52u as=0 ps=0 w=0.42u l=1u
X1837 VDD VSS.t1649 VDD VDD sg13_lv_pmos ad=0.19p pd=1.38u as=0 ps=0 w=1u l=1u
X1838 VSS.t1537 VDD VSS.t1539 VSS.t1538 sg13_lv_nmos ad=79.8f pd=0.8u as=0 ps=0 w=0.42u l=1u
X1839 VSS.t2446 VDD VSS.t2448 VSS.t2447 sg13_lv_nmos ad=79.8f pd=0.8u as=0 ps=0 w=0.42u l=1u
X1840 VSS.t887 VDD VSS.t886 VSS.t885 sg13_lv_nmos ad=0.1428p pd=1.52u as=0 ps=0 w=0.42u l=1u
X1841 VDD VSS.t1231 VDD VDD sg13_lv_pmos ad=0.19p pd=1.38u as=0 ps=0 w=1u l=1u
X1842 VDD VSS.t2021 VDD VDD sg13_lv_pmos ad=0.19p pd=1.38u as=0 ps=0 w=1u l=1u
X1843 VSS.t1667 VDD VSS.t1666 VSS.t1665 sg13_lv_nmos ad=0.1428p pd=1.52u as=0 ps=0 w=0.42u l=1u
X1844 VSS.t3189 VDD VSS.t3188 VSS.t3187 sg13_lv_nmos ad=0.1428p pd=1.52u as=0 ps=0 w=0.42u l=1u
X1845 a_17327_13799# a_16485_13701# a_16068_14040# VDD sg13_lv_pmos ad=0.2048p pd=1.63u as=0.34p ps=2.68u w=1u l=0.13u
X1846 sg13cmos5l_dfrbpq_1_2.CLK a_12010_15202# VDD VDD sg13_lv_pmos ad=0.2128p pd=1.5u as=0.2128p ps=1.5u w=1.12u l=0.13u
X1847 VDD VSS.t620 VDD VDD sg13_lv_pmos ad=0.19p pd=1.38u as=0 ps=0 w=1u l=1u
X1848 VSS.t2989 VDD VSS.t2991 VSS.t2990 sg13_lv_nmos ad=79.8f pd=0.8u as=0 ps=0 w=0.42u l=1u
X1849 VSS.t1904 VDD VSS.t1906 VSS.t1905 sg13_lv_nmos ad=79.8f pd=0.8u as=0 ps=0 w=0.42u l=1u
X1850 VDD VSS.t1344 VDD VDD sg13_lv_pmos ad=0.19p pd=1.38u as=0 ps=0 w=1u l=1u
X1851 VDD sg13cmos5l_dfrbpq_1_5.RESET_B a_25862_13722# VDD sg13_lv_pmos ad=0.36237p pd=2.605u as=79.8f ps=0.8u w=0.42u l=0.13u
X1852 VDD VSS.t2388 VDD VDD sg13_lv_pmos ad=0.19p pd=1.38u as=0 ps=0 w=1u l=1u
X1853 VDD VSS.t1534 VDD VDD sg13_lv_pmos ad=0.19p pd=1.38u as=0 ps=0 w=1u l=1u
X1854 VDD a_15579_14854# sg13cmos5l_buf_8_2.A VDD sg13_lv_pmos ad=0.2128p pd=1.5u as=0.2128p ps=1.5u w=1.12u l=0.13u
X1855 VSS.t1577 VDD VSS.t1579 VSS.t1578 sg13_lv_nmos ad=79.8f pd=0.8u as=0 ps=0 w=0.42u l=1u
X1856 VSS.t1757 VDD VSS.t1756 VSS.t1755 sg13_lv_nmos ad=0.1428p pd=1.52u as=0 ps=0 w=0.42u l=1u
X1857 VDD VSS.t3093 VDD VDD sg13_lv_pmos ad=0.34p pd=2.68u as=0 ps=0 w=1u l=1u
X1858 VDD VSS.t2305 VDD VDD sg13_lv_pmos ad=0.34p pd=2.68u as=0 ps=0 w=1u l=1u
X1859 VSS.t1994 VDD VSS.t1996 VSS.t1995 sg13_lv_nmos ad=79.8f pd=0.8u as=0 ps=0 w=0.42u l=1u
X1860 VDD a_22319_14845# a_22576_14726# VDD sg13_lv_pmos ad=2.42015p pd=15.68u as=79.8f ps=0.8u w=0.42u l=0.13u
X1861 a_25094_14484# a_24824_14525# VSS.t1 VSS.t0 sg13_lv_nmos ad=0.1428p pd=1.52u as=79.8f ps=0.8u w=0.42u l=0.5u
X1862 VSS.t643 VDD VSS.t640 VSS.t642 sg13_lv_nmos ad=0.1428p pd=1.52u as=0 ps=0 w=0.42u l=1u
X1863 VSS.t2734 VDD VSS.t2735 VSS.t199 sg13_lv_nmos ad=79.8f pd=0.8u as=0 ps=0 w=0.42u l=1u
X1864 VDD VSS.t2700 VDD VDD sg13_lv_pmos ad=0.19p pd=1.38u as=0 ps=0 w=1u l=1u
X1865 VDD VSS.t1669 VDD VDD sg13_lv_pmos ad=0.19p pd=1.38u as=0 ps=0 w=1u l=1u
X1866 VDD VSS.t3011 VDD VDD sg13_lv_pmos ad=0.19p pd=1.38u as=0 ps=0 w=1u l=1u
X1867 VDD VSS.t2013 VDD VDD sg13_lv_pmos ad=0.34p pd=2.68u as=0 ps=0 w=1u l=1u
X1868 VSS.t847 VDD VSS.t849 VSS.t848 sg13_lv_nmos ad=79.8f pd=0.8u as=0 ps=0 w=0.42u l=1u
X1869 VDD VSS.t467 VDD VDD sg13_lv_pmos ad=0.19p pd=1.38u as=0 ps=0 w=1u l=1u
X1870 VDD VSS.t906 VDD VDD sg13_lv_pmos ad=0.34p pd=2.68u as=0 ps=0 w=1u l=1u
X1871 VDD VSS.t2804 VDD VDD sg13_lv_pmos ad=0.19p pd=1.38u as=0 ps=0 w=1u l=1u
X1872 VSS.t2401 VDD VSS.t2400 VSS.t2399 sg13_lv_nmos ad=0.1428p pd=1.52u as=0 ps=0 w=0.42u l=1u
X1873 VSS.t2124 VDD VSS.t2123 VSS.t2122 sg13_lv_nmos ad=0.1428p pd=1.52u as=0 ps=0 w=0.42u l=1u
X1874 VSS.t1687 VDD VSS.t1686 VSS.t1685 sg13_lv_nmos ad=0.1428p pd=1.52u as=0 ps=0 w=0.42u l=1u
X1875 VSS.t3209 VDD VSS.t3208 VSS.t3207 sg13_lv_nmos ad=0.1428p pd=1.52u as=0 ps=0 w=0.42u l=1u
X1876 VSS.t3029 VDD VSS.t3031 VSS.t3030 sg13_lv_nmos ad=79.8f pd=0.8u as=0 ps=0 w=0.42u l=1u
X1877 VDD a_16485_13701# a_16587_13844# VDD sg13_lv_pmos ad=2.42015p pd=15.68u as=0.3864p ps=2.93u w=1.12u l=0.13u
X1878 VDD VSS.t1696 VDD VDD sg13_lv_pmos ad=0.34p pd=2.68u as=0 ps=0 w=1u l=1u
X1879 a_10618_14448# sg13cmos5l_dlygate4sd3_1_8.A VDD VDD sg13_lv_pmos ad=0.1428p pd=1.52u as=0.1523p ps=1.38u w=0.42u l=0.13u
X1880 VDD VSS.t1031 VDD VDD sg13_lv_pmos ad=0.34p pd=2.68u as=0 ps=0 w=1u l=1u
X1881 VSS.t1727 VDD VSS.t1729 VSS.t1728 sg13_lv_nmos ad=79.8f pd=0.8u as=0 ps=0 w=0.42u l=1u
X1882 VSS.t744 VDD VSS.t742 VSS.t743 sg13_lv_nmos ad=0.1428p pd=1.52u as=0 ps=0 w=0.42u l=1u
X1883 VSS.t649 VDD VSS.t649 VSS.t786 sg13_lv_nmos ad=0.1428p pd=1.52u as=0 ps=0 w=0.42u l=1u
X1884 VSS.t2814 VDD VSS.t2815 VSS.t199 sg13_lv_nmos ad=79.8f pd=0.8u as=0 ps=0 w=0.42u l=1u
X1885 VSS.t1889 VDD VSS.t1891 VSS.t1890 sg13_lv_nmos ad=79.8f pd=0.8u as=0 ps=0 w=0.42u l=1u
X1886 a_25025_16344# sg13cmos5l_a21oi_1_2.A1 sg13cmos5l_dlygate4sd3_1_17.A VSS.t69 sg13_lv_nmos ad=0.1406p pd=1.12u as=0.1406p ps=1.12u w=0.74u l=0.13u
X1887 VDD VSS.t2345 VDD VDD sg13_lv_pmos ad=0.34p pd=2.68u as=0 ps=0 w=1u l=1u
X1888 VSS.t613 VDD VSS.t612 VSS.t611 sg13_lv_nmos ad=0.1428p pd=1.52u as=0 ps=0 w=0.42u l=1u
X1889 VDD VSS.t2373 VDD VDD sg13_lv_pmos ad=0.19p pd=1.38u as=0 ps=0 w=1u l=1u
X1890 VSS.t2431 VDD VSS.t2433 VSS.t2432 sg13_lv_nmos ad=79.8f pd=0.8u as=0 ps=0 w=0.42u l=1u
X1891 VDD VSS.t969 VDD VDD sg13_lv_pmos ad=0.19p pd=1.38u as=0 ps=0 w=1u l=1u
X1892 VSS.t1265 VDD VSS.t1266 VSS.t248 sg13_lv_nmos ad=79.8f pd=0.8u as=0 ps=0 w=0.42u l=1u
X1893 VDD VSS.t1519 VDD VDD sg13_lv_pmos ad=0.19p pd=1.38u as=0 ps=0 w=1u l=1u
X1894 a_22025_16334# a_22149_16033# VDD VDD sg13_lv_pmos ad=0.2442p pd=2.06u as=2.8961p ps=18.25u w=0.66u l=0.13u
X1895 VDD VSS.t2128 VDD VDD sg13_lv_pmos ad=0.34p pd=2.68u as=0 ps=0 w=1u l=1u
X1896 VDD VSS.t1360 VDD VDD sg13_lv_pmos ad=0.19p pd=1.38u as=0 ps=0 w=1u l=1u
X1897 VDD VSS.t1315 VDD VDD sg13_lv_pmos ad=0.34p pd=2.68u as=0 ps=0 w=1u l=1u
X1898 VSS.t1597 VDD VSS.t1599 VSS.t1598 sg13_lv_nmos ad=79.8f pd=0.8u as=0 ps=0 w=0.42u l=1u
X1899 VDD VSS.t2815 VDD VDD sg13_lv_pmos ad=0.34p pd=2.68u as=0 ps=0 w=1u l=1u
X1900 VSS.t1979 VDD VSS.t1981 VSS.t1980 sg13_lv_nmos ad=79.8f pd=0.8u as=0 ps=0 w=0.42u l=1u
X1901 VDD VSS.t555 VDD VDD sg13_lv_pmos ad=0.19p pd=1.38u as=0 ps=0 w=1u l=1u
X1902 VDD a_15579_14854# sg13cmos5l_buf_8_2.A VDD sg13_lv_pmos ad=0.2128p pd=1.5u as=0.2128p ps=1.5u w=1.12u l=0.13u
X1903 VSS.t550 VDD VSS.t550 VSS.t553 sg13_lv_nmos ad=0.1428p pd=1.52u as=0 ps=0 w=0.42u l=1u
X1904 VSS.t1308 VDD VSS.t1308 VSS.t248 sg13_lv_nmos ad=79.8f pd=0.8u as=0 ps=0 w=0.42u l=1u
X1905 VSS.t3004 VDD VSS.t3003 VSS.t3002 sg13_lv_nmos ad=0.1428p pd=1.52u as=0 ps=0 w=0.42u l=1u
X1906 VSS.t1919 VDD VSS.t1918 VSS.t1917 sg13_lv_nmos ad=0.1428p pd=1.52u as=0 ps=0 w=0.42u l=1u
X1907 VSS.t1230 VDD VSS.t1229 VSS.t248 sg13_lv_nmos ad=0.1428p pd=1.52u as=0 ps=0 w=0.42u l=1u
X1908 VSS.t118 VDD VSS.t118 VSS.t397 sg13_lv_nmos ad=0.1428p pd=1.52u as=0 ps=0 w=0.42u l=1u
X1909 a_16314_15532# sg13cmos5l_or3_1_2.B sg13cmos5l_nor2_1_0.B VDD sg13_lv_pmos ad=0.1428p pd=1.375u as=0.2408p ps=1.55u w=1.12u l=0.13u
X1910 VSS.t1002 VDD VSS.t1004 VSS.t1003 sg13_lv_nmos ad=79.8f pd=0.8u as=0 ps=0 w=0.42u l=1u
X1911 VDD VSS.t1071 VDD VDD sg13_lv_pmos ad=0.34p pd=2.68u as=0 ps=0 w=1u l=1u
X1912 VSS.t887 VDD VSS.t886 VSS.t885 sg13_lv_nmos ad=0.1428p pd=1.52u as=0 ps=0 w=0.42u l=1u
X1913 VSS.t1717 VDD VSS.t1719 VSS.t1718 sg13_lv_nmos ad=79.8f pd=0.8u as=0 ps=0 w=0.42u l=1u
X1914 VSS.t2702 VDD VSS.t2703 VSS.t199 sg13_lv_nmos ad=79.8f pd=0.8u as=0 ps=0 w=0.42u l=1u
X1915 a_25930_14452# a_26373_14495# a_25670_14922# VSS.t223 sg13_lv_nmos ad=79.8f pd=0.8u as=0.1296p ps=1.52u w=0.42u l=0.13u
X1916 VDD VSS.t1676 VDD VDD sg13_lv_pmos ad=0.34p pd=2.68u as=0 ps=0 w=1u l=1u
X1917 VDD VSS.t2956 VDD VDD sg13_lv_pmos ad=0.19p pd=1.38u as=0 ps=0 w=1u l=1u
X1918 VDD VSS.t59 VDD VDD sg13_lv_pmos ad=0.34p pd=2.68u as=0 ps=0 w=1u l=1u
X1919 VDD VSS.t1681 VDD VDD sg13_lv_pmos ad=0.34p pd=2.68u as=0 ps=0 w=1u l=1u
X1920 VDD VSS.t2777 VDD VDD sg13_lv_pmos ad=0.34p pd=2.68u as=0 ps=0 w=1u l=1u
X1921 VDD a_27502_15423# sg13cmos5l_or3_1_1.A VDD sg13_lv_pmos ad=0.2254p pd=1.53u as=0.4256p ps=3u w=1.12u l=0.13u
X1922 VSS.t1712 VDD VSS.t1714 VSS.t1713 sg13_lv_nmos ad=79.8f pd=0.8u as=0 ps=0 w=0.42u l=1u
X1923 VSS.t573 VDD VSS.t575 VSS.t574 sg13_lv_nmos ad=79.8f pd=0.8u as=0 ps=0 w=0.42u l=1u
X1924 VSS.t105 VDD VSS.t105 VSS.t560 sg13_lv_nmos ad=0.1428p pd=1.52u as=0 ps=0 w=0.42u l=1u
X1925 VDD VSS.t1242 VDD VDD sg13_lv_pmos ad=0.34p pd=2.68u as=0 ps=0 w=1u l=1u
X1926 VDD VSS.t2365 VDD VDD sg13_lv_pmos ad=0.34p pd=2.68u as=0 ps=0 w=1u l=1u
X1927 VDD VSS.t2023 VDD VDD sg13_lv_pmos ad=0.34p pd=2.68u as=0 ps=0 w=1u l=1u
X1928 VSS.t276 sg13cmos5l_o21ai_1_2.A2 a_24169_14508# VSS.t0 sg13_lv_nmos ad=0.1045p pd=0.93u as=0.187p ps=1.78u w=0.55u l=0.13u
X1929 VSS.t2974 VDD VSS.t2976 VSS.t2975 sg13_lv_nmos ad=79.8f pd=0.8u as=0 ps=0 w=0.42u l=1u
X1930 VDD VSS.t1335 VDD VDD sg13_lv_pmos ad=0.19p pd=1.38u as=0 ps=0 w=1u l=1u
X1931 VDD VSS.t2550 VDD VDD sg13_lv_pmos ad=0.34p pd=2.68u as=0 ps=0 w=1u l=1u
X1932 a_3333_15213# sg13cmos5l_dfrbpq_1_2.CLK VSS.t19 VSS.t217 sg13_lv_nmos ad=0.2516p pd=2.16u as=3.8707p ps=25.555u w=0.74u l=0.13u
X1933 a_21070_15423# a_21185_15424# VDD VDD sg13_lv_pmos ad=0.34p pd=2.68u as=0.2254p ps=1.53u w=1u l=0.5u
X1934 VDD VSS.t2731 VDD VDD sg13_lv_pmos ad=0.19p pd=1.38u as=0 ps=0 w=1u l=1u
X1935 sg13cmos5l_dfrbpq_1_3.Q a_19530_14484# VDD VDD sg13_lv_pmos ad=0.3808p pd=2.92u as=0.2128p ps=1.5u w=1.12u l=0.13u
X1936 VDD VSS.t637 VDD VDD sg13_lv_pmos ad=0.19p pd=1.38u as=0 ps=0 w=1u l=1u
X1937 VDD VSS.t1086 VDD VDD sg13_lv_pmos ad=0.34p pd=2.68u as=0 ps=0 w=1u l=1u
X1938 VSS.t1547 VDD VSS.t1549 VSS.t1548 sg13_lv_nmos ad=79.8f pd=0.8u as=0 ps=0 w=0.42u l=1u
X1939 VSS.t2386 VDD VSS.t2385 VSS.t2384 sg13_lv_nmos ad=0.1428p pd=1.52u as=0 ps=0 w=0.42u l=1u
X1940 a_26373_14495# sg13cmos5l_buf_8_2.X VDD VDD sg13_lv_pmos ad=0.4088p pd=2.97u as=2.3367p ps=15.135u w=1.12u l=0.13u
X1941 VSS.t670 VDD VSS.t667 VSS.t669 sg13_lv_nmos ad=0.1428p pd=1.52u as=0 ps=0 w=0.42u l=1u
X1942 VSS.t1742 VDD VSS.t1741 VSS.t1740 sg13_lv_nmos ad=0.1428p pd=1.52u as=0 ps=0 w=0.42u l=1u
X1943 VSS.t2159 VDD VSS.t2158 VSS.t2157 sg13_lv_nmos ad=0.1428p pd=1.52u as=0 ps=0 w=0.42u l=1u
X1944 VSS.t47 VDD VSS.t421 VSS.t423 sg13_lv_nmos ad=0.1428p pd=1.52u as=0 ps=0 w=0.42u l=1u
X1945 sg13cmos5l_dlygate4sd3_1_3.A a_4842_15532# VSS.t41 VSS.t3292 sg13_lv_nmos ad=0.2516p pd=2.16u as=0.1406p ps=1.12u w=0.74u l=0.13u
X1946 VSS.t847 VDD VSS.t849 VSS.t848 sg13_lv_nmos ad=79.8f pd=0.8u as=0 ps=0 w=0.42u l=1u
X1947 VSS.t1283 VDD VSS.t1284 VSS.t248 sg13_lv_nmos ad=79.8f pd=0.8u as=0 ps=0 w=0.42u l=1u
X1948 VDD VSS.t1654 VDD VDD sg13_lv_pmos ad=0.19p pd=1.38u as=0 ps=0 w=1u l=1u
X1949 VDD VSS.t1709 VDD VDD sg13_lv_pmos ad=0.19p pd=1.38u as=0 ps=0 w=1u l=1u
X1950 VSS.t1542 VDD VSS.t1544 VSS.t1543 sg13_lv_nmos ad=79.8f pd=0.8u as=0 ps=0 w=0.42u l=1u
X1951 VDD VSS.t3173 VDD VDD sg13_lv_pmos ad=0.34p pd=2.68u as=0 ps=0 w=1u l=1u
X1952 VSS.t2451 VDD VSS.t2453 VSS.t2452 sg13_lv_nmos ad=79.8f pd=0.8u as=0 ps=0 w=0.42u l=1u
X1953 VDD VSS.t102 VDD VDD sg13_lv_pmos ad=0.19p pd=1.38u as=0 ps=0 w=1u l=1u
X1954 VSS.t50 a_7822_13911# sg13cmos5l_xnor2_1_2.A VSS.t49 sg13_lv_nmos ad=0.1426p pd=1.16u as=0.2516p ps=2.16u w=0.74u l=0.13u
X1955 VSS.t772 VDD VSS.t771 VSS.t770 sg13_lv_nmos ad=0.1428p pd=1.52u as=0 ps=0 w=0.42u l=1u
X1956 VDD VSS.t1234 VDD VDD sg13_lv_pmos ad=0.19p pd=1.38u as=0 ps=0 w=1u l=1u
X1957 VDD VSS.t2796 VDD VDD sg13_lv_pmos ad=0.19p pd=1.38u as=0 ps=0 w=1u l=1u
X1958 VSS.t1672 VDD VSS.t1671 VSS.t1670 sg13_lv_nmos ad=0.1428p pd=1.52u as=0 ps=0 w=0.42u l=1u
X1959 sg13cmos5l_buf_1_0.X a_1192_3900# VDD VDD sg13_lv_pmos ad=0.42p pd=2.99u as=0.2114p ps=1.54u w=1.12u l=0.13u
X1960 VSS.t3194 VDD VSS.t3193 VSS.t3192 sg13_lv_nmos ad=0.1428p pd=1.52u as=0 ps=0 w=0.42u l=1u
X1961 VSS.t105 VDD VSS.t105 VSS.t562 sg13_lv_nmos ad=0.1428p pd=1.52u as=0 ps=0 w=0.42u l=1u
X1962 VSS.t1032 VDD VSS.t1034 VSS.t1033 sg13_lv_nmos ad=79.8f pd=0.8u as=0 ps=0 w=0.42u l=1u
X1963 VDD VSS.t1221 VDD VDD sg13_lv_pmos ad=0.19p pd=1.38u as=0 ps=0 w=1u l=1u
X1964 VSS.t323 VDD VSS.t323 VSS.t325 sg13_lv_nmos ad=0.1428p pd=1.52u as=0 ps=0 w=0.42u l=1u
X1965 VSS.t487 VDD VSS.t488 VSS.t19 sg13_lv_nmos ad=79.8f pd=0.8u as=0 ps=0 w=0.42u l=1u
X1966 a_16955_14484# sg13cmos5l_a21oi_1_3.B1 sg13cmos5l_a21oi_1_0.Y VDD sg13_lv_pmos ad=0.2128p pd=1.5u as=0.3808p ps=2.92u w=1.12u l=0.13u
X1967 VSS.t2481 VDD VSS.t2480 VSS.t2479 sg13_lv_nmos ad=0.1428p pd=1.52u as=0 ps=0 w=0.42u l=1u
X1968 VDD VSS.t1347 VDD VDD sg13_lv_pmos ad=0.19p pd=1.38u as=0 ps=0 w=1u l=1u
X1969 VSS.t2674 VDD VSS.t2673 VSS.t199 sg13_lv_nmos ad=0.1428p pd=1.52u as=0 ps=0 w=0.42u l=1u
X1970 VDD VSS.t747 VDD VDD sg13_lv_pmos ad=0.34p pd=2.68u as=0 ps=0 w=1u l=1u
X1971 VDD VSS.t2727 VDD VDD sg13_lv_pmos ad=0.19p pd=1.38u as=0 ps=0 w=1u l=1u
X1972 VSS.t2416 VDD VSS.t2418 VSS.t2417 sg13_lv_nmos ad=79.8f pd=0.8u as=0 ps=0 w=0.42u l=1u
X1973 a_9418_15457# a_9861_15213# a_9801_15625# VDD sg13_lv_pmos ad=79.8f pd=0.8u as=63f ps=0.72u w=0.42u l=0.13u
X1974 VDD VSS.t2535 VDD VDD sg13_lv_pmos ad=0.34p pd=2.68u as=0 ps=0 w=1u l=1u
X1975 VDD VSS.t2358 VDD VDD sg13_lv_pmos ad=0.19p pd=1.38u as=0 ps=0 w=1u l=1u
X1976 VDD VSS.t1504 VDD VDD sg13_lv_pmos ad=0.19p pd=1.38u as=0 ps=0 w=1u l=1u
X1977 VSS.t108 sg13cmos5l_dfrbpq_1_7.RESET_B a_25764_14922# VSS.t3298 sg13_lv_nmos ad=0.1626p pd=1.415u as=60.89999f ps=0.71u w=0.42u l=0.13u
X1978 VSS.t1582 VDD VSS.t1584 VSS.t1583 sg13_lv_nmos ad=79.8f pd=0.8u as=0 ps=0 w=0.42u l=1u
X1979 VSS.t1762 VDD VSS.t1761 VSS.t1760 sg13_lv_nmos ad=0.1428p pd=1.52u as=0 ps=0 w=0.42u l=1u
X1980 VSS.t2736 VDD VSS.t2737 VSS.t199 sg13_lv_nmos ad=79.8f pd=0.8u as=0 ps=0 w=0.42u l=1u
X1981 VDD VSS.t2483 VDD VDD sg13_lv_pmos ad=0.19p pd=1.38u as=0 ps=0 w=1u l=1u
X1982 VSS.t2144 VDD VSS.t2143 VSS.t2142 sg13_lv_nmos ad=0.1428p pd=1.52u as=0 ps=0 w=0.42u l=1u
X1983 VSS.t1002 VDD VSS.t1004 VSS.t1003 sg13_lv_nmos ad=79.8f pd=0.8u as=0 ps=0 w=0.42u l=1u
X1984 VDD VSS.t1274 VDD VDD sg13_lv_pmos ad=0.34p pd=2.68u as=0 ps=0 w=1u l=1u
X1985 VSS.t1335 VDD VSS.t1334 VSS.t248 sg13_lv_nmos ad=0.1428p pd=1.52u as=0 ps=0 w=0.42u l=1u
X1986 VSS.t384 VDD VSS.t386 VSS.t385 sg13_lv_nmos ad=79.8f pd=0.8u as=0 ps=0 w=0.42u l=1u
X1987 VDD VSS.t1363 VDD VDD sg13_lv_pmos ad=0.34p pd=2.68u as=0 ps=0 w=1u l=1u
X1988 VDD VSS.t3016 VDD VDD sg13_lv_pmos ad=0.19p pd=1.38u as=0 ps=0 w=1u l=1u
X1989 VSS.t2989 VDD VSS.t2988 VSS.t2987 sg13_lv_nmos ad=0.1428p pd=1.52u as=0 ps=0 w=0.42u l=1u
X1990 VDD VSS.t47 VDD VDD sg13_lv_pmos ad=0.34p pd=2.68u as=0 ps=0 w=1u l=1u
X1991 VSS.t1047 VDD VSS.t1049 VSS.t1048 sg13_lv_nmos ad=79.8f pd=0.8u as=0 ps=0 w=0.42u l=1u
X1992 VDD VSS.t1886 VDD VDD sg13_lv_pmos ad=0.19p pd=1.38u as=0 ps=0 w=1u l=1u
X1993 VSS.t352 VDD VSS.t354 VSS.t353 sg13_lv_nmos ad=79.8f pd=0.8u as=0 ps=0 w=0.42u l=1u
X1994 VSS.t433 VDD VSS.t432 VSS.t431 sg13_lv_nmos ad=0.1428p pd=1.52u as=0 ps=0 w=0.42u l=1u
X1995 VDD VSS.t2737 VDD VDD sg13_lv_pmos ad=0.34p pd=2.68u as=0 ps=0 w=1u l=1u
X1996 VDD VSS.t1983 VDD VDD sg13_lv_pmos ad=0.34p pd=2.68u as=0 ps=0 w=1u l=1u
X1997 VSS.t34 sg13cmos5l_dfrbpq_1_5.RESET_B a_25956_13722# VSS.t33 sg13_lv_nmos ad=0.1626p pd=1.415u as=60.89999f ps=0.71u w=0.42u l=0.13u
X1998 VDD VSS.t1661 VDD VDD sg13_lv_pmos ad=0.34p pd=2.68u as=0 ps=0 w=1u l=1u
X1999 VDD VSS.t2807 VDD VDD sg13_lv_pmos ad=0.19p pd=1.38u as=0 ps=0 w=1u l=1u
X2000 VDD VSS.t249 VDD VDD sg13_lv_pmos ad=0.34p pd=2.68u as=0 ps=0 w=1u l=1u
X2001 VDD VSS.t1312 VDD VDD sg13_lv_pmos ad=0.19p pd=1.38u as=0 ps=0 w=1u l=1u
X2002 VSS.t469 VDD VSS.t468 VSS.t19 sg13_lv_nmos ad=0.1428p pd=1.52u as=0 ps=0 w=0.42u l=1u
X2003 VSS.t493 VDD VSS.t492 VSS.t19 sg13_lv_nmos ad=0.1428p pd=1.52u as=0 ps=0 w=0.42u l=1u
X2004 VDD VSS.t1666 VDD VDD sg13_lv_pmos ad=0.34p pd=2.68u as=0 ps=0 w=1u l=1u
X2005 VSS.t640 VDD VSS.t640 VSS.t641 sg13_lv_nmos ad=79.8f pd=0.8u as=0 ps=0 w=0.42u l=1u
X2006 VSS.t1260 VDD VSS.t1260 VSS.t248 sg13_lv_nmos ad=79.8f pd=0.8u as=0 ps=0 w=0.42u l=1u
X2007 VSS.t1557 VDD VSS.t1556 VSS.t1555 sg13_lv_nmos ad=0.1428p pd=1.52u as=0 ps=0 w=0.42u l=1u
X2008 VSS.t2466 VDD VSS.t2465 VSS.t2464 sg13_lv_nmos ad=0.1428p pd=1.52u as=0 ps=0 w=0.42u l=1u
X2009 VDD VSS.t2350 VDD VDD sg13_lv_pmos ad=0.34p pd=2.68u as=0 ps=0 w=1u l=1u
X2010 VSS.t454 VDD VSS.t455 VSS.t19 sg13_lv_nmos ad=79.8f pd=0.8u as=0 ps=0 w=0.42u l=1u
X2011 VDD VSS.t664 VDD VDD sg13_lv_pmos ad=0.19p pd=1.38u as=0 ps=0 w=1u l=1u
X2012 VDD sg13cmos5l_xnor2_1_2.A a_6540_13238# VDD sg13_lv_pmos ad=0.4536p pd=2.76u as=0.1596p ps=1.22u w=0.84u l=0.13u
X2013 a_22426_15202# sg13cmos5l_dfrbpq_1_6.Q VDD VDD sg13_lv_pmos ad=0.1428p pd=1.52u as=0.1523p ps=1.38u w=0.42u l=0.13u
X2014 VDD VSS.t443 VDD VDD sg13_lv_pmos ad=0.19p pd=1.38u as=0 ps=0 w=1u l=1u
X2015 VSS.t1532 VDD VSS.t1534 VSS.t1533 sg13_lv_nmos ad=79.8f pd=0.8u as=0 ps=0 w=0.42u l=1u
X2016 sg13cmos5l_dfrbpq_1_3.Q a_19530_14484# VSS.t123 VSS.t52 sg13_lv_nmos ad=0.2516p pd=2.16u as=0.1406p ps=1.12u w=0.74u l=0.13u
X2017 VSS.t1478 VDD VSS.t1347 VSS.t248 sg13_lv_nmos ad=0.1428p pd=1.52u as=0 ps=0 w=0.42u l=1u
X2018 VDD VSS.t587 VDD VDD sg13_lv_pmos ad=0.34p pd=2.68u as=0 ps=0 w=1u l=1u
X2019 VDD VSS.t2694 VDD VDD sg13_lv_pmos ad=0.19p pd=1.38u as=0 ps=0 w=1u l=1u
X2020 VSS.t1924 VDD VSS.t1923 VSS.t1922 sg13_lv_nmos ad=0.1428p pd=1.52u as=0 ps=0 w=0.42u l=1u
X2021 a_3333_15213# sg13cmos5l_dfrbpq_1_2.CLK VDD VDD sg13_lv_pmos ad=0.4088p pd=2.97u as=2.77542p ps=17.49u w=1.12u l=0.13u
X2022 VSS.t2094 VDD VSS.t2096 VSS.t2095 sg13_lv_nmos ad=79.8f pd=0.8u as=0 ps=0 w=0.42u l=1u
X2023 VDD VSS.t2051 VDD VDD sg13_lv_pmos ad=0.19p pd=1.38u as=0 ps=0 w=1u l=1u
X2024 VDD VSS.t1249 VDD VDD sg13_lv_pmos ad=0.19p pd=1.38u as=0 ps=0 w=1u l=1u
X2025 VDD VSS.t2405 VDD VDD sg13_lv_pmos ad=0.34p pd=2.68u as=0 ps=0 w=1u l=1u
X2026 VDD VSS.t47 VDD VDD sg13_lv_pmos ad=0.34p pd=2.68u as=0 ps=0 w=1u l=1u
X2027 VSS.t1527 VDD VSS.t1529 VSS.t1528 sg13_lv_nmos ad=79.8f pd=0.8u as=0 ps=0 w=0.42u l=1u
X2028 VDD VSS.t3158 VDD VDD sg13_lv_pmos ad=0.34p pd=2.68u as=0 ps=0 w=1u l=1u
X2029 VSS.t2436 VDD VSS.t2438 VSS.t2437 sg13_lv_nmos ad=79.8f pd=0.8u as=0 ps=0 w=0.42u l=1u
X2030 VSS.t1722 VDD VSS.t1724 VSS.t1723 sg13_lv_nmos ad=79.8f pd=0.8u as=0 ps=0 w=0.42u l=1u
X2031 VDD VSS.t452 VDD VDD sg13_lv_pmos ad=0.19p pd=1.38u as=0 ps=0 w=1u l=1u
X2032 VDD VSS.t1646 VDD VDD sg13_lv_pmos ad=0.34p pd=2.68u as=0 ps=0 w=1u l=1u
X2033 VSS.t2014 VDD VSS.t2013 VSS.t2012 sg13_lv_nmos ad=0.1428p pd=1.52u as=0 ps=0 w=0.42u l=1u
X2034 VSS.t1032 VDD VSS.t1034 VSS.t1033 sg13_lv_nmos ad=79.8f pd=0.8u as=0 ps=0 w=0.42u l=1u
X2035 VDD VSS.t1292 VDD VDD sg13_lv_pmos ad=0.34p pd=2.68u as=0 ps=0 w=1u l=1u
X2036 VDD VSS.t2961 VDD VDD sg13_lv_pmos ad=0.19p pd=1.38u as=0 ps=0 w=1u l=1u
X2037 VSS.t3019 VDD VSS.t3021 VSS.t3020 sg13_lv_nmos ad=79.8f pd=0.8u as=0 ps=0 w=0.42u l=1u
X2038 VDD a_7532_15960# counter_value_o[1] VDD sg13_lv_pmos ad=0.2114p pd=1.54u as=0.42p ps=2.99u w=1.12u l=0.13u
X2039 VDD VSS.t1006 VDD VDD sg13_lv_pmos ad=0.34p pd=2.68u as=0 ps=0 w=1u l=1u
X2040 VSS.t1243 VDD VSS.t1242 VSS.t248 sg13_lv_nmos ad=0.1428p pd=1.52u as=0 ps=0 w=0.42u l=1u
X2041 VDD VSS.t1564 VDD VDD sg13_lv_pmos ad=0.19p pd=1.38u as=0 ps=0 w=1u l=1u
X2042 VSS.t90 a_15579_14854# sg13cmos5l_buf_8_2.A VSS.t153 sg13_lv_nmos ad=0.1406p pd=1.12u as=0.1406p ps=1.12u w=0.74u l=0.13u
X2043 a_27502_15423# a_27617_15424# VSS.t19 VSS.t19 sg13_lv_nmos ad=0.1428p pd=1.52u as=0.1426p ps=1.16u w=0.42u l=0.5u
X2044 VDD VSS.t1338 VDD VDD sg13_lv_pmos ad=0.19p pd=1.38u as=0 ps=0 w=1u l=1u
X2045 VDD VSS.t2813 VDD VDD sg13_lv_pmos ad=0.34p pd=2.68u as=0 ps=0 w=1u l=1u
X2046 VDD VSS.t2718 VDD VDD sg13_lv_pmos ad=0.19p pd=1.38u as=0 ps=0 w=1u l=1u
X2047 VSS.t6 a_10960_15454# a_10609_15311# VSS.t3254 sg13_lv_nmos ad=79.8f pd=0.8u as=0.1428p ps=1.52u w=0.42u l=0.13u
X2048 VDD VSS.t2520 VDD VDD sg13_lv_pmos ad=0.34p pd=2.68u as=0 ps=0 w=1u l=1u
X2049 VSS.t832 VDD VSS.t831 VSS.t830 sg13_lv_nmos ad=0.1428p pd=1.52u as=0 ps=0 w=0.42u l=1u
X2050 VSS.t73 a_19120_14726# a_18769_14845# VSS.t52 sg13_lv_nmos ad=79.8f pd=0.8u as=0.1428p ps=1.52u w=0.42u l=0.13u
X2051 VSS.t1517 VDD VSS.t1519 VSS.t1518 sg13_lv_nmos ad=79.8f pd=0.8u as=0 ps=0 w=0.42u l=1u
X2052 VSS.t1747 VDD VSS.t1746 VSS.t1745 sg13_lv_nmos ad=0.1428p pd=1.52u as=0 ps=0 w=0.42u l=1u
X2053 VDD a_10703_15311# a_10960_15454# VDD sg13_lv_pmos ad=2.8961p pd=18.25u as=79.8f ps=0.8u w=0.42u l=0.13u
X2054 a_6086_14922# a_6891_14495# a_6346_14452# VDD sg13_lv_pmos ad=0.1428p pd=1.52u as=79.8f ps=0.8u w=0.42u l=0.13u
X2055 VSS.t472 VDD VSS.t473 VSS.t19 sg13_lv_nmos ad=79.8f pd=0.8u as=0 ps=0 w=0.42u l=1u
X2056 VSS.t1047 VDD VSS.t1049 VSS.t1048 sg13_lv_nmos ad=79.8f pd=0.8u as=0 ps=0 w=0.42u l=1u
X2057 VDD VSS.t1301 VDD VDD sg13_lv_pmos ad=0.34p pd=2.68u as=0 ps=0 w=1u l=1u
X2058 VDD VSS.t725 VDD VDD sg13_lv_pmos ad=0.19p pd=1.38u as=0 ps=0 w=1u l=1u
X2059 VDD VSS.t2036 VDD VDD sg13_lv_pmos ad=0.19p pd=1.38u as=0 ps=0 w=1u l=1u
X2060 VDD VSS.t17 VDD VDD sg13_lv_pmos ad=0.34p pd=2.68u as=0 ps=0 w=1u l=1u
X2061 VSS.t613 VDD VSS.t612 VSS.t611 sg13_lv_nmos ad=0.1428p pd=1.52u as=0 ps=0 w=0.42u l=1u
X2062 VDD VSS.t254 VDD VDD sg13_lv_pmos ad=0.34p pd=2.68u as=0 ps=0 w=1u l=1u
X2063 VDD VSS.t3178 VDD VDD sg13_lv_pmos ad=0.34p pd=2.68u as=0 ps=0 w=1u l=1u
X2064 VDD VSS.t1237 VDD VDD sg13_lv_pmos ad=0.19p pd=1.38u as=0 ps=0 w=1u l=1u
X2065 VDD VSS.t1719 VDD VDD sg13_lv_pmos ad=0.19p pd=1.38u as=0 ps=0 w=1u l=1u
X2066 VDD VSS.t2799 VDD VDD sg13_lv_pmos ad=0.19p pd=1.38u as=0 ps=0 w=1u l=1u
X2067 VDD VSS.t1338 VDD VDD sg13_lv_pmos ad=0.19p pd=1.38u as=0 ps=0 w=1u l=1u
X2068 VSS.t1220 VDD VSS.t1221 VSS.t248 sg13_lv_nmos ad=79.8f pd=0.8u as=0 ps=0 w=0.42u l=1u
X2069 VSS.t1677 VDD VSS.t1676 VSS.t1675 sg13_lv_nmos ad=0.1428p pd=1.52u as=0 ps=0 w=0.42u l=1u
X2070 VSS.t3164 VDD VSS.t3163 VSS.t3162 sg13_lv_nmos ad=0.1428p pd=1.52u as=0 ps=0 w=0.42u l=1u
X2071 a_26170_15202# sg13cmos5l_a21oi_1_3.Y VDD VDD sg13_lv_pmos ad=0.1428p pd=1.52u as=0.1523p ps=1.38u w=0.42u l=0.13u
X2072 VSS.t1542 VDD VSS.t1541 VSS.t1540 sg13_lv_nmos ad=0.1428p pd=1.52u as=0 ps=0 w=0.42u l=1u
X2073 VSS.t2451 VDD VSS.t2450 VSS.t2449 sg13_lv_nmos ad=0.1428p pd=1.52u as=0 ps=0 w=0.42u l=1u
X2074 VSS.t165 sg13cmos5l_dfrbpq_1_0.RESET_B a_2724_15234# VSS.t195 sg13_lv_nmos ad=0.1626p pd=1.415u as=60.89999f ps=0.71u w=0.42u l=0.13u
X2075 VSS.t2771 VDD VSS.t2772 VSS.t199 sg13_lv_nmos ad=79.8f pd=0.8u as=0 ps=0 w=0.42u l=1u
X2076 VSS.t2421 VDD VSS.t2423 VSS.t2422 sg13_lv_nmos ad=79.8f pd=0.8u as=0 ps=0 w=0.42u l=1u
X2077 VDD VSS.t1036 VDD VDD sg13_lv_pmos ad=0.34p pd=2.68u as=0 ps=0 w=1u l=1u
X2078 VDD VSS.t2973 VDD VDD sg13_lv_pmos ad=0.34p pd=2.68u as=0 ps=0 w=1u l=1u
X2079 VDD VSS.t440 VDD VDD sg13_lv_pmos ad=0.19p pd=1.38u as=0 ps=0 w=1u l=1u
X2080 VDD VSS.t851 VDD VDD sg13_lv_pmos ad=0.34p pd=2.68u as=0 ps=0 w=1u l=1u
X2081 VDD VSS.t1509 VDD VDD sg13_lv_pmos ad=0.19p pd=1.38u as=0 ps=0 w=1u l=1u
X2082 VSS.t41 VDD VSS.t41 VSS.t499 sg13_lv_nmos ad=0.1428p pd=1.52u as=0 ps=0 w=0.42u l=1u
X2083 VDD VSS.t587 VDD VDD sg13_lv_pmos ad=0.34p pd=2.68u as=0 ps=0 w=1u l=1u
X2084 VSS.t573 VDD VSS.t575 VSS.t574 sg13_lv_nmos ad=79.8f pd=0.8u as=0 ps=0 w=0.42u l=1u
X2085 VSS.t2739 VDD VSS.t2740 VSS.t199 sg13_lv_nmos ad=79.8f pd=0.8u as=0 ps=0 w=0.42u l=1u
X2086 VSS.t287 VDD VSS.t287 VSS.t316 sg13_lv_nmos ad=0.1428p pd=1.52u as=0 ps=0 w=0.42u l=1u
X2087 VDD VSS.t2685 VDD VDD sg13_lv_pmos ad=0.19p pd=1.38u as=0 ps=0 w=1u l=1u
X2088 VSS.t1909 VDD VSS.t1908 VSS.t1907 sg13_lv_nmos ad=0.1428p pd=1.52u as=0 ps=0 w=0.42u l=1u
X2089 VSS.t2994 VDD VSS.t2993 VSS.t2992 sg13_lv_nmos ad=0.1428p pd=1.52u as=0 ps=0 w=0.42u l=1u
X2090 sg13cmos5l_or3_1_1.B a_14261_15238# VSS.t143 VSS.t145 sg13_lv_nmos ad=0.1406p pd=1.12u as=0.1406p ps=1.12u w=0.74u l=0.13u
X2091 VDD VSS.t1475 VDD VDD sg13_lv_pmos ad=0.34p pd=2.68u as=0 ps=0 w=1u l=1u
X2092 VSS.t2064 VDD VSS.t2066 VSS.t2065 sg13_lv_nmos ad=79.8f pd=0.8u as=0 ps=0 w=0.42u l=1u
X2093 VDD VSS.t2740 VDD VDD sg13_lv_pmos ad=0.34p pd=2.68u as=0 ps=0 w=1u l=1u
X2094 VDD VSS.t1988 VDD VDD sg13_lv_pmos ad=0.34p pd=2.68u as=0 ps=0 w=1u l=1u
X2095 VDD VSS.t479 VDD VDD sg13_lv_pmos ad=0.19p pd=1.38u as=0 ps=0 w=1u l=1u
X2096 VSS.t1707 VDD VSS.t1709 VSS.t1708 sg13_lv_nmos ad=79.8f pd=0.8u as=0 ps=0 w=0.42u l=1u
X2097 VDD VSS.t914 VDD VDD sg13_lv_pmos ad=0.19p pd=1.38u as=0 ps=0 w=1u l=1u
X2098 VDD VSS.t1228 VDD VDD sg13_lv_pmos ad=0.19p pd=1.38u as=0 ps=0 w=1u l=1u
X2099 VDD VSS.t2790 VDD VDD sg13_lv_pmos ad=0.19p pd=1.38u as=0 ps=0 w=1u l=1u
X2100 VSS.t2099 VDD VSS.t2098 VSS.t2097 sg13_lv_nmos ad=0.1428p pd=1.52u as=0 ps=0 w=0.42u l=1u
X2101 a_24923_15996# sg13cmos5l_a21oi_1_3.B1 sg13cmos5l_dlygate4sd3_1_17.A VDD sg13_lv_pmos ad=0.2128p pd=1.5u as=0.3808p ps=2.92u w=1.12u l=0.13u
X2102 VSS.t649 VDD VSS.t646 VSS.t648 sg13_lv_nmos ad=0.1428p pd=1.52u as=0 ps=0 w=0.42u l=1u
X2103 VSS.t1662 VDD VSS.t1661 VSS.t1660 sg13_lv_nmos ad=0.1428p pd=1.52u as=0 ps=0 w=0.42u l=1u
X2104 VDD VSS.t2946 VDD VDD sg13_lv_pmos ad=0.19p pd=1.38u as=0 ps=0 w=1u l=1u
X2105 VSS.t3184 VDD VSS.t3183 VSS.t3182 sg13_lv_nmos ad=0.1428p pd=1.52u as=0 ps=0 w=0.42u l=1u
X2106 VSS.t3004 VDD VSS.t3006 VSS.t3005 sg13_lv_nmos ad=79.8f pd=0.8u as=0 ps=0 w=0.42u l=1u
X2107 a_18202_15202# sg13cmos5l_dfrbpq_1_2.Q VSS.t13 VSS.t268 sg13_lv_nmos ad=0.1428p pd=1.52u as=79.8f ps=0.8u w=0.42u l=0.13u
X2108 VDD VSS.t1671 VDD VDD sg13_lv_pmos ad=0.34p pd=2.68u as=0 ps=0 w=1u l=1u
X2109 a_2630_15234# a_3435_15356# a_2890_15457# VDD sg13_lv_pmos ad=0.1428p pd=1.52u as=79.8f ps=0.8u w=0.42u l=0.13u
X2110 VDD VSS.t1726 VDD VDD sg13_lv_pmos ad=0.34p pd=2.68u as=0 ps=0 w=1u l=1u
X2111 VSS.t2471 VDD VSS.t2470 VSS.t2469 sg13_lv_nmos ad=0.1428p pd=1.52u as=0 ps=0 w=0.42u l=1u
X2112 VDD VSS.t453 VDD VDD sg13_lv_pmos ad=0.34p pd=2.68u as=0 ps=0 w=1u l=1u
X2113 VDD VSS.t2355 VDD VDD sg13_lv_pmos ad=0.34p pd=2.68u as=0 ps=0 w=1u l=1u
X2114 VSS.t832 VDD VSS.t831 VSS.t830 sg13_lv_nmos ad=0.1428p pd=1.52u as=0 ps=0 w=0.42u l=1u
X2115 VDD VSS.t2805 VDD VDD sg13_lv_pmos ad=0.34p pd=2.68u as=0 ps=0 w=1u l=1u
X2116 a_25956_14488# a_25930_14452# VDD VDD sg13_lv_pmos ad=0.34p pd=2.68u as=0.36237p ps=2.605u w=1u l=0.13u
X2117 VDD a_4432_15454# a_4377_15549# VDD sg13_lv_pmos ad=2.8961p pd=18.25u as=93.45f ps=0.865u w=0.42u l=0.13u
X2118 VSS.t105 VDD VSS.t105 VSS.t562 sg13_lv_nmos ad=0.1428p pd=1.52u as=0 ps=0 w=0.42u l=1u
X2119 VDD VSS.t1247 VDD VDD sg13_lv_pmos ad=0.19p pd=1.38u as=0 ps=0 w=1u l=1u
X2120 VSS.t1572 VDD VSS.t1574 VSS.t1573 sg13_lv_nmos ad=79.8f pd=0.8u as=0 ps=0 w=0.42u l=1u
X2121 VSS.t1320 VDD VSS.t1320 VSS.t248 sg13_lv_nmos ad=79.8f pd=0.8u as=0 ps=0 w=0.42u l=1u
X2122 VSS.t1502 VDD VSS.t1504 VSS.t1503 sg13_lv_nmos ad=79.8f pd=0.8u as=0 ps=0 w=0.42u l=1u
X2123 VDD VSS.t2697 VDD VDD sg13_lv_pmos ad=0.19p pd=1.38u as=0 ps=0 w=1u l=1u
X2124 VSS.t1894 VDD VSS.t1893 VSS.t1892 sg13_lv_nmos ad=0.1428p pd=1.52u as=0 ps=0 w=0.42u l=1u
X2125 VSS.t47 a_37484_15960# counter_value_o[7] VSS.t46 sg13_lv_nmos ad=0.14875p pd=1.16u as=0.2886p ps=2.26u w=0.74u l=0.13u
X2126 VSS.t466 VDD VSS.t467 VSS.t19 sg13_lv_nmos ad=79.8f pd=0.8u as=0 ps=0 w=0.42u l=1u
X2127 VDD VSS.t459 VDD VDD sg13_lv_pmos ad=0.34p pd=2.68u as=0 ps=0 w=1u l=1u
X2128 VDD VSS.t1252 VDD VDD sg13_lv_pmos ad=0.19p pd=1.38u as=0 ps=0 w=1u l=1u
X2129 VDD VSS.t2756 VDD VDD sg13_lv_pmos ad=0.19p pd=1.38u as=0 ps=0 w=1u l=1u
X2130 VSS.t2436 VDD VSS.t2435 VSS.t2434 sg13_lv_nmos ad=0.1428p pd=1.52u as=0 ps=0 w=0.42u l=1u
X2131 VSS.t143 sg13cmos5l_nand4_1_0.Y a_14261_15238# VSS.t260 sg13_lv_nmos ad=0.3293p pd=1.63u as=0.2516p ps=2.16u w=0.74u l=0.13u
X2132 VSS.t9 a_17584_13942# a_17233_13799# VSS.t148 sg13_lv_nmos ad=79.8f pd=0.8u as=0.1428p ps=1.52u w=0.42u l=0.13u
X2133 VDD VSS.t2375 VDD VDD sg13_lv_pmos ad=0.34p pd=2.68u as=0 ps=0 w=1u l=1u
X2134 a_16596_15280# sg13cmos5l_or3_1_2.B a_16140_15424# VSS.t3243 sg13_lv_nmos ad=78.39999f pd=0.885u as=0.2176p ps=1.96u w=0.64u l=0.13u
X2135 a_7833_14607# a_6891_14495# a_7631_14845# VDD sg13_lv_pmos ad=93.45f pd=0.865u as=0.2048p ps=1.63u w=0.42u l=0.13u
X2136 a_16485_13701# sg13cmos5l_dfrbpq_1_2.CLK VSS.t105 VSS.t219 sg13_lv_nmos ad=0.2516p pd=2.16u as=15.38618p ps=0.10091m w=0.74u l=0.13u
X2137 VSS.t339 VDD VSS.t339 VSS.t345 sg13_lv_nmos ad=0.1428p pd=1.52u as=0 ps=0 w=0.42u l=1u
X2138 VSS.t47 VDD VSS.t47 VSS.t425 sg13_lv_nmos ad=0.1428p pd=1.52u as=0 ps=0 w=0.42u l=1u
X2139 VSS.t487 VDD VSS.t486 VSS.t19 sg13_lv_nmos ad=0.1428p pd=1.52u as=0 ps=0 w=0.42u l=1u
X2140 VDD VSS.t2016 VDD VDD sg13_lv_pmos ad=0.19p pd=1.38u as=0 ps=0 w=1u l=1u
X2141 VSS.t1984 VDD VSS.t1983 VSS.t1982 sg13_lv_nmos ad=0.1428p pd=1.52u as=0 ps=0 w=0.42u l=1u
X2142 VSS.t2501 VDD VSS.t2503 VSS.t2502 sg13_lv_nmos ad=79.8f pd=0.8u as=0 ps=0 w=0.42u l=1u
X2143 VDD VSS.t1569 VDD VDD sg13_lv_pmos ad=0.19p pd=1.38u as=0 ps=0 w=1u l=1u
X2144 a_17584_13942# a_17327_13799# a_17746_13722# VSS.t7 sg13_lv_nmos ad=0.1428p pd=1.52u as=37.8f ps=0.6u w=0.42u l=0.13u
X2145 VSS.t2669 VDD VSS.t2668 VSS.t199 sg13_lv_nmos ad=0.1428p pd=1.52u as=0 ps=0 w=0.42u l=1u
X2146 VSS.t1032 VDD VSS.t1031 VSS.t1030 sg13_lv_nmos ad=0.1428p pd=1.52u as=0 ps=0 w=0.42u l=1u
X2147 VDD VSS.t2721 VDD VDD sg13_lv_pmos ad=0.19p pd=1.38u as=0 ps=0 w=1u l=1u
X2148 VSS.t3054 VDD VSS.t3053 VSS.t3052 sg13_lv_nmos ad=0.1428p pd=1.52u as=0 ps=0 w=0.42u l=1u
X2149 VSS.t328 VDD VSS.t328 VSS.t329 sg13_lv_nmos ad=79.8f pd=0.8u as=0 ps=0 w=0.42u l=1u
X2150 VDD VSS.t1084 VDD VDD sg13_lv_pmos ad=0.19p pd=1.38u as=0 ps=0 w=1u l=1u
X2151 VDD VSS.t2958 VDD VDD sg13_lv_pmos ad=0.34p pd=2.68u as=0 ps=0 w=1u l=1u
X2152 VSS.t1522 VDD VSS.t1524 VSS.t1523 sg13_lv_nmos ad=79.8f pd=0.8u as=0 ps=0 w=0.42u l=1u
X2153 VSS.t1717 VDD VSS.t1716 VSS.t1715 sg13_lv_nmos ad=0.1428p pd=1.52u as=0 ps=0 w=0.42u l=1u
X2154 VDD VSS.t1534 VDD VDD sg13_lv_pmos ad=0.19p pd=1.38u as=0 ps=0 w=1u l=1u
X2155 VSS.t2731 VDD VSS.t2732 VSS.t199 sg13_lv_nmos ad=79.8f pd=0.8u as=0 ps=0 w=0.42u l=1u
X2156 VDD VSS.t2443 VDD VDD sg13_lv_pmos ad=0.19p pd=1.38u as=0 ps=0 w=1u l=1u
X2157 a_18454_16374# sg13cmos5l_or3_1_2.B VSS.t370 VSS.t3241 sg13_lv_nmos ad=0.1406p pd=1.12u as=0.1406p ps=1.12u w=0.74u l=0.15u
X2158 a_9732_15247# a_9963_15356# a_9418_15457# VSS.t2 sg13_lv_nmos ad=0.2373p pd=1.97u as=79.8f ps=0.8u w=0.42u l=0.13u
X2159 a_9670_15247# sg13cmos5l_tiehi_1.L_HI VSS.t3 VSS.t2 sg13_lv_nmos ad=37.8f pd=0.6u as=0.1701p ps=1.65u w=0.42u l=0.13u
X2160 a_25094_14484# a_24824_14525# VDD VDD sg13_lv_pmos ad=0.34p pd=2.68u as=0.1523p ps=1.38u w=1u l=0.5u
X2161 sg13cmos5l_dfrbpq_1_7.Q a_27882_14484# VDD VDD sg13_lv_pmos ad=0.3808p pd=2.92u as=0.2128p ps=1.5u w=1.12u l=0.13u
X2162 VSS.t2331 VDD VSS.t2333 VSS.t2332 sg13_lv_nmos ad=79.8f pd=0.8u as=0 ps=0 w=0.42u l=1u
X2163 VSS.t2049 VDD VSS.t2051 VSS.t2050 sg13_lv_nmos ad=79.8f pd=0.8u as=0 ps=0 w=0.42u l=1u
X2164 VSS.t643 VDD VSS.t643 VSS.t782 sg13_lv_nmos ad=0.1428p pd=1.52u as=0 ps=0 w=0.42u l=1u
X2165 a_7532_15960# sg13cmos5l_dlygate4sd3_1_1.A VSS.t31 VSS.t3227 sg13_lv_nmos ad=0.187p pd=1.78u as=0.14875p ps=1.16u w=0.55u l=0.13u
X2166 VSS.t1338 VDD VSS.t1338 VSS.t248 sg13_lv_nmos ad=79.8f pd=0.8u as=0 ps=0 w=0.42u l=1u
X2167 VDD VSS.t2732 VDD VDD sg13_lv_pmos ad=0.34p pd=2.68u as=0 ps=0 w=1u l=1u
X2168 VSS.t2004 VDD VSS.t2003 VSS.t2002 sg13_lv_nmos ad=0.1428p pd=1.52u as=0 ps=0 w=0.42u l=1u
X2169 VDD VSS.t1220 VDD VDD sg13_lv_pmos ad=0.19p pd=1.38u as=0 ps=0 w=1u l=1u
X2170 VSS.t1647 VDD VSS.t1646 VSS.t1645 sg13_lv_nmos ad=0.1428p pd=1.52u as=0 ps=0 w=0.42u l=1u
X2171 VSS.t3169 VDD VSS.t3168 VSS.t3167 sg13_lv_nmos ad=0.1428p pd=1.52u as=0 ps=0 w=0.42u l=1u
X2172 VDD VSS.t2704 VDD VDD sg13_lv_pmos ad=0.34p pd=2.68u as=0 ps=0 w=1u l=1u
X2173 VSS.t357 VDD VSS.t359 VSS.t358 sg13_lv_nmos ad=79.8f pd=0.8u as=0 ps=0 w=0.42u l=1u
X2174 a_10618_14448# sg13cmos5l_dlygate4sd3_1_8.A VSS.t6 VSS.t3265 sg13_lv_nmos ad=0.1428p pd=1.52u as=79.8f ps=0.8u w=0.42u l=0.13u
X2175 VDD VSS.t480 VDD VDD sg13_lv_pmos ad=0.34p pd=2.68u as=0 ps=0 w=1u l=1u
X2176 VDD VSS.t1711 VDD VDD sg13_lv_pmos ad=0.34p pd=2.68u as=0 ps=0 w=1u l=1u
X2177 VSS.t1547 VDD VSS.t1546 VSS.t1545 sg13_lv_nmos ad=0.1428p pd=1.52u as=0 ps=0 w=0.42u l=1u
X2178 VSS.t2456 VDD VSS.t2455 VSS.t2454 sg13_lv_nmos ad=0.1428p pd=1.52u as=0 ps=0 w=0.42u l=1u
X2179 VSS.t1562 VDD VSS.t1564 VSS.t1563 sg13_lv_nmos ad=79.8f pd=0.8u as=0 ps=0 w=0.42u l=1u
X2180 VDD VSS.t1051 VDD VDD sg13_lv_pmos ad=0.34p pd=2.68u as=0 ps=0 w=1u l=1u
X2181 VSS.t2774 VDD VSS.t2775 VSS.t199 sg13_lv_nmos ad=79.8f pd=0.8u as=0 ps=0 w=0.42u l=1u
X2182 VSS.t1954 VDD VSS.t1953 VSS.t1952 sg13_lv_nmos ad=0.1428p pd=1.52u as=0 ps=0 w=0.42u l=1u
X2183 VDD VSS.t1514 VDD VDD sg13_lv_pmos ad=0.19p pd=1.38u as=0 ps=0 w=1u l=1u
X2184 VDD VSS.t2978 VDD VDD sg13_lv_pmos ad=0.34p pd=2.68u as=0 ps=0 w=1u l=1u
X2185 VDD VSS.t3151 VDD VDD sg13_lv_pmos ad=0.19p pd=1.38u as=0 ps=0 w=1u l=1u
X2186 VSS.t1557 VDD VSS.t1559 VSS.t1558 sg13_lv_nmos ad=79.8f pd=0.8u as=0 ps=0 w=0.42u l=1u
X2187 VSS.t1737 VDD VSS.t1736 VSS.t1735 sg13_lv_nmos ad=0.1428p pd=1.52u as=0 ps=0 w=0.42u l=1u
X2188 VDD VSS.t1519 VDD VDD sg13_lv_pmos ad=0.19p pd=1.38u as=0 ps=0 w=1u l=1u
X2189 sg13cmos5l_buf_8_2.X a_19323_13726# VSS.t747 VSS.t3234 sg13_lv_nmos ad=0.1406p pd=1.12u as=0.1406p ps=1.12u w=0.74u l=0.13u
X2190 VSS.t2723 VDD VSS.t2724 VSS.t199 sg13_lv_nmos ad=79.8f pd=0.8u as=0 ps=0 w=0.42u l=1u
X2191 VDD VSS.t2688 VDD VDD sg13_lv_pmos ad=0.19p pd=1.38u as=0 ps=0 w=1u l=1u
X2192 VDD VSS.t2428 VDD VDD sg13_lv_pmos ad=0.19p pd=1.38u as=0 ps=0 w=1u l=1u
X2193 VSS.t15 VDD VSS.t15 VSS.t436 sg13_lv_nmos ad=0.1428p pd=1.52u as=0 ps=0 w=0.42u l=1u
X2194 VDD VSS.t34 VDD VDD sg13_lv_pmos ad=0.34p pd=2.68u as=0 ps=0 w=1u l=1u
X2195 VSS.t2999 VDD VSS.t2998 VSS.t2997 sg13_lv_nmos ad=0.1428p pd=1.52u as=0 ps=0 w=0.42u l=1u
X2196 VDD VSS.t1347 VDD VDD sg13_lv_pmos ad=0.34p pd=2.68u as=0 ps=0 w=1u l=1u
X2197 VSS.t2034 VDD VSS.t2036 VSS.t2035 sg13_lv_nmos ad=79.8f pd=0.8u as=0 ps=0 w=0.42u l=1u
X2198 VDD a_9658_14725# sg13cmos5l_tiehi_1.L_HI VDD sg13_lv_pmos ad=2.42015p pd=15.68u as=0.3927p ps=2.99u w=1.155u l=0.13u
X2199 VDD VSS.t2742 VDD VDD sg13_lv_pmos ad=0.34p pd=2.68u as=0 ps=0 w=1u l=1u
X2200 VDD VSS.t2553 VDD VDD sg13_lv_pmos ad=0.19p pd=1.38u as=0 ps=0 w=1u l=1u
X2201 VDD VSS.t1993 VDD VDD sg13_lv_pmos ad=0.34p pd=2.68u as=0 ps=0 w=1u l=1u
X2202 a_6789_14495# sg13cmos5l_dfrbpq_1_2.CLK VDD VDD sg13_lv_pmos ad=0.4088p pd=2.97u as=2.3367p ps=15.135u w=1.12u l=0.13u
X2203 VDD VSS.t1324 VDD VDD sg13_lv_pmos ad=0.19p pd=1.38u as=0 ps=0 w=1u l=1u
X2204 VDD sg13cmos5l_dfrbpq_1_3.Q sg13cmos5l_o21ai_1_2.A2 VDD sg13_lv_pmos ad=0.2128p pd=1.5u as=0.2128p ps=1.5u w=1.12u l=0.13u
X2205 a_25764_14922# sg13cmos5l_dfrbpq_1_7.D a_25670_14922# VSS.t0 sg13_lv_nmos ad=60.89999f pd=0.71u as=0.1428p ps=1.52u w=0.42u l=0.13u
X2206 a_24365_14508# sg13cmos5l_or3_1_2.B a_24263_14508# VDD sg13_lv_pmos ad=0.1575p pd=1.315u as=0.19p ps=1.38u w=1u l=0.13u
X2207 VDD VSS.t667 VDD VDD sg13_lv_pmos ad=0.19p pd=1.38u as=0 ps=0 w=1u l=1u
X2208 VSS.t1272 VDD VSS.t1273 VSS.t248 sg13_lv_nmos ad=79.8f pd=0.8u as=0 ps=0 w=0.42u l=1u
X2209 VDD VSS.t1676 VDD VDD sg13_lv_pmos ad=0.34p pd=2.68u as=0 ps=0 w=1u l=1u
X2210 VSS.t661 VDD VSS.t661 VSS.t794 sg13_lv_nmos ad=0.1428p pd=1.52u as=0 ps=0 w=0.42u l=1u
X2211 VDD VSS.t1731 VDD VDD sg13_lv_pmos ad=0.34p pd=2.68u as=0 ps=0 w=1u l=1u
X2212 VDD VSS.t1888 VDD VDD sg13_lv_pmos ad=0.34p pd=2.68u as=0 ps=0 w=1u l=1u
X2213 VSS.t1032 VDD VSS.t1031 VSS.t1030 sg13_lv_nmos ad=0.1428p pd=1.52u as=0 ps=0 w=0.42u l=1u
X2214 VDD VSS.t1014 VDD VDD sg13_lv_pmos ad=0.19p pd=1.38u as=0 ps=0 w=1u l=1u
X2215 VDD VSS.t2808 VDD VDD sg13_lv_pmos ad=0.34p pd=2.68u as=0 ps=0 w=1u l=1u
X2216 VDD a_26373_14495# a_26475_14495# VDD sg13_lv_pmos ad=2.42015p pd=15.68u as=0.3864p ps=2.93u w=1.12u l=0.13u
X2217 sg13cmos5l_or3_1_1.X a_24841_13726# VDD VDD sg13_lv_pmos ad=0.3808p pd=2.92u as=0.3822p ps=1.84u w=1.12u l=0.13u
X2218 VSS.t1361 VDD VSS.t1360 VSS.t248 sg13_lv_nmos ad=0.1428p pd=1.52u as=0 ps=0 w=0.42u l=1u
X2219 VDD VSS.t607 VDD VDD sg13_lv_pmos ad=0.34p pd=2.68u as=0 ps=0 w=1u l=1u
X2220 VDD VSS.t941 VDD VDD sg13_lv_pmos ad=0.34p pd=2.68u as=0 ps=0 w=1u l=1u
X2221 VSS.t1507 VDD VSS.t1509 VSS.t1508 sg13_lv_nmos ad=79.8f pd=0.8u as=0 ps=0 w=0.42u l=1u
X2222 VSS.t1899 VDD VSS.t1898 VSS.t1897 sg13_lv_nmos ad=0.1428p pd=1.52u as=0 ps=0 w=0.42u l=1u
X2223 a_21466_15202# sg13cmos5l_o21ai_1_1.Y VDD VDD sg13_lv_pmos ad=0.1428p pd=1.52u as=0.1523p ps=1.38u w=0.42u l=0.13u
X2224 VSS.t2984 VDD VSS.t2983 VSS.t2982 sg13_lv_nmos ad=0.1428p pd=1.52u as=0 ps=0 w=0.42u l=1u
X2225 VSS.t2820 VDD VSS.t2819 VSS.t199 sg13_lv_nmos ad=0.1428p pd=1.52u as=0 ps=0 w=0.42u l=1u
X2226 VSS.t2069 VDD VSS.t2071 VSS.t2070 sg13_lv_nmos ad=79.8f pd=0.8u as=0 ps=0 w=0.42u l=1u
X2227 VDD VSS.t2026 VDD VDD sg13_lv_pmos ad=0.19p pd=1.38u as=0 ps=0 w=1u l=1u
X2228 sg13cmos5l_dfrbpq_1_7.Q a_27882_14484# VSS.t39 VSS.t19 sg13_lv_nmos ad=0.2516p pd=2.16u as=0.1406p ps=1.12u w=0.74u l=0.13u
X2229 VDD VSS.t1254 VDD VDD sg13_lv_pmos ad=0.19p pd=1.38u as=0 ps=0 w=1u l=1u
X2230 VDD VSS.t2759 VDD VDD sg13_lv_pmos ad=0.19p pd=1.38u as=0 ps=0 w=1u l=1u
X2231 VSS.t2316 VDD VSS.t2318 VSS.t2317 sg13_lv_nmos ad=79.8f pd=0.8u as=0 ps=0 w=0.42u l=1u
X2232 VSS.t2441 VDD VSS.t2440 VSS.t2439 sg13_lv_nmos ad=0.1428p pd=1.52u as=0 ps=0 w=0.42u l=1u
X2233 VSS.t670 VDD VSS.t670 VSS.t800 sg13_lv_nmos ad=0.1428p pd=1.52u as=0 ps=0 w=0.42u l=1u
X2234 VDD VSS.t2380 VDD VDD sg13_lv_pmos ad=0.34p pd=2.68u as=0 ps=0 w=1u l=1u
X2235 VDD sg13cmos5l_tiehi_1.L_HI a_9418_15457# VDD sg13_lv_pmos ad=0.1563p pd=1.22u as=0.147p ps=1.54u w=0.42u l=0.13u
X2236 VDD VSS.t1526 VDD VDD sg13_lv_pmos ad=0.34p pd=2.68u as=0 ps=0 w=1u l=1u
X2237 VSS.t617 VDD VSS.t725 VSS.t724 sg13_lv_nmos ad=79.8f pd=0.8u as=0 ps=0 w=0.42u l=1u
X2238 VSS.t1607 VDD VSS.t1606 VSS.t1605 sg13_lv_nmos ad=0.1428p pd=1.52u as=0 ps=0 w=0.42u l=1u
X2239 VDD VSS.t816 VDD VDD sg13_lv_pmos ad=0.34p pd=2.68u as=0 ps=0 w=1u l=1u
X2240 VSS.t1254 VDD VSS.t1254 VSS.t248 sg13_lv_nmos ad=0.1428p pd=1.52u as=0 ps=0 w=0.42u l=1u
X2241 VDD VSS.t1709 VDD VDD sg13_lv_pmos ad=0.19p pd=1.38u as=0 ps=0 w=1u l=1u
X2242 VSS.t1989 VDD VSS.t1988 VSS.t1987 sg13_lv_nmos ad=0.1428p pd=1.52u as=0 ps=0 w=0.42u l=1u
X2243 VDD VSS.t2694 VDD VDD sg13_lv_pmos ad=0.34p pd=2.68u as=0 ps=0 w=1u l=1u
X2244 VSS.t2506 VDD VSS.t2508 VSS.t2507 sg13_lv_nmos ad=79.8f pd=0.8u as=0 ps=0 w=0.42u l=1u
X2245 VDD VSS.t418 VDD VDD sg13_lv_pmos ad=0.34p pd=2.68u as=0 ps=0 w=1u l=1u
X2246 VSS.t448 VDD VSS.t39 VSS.t19 sg13_lv_nmos ad=0.1428p pd=1.52u as=0 ps=0 w=0.42u l=1u
X2247 VSS.t583 VDD VSS.t585 VSS.t584 sg13_lv_nmos ad=79.8f pd=0.8u as=0 ps=0 w=0.42u l=1u
X2248 a_25786_15960# sg13cmos5l_o21ai_1_3.Y VDD VDD sg13_lv_pmos ad=0.1428p pd=1.52u as=0.1523p ps=1.38u w=0.42u l=0.13u
X2249 VDD VSS.t630 VDD VDD sg13_lv_pmos ad=0.34p pd=2.68u as=0 ps=0 w=1u l=1u
X2250 VDD VSS.t2081 VDD VDD sg13_lv_pmos ad=0.19p pd=1.38u as=0 ps=0 w=1u l=1u
X2251 VSS.t1727 VDD VSS.t1726 VSS.t1725 sg13_lv_nmos ad=0.1428p pd=1.52u as=0 ps=0 w=0.42u l=1u
X2252 VSS.t2671 VDD VSS.t2671 VSS.t199 sg13_lv_nmos ad=0.1428p pd=1.52u as=0 ps=0 w=0.42u l=1u
X2253 VSS.t2766 VDD VSS.t2767 VSS.t199 sg13_lv_nmos ad=79.8f pd=0.8u as=0 ps=0 w=0.42u l=1u
X2254 VSS.t852 VDD VSS.t851 VSS.t850 sg13_lv_nmos ad=0.1428p pd=1.52u as=0 ps=0 w=0.42u l=1u
X2255 VSS.t1290 VDD VSS.t1291 VSS.t248 sg13_lv_nmos ad=79.8f pd=0.8u as=0 ps=0 w=0.42u l=1u
X2256 VSS.t3024 VDD VSS.t3023 VSS.t3022 sg13_lv_nmos ad=0.1428p pd=1.52u as=0 ps=0 w=0.42u l=1u
X2257 VSS.t1214 VDD VSS.t1215 VSS.t248 sg13_lv_nmos ad=79.8f pd=0.8u as=0 ps=0 w=0.42u l=1u
X2258 VDD VSS.t1499 VDD VDD sg13_lv_pmos ad=0.19p pd=1.38u as=0 ps=0 w=1u l=1u
X2259 VDD VSS.t2963 VDD VDD sg13_lv_pmos ad=0.34p pd=2.68u as=0 ps=0 w=1u l=1u
X2260 VSS.t484 VDD VSS.t485 VSS.t19 sg13_lv_nmos ad=79.8f pd=0.8u as=0 ps=0 w=0.42u l=1u
X2261 VSS.t1722 VDD VSS.t1721 VSS.t1720 sg13_lv_nmos ad=0.1428p pd=1.52u as=0 ps=0 w=0.42u l=1u
X2262 VSS.t451 VDD VSS.t452 VSS.t19 sg13_lv_nmos ad=79.8f pd=0.8u as=0 ps=0 w=0.42u l=1u
X2263 a_21477_14495# sg13cmos5l_buf_8_2.X VSS.t19 VSS.t103 sg13_lv_nmos ad=0.2516p pd=2.16u as=3.8707p ps=25.555u w=0.74u l=0.13u
X2264 VDD VSS.t1504 VDD VDD sg13_lv_pmos ad=0.19p pd=1.38u as=0 ps=0 w=1u l=1u
X2265 VSS.t2811 VDD VSS.t2811 VSS.t199 sg13_lv_nmos ad=0.1428p pd=1.52u as=0 ps=0 w=0.42u l=1u
X2266 VSS.t2089 VDD VSS.t2091 VSS.t2090 sg13_lv_nmos ad=79.8f pd=0.8u as=0 ps=0 w=0.42u l=1u
X2267 VSS.t2301 VDD VSS.t2303 VSS.t2302 sg13_lv_nmos ad=79.8f pd=0.8u as=0 ps=0 w=0.42u l=1u
X2268 VDD VSS.t3153 VDD VDD sg13_lv_pmos ad=0.34p pd=2.68u as=0 ps=0 w=1u l=1u
X2269 VDD VSS.t2538 VDD VDD sg13_lv_pmos ad=0.19p pd=1.38u as=0 ps=0 w=1u l=1u
X2270 VDD VSS.t971 VDD VDD sg13_lv_pmos ad=0.34p pd=2.68u as=0 ps=0 w=1u l=1u
X2271 VSS.t1231 VDD VSS.t1232 VSS.t248 sg13_lv_nmos ad=79.8f pd=0.8u as=0 ps=0 w=0.42u l=1u
X2272 VSS.t1268 VDD VSS.t1266 VSS.t248 sg13_lv_nmos ad=0.1428p pd=1.52u as=0 ps=0 w=0.42u l=1u
X2273 VDD VSS.t1978 VDD VDD sg13_lv_pmos ad=0.34p pd=2.68u as=0 ps=0 w=1u l=1u
X2274 a_22149_16033# a_22149_16033# VSS.t21 VSS.t62 sg13_lv_nmos ad=0.111p pd=1.34u as=7.70437p ps=50.66u w=0.3u l=0.13u
X2275 VSS.t1299 VDD VSS.t1300 VSS.t248 sg13_lv_nmos ad=79.8f pd=0.8u as=0 ps=0 w=0.42u l=1u
X2276 VDD VSS.t1661 VDD VDD sg13_lv_pmos ad=0.34p pd=2.68u as=0 ps=0 w=1u l=1u
X2277 VSS.t1552 VDD VSS.t1551 VSS.t1550 sg13_lv_nmos ad=0.1428p pd=1.52u as=0 ps=0 w=0.42u l=1u
X2278 VSS.t2461 VDD VSS.t2460 VSS.t2459 sg13_lv_nmos ad=0.1428p pd=1.52u as=0 ps=0 w=0.42u l=1u
X2279 VDD VSS.t1056 VDD VDD sg13_lv_pmos ad=0.34p pd=2.68u as=0 ps=0 w=1u l=1u
X2280 VSS.t1007 VDD VSS.t1006 VSS.t1005 sg13_lv_nmos ad=0.1428p pd=1.52u as=0 ps=0 w=0.42u l=1u
X2281 VSS.t1567 VDD VSS.t1569 VSS.t1568 sg13_lv_nmos ad=79.8f pd=0.8u as=0 ps=0 w=0.42u l=1u
X2282 VSS.t2776 VDD VSS.t2777 VSS.t199 sg13_lv_nmos ad=79.8f pd=0.8u as=0 ps=0 w=0.42u l=1u
X2283 VSS.t466 VDD VSS.t465 VSS.t19 sg13_lv_nmos ad=0.1428p pd=1.52u as=0 ps=0 w=0.42u l=1u
X2284 VDD VSS.t871 VDD VDD sg13_lv_pmos ad=0.34p pd=2.68u as=0 ps=0 w=1u l=1u
X2285 VSS.t1304 VDD VSS.t1305 VSS.t248 sg13_lv_nmos ad=79.8f pd=0.8u as=0 ps=0 w=0.42u l=1u
X2286 VDD VSS.t1238 VDD VDD sg13_lv_pmos ad=0.34p pd=2.68u as=0 ps=0 w=1u l=1u
X2287 VSS.t625 VDD VSS.t625 VSS.t624 sg13_lv_nmos ad=0.1428p pd=1.52u as=0 ps=0 w=0.42u l=1u
X2288 VDD VSS.t607 VDD VDD sg13_lv_pmos ad=0.34p pd=2.68u as=0 ps=0 w=1u l=1u
X2289 VDD VSS.t2948 VDD VDD sg13_lv_pmos ad=0.34p pd=2.68u as=0 ps=0 w=1u l=1u
X2290 VDD VSS.t287 VDD VDD sg13_lv_pmos ad=0.34p pd=2.68u as=0 ps=0 w=1u l=1u
X2291 VSS.t1884 VDD VSS.t1883 VSS.t1882 sg13_lv_nmos ad=0.1428p pd=1.52u as=0 ps=0 w=0.42u l=1u
X2292 VSS.t578 VDD VSS.t577 VSS.t576 sg13_lv_nmos ad=0.1428p pd=1.52u as=0 ps=0 w=0.42u l=1u
X2293 VSS.t2969 VDD VSS.t2968 VSS.t2967 sg13_lv_nmos ad=0.1428p pd=1.52u as=0 ps=0 w=0.42u l=1u
X2294 VSS.t92 VDD VSS.t92 VSS.t638 sg13_lv_nmos ad=0.1428p pd=1.52u as=0 ps=0 w=0.42u l=1u
X2295 VSS.t1067 VDD VSS.t1069 VSS.t1068 sg13_lv_nmos ad=79.8f pd=0.8u as=0 ps=0 w=0.42u l=1u
X2296 VDD VSS.t1246 VDD VDD sg13_lv_pmos ad=0.19p pd=1.38u as=0 ps=0 w=1u l=1u
X2297 VDD VSS.t1350 VDD VDD sg13_lv_pmos ad=0.34p pd=2.68u as=0 ps=0 w=1u l=1u
X2298 VDD VSS.t2751 VDD VDD sg13_lv_pmos ad=0.19p pd=1.38u as=0 ps=0 w=1u l=1u
X2299 VSS.t2426 VDD VSS.t2425 VSS.t2424 sg13_lv_nmos ad=0.1428p pd=1.52u as=0 ps=0 w=0.42u l=1u
X2300 VSS.t2039 VDD VSS.t2041 VSS.t2040 sg13_lv_nmos ad=79.8f pd=0.8u as=0 ps=0 w=0.42u l=1u
X2301 VSS.t215 sg13cmos5l_or3_1_2.B a_21251_13690# VSS.t3246 sg13_lv_nmos ad=0.1045p pd=0.93u as=0.198p ps=1.27u w=0.55u l=0.13u
X2302 VSS.t1323 VDD VSS.t1324 VSS.t248 sg13_lv_nmos ad=79.8f pd=0.8u as=0 ps=0 w=0.42u l=1u
X2303 a_2724_15234# sg13cmos5l_and2_1_0.X a_2630_15234# VSS.t53 sg13_lv_nmos ad=60.89999f pd=0.71u as=0.1428p ps=1.52u w=0.42u l=0.13u
X2304 VSS.t548 VDD VSS.t550 VSS.t549 sg13_lv_nmos ad=79.8f pd=0.8u as=0 ps=0 w=0.42u l=1u
X2305 VDD VSS.t627 VDD VDD sg13_lv_pmos ad=0.19p pd=1.38u as=0 ps=0 w=1u l=1u
X2306 VDD VSS.t934 VDD VDD sg13_lv_pmos ad=0.19p pd=1.38u as=0 ps=0 w=1u l=1u
X2307 VDD VSS.t1511 VDD VDD sg13_lv_pmos ad=0.34p pd=2.68u as=0 ps=0 w=1u l=1u
X2308 VDD VSS.t2727 VDD VDD sg13_lv_pmos ad=0.34p pd=2.68u as=0 ps=0 w=1u l=1u
X2309 VSS.t2741 VDD VSS.t2741 VSS.t199 sg13_lv_nmos ad=0.1428p pd=1.52u as=0 ps=0 w=0.42u l=1u
X2310 VDD VSS.t403 VDD VDD sg13_lv_pmos ad=0.19p pd=1.38u as=0 ps=0 w=1u l=1u
X2311 VDD VSS.t1646 VDD VDD sg13_lv_pmos ad=0.34p pd=2.68u as=0 ps=0 w=1u l=1u
X2312 VSS.t2491 VDD VSS.t2493 VSS.t2492 sg13_lv_nmos ad=79.8f pd=0.8u as=0 ps=0 w=0.42u l=1u
X2313 VSS.t1537 VDD VSS.t1536 VSS.t1535 sg13_lv_nmos ad=0.1428p pd=1.52u as=0 ps=0 w=0.42u l=1u
X2314 VSS.t852 VDD VSS.t851 VSS.t850 sg13_lv_nmos ad=0.1428p pd=1.52u as=0 ps=0 w=0.42u l=1u
X2315 VSS.t2446 VDD VSS.t2445 VSS.t2444 sg13_lv_nmos ad=0.1428p pd=1.52u as=0 ps=0 w=0.42u l=1u
X2316 VDD VSS.t2066 VDD VDD sg13_lv_pmos ad=0.19p pd=1.38u as=0 ps=0 w=1u l=1u
X2317 VDD VSS.t34 VDD VDD sg13_lv_pmos ad=0.19p pd=1.38u as=0 ps=0 w=1u l=1u
X2318 VSS.t19 a_9861_15213# a_9963_15356# VSS.t63 sg13_lv_nmos ad=4.11262p pd=27.15u as=0.2516p ps=2.16u w=0.74u l=0.13u
X2319 VSS.t608 VDD VSS.t607 VSS.t606 sg13_lv_nmos ad=0.1428p pd=1.52u as=0 ps=0 w=0.42u l=1u
X2320 VSS.t1082 VDD VSS.t1084 VSS.t1083 sg13_lv_nmos ad=79.8f pd=0.8u as=0 ps=0 w=0.42u l=1u
X2321 VDD VSS.t1564 VDD VDD sg13_lv_pmos ad=0.19p pd=1.38u as=0 ps=0 w=1u l=1u
X2322 VDD VSS.t2018 VDD VDD sg13_lv_pmos ad=0.34p pd=2.68u as=0 ps=0 w=1u l=1u
X2323 VDD VSS.t1229 VDD VDD sg13_lv_pmos ad=0.34p pd=2.68u as=0 ps=0 w=1u l=1u
X2324 VDD VSS.t2790 VDD VDD sg13_lv_pmos ad=0.34p pd=2.68u as=0 ps=0 w=1u l=1u
X2325 a_2059_14832# sg13cmos5l_buf_1_10.X a_1965_14832# VSS.t188 sg13_lv_nmos ad=0.1216p pd=1.02u as=0.2176p ps=1.96u w=0.64u l=0.13u
X2326 VSS.t1512 VDD VSS.t1514 VSS.t1513 sg13_lv_nmos ad=79.8f pd=0.8u as=0 ps=0 w=0.42u l=1u
X2327 VSS.t2735 VDD VSS.t2735 VSS.t199 sg13_lv_nmos ad=0.1428p pd=1.52u as=0 ps=0 w=0.42u l=1u
X2328 VSS.t249 reset_n_i a_1192_9948# VSS.t248 sg13_lv_nmos ad=0.14875p pd=1.16u as=0.187p ps=1.78u w=0.55u l=0.13u
X2329 VDD VSS.t1222 VDD VDD sg13_lv_pmos ad=0.34p pd=2.68u as=0 ps=0 w=1u l=1u
X2330 VSS.t2074 VDD VSS.t2076 VSS.t2075 sg13_lv_nmos ad=79.8f pd=0.8u as=0 ps=0 w=0.42u l=1u
X2331 VDD VSS.t2031 VDD VDD sg13_lv_pmos ad=0.19p pd=1.38u as=0 ps=0 w=1u l=1u
X2332 VDD VSS.t901 VDD VDD sg13_lv_pmos ad=0.34p pd=2.68u as=0 ps=0 w=1u l=1u
X2333 VDD VSS.t1089 VDD VDD sg13_lv_pmos ad=0.19p pd=1.38u as=0 ps=0 w=1u l=1u
X2334 VDD VSS.t1257 VDD VDD sg13_lv_pmos ad=0.19p pd=1.38u as=0 ps=0 w=1u l=1u
X2335 VSS.t2784 VDD VSS.t2784 VSS.t199 sg13_lv_nmos ad=0.1428p pd=1.52u as=0 ps=0 w=0.42u l=1u
X2336 VSS.t2286 VDD VSS.t2288 VSS.t2287 sg13_lv_nmos ad=79.8f pd=0.8u as=0 ps=0 w=0.42u l=1u
X2337 VDD VSS.t339 VDD VDD sg13_lv_pmos ad=0.34p pd=2.68u as=0 ps=0 w=1u l=1u
X2338 VDD VSS.t2385 VDD VDD sg13_lv_pmos ad=0.34p pd=2.68u as=0 ps=0 w=1u l=1u
X2339 VDD sg13cmos5l_or3_1_1.B a_16168_15996# VDD sg13_lv_pmos ad=0.2114p pd=1.54u as=0.2856p ps=2.36u w=0.84u l=0.13u
X2340 VDD VSS.t1531 VDD VDD sg13_lv_pmos ad=0.34p pd=2.68u as=0 ps=0 w=1u l=1u
X2341 VDD VSS.t1704 VDD VDD sg13_lv_pmos ad=0.19p pd=1.38u as=0 ps=0 w=1u l=1u
X2342 VDD sg13cmos5l_dfrbpq_1_3.Q sg13cmos5l_or3_1_1.C VDD sg13_lv_pmos ad=0.2128p pd=1.5u as=0.2128p ps=1.5u w=1.12u l=0.13u
X2343 VSS.t1577 VDD VSS.t1576 VSS.t1575 sg13_lv_nmos ad=0.1428p pd=1.52u as=0 ps=0 w=0.42u l=1u
X2344 VSS.t1994 VDD VSS.t1993 VSS.t1992 sg13_lv_nmos ad=0.1428p pd=1.52u as=0 ps=0 w=0.42u l=1u
X2345 VDD VSS.t2698 VDD VDD sg13_lv_pmos ad=0.34p pd=2.68u as=0 ps=0 w=1u l=1u
X2346 VSS.t1007 VDD VSS.t1006 VSS.t1005 sg13_lv_nmos ad=0.1428p pd=1.52u as=0 ps=0 w=0.42u l=1u
X2347 VDD VSS.t964 VDD VDD sg13_lv_pmos ad=0.19p pd=1.38u as=0 ps=0 w=1u l=1u
X2348 VSS.t1052 VDD VSS.t1051 VSS.t1050 sg13_lv_nmos ad=0.1428p pd=1.52u as=0 ps=0 w=0.42u l=1u
X2349 VDD VSS.t2393 VDD VDD sg13_lv_pmos ad=0.19p pd=1.38u as=0 ps=0 w=1u l=1u
X2350 VDD VSS.t2086 VDD VDD sg13_lv_pmos ad=0.19p pd=1.38u as=0 ps=0 w=1u l=1u
X2351 a_7160_15242# sg13cmos5l_xnor2_1_2.A a_7058_15242# VSS.t252 sg13_lv_nmos ad=0.1406p pd=1.12u as=0.1406p ps=1.12u w=0.74u l=0.13u
X2352 VSS.t1331 VDD VSS.t1332 VSS.t248 sg13_lv_nmos ad=79.8f pd=0.8u as=0 ps=0 w=0.42u l=1u
X2353 VSS.t1732 VDD VSS.t1731 VSS.t1730 sg13_lv_nmos ad=0.1428p pd=1.52u as=0 ps=0 w=0.42u l=1u
X2354 VSS.t108 a_25774_15423# sg13cmos5l_dfrbpq_1_7.D VSS.t48 sg13_lv_nmos ad=0.1426p pd=1.16u as=0.2516p ps=2.16u w=0.74u l=0.13u
X2355 VSS.t2769 VDD VSS.t2770 VSS.t199 sg13_lv_nmos ad=79.8f pd=0.8u as=0 ps=0 w=0.42u l=1u
X2356 VDD VSS.t2706 VDD VDD sg13_lv_pmos ad=0.19p pd=1.38u as=0 ps=0 w=1u l=1u
X2357 VSS.t3029 VDD VSS.t3028 VSS.t3027 sg13_lv_nmos ad=0.1428p pd=1.52u as=0 ps=0 w=0.42u l=1u
X2358 VDD VSS.t483 VDD VDD sg13_lv_pmos ad=0.34p pd=2.68u as=0 ps=0 w=1u l=1u
X2359 VSS.t2411 VDD VSS.t2413 VSS.t2412 sg13_lv_nmos ad=79.8f pd=0.8u as=0 ps=0 w=0.42u l=1u
X2360 VSS.t460 VDD VSS.t459 VSS.t19 sg13_lv_nmos ad=0.1428p pd=1.52u as=0 ps=0 w=0.42u l=1u
X2361 VSS.t1497 VDD VSS.t1499 VSS.t1498 sg13_lv_nmos ad=79.8f pd=0.8u as=0 ps=0 w=0.42u l=1u
X2362 a_21166_16263# a_21281_16262# VSS.t56 VSS.t3280 sg13_lv_nmos ad=0.1428p pd=1.52u as=0.1426p ps=1.16u w=0.42u l=0.5u
X2363 VSS.t1067 VDD VSS.t1069 VSS.t1068 sg13_lv_nmos ad=79.8f pd=0.8u as=0 ps=0 w=0.42u l=1u
X2364 VDD VSS.t1313 VDD VDD sg13_lv_pmos ad=0.34p pd=2.68u as=0 ps=0 w=1u l=1u
X2365 VSS.t1252 VDD VSS.t1253 VSS.t248 sg13_lv_nmos ad=79.8f pd=0.8u as=0 ps=0 w=0.42u l=1u
X2366 VDD VSS.t50 VDD VDD sg13_lv_pmos ad=0.19p pd=1.38u as=0 ps=0 w=1u l=1u
X2367 VDD VSS.t864 VDD VDD sg13_lv_pmos ad=0.19p pd=1.38u as=0 ps=0 w=1u l=1u
X2368 VDD VSS.t1509 VDD VDD sg13_lv_pmos ad=0.19p pd=1.38u as=0 ps=0 w=1u l=1u
X2369 VDD VSS.t2418 VDD VDD sg13_lv_pmos ad=0.19p pd=1.38u as=0 ps=0 w=1u l=1u
X2370 VSS.t135 a_22426_15202# a_22145_15424# VSS.t48 sg13_lv_nmos ad=79.8f pd=0.8u as=0.1428p ps=1.52u w=0.42u l=0.5u
X2371 VDD VSS.t655 VDD VDD sg13_lv_pmos ad=0.19p pd=1.38u as=0 ps=0 w=1u l=1u
X2372 VSS.t2306 VDD VSS.t2308 VSS.t2307 sg13_lv_nmos ad=79.8f pd=0.8u as=0 ps=0 w=0.42u l=1u
X2373 VSS.t1350 VDD VSS.t1350 VSS.t248 sg13_lv_nmos ad=79.8f pd=0.8u as=0 ps=0 w=0.42u l=1u
X2374 VDD VSS.t1341 VDD VDD sg13_lv_pmos ad=0.34p pd=2.68u as=0 ps=0 w=1u l=1u
X2375 sg13cmos5l_or3_1_1.B a_14261_15238# VDD VDD sg13_lv_pmos ad=0.2128p pd=1.5u as=0.2128p ps=1.5u w=1.12u l=0.13u
X2376 a_17806_15423# a_17921_15424# VSS.t13 VSS.t234 sg13_lv_nmos ad=0.1428p pd=1.52u as=0.1426p ps=1.16u w=0.42u l=0.5u
X2377 VDD VSS.t630 VDD VDD sg13_lv_pmos ad=0.19p pd=1.38u as=0 ps=0 w=1u l=1u
X2378 VDD VSS.t979 VDD VDD sg13_lv_pmos ad=0.19p pd=1.38u as=0 ps=0 w=1u l=1u
X2379 VSS.t2767 VDD VSS.t2768 VSS.t199 sg13_lv_nmos ad=79.8f pd=0.8u as=0 ps=0 w=0.42u l=1u
X2380 VDD VSS.t2543 VDD VDD sg13_lv_pmos ad=0.19p pd=1.38u as=0 ps=0 w=1u l=1u
X2381 VSS.t2024 VDD VSS.t2026 VSS.t2025 sg13_lv_nmos ad=79.8f pd=0.8u as=0 ps=0 w=0.42u l=1u
X2382 VSS.t135 a_22576_14726# a_22225_14845# VSS.t0 sg13_lv_nmos ad=79.8f pd=0.8u as=0.1428p ps=1.52u w=0.42u l=0.13u
X2383 VDD VSS.t2718 VDD VDD sg13_lv_pmos ad=0.34p pd=2.68u as=0 ps=0 w=1u l=1u
X2384 VSS.t1527 VDD VSS.t1526 VSS.t1525 sg13_lv_nmos ad=0.1428p pd=1.52u as=0 ps=0 w=0.42u l=1u
X2385 a_27472_14726# sg13cmos5l_dfrbpq_1_7.RESET_B VDD VDD sg13_lv_pmos ad=79.8f pd=0.8u as=2.42015p ps=15.68u w=0.42u l=0.13u
X2386 a_8218_13690# sg13cmos5l_dlygate4sd3_1_1.A VDD VDD sg13_lv_pmos ad=0.1428p pd=1.52u as=0.1523p ps=1.38u w=0.42u l=0.13u
X2387 VSS.t744 sg13cmos5l_buf_8_2.A a_19323_13726# VSS.t3288 sg13_lv_nmos ad=0.1406p pd=1.12u as=0.1406p ps=1.12u w=0.74u l=0.13u
X2388 a_26148_14040# a_26122_13945# VSS.t34 VSS.t237 sg13_lv_nmos ad=0.2516p pd=2.16u as=0.1626p ps=1.415u w=0.74u l=0.13u
X2389 VDD VSS.t1264 VDD VDD sg13_lv_pmos ad=0.34p pd=2.68u as=0 ps=0 w=1u l=1u
X2390 VDD VSS.t2768 VDD VDD sg13_lv_pmos ad=0.34p pd=2.68u as=0 ps=0 w=1u l=1u
X2391 VDD VSS.t2043 VDD VDD sg13_lv_pmos ad=0.34p pd=2.68u as=0 ps=0 w=1u l=1u
X2392 VSS.t1082 VDD VSS.t1084 VSS.t1083 sg13_lv_nmos ad=79.8f pd=0.8u as=0 ps=0 w=0.42u l=1u
X2393 VDD VSS.t1322 VDD VDD sg13_lv_pmos ad=0.34p pd=2.68u as=0 ps=0 w=1u l=1u
X2394 a_17746_13722# sg13cmos5l_dfrbpq_1_2.RESET_B VSS.t9 VSS.t61 sg13_lv_nmos ad=37.8f pd=0.6u as=79.8f ps=0.8u w=0.42u l=0.13u
X2395 VSS.t1522 VDD VSS.t1521 VSS.t1520 sg13_lv_nmos ad=0.1428p pd=1.52u as=0 ps=0 w=0.42u l=1u
X2396 VSS.t2431 VDD VSS.t2430 VSS.t2429 sg13_lv_nmos ad=0.1428p pd=1.52u as=0 ps=0 w=0.42u l=1u
X2397 VDD VSS.t1726 VDD VDD sg13_lv_pmos ad=0.34p pd=2.68u as=0 ps=0 w=1u l=1u
X2398 VSS.t2761 VDD VSS.t2762 VSS.t199 sg13_lv_nmos ad=79.8f pd=0.8u as=0 ps=0 w=0.42u l=1u
X2399 VDD VSS.t2003 VDD VDD sg13_lv_pmos ad=0.34p pd=2.68u as=0 ps=0 w=1u l=1u
X2400 VDD VSS.t453 VDD VDD sg13_lv_pmos ad=0.34p pd=2.68u as=0 ps=0 w=1u l=1u
X2401 VSS.t583 VDD VSS.t585 VSS.t584 sg13_lv_nmos ad=79.8f pd=0.8u as=0 ps=0 w=0.42u l=1u
X2402 VSS.t942 VDD VSS.t941 VSS.t940 sg13_lv_nmos ad=0.1428p pd=1.52u as=0 ps=0 w=0.42u l=1u
X2403 VDD VSS.t2953 VDD VDD sg13_lv_pmos ad=0.34p pd=2.68u as=0 ps=0 w=1u l=1u
X2404 VSS.t2346 VDD VSS.t2348 VSS.t2347 sg13_lv_nmos ad=79.8f pd=0.8u as=0 ps=0 w=0.42u l=1u
X2405 a_2916_15552# a_2890_15457# VDD VDD sg13_lv_pmos ad=0.34p pd=2.68u as=0.36237p ps=2.605u w=1u l=0.13u
X2406 VDD VSS.t3126 VDD VDD sg13_lv_pmos ad=0.19p pd=1.38u as=0 ps=0 w=1u l=1u
X2407 VDD VSS.t2338 VDD VDD sg13_lv_pmos ad=0.19p pd=1.38u as=0 ps=0 w=1u l=1u
X2408 VDD a_9861_15213# a_9963_15356# VDD sg13_lv_pmos ad=2.8961p pd=18.25u as=0.3864p ps=2.93u w=1.12u l=0.13u
X2409 VDD VSS.t435 VDD VDD sg13_lv_pmos ad=0.19p pd=1.38u as=0 ps=0 w=1u l=1u
X2410 a_4078_14751# a_4193_14750# VDD VDD sg13_lv_pmos ad=0.34p pd=2.68u as=0.2254p ps=1.53u w=1u l=0.5u
X2411 a_22521_14607# a_21579_14495# a_22319_14845# VDD sg13_lv_pmos ad=93.45f pd=0.865u as=0.2048p ps=1.63u w=0.42u l=0.13u
X2412 VSS.t2776 VDD VSS.t2776 VSS.t199 sg13_lv_nmos ad=0.1428p pd=1.52u as=0 ps=0 w=0.42u l=1u
X2413 VDD VSS.t2733 VDD VDD sg13_lv_pmos ad=0.34p pd=2.68u as=0 ps=0 w=1u l=1u
X2414 VDD VSS.t946 VDD VDD sg13_lv_pmos ad=0.34p pd=2.68u as=0 ps=0 w=1u l=1u
X2415 VDD VSS.t2370 VDD VDD sg13_lv_pmos ad=0.34p pd=2.68u as=0 ps=0 w=1u l=1u
X2416 VSS.t817 VDD VSS.t816 VSS.t815 sg13_lv_nmos ad=0.1428p pd=1.52u as=0 ps=0 w=0.42u l=1u
X2417 VDD VSS.t1516 VDD VDD sg13_lv_pmos ad=0.34p pd=2.68u as=0 ps=0 w=1u l=1u
X2418 a_14261_15238# sg13cmos5l_nand4_1_0.Y VDD VDD sg13_lv_pmos ad=0.1596p pd=1.22u as=0.2856p ps=2.36u w=0.84u l=0.13u
X2419 VSS.t2154 VDD VSS.t2156 VSS.t2155 sg13_lv_nmos ad=79.8f pd=0.8u as=0 ps=0 w=0.42u l=1u
X2420 VDD VSS.t679 VDD VDD sg13_lv_pmos ad=0.19p pd=1.38u as=0 ps=0 w=1u l=1u
X2421 VDD VSS.t869 VDD VDD sg13_lv_pmos ad=0.19p pd=1.38u as=0 ps=0 w=1u l=1u
X2422 VSS.t673 VDD VSS.t673 VSS.t802 sg13_lv_nmos ad=0.1428p pd=1.52u as=0 ps=0 w=0.42u l=1u
X2423 VSS.t2726 VDD VSS.t2724 VSS.t199 sg13_lv_nmos ad=0.1428p pd=1.52u as=0 ps=0 w=0.42u l=1u
X2424 VDD VSS.t403 VDD VDD sg13_lv_pmos ad=0.34p pd=2.68u as=0 ps=0 w=1u l=1u
X2425 VSS.t1052 VDD VSS.t1051 VSS.t1050 sg13_lv_nmos ad=0.1428p pd=1.52u as=0 ps=0 w=0.42u l=1u
X2426 VDD VSS.t1706 VDD VDD sg13_lv_pmos ad=0.34p pd=2.68u as=0 ps=0 w=1u l=1u
X2427 VDD VSS.t821 VDD VDD sg13_lv_pmos ad=0.34p pd=2.68u as=0 ps=0 w=1u l=1u
X2428 VDD VSS.t492 VDD VDD sg13_lv_pmos ad=0.34p pd=2.68u as=0 ps=0 w=1u l=1u
X2429 VDD VSS.t1569 VDD VDD sg13_lv_pmos ad=0.19p pd=1.38u as=0 ps=0 w=1u l=1u
X2430 a_18021_14495# sg13cmos5l_buf_8_2.X VSS.t19 VSS.t107 sg13_lv_nmos ad=0.2516p pd=2.16u as=3.8707p ps=25.555u w=0.74u l=0.13u
X2431 VSS.t1212 VDD VSS.t1213 VSS.t248 sg13_lv_nmos ad=79.8f pd=0.8u as=0 ps=0 w=0.42u l=1u
X2432 VSS.t1248 VDD VSS.t1247 VSS.t248 sg13_lv_nmos ad=0.1428p pd=1.52u as=0 ps=0 w=0.42u l=1u
X2433 VDD VSS.t1232 VDD VDD sg13_lv_pmos ad=0.34p pd=2.68u as=0 ps=0 w=1u l=1u
X2434 VSS.t3014 VDD VSS.t3013 VSS.t3012 sg13_lv_nmos ad=0.1428p pd=1.52u as=0 ps=0 w=0.42u l=1u
X2435 VDD VSS.t2794 VDD VDD sg13_lv_pmos ad=0.34p pd=2.68u as=0 ps=0 w=1u l=1u
X2436 VDD VSS.t1340 VDD VDD sg13_lv_pmos ad=0.34p pd=2.68u as=0 ps=0 w=1u l=1u
X2437 VSS.t857 VDD VSS.t856 VSS.t855 sg13_lv_nmos ad=0.1428p pd=1.52u as=0 ps=0 w=0.42u l=1u
X2438 VSS.t125 a_12524_15960# counter_value_o[2] VSS.t124 sg13_lv_nmos ad=0.14875p pd=1.16u as=0.2886p ps=2.26u w=0.74u l=0.13u
X2439 a_17165_16020# sg13cmos5l_inv_1_0.Y a_17063_16020# VDD sg13_lv_pmos ad=0.1575p pd=1.315u as=0.19p ps=1.38u w=1u l=0.13u
X2440 VSS.t1217 VDD VSS.t1218 VSS.t248 sg13_lv_nmos ad=79.8f pd=0.8u as=0 ps=0 w=0.42u l=1u
X2441 VDD VSS.t2746 VDD VDD sg13_lv_pmos ad=0.19p pd=1.38u as=0 ps=0 w=1u l=1u
X2442 VSS.t2291 VDD VSS.t2293 VSS.t2292 sg13_lv_nmos ad=79.8f pd=0.8u as=0 ps=0 w=0.42u l=1u
X2443 VDD clock_i a_15579_14854# VDD sg13_lv_pmos ad=0.2128p pd=1.5u as=0.3808p ps=2.92u w=1.12u l=0.13u
X2444 VSS.t972 VDD VSS.t971 VSS.t970 sg13_lv_nmos ad=0.1428p pd=1.52u as=0 ps=0 w=0.42u l=1u
X2445 VSS.t2416 VDD VSS.t2415 VSS.t2414 sg13_lv_nmos ad=0.1428p pd=1.52u as=0 ps=0 w=0.42u l=1u
X2446 VSS.t620 VDD VSS.t620 VSS.t739 sg13_lv_nmos ad=79.8f pd=0.8u as=0 ps=0 w=0.42u l=1u
X2447 VDD VSS.t836 VDD VDD sg13_lv_pmos ad=0.34p pd=2.68u as=0 ps=0 w=1u l=1u
X2448 VDD VSS.t1501 VDD VDD sg13_lv_pmos ad=0.34p pd=2.68u as=0 ps=0 w=1u l=1u
X2449 VSS.t2759 VDD VSS.t2760 VSS.t199 sg13_lv_nmos ad=79.8f pd=0.8u as=0 ps=0 w=0.42u l=1u
X2450 VDD VSS.t658 VDD VDD sg13_lv_pmos ad=0.34p pd=2.68u as=0 ps=0 w=1u l=1u
X2451 VDD VSS.t1024 VDD VDD sg13_lv_pmos ad=0.19p pd=1.38u as=0 ps=0 w=1u l=1u
X2452 VSS.t1266 VDD VSS.t1265 VSS.t248 sg13_lv_nmos ad=0.1428p pd=1.52u as=0 ps=0 w=0.42u l=1u
X2453 VSS.t2139 VDD VSS.t2141 VSS.t2140 sg13_lv_nmos ad=79.8f pd=0.8u as=0 ps=0 w=0.42u l=1u
X2454 VDD VSS.t323 VDD VDD sg13_lv_pmos ad=0.19p pd=1.38u as=0 ps=0 w=1u l=1u
X2455 VSS.t339 VDD VSS.t339 VSS.t343 sg13_lv_nmos ad=0.1428p pd=1.52u as=0 ps=0 w=0.42u l=1u
X2456 sg13cmos5l_and2_1_0.X a_1965_14832# VDD VDD sg13_lv_pmos ad=0.3808p pd=2.92u as=0.1918p ps=1.5u w=1.12u l=0.13u
X2457 VSS.t603 VDD VSS.t605 VSS.t604 sg13_lv_nmos ad=79.8f pd=0.8u as=0 ps=0 w=0.42u l=1u
X2458 VSS.t1582 VDD VSS.t1581 VSS.t1580 sg13_lv_nmos ad=0.1428p pd=1.52u as=0 ps=0 w=0.42u l=1u
X2459 VDD VSS.t77 VDD VDD sg13_lv_pmos ad=0.34p pd=2.68u as=0 ps=0 w=1u l=1u
X2460 VSS.t2736 VDD VSS.t2736 VSS.t199 sg13_lv_nmos ad=0.1428p pd=1.52u as=0 ps=0 w=0.42u l=1u
X2461 VDD VSS.t2700 VDD VDD sg13_lv_pmos ad=0.34p pd=2.68u as=0 ps=0 w=1u l=1u
X2462 VSS.t578 VDD VSS.t577 VSS.t576 sg13_lv_nmos ad=0.1428p pd=1.52u as=0 ps=0 w=0.42u l=1u
X2463 VDD sg13cmos5l_dfrbpq_1_3.RESET_B a_17318_14922# VDD sg13_lv_pmos ad=0.36237p pd=2.605u as=79.8f ps=0.8u w=0.42u l=0.13u
X2464 VDD VSS.t1408 VDD VDD sg13_lv_pmos ad=0.34p pd=2.68u as=0 ps=0 w=1u l=1u
X2465 VDD VSS.t2760 VDD VDD sg13_lv_pmos ad=0.34p pd=2.68u as=0 ps=0 w=1u l=1u
X2466 VDD VSS.t2028 VDD VDD sg13_lv_pmos ad=0.34p pd=2.68u as=0 ps=0 w=1u l=1u
X2467 VDD VSS.t2398 VDD VDD sg13_lv_pmos ad=0.19p pd=1.38u as=0 ps=0 w=1u l=1u
X2468 VDD VSS.t2056 VDD VDD sg13_lv_pmos ad=0.19p pd=1.38u as=0 ps=0 w=1u l=1u
X2469 VSS.t548 VDD VSS.t550 VSS.t549 sg13_lv_nmos ad=79.8f pd=0.8u as=0 ps=0 w=0.42u l=1u
X2470 VSS.t872 VDD VSS.t871 VSS.t870 sg13_lv_nmos ad=0.1428p pd=1.52u as=0 ps=0 w=0.42u l=1u
X2471 VSS.t942 VDD VSS.t941 VSS.t940 sg13_lv_nmos ad=0.1428p pd=1.52u as=0 ps=0 w=0.42u l=1u
X2472 VSS.t1302 VDD VSS.t1303 VSS.t248 sg13_lv_nmos ad=79.8f pd=0.8u as=0 ps=0 w=0.42u l=1u
X2473 VSS.t1225 VDD VSS.t1226 VSS.t248 sg13_lv_nmos ad=79.8f pd=0.8u as=0 ps=0 w=0.42u l=1u
X2474 VDD VSS.t480 VDD VDD sg13_lv_pmos ad=0.34p pd=2.68u as=0 ps=0 w=1u l=1u
X2475 VDD VSS.t899 VDD VDD sg13_lv_pmos ad=0.19p pd=1.38u as=0 ps=0 w=1u l=1u
X2476 VDD VSS.t1711 VDD VDD sg13_lv_pmos ad=0.34p pd=2.68u as=0 ps=0 w=1u l=1u
X2477 VSS.t3034 VDD VSS.t3033 VSS.t3032 sg13_lv_nmos ad=0.1428p pd=1.52u as=0 ps=0 w=0.42u l=1u
X2478 VSS.t2753 VDD VSS.t2754 VSS.t199 sg13_lv_nmos ad=79.8f pd=0.8u as=0 ps=0 w=0.42u l=1u
X2479 VDD VSS.t2938 VDD VDD sg13_lv_pmos ad=0.34p pd=2.68u as=0 ps=0 w=1u l=1u
X2480 a_6180_14922# sg13cmos5l_and2_1_1.X a_6086_14922# VSS.t3271 sg13_lv_nmos ad=60.89999f pd=0.71u as=0.1428p ps=1.52u w=0.42u l=0.13u
X2481 VDD VSS.t1064 VDD VDD sg13_lv_pmos ad=0.19p pd=1.38u as=0 ps=0 w=1u l=1u
X2482 VSS.t2511 VDD VSS.t2510 VSS.t2509 sg13_lv_nmos ad=0.1428p pd=1.52u as=0 ps=0 w=0.42u l=1u
X2483 VSS.t2923 VDD VSS.t2806 VSS.t199 sg13_lv_nmos ad=79.8f pd=0.8u as=0 ps=0 w=0.42u l=1u
X2484 sg13cmos5l_buf_8_2.X a_19323_13726# VSS.t744 VSS.t3232 sg13_lv_nmos ad=0.1406p pd=1.12u as=0.1406p ps=1.12u w=0.74u l=0.13u
X2485 VDD VSS.t1514 VDD VDD sg13_lv_pmos ad=0.19p pd=1.38u as=0 ps=0 w=1u l=1u
X2486 VDD VSS.t2423 VDD VDD sg13_lv_pmos ad=0.19p pd=1.38u as=0 ps=0 w=1u l=1u
X2487 sg13cmos5l_or3_1_2.B a_16168_15996# VSS.t263 VSS.t3267 sg13_lv_nmos ad=0.2886p pd=2.26u as=0.14875p ps=1.16u w=0.74u l=0.13u
X2488 VSS.t627 VDD VSS.t630 VSS.t629 sg13_lv_nmos ad=79.8f pd=0.8u as=0 ps=0 w=0.42u l=1u
X2489 VSS.t608 VDD VSS.t607 VSS.t606 sg13_lv_nmos ad=0.1428p pd=1.52u as=0 ps=0 w=0.42u l=1u
X2490 VSS.t817 VDD VSS.t816 VSS.t815 sg13_lv_nmos ad=0.1428p pd=1.52u as=0 ps=0 w=0.42u l=1u
X2491 VDD VSS.t991 VDD VDD sg13_lv_pmos ad=0.34p pd=2.68u as=0 ps=0 w=1u l=1u
X2492 VSS.t371 VDD VSS.t373 VSS.t372 sg13_lv_nmos ad=79.8f pd=0.8u as=0 ps=0 w=0.42u l=1u
X2493 VDD a_6789_14495# a_6891_14495# VDD sg13_lv_pmos ad=2.42015p pd=15.68u as=0.3864p ps=2.93u w=1.12u l=0.13u
X2494 VSS.t1280 VDD VSS.t1279 VSS.t248 sg13_lv_nmos ad=0.1428p pd=1.52u as=0 ps=0 w=0.42u l=1u
X2495 VSS.t2029 VDD VSS.t2031 VSS.t2030 sg13_lv_nmos ad=79.8f pd=0.8u as=0 ps=0 w=0.42u l=1u
X2496 VSS.t2751 VDD VSS.t2752 VSS.t199 sg13_lv_nmos ad=79.8f pd=0.8u as=0 ps=0 w=0.42u l=1u
X2497 VSS.t1532 VDD VSS.t1531 VSS.t1530 sg13_lv_nmos ad=0.1428p pd=1.52u as=0 ps=0 w=0.42u l=1u
X2498 VDD a_21166_16263# sg13cmos5l_dfrbpq_1_6.D VDD sg13_lv_pmos ad=0.2254p pd=1.53u as=0.4256p ps=3u w=1.12u l=0.13u
X2499 VSS.t1702 VDD VSS.t1704 VSS.t1703 sg13_lv_nmos ad=79.8f pd=0.8u as=0 ps=0 w=0.42u l=1u
X2500 VDD VSS.t482 VDD VDD sg13_lv_pmos ad=0.19p pd=1.38u as=0 ps=0 w=1u l=1u
X2501 VSS.t2094 VDD VSS.t2093 VSS.t2092 sg13_lv_nmos ad=0.1428p pd=1.52u as=0 ps=0 w=0.42u l=1u
X2502 VSS.t550 VDD VSS.t550 VSS.t552 sg13_lv_nmos ad=79.8f pd=0.8u as=0 ps=0 w=0.42u l=1u
X2503 VDD VSS.t2752 VDD VDD sg13_lv_pmos ad=0.34p pd=2.68u as=0 ps=0 w=1u l=1u
X2504 VDD VSS.t2048 VDD VDD sg13_lv_pmos ad=0.34p pd=2.68u as=0 ps=0 w=1u l=1u
X2505 VDD VSS.t263 VDD VDD sg13_lv_pmos ad=0.19p pd=1.38u as=0 ps=0 w=1u l=1u
X2506 VSS.t627 VDD VSS.t627 VSS.t755 sg13_lv_nmos ad=79.8f pd=0.8u as=0 ps=0 w=0.42u l=1u
X2507 VSS.t1284 VDD VSS.t1283 VSS.t248 sg13_lv_nmos ad=0.1428p pd=1.52u as=0 ps=0 w=0.42u l=1u
X2508 VDD VSS.t1054 VDD VDD sg13_lv_pmos ad=0.19p pd=1.38u as=0 ps=0 w=1u l=1u
X2509 VSS.t1208 VDD VSS.t1207 VSS.t248 sg13_lv_nmos ad=0.1428p pd=1.52u as=0 ps=0 w=0.42u l=1u
X2510 VSS.t1451 VDD VSS.t1317 VSS.t248 sg13_lv_nmos ad=79.8f pd=0.8u as=0 ps=0 w=0.42u l=1u
X2511 VSS.t2276 VDD VSS.t2278 VSS.t2277 sg13_lv_nmos ad=79.8f pd=0.8u as=0 ps=0 w=0.42u l=1u
X2512 VSS.t478 VDD VSS.t477 VSS.t19 sg13_lv_nmos ad=0.1428p pd=1.52u as=0 ps=0 w=0.42u l=1u
X2513 a_27898_15202# sg13cmos5l_dfrbpq_1_5.Q VDD VDD sg13_lv_pmos ad=0.1428p pd=1.52u as=0.1523p ps=1.38u w=0.42u l=0.13u
X2514 VDD VSS.t1731 VDD VDD sg13_lv_pmos ad=0.34p pd=2.68u as=0 ps=0 w=1u l=1u
X2515 VDD VSS.t2008 VDD VDD sg13_lv_pmos ad=0.34p pd=2.68u as=0 ps=0 w=1u l=1u
X2516 VDD VSS.t1224 VDD VDD sg13_lv_pmos ad=0.34p pd=2.68u as=0 ps=0 w=1u l=1u
X2517 VSS.t2351 VDD VSS.t2353 VSS.t2352 sg13_lv_nmos ad=79.8f pd=0.8u as=0 ps=0 w=0.42u l=1u
X2518 VSS.t857 VDD VSS.t856 VSS.t855 sg13_lv_nmos ad=0.1428p pd=1.52u as=0 ps=0 w=0.42u l=1u
X2519 VDD VSS.t3131 VDD VDD sg13_lv_pmos ad=0.19p pd=1.38u as=0 ps=0 w=1u l=1u
X2520 VDD VSS.t769 VDD VDD sg13_lv_pmos ad=0.19p pd=1.38u as=0 ps=0 w=1u l=1u
X2521 VSS.t1087 VDD VSS.t1089 VSS.t1088 sg13_lv_nmos ad=79.8f pd=0.8u as=0 ps=0 w=0.42u l=1u
X2522 VSS.t972 VDD VSS.t971 VSS.t970 sg13_lv_nmos ad=0.1428p pd=1.52u as=0 ps=0 w=0.42u l=1u
X2523 VSS.t197 sg13cmos5l_dfrbpq_1_2.Q a_16552_15996# VSS.t269 sg13_lv_nmos ad=0.14875p pd=1.16u as=0.187p ps=1.78u w=0.55u l=0.13u
X2524 VSS.t45 VDD VSS.t45 VSS.t408 sg13_lv_nmos ad=79.8f pd=0.8u as=0 ps=0 w=0.42u l=1u
X2525 VSS.t555 VDD VSS.t105 VSS.t559 sg13_lv_nmos ad=79.8f pd=0.8u as=0 ps=0 w=0.42u l=1u
X2526 VSS.t2779 VDD VSS.t2778 VSS.t199 sg13_lv_nmos ad=0.1428p pd=1.52u as=0 ps=0 w=0.42u l=1u
X2527 a_21348_14909# a_21579_14495# a_21034_14452# VSS.t3296 sg13_lv_nmos ad=0.2373p pd=1.97u as=79.8f ps=0.8u w=0.42u l=0.13u
X2528 VDD VSS.t2716 VDD VDD sg13_lv_pmos ad=0.34p pd=2.68u as=0 ps=0 w=1u l=1u
X2529 VSS.t318 VDD VSS.t318 VSS.t321 sg13_lv_nmos ad=79.8f pd=0.8u as=0 ps=0 w=0.42u l=1u
X2530 VDD VSS.t1069 VDD VDD sg13_lv_pmos ad=0.19p pd=1.38u as=0 ps=0 w=1u l=1u
X2531 VDD a_27898_15202# a_27617_15424# VDD sg13_lv_pmos ad=0.1523p pd=1.38u as=0.34p ps=2.68u w=1u l=0.5u
X2532 VDD VSS.t462 VDD VDD sg13_lv_pmos ad=0.34p pd=2.68u as=0 ps=0 w=1u l=1u
X2533 VSS.t2124 VDD VSS.t2126 VSS.t2125 sg13_lv_nmos ad=79.8f pd=0.8u as=0 ps=0 w=0.42u l=1u
X2534 VDD VSS.t1287 VDD VDD sg13_lv_pmos ad=0.19p pd=1.38u as=0 ps=0 w=1u l=1u
X2535 VSS.t1567 VDD VSS.t1566 VSS.t1565 sg13_lv_nmos ad=0.1428p pd=1.52u as=0 ps=0 w=0.42u l=1u
X2536 VDD VSS.t2789 VDD VDD sg13_lv_pmos ad=0.19p pd=1.38u as=0 ps=0 w=1u l=1u
X2537 VSS.t2496 VDD VSS.t2495 VSS.t2494 sg13_lv_nmos ad=0.1428p pd=1.52u as=0 ps=0 w=0.42u l=1u
X2538 VDD VSS.t1526 VDD VDD sg13_lv_pmos ad=0.34p pd=2.68u as=0 ps=0 w=1u l=1u
X2539 VSS.t2729 VDD VSS.t2728 VSS.t199 sg13_lv_nmos ad=0.1428p pd=1.52u as=0 ps=0 w=0.42u l=1u
X2540 VDD VSS.t2692 VDD VDD sg13_lv_pmos ad=0.34p pd=2.68u as=0 ps=0 w=1u l=1u
X2541 VDD VSS.t2435 VDD VDD sg13_lv_pmos ad=0.34p pd=2.68u as=0 ps=0 w=1u l=1u
X2542 VSS.t872 VDD VSS.t871 VSS.t870 sg13_lv_nmos ad=0.1428p pd=1.52u as=0 ps=0 w=0.42u l=1u
X2543 VSS.t1298 VDD VSS.t1297 VSS.t248 sg13_lv_nmos ad=0.1428p pd=1.52u as=0 ps=0 w=0.42u l=1u
X2544 VDD VSS.t640 VDD VDD sg13_lv_pmos ad=0.19p pd=1.38u as=0 ps=0 w=1u l=1u
X2545 VDD VSS.t829 VDD VDD sg13_lv_pmos ad=0.19p pd=1.38u as=0 ps=0 w=1u l=1u
X2546 VSS.t776 VDD VSS.t36 VSS.t775 sg13_lv_nmos ad=0.1428p pd=1.52u as=0 ps=0 w=0.42u l=1u
X2547 VDD VSS.t2383 VDD VDD sg13_lv_pmos ad=0.19p pd=1.38u as=0 ps=0 w=1u l=1u
X2548 VDD VSS.t2041 VDD VDD sg13_lv_pmos ad=0.19p pd=1.38u as=0 ps=0 w=1u l=1u
X2549 VSS.t2044 VDD VSS.t2043 VSS.t2042 sg13_lv_nmos ad=0.1428p pd=1.52u as=0 ps=0 w=0.42u l=1u
X2550 VSS.t1329 VDD VSS.t1330 VSS.t248 sg13_lv_nmos ad=79.8f pd=0.8u as=0 ps=0 w=0.42u l=1u
X2551 a_26148_14040# a_26122_13945# VDD VDD sg13_lv_pmos ad=0.34p pd=2.68u as=0.36237p ps=2.605u w=1u l=0.13u
X2552 VDD VSS.t1235 VDD VDD sg13_lv_pmos ad=0.34p pd=2.68u as=0 ps=0 w=1u l=1u
X2553 VSS.t3019 VDD VSS.t3018 VSS.t3017 sg13_lv_nmos ad=0.1428p pd=1.52u as=0 ps=0 w=0.42u l=1u
X2554 VSS.t440 VDD VSS.t440 VSS.t511 sg13_lv_nmos ad=79.8f pd=0.8u as=0 ps=0 w=0.42u l=1u
X2555 VSS.t1057 VDD VSS.t1056 VSS.t1055 sg13_lv_nmos ad=0.1428p pd=1.52u as=0 ps=0 w=0.42u l=1u
X2556 VDD VSS.t1233 VDD VDD sg13_lv_pmos ad=0.34p pd=2.68u as=0 ps=0 w=1u l=1u
X2557 VDD VSS.t471 VDD VDD sg13_lv_pmos ad=0.34p pd=2.68u as=0 ps=0 w=1u l=1u
X2558 VSS.t1334 VDD VSS.t1335 VSS.t248 sg13_lv_nmos ad=79.8f pd=0.8u as=0 ps=0 w=0.42u l=1u
X2559 VSS.t670 VDD VSS.t673 VSS.t801 sg13_lv_nmos ad=79.8f pd=0.8u as=0 ps=0 w=0.42u l=1u
X2560 VDD VSS.t921 VDD VDD sg13_lv_pmos ad=0.34p pd=2.68u as=0 ps=0 w=1u l=1u
X2561 VDD VSS.t1499 VDD VDD sg13_lv_pmos ad=0.19p pd=1.38u as=0 ps=0 w=1u l=1u
X2562 VSS.t2797 VDD VSS.t2798 VSS.t199 sg13_lv_nmos ad=79.8f pd=0.8u as=0 ps=0 w=0.42u l=1u
X2563 VSS.t2296 VDD VSS.t2298 VSS.t2297 sg13_lv_nmos ad=79.8f pd=0.8u as=0 ps=0 w=0.42u l=1u
X2564 VSS.t2771 VDD VSS.t2771 VSS.t199 sg13_lv_nmos ad=0.1428p pd=1.52u as=0 ps=0 w=0.42u l=1u
X2565 VDD VSS.t1506 VDD VDD sg13_lv_pmos ad=0.34p pd=2.68u as=0 ps=0 w=1u l=1u
X2566 VDD VSS.t1679 VDD VDD sg13_lv_pmos ad=0.19p pd=1.38u as=0 ps=0 w=1u l=1u
X2567 VSS.t1517 VDD VSS.t1516 VSS.t1515 sg13_lv_nmos ad=0.1428p pd=1.52u as=0 ps=0 w=0.42u l=1u
X2568 VSS.t1587 VDD VSS.t1586 VSS.t1585 sg13_lv_nmos ad=0.1428p pd=1.52u as=0 ps=0 w=0.42u l=1u
X2569 sg13cmos5l_or3_1_1.C sg13cmos5l_o21ai_1_2.B1 a_24062_15242# VSS.t48 sg13_lv_nmos ad=0.2516p pd=2.16u as=0.1406p ps=1.12u w=0.74u l=0.13u
X2570 VDD VSS.t2683 VDD VDD sg13_lv_pmos ad=0.34p pd=2.68u as=0 ps=0 w=1u l=1u
X2571 VDD VSS.t984 VDD VDD sg13_lv_pmos ad=0.19p pd=1.38u as=0 ps=0 w=1u l=1u
X2572 VSS.t3 sg13cmos5l_and2_1_2.B a_8779_14832# VSS.t42 sg13_lv_nmos ad=0.1331p pd=1.12u as=0.1216p ps=1.02u w=0.64u l=0.13u
X2573 a_27407_13799# a_26565_13701# a_27313_13799# VSS.t203 sg13_lv_nmos ad=0.12665p pd=1.145u as=0.1428p ps=1.52u w=0.42u l=0.13u
X2574 VDD VSS.t1257 VDD VDD sg13_lv_pmos ad=0.34p pd=2.68u as=0 ps=0 w=1u l=1u
X2575 VDD VSS.t2033 VDD VDD sg13_lv_pmos ad=0.34p pd=2.68u as=0 ps=0 w=1u l=1u
X2576 VDD VSS.t2403 VDD VDD sg13_lv_pmos ad=0.19p pd=1.38u as=0 ps=0 w=1u l=1u
X2577 VDD VSS.t2061 VDD VDD sg13_lv_pmos ad=0.19p pd=1.38u as=0 ps=0 w=1u l=1u
X2578 a_6660_14909# a_6372_14488# a_6598_14909# VSS.t132 sg13_lv_nmos ad=0.1428p pd=1.52u as=37.8f ps=0.6u w=0.42u l=0.13u
X2579 a_25203_13320# sg13cmos5l_a21oi_1_3.A2 VSS.t77 VSS.t225 sg13_lv_nmos ad=0.1406p pd=1.12u as=0.2516p ps=2.16u w=0.74u l=0.13u
X2580 VSS.t1707 VDD VSS.t1706 VSS.t1705 sg13_lv_nmos ad=0.1428p pd=1.52u as=0 ps=0 w=0.42u l=1u
X2581 VDD VSS.t911 VDD VDD sg13_lv_pmos ad=0.34p pd=2.68u as=0 ps=0 w=1u l=1u
X2582 VSS.t90 clock_i a_15579_14854# VSS.t3251 sg13_lv_nmos ad=0.1406p pd=1.12u as=0.1406p ps=1.12u w=0.74u l=0.13u
X2583 VDD VSS.t1325 VDD VDD sg13_lv_pmos ad=0.34p pd=2.68u as=0 ps=0 w=1u l=1u
X2584 a_17892_14909# a_18123_14495# a_17578_14452# VSS.t51 sg13_lv_nmos ad=0.2373p pd=1.97u as=79.8f ps=0.8u w=0.42u l=0.13u
X2585 a_17961_14531# a_17604_14488# VDD VDD sg13_lv_pmos ad=63f pd=0.72u as=0.1563p ps=1.22u w=0.42u l=0.13u
X2586 VDD VSS.t550 VDD VDD sg13_lv_pmos ad=0.34p pd=2.68u as=0 ps=0 w=1u l=1u
X2587 VDD VSS.t658 VDD VDD sg13_lv_pmos ad=0.19p pd=1.38u as=0 ps=0 w=1u l=1u
X2588 VSS.t1087 VDD VSS.t1089 VSS.t1088 sg13_lv_nmos ad=79.8f pd=0.8u as=0 ps=0 w=0.42u l=1u
X2589 VSS.t2516 VDD VSS.t2515 VSS.t2514 sg13_lv_nmos ad=0.1428p pd=1.52u as=0 ps=0 w=0.42u l=1u
X2590 VDD a_32492_15960# counter_value_o[6] VDD sg13_lv_pmos ad=0.2114p pd=1.54u as=0.42p ps=2.99u w=1.12u l=0.13u
X2591 VSS.t652 VDD VSS.t652 VSS.t788 sg13_lv_nmos ad=0.1428p pd=1.52u as=0 ps=0 w=0.42u l=1u
X2592 VDD VSS.t1288 VDD VDD sg13_lv_pmos ad=0.19p pd=1.38u as=0 ps=0 w=1u l=1u
X2593 VDD VSS.t2088 VDD VDD sg13_lv_pmos ad=0.34p pd=2.68u as=0 ps=0 w=1u l=1u
X2594 a_17126_15238# a_16856_15238# VSS.t13 VSS.t71 sg13_lv_nmos ad=0.1428p pd=1.52u as=79.8f ps=0.8u w=0.42u l=0.5u
X2595 VSS.t947 VDD VSS.t946 VSS.t945 sg13_lv_nmos ad=0.1428p pd=1.52u as=0 ps=0 w=0.42u l=1u
X2596 VDD VSS.t3211 VDD VDD sg13_lv_pmos ad=0.19p pd=1.38u as=0 ps=0 w=1u l=1u
X2597 VSS.t2281 VDD VSS.t2283 VSS.t2282 sg13_lv_nmos ad=79.8f pd=0.8u as=0 ps=0 w=0.42u l=1u
X2598 VSS.t1268 VDD VSS.t1269 VSS.t248 sg13_lv_nmos ad=79.8f pd=0.8u as=0 ps=0 w=0.42u l=1u
X2599 VDD VSS.t2706 VDD VDD sg13_lv_pmos ad=0.34p pd=2.68u as=0 ps=0 w=1u l=1u
X2600 VSS.t2754 VDD VSS.t2755 VSS.t199 sg13_lv_nmos ad=79.8f pd=0.8u as=0 ps=0 w=0.42u l=1u
X2601 VSS.t1502 VDD VSS.t1501 VSS.t1500 sg13_lv_nmos ad=0.1428p pd=1.52u as=0 ps=0 w=0.42u l=1u
X2602 VSS.t174 a_21466_15202# a_21185_15424# VSS.t173 sg13_lv_nmos ad=79.8f pd=0.8u as=0.1428p ps=1.52u w=0.42u l=0.5u
X2603 VDD VSS.t951 VDD VDD sg13_lv_pmos ad=0.34p pd=2.68u as=0 ps=0 w=1u l=1u
X2604 VDD VSS.t1511 VDD VDD sg13_lv_pmos ad=0.34p pd=2.68u as=0 ps=0 w=1u l=1u
X2605 VDD VSS.t2420 VDD VDD sg13_lv_pmos ad=0.34p pd=2.68u as=0 ps=0 w=1u l=1u
X2606 VSS.t822 VDD VSS.t821 VSS.t820 sg13_lv_nmos ad=0.1428p pd=1.52u as=0 ps=0 w=0.42u l=1u
X2607 VDD VSS.t1250 VDD VDD sg13_lv_pmos ad=0.34p pd=2.68u as=0 ps=0 w=1u l=1u
X2608 VDD VSS.t2755 VDD VDD sg13_lv_pmos ad=0.34p pd=2.68u as=0 ps=0 w=1u l=1u
X2609 VSS.t2311 VDD VSS.t2310 VSS.t2309 sg13_lv_nmos ad=0.1428p pd=1.52u as=0 ps=0 w=0.42u l=1u
X2610 VSS.t197 a_18106_15960# a_17825_16262# VSS.t3226 sg13_lv_nmos ad=79.8f pd=0.8u as=0.1428p ps=1.52u w=0.42u l=0.5u
X2611 a_32492_15960# sg13cmos5l_dfrbpq_1_7.Q VDD VDD sg13_lv_pmos ad=0.2856p pd=2.36u as=0.2114p ps=1.54u w=0.84u l=0.13u
X2612 VDD VSS.t874 VDD VDD sg13_lv_pmos ad=0.19p pd=1.38u as=0 ps=0 w=1u l=1u
X2613 VSS.t2694 VDD VSS.t2696 VSS.t199 sg13_lv_nmos ad=79.8f pd=0.8u as=0 ps=0 w=0.42u l=1u
X2614 VDD VSS.t2545 VDD VDD sg13_lv_pmos ad=0.34p pd=2.68u as=0 ps=0 w=1u l=1u
X2615 VSS.t603 VDD VSS.t605 VSS.t604 sg13_lv_nmos ad=79.8f pd=0.8u as=0 ps=0 w=0.42u l=1u
X2616 VSS.t1057 VDD VSS.t1056 VSS.t1055 sg13_lv_nmos ad=0.1428p pd=1.52u as=0 ps=0 w=0.42u l=1u
X2617 VSS.t1246 VDD VSS.t1245 VSS.t248 sg13_lv_nmos ad=0.1428p pd=1.52u as=0 ps=0 w=0.42u l=1u
X2618 VSS.t440 VDD VSS.t440 VSS.t441 sg13_lv_nmos ad=79.8f pd=0.8u as=0 ps=0 w=0.42u l=1u
X2619 VSS.t1277 VDD VSS.t1278 VSS.t248 sg13_lv_nmos ad=79.8f pd=0.8u as=0 ps=0 w=0.42u l=1u
X2620 VDD VSS.t1227 VDD VDD sg13_lv_pmos ad=0.34p pd=2.68u as=0 ps=0 w=1u l=1u
X2621 VDD VSS.t2073 VDD VDD sg13_lv_pmos ad=0.34p pd=2.68u as=0 ps=0 w=1u l=1u
X2622 VSS.t1251 VDD VSS.t1250 VSS.t248 sg13_lv_nmos ad=0.1428p pd=1.52u as=0 ps=0 w=0.42u l=1u
X2623 a_2540_15960# sg13cmos5l_dlygate4sd3_1_3.A VDD VDD sg13_lv_pmos ad=0.2856p pd=2.36u as=0.2114p ps=1.54u w=0.84u l=0.13u
X2624 VSS.t837 VDD VSS.t836 VSS.t835 sg13_lv_nmos ad=0.1428p pd=1.52u as=0 ps=0 w=0.42u l=1u
X2625 VSS.t1022 VDD VSS.t1024 VSS.t1023 sg13_lv_nmos ad=79.8f pd=0.8u as=0 ps=0 w=0.42u l=1u
X2626 VSS.t2764 VDD VSS.t2763 VSS.t199 sg13_lv_nmos ad=0.1428p pd=1.52u as=0 ps=0 w=0.42u l=1u
X2627 VDD VSS.t2718 VDD VDD sg13_lv_pmos ad=0.34p pd=2.68u as=0 ps=0 w=1u l=1u
X2628 VDD VSS.t2021 VDD VDD sg13_lv_pmos ad=0.19p pd=1.38u as=0 ps=0 w=1u l=1u
X2629 VSS.t1205 VDD VSS.t1206 VSS.t248 sg13_lv_nmos ad=79.8f pd=0.8u as=0 ps=0 w=0.42u l=1u
X2630 VDD VSS.t1491 VDD VDD sg13_lv_pmos ad=0.34p pd=2.68u as=0 ps=0 w=1u l=1u
X2631 VDD VSS.t572 VDD VDD sg13_lv_pmos ad=0.34p pd=2.68u as=0 ps=0 w=1u l=1u
X2632 VSS.t2129 VDD VSS.t2131 VSS.t2130 sg13_lv_nmos ad=79.8f pd=0.8u as=0 ps=0 w=0.42u l=1u
X2633 VSS.t1572 VDD VSS.t1571 VSS.t1570 sg13_lv_nmos ad=0.1428p pd=1.52u as=0 ps=0 w=0.42u l=1u
X2634 VSS.t3214 VDD VSS.t3216 VSS.t3215 sg13_lv_nmos ad=79.8f pd=0.8u as=0 ps=0 w=0.42u l=1u
X2635 VDD VSS.t620 VDD VDD sg13_lv_pmos ad=0.34p pd=2.68u as=0 ps=0 w=1u l=1u
X2636 VDD VSS.t1029 VDD VDD sg13_lv_pmos ad=0.19p pd=1.38u as=0 ps=0 w=1u l=1u
X2637 VDD VSS.t1531 VDD VDD sg13_lv_pmos ad=0.34p pd=2.68u as=0 ps=0 w=1u l=1u
X2638 VSS.t2731 VDD VSS.t2731 VSS.t199 sg13_lv_nmos ad=0.1428p pd=1.52u as=0 ps=0 w=0.42u l=1u
X2639 VDD VSS.t2440 VDD VDD sg13_lv_pmos ad=0.34p pd=2.68u as=0 ps=0 w=1u l=1u
X2640 VDD VSS.t1704 VDD VDD sg13_lv_pmos ad=0.19p pd=1.38u as=0 ps=0 w=1u l=1u
X2641 VSS.t454 VDD VSS.t453 VSS.t19 sg13_lv_nmos ad=0.1428p pd=1.52u as=0 ps=0 w=0.42u l=1u
X2642 VDD VSS.t841 VDD VDD sg13_lv_pmos ad=0.34p pd=2.68u as=0 ps=0 w=1u l=1u
X2643 VSS.t339 VDD VSS.t334 VSS.t338 sg13_lv_nmos ad=0.1428p pd=1.52u as=0 ps=0 w=0.42u l=1u
X2644 sg13cmos5l_xor2_1_0.X a_2490_14447# VSS.t131 VSS.t130 sg13_lv_nmos ad=0.1628p pd=1.18u as=0.3108p ps=2.32u w=0.74u l=0.13u
X2645 VSS.t608 VDD VSS.t610 VSS.t609 sg13_lv_nmos ad=79.8f pd=0.8u as=0 ps=0 w=0.42u l=1u
X2646 sg13cmos5l_dfrbpq_1_2.Q a_17994_14020# VSS.t9 VSS.t3259 sg13_lv_nmos ad=0.2516p pd=2.16u as=0.1406p ps=1.12u w=0.74u l=0.13u
X2647 VDD VSS.t2388 VDD VDD sg13_lv_pmos ad=0.19p pd=1.38u as=0 ps=0 w=1u l=1u
X2648 VDD VSS.t2046 VDD VDD sg13_lv_pmos ad=0.19p pd=1.38u as=0 ps=0 w=1u l=1u
X2649 VSS.t2049 VDD VSS.t2048 VSS.t2047 sg13_lv_nmos ad=0.1428p pd=1.52u as=0 ps=0 w=0.42u l=1u
X2650 VDD VSS.t956 VDD VDD sg13_lv_pmos ad=0.34p pd=2.68u as=0 ps=0 w=1u l=1u
X2651 VSS.t1223 VDD VSS.t1224 VSS.t248 sg13_lv_nmos ad=79.8f pd=0.8u as=0 ps=0 w=0.42u l=1u
X2652 VSS.t1259 VDD VSS.t1257 VSS.t248 sg13_lv_nmos ad=0.1428p pd=1.52u as=0 ps=0 w=0.42u l=1u
X2653 VDD VSS.t1352 VDD VDD sg13_lv_pmos ad=0.34p pd=2.68u as=0 ps=0 w=1u l=1u
X2654 VDD VSS.t550 VDD VDD sg13_lv_pmos ad=0.34p pd=2.68u as=0 ps=0 w=1u l=1u
X2655 a_9444_15552# a_9963_15356# a_10703_15311# VSS.t176 sg13_lv_nmos ad=0.3473p pd=2.71u as=0.12665p ps=1.145u w=0.74u l=0.13u
X2656 a_7888_14726# sg13cmos5l_dfrbpq_1_1.RESET_B VDD VDD sg13_lv_pmos ad=79.8f pd=0.8u as=2.42015p ps=15.68u w=0.42u l=0.13u
X2657 VSS.t682 VDD VSS.t679 VSS.t681 sg13_lv_nmos ad=0.1428p pd=1.52u as=0 ps=0 w=0.42u l=1u
X2658 VSS.t550 VDD VSS.t550 VSS.t552 sg13_lv_nmos ad=79.8f pd=0.8u as=0 ps=0 w=0.42u l=1u
X2659 VDD a_27215_14845# a_27472_14726# VDD sg13_lv_pmos ad=2.42015p pd=15.68u as=79.8f ps=0.8u w=0.42u l=0.13u
X2660 VSS.t947 VDD VSS.t946 VSS.t945 sg13_lv_nmos ad=0.1428p pd=1.52u as=0 ps=0 w=0.42u l=1u
X2661 VSS.t1385 VDD VSS.t1228 VSS.t248 sg13_lv_nmos ad=79.8f pd=0.8u as=0 ps=0 w=0.42u l=1u
X2662 VDD VSS.t2678 VDD VDD sg13_lv_pmos ad=0.19p pd=1.38u as=0 ps=0 w=1u l=1u
X2663 VDD VSS.t483 VDD VDD sg13_lv_pmos ad=0.34p pd=2.68u as=0 ps=0 w=1u l=1u
X2664 VSS.t1562 VDD VSS.t1561 VSS.t1560 sg13_lv_nmos ad=0.1428p pd=1.52u as=0 ps=0 w=0.42u l=1u
X2665 VSS.t3084 VDD VSS.t3083 VSS.t3082 sg13_lv_nmos ad=0.1428p pd=1.52u as=0 ps=0 w=0.42u l=1u
X2666 VSS.t2296 VDD VSS.t2295 VSS.t2294 sg13_lv_nmos ad=0.1428p pd=1.52u as=0 ps=0 w=0.42u l=1u
X2667 VDD a_7631_14845# a_8298_14484# VDD sg13_lv_pmos ad=0.2128p pd=1.5u as=0.3864p ps=2.93u w=1.12u l=0.13u
X2668 VSS.t992 VDD VSS.t991 VSS.t990 sg13_lv_nmos ad=0.1428p pd=1.52u as=0 ps=0 w=0.42u l=1u
X2669 VDD VSS.t856 VDD VDD sg13_lv_pmos ad=0.34p pd=2.68u as=0 ps=0 w=1u l=1u
X2670 VSS.t1295 VDD VSS.t1296 VSS.t248 sg13_lv_nmos ad=79.8f pd=0.8u as=0 ps=0 w=0.42u l=1u
X2671 VDD VSS.t3196 VDD VDD sg13_lv_pmos ad=0.19p pd=1.38u as=0 ps=0 w=1u l=1u
X2672 VDD VSS.t1684 VDD VDD sg13_lv_pmos ad=0.19p pd=1.38u as=0 ps=0 w=1u l=1u
X2673 VDD VSS.t3148 VDD VDD sg13_lv_pmos ad=0.34p pd=2.68u as=0 ps=0 w=1u l=1u
X2674 VSS.t2746 VDD VSS.t2747 VSS.t199 sg13_lv_nmos ad=79.8f pd=0.8u as=0 ps=0 w=0.42u l=1u
X2675 VSS.t822 VDD VSS.t821 VSS.t820 sg13_lv_nmos ad=0.1428p pd=1.52u as=0 ps=0 w=0.42u l=1u
X2676 VSS.t389 VDD VSS.t391 VSS.t390 sg13_lv_nmos ad=79.8f pd=0.8u as=0 ps=0 w=0.42u l=1u
X2677 VSS.t2084 VDD VSS.t2083 VSS.t2082 sg13_lv_nmos ad=0.1428p pd=1.52u as=0 ps=0 w=0.42u l=1u
X2678 a_19054_15423# a_19169_15424# VSS.t73 VSS.t87 sg13_lv_nmos ad=0.1428p pd=1.52u as=0.1426p ps=1.16u w=0.42u l=0.5u
X2679 VSS.t555 VDD VSS.t105 VSS.t559 sg13_lv_nmos ad=79.8f pd=0.8u as=0 ps=0 w=0.42u l=1u
X2680 VSS.t1052 VDD VSS.t1054 VSS.t1053 sg13_lv_nmos ad=79.8f pd=0.8u as=0 ps=0 w=0.42u l=1u
X2681 VDD VSS.t1241 VDD VDD sg13_lv_pmos ad=0.19p pd=1.38u as=0 ps=0 w=1u l=1u
X2682 VDD VSS.t1241 VDD VDD sg13_lv_pmos ad=0.34p pd=2.68u as=0 ps=0 w=1u l=1u
X2683 VDD VSS.t2747 VDD VDD sg13_lv_pmos ad=0.34p pd=2.68u as=0 ps=0 w=1u l=1u
X2684 VDD VSS.t2781 VDD VDD sg13_lv_pmos ad=0.19p pd=1.38u as=0 ps=0 w=1u l=1u
X2685 VSS.t1314 VDD VSS.t1315 VSS.t248 sg13_lv_nmos ad=79.8f pd=0.8u as=0 ps=0 w=0.42u l=1u
X2686 VSS.t1392 VDD VSS.t1237 VSS.t248 sg13_lv_nmos ad=79.8f pd=0.8u as=0 ps=0 w=0.42u l=1u
X2687 VDD VSS.t2373 VDD VDD sg13_lv_pmos ad=0.19p pd=1.38u as=0 ps=0 w=1u l=1u
X2688 VDD VSS.t919 VDD VDD sg13_lv_pmos ad=0.19p pd=1.38u as=0 ps=0 w=1u l=1u
X2689 VSS.t2685 VDD VSS.t2687 VSS.t199 sg13_lv_nmos ad=79.8f pd=0.8u as=0 ps=0 w=0.42u l=1u
X2690 VDD sg13cmos5l_nand4_1_0.Y a_14261_15238# VDD sg13_lv_pmos ad=0.203p pd=1.5u as=0.1596p ps=1.22u w=0.84u l=0.13u
X2691 VDD VSS.t627 VDD VDD sg13_lv_pmos ad=0.34p pd=2.68u as=0 ps=0 w=1u l=1u
X2692 sg13cmos5l_dfrbpq_1_1.RESET_B a_5886_15486# VDD VDD sg13_lv_pmos ad=0.3927p pd=2.99u as=2.8961p ps=18.25u w=1.155u l=0.13u
X2693 VSS.t472 VDD VSS.t471 VSS.t19 sg13_lv_nmos ad=0.1428p pd=1.52u as=0 ps=0 w=0.42u l=1u
X2694 VSS.t421 VDD VSS.t421 VSS.t422 sg13_lv_nmos ad=79.8f pd=0.8u as=0 ps=0 w=0.42u l=1u
X2695 VSS.t114 sg13cmos5l_dlygate4sd3_1_0.X a_5707_14832# VSS.t179 sg13_lv_nmos ad=0.1331p pd=1.12u as=0.1216p ps=1.02u w=0.64u l=0.13u
X2696 VSS.t837 VDD VSS.t836 VSS.t835 sg13_lv_nmos ad=0.1428p pd=1.52u as=0 ps=0 w=0.42u l=1u
X2697 VSS.t2790 VDD VSS.t2792 VSS.t199 sg13_lv_nmos ad=79.8f pd=0.8u as=0 ps=0 w=0.42u l=1u
X2698 VDD a_25390_16263# sg13cmos5l_a21oi_1_2.A1 VDD sg13_lv_pmos ad=0.2254p pd=1.53u as=0.4256p ps=3u w=1.12u l=0.13u
X2699 VSS.t1022 VDD VSS.t1024 VSS.t1023 sg13_lv_nmos ad=79.8f pd=0.8u as=0 ps=0 w=0.42u l=1u
X2700 VDD VSS.t1011 VDD VDD sg13_lv_pmos ad=0.34p pd=2.68u as=0 ps=0 w=1u l=1u
X2701 VDD VSS.t2058 VDD VDD sg13_lv_pmos ad=0.34p pd=2.68u as=0 ps=0 w=1u l=1u
X2702 VDD VSS.t318 VDD VDD sg13_lv_pmos ad=0.34p pd=2.68u as=0 ps=0 w=1u l=1u
X2703 VSS.t593 VDD VSS.t592 VSS.t591 sg13_lv_nmos ad=0.1428p pd=1.52u as=0 ps=0 w=0.42u l=1u
X2704 VDD VSS.t3181 VDD VDD sg13_lv_pmos ad=0.19p pd=1.38u as=0 ps=0 w=1u l=1u
X2705 VSS.t108 a_25094_15238# a_25206_15302# VSS.t48 sg13_lv_nmos ad=0.1426p pd=1.16u as=0.1428p ps=1.52u w=0.42u l=0.5u
X2706 VDD VSS.t435 VDD VDD sg13_lv_pmos ad=0.19p pd=1.38u as=0 ps=0 w=1u l=1u
X2707 a_9861_14521# a_9861_14521# VSS.t19 VSS.t158 sg13_lv_nmos ad=0.111p pd=1.34u as=4.11262p ps=27.15u w=0.3u l=0.13u
X2708 VDD VSS.t572 VDD VDD sg13_lv_pmos ad=0.34p pd=2.68u as=0 ps=0 w=1u l=1u
X2709 VDD VSS.t2710 VDD VDD sg13_lv_pmos ad=0.34p pd=2.68u as=0 ps=0 w=1u l=1u
X2710 a_10703_15311# a_9861_15213# a_10609_15311# VSS.t64 sg13_lv_nmos ad=0.12665p pd=1.145u as=0.1428p ps=1.52u w=0.42u l=0.13u
X2711 VDD VSS.t102 VDD VDD sg13_lv_pmos ad=0.34p pd=2.68u as=0 ps=0 w=1u l=1u
X2712 VSS.t1507 VDD VSS.t1506 VSS.t1505 sg13_lv_nmos ad=0.1428p pd=1.52u as=0 ps=0 w=0.42u l=1u
X2713 VSS.t45 VDD VSS.t45 VSS.t410 sg13_lv_nmos ad=79.8f pd=0.8u as=0 ps=0 w=0.42u l=1u
X2714 VSS.t1677 VDD VSS.t1679 VSS.t1678 sg13_lv_nmos ad=79.8f pd=0.8u as=0 ps=0 w=0.42u l=1u
X2715 VSS.t3199 VDD VSS.t3201 VSS.t3200 sg13_lv_nmos ad=79.8f pd=0.8u as=0 ps=0 w=0.42u l=1u
X2716 sg13cmos5l_buf_8_2.X a_19323_13726# VDD VDD sg13_lv_pmos ad=0.2128p pd=1.5u as=0.2128p ps=1.5u w=1.12u l=0.13u
X2717 VDD VSS.t1214 VDD VDD sg13_lv_pmos ad=0.34p pd=2.68u as=0 ps=0 w=1u l=1u
X2718 VDD VSS.t1516 VDD VDD sg13_lv_pmos ad=0.34p pd=2.68u as=0 ps=0 w=1u l=1u
X2719 VDD VSS.t2425 VDD VDD sg13_lv_pmos ad=0.34p pd=2.68u as=0 ps=0 w=1u l=1u
X2720 VSS.t481 VDD VSS.t480 VSS.t19 sg13_lv_nmos ad=0.1428p pd=1.52u as=0 ps=0 w=0.42u l=1u
X2721 VDD VSS.t886 VDD VDD sg13_lv_pmos ad=0.34p pd=2.68u as=0 ps=0 w=1u l=1u
X2722 VDD VSS.t1074 VDD VDD sg13_lv_pmos ad=0.19p pd=1.38u as=0 ps=0 w=1u l=1u
X2723 VSS.t2316 VDD VSS.t2315 VSS.t2314 sg13_lv_nmos ad=0.1428p pd=1.52u as=0 ps=0 w=0.42u l=1u
X2724 VDD VSS.t2023 VDD VDD sg13_lv_pmos ad=0.34p pd=2.68u as=0 ps=0 w=1u l=1u
X2725 VSS.t323 VDD VSS.t323 VSS.t324 sg13_lv_nmos ad=79.8f pd=0.8u as=0 ps=0 w=0.42u l=1u
X2726 a_15579_14854# clock_i VDD VDD sg13_lv_pmos ad=0.2128p pd=1.5u as=0.2128p ps=1.5u w=1.12u l=0.13u
X2727 VSS.t2486 VDD VSS.t2488 VSS.t2487 sg13_lv_nmos ad=79.8f pd=0.8u as=0 ps=0 w=0.42u l=1u
X2728 VDD VSS.t2550 VDD VDD sg13_lv_pmos ad=0.34p pd=2.68u as=0 ps=0 w=1u l=1u
X2729 VSS.t2034 VDD VSS.t2033 VSS.t2032 sg13_lv_nmos ad=0.1428p pd=1.52u as=0 ps=0 w=0.42u l=1u
X2730 VSS.t381 VDD VSS.t56 VSS.t382 sg13_lv_nmos ad=79.8f pd=0.8u as=0 ps=0 w=0.42u l=1u
X2731 VSS.t19 a_18021_14495# a_18123_14495# VSS.t232 sg13_lv_nmos ad=4.11262p pd=27.15u as=0.2516p ps=2.16u w=0.74u l=0.13u
X2732 VDD VSS.t676 VDD VDD sg13_lv_pmos ad=0.19p pd=1.38u as=0 ps=0 w=1u l=1u
X2733 VSS.t1984 VDD VSS.t1986 VSS.t1985 sg13_lv_nmos ad=79.8f pd=0.8u as=0 ps=0 w=0.42u l=1u
X2734 VDD VSS.t1706 VDD VDD sg13_lv_pmos ad=0.34p pd=2.68u as=0 ps=0 w=1u l=1u
X2735 VSS.t3069 VDD VSS.t3071 VSS.t3070 sg13_lv_nmos ad=79.8f pd=0.8u as=0 ps=0 w=0.42u l=1u
X2736 VDD sg13cmos5l_dfrbpq_1_6.RESET_B a_21034_14452# VDD sg13_lv_pmos ad=0.1563p pd=1.22u as=0.147p ps=1.54u w=0.42u l=0.13u
X2737 VDD sg13cmos5l_dlygate4sd3_1_8.X sg13cmos5l_nand4_1_0.Y VDD sg13_lv_pmos ad=0.3808p pd=2.92u as=0.2128p ps=1.5u w=1.12u l=0.13u
X2738 a_6680_15242# sg13cmos5l_dlygate4sd3_1_1.A a_6578_15242# VSS.t3228 sg13_lv_nmos ad=0.1406p pd=1.12u as=0.1406p ps=1.12u w=0.74u l=0.13u
X2739 VDD VSS.t643 VDD VDD sg13_lv_pmos ad=0.19p pd=1.38u as=0 ps=0 w=1u l=1u
X2740 VSS.t992 VDD VSS.t991 VSS.t990 sg13_lv_nmos ad=0.1428p pd=1.52u as=0 ps=0 w=0.42u l=1u
X2741 VSS.t1332 VDD VSS.t1333 VSS.t248 sg13_lv_nmos ad=79.8f pd=0.8u as=0 ps=0 w=0.42u l=1u
X2742 VSS.t1767 VDD VSS.t1769 VSS.t1768 sg13_lv_nmos ad=79.8f pd=0.8u as=0 ps=0 w=0.42u l=1u
X2743 VDD VSS.t2670 VDD VDD sg13_lv_pmos ad=0.19p pd=1.38u as=0 ps=0 w=1u l=1u
X2744 VSS.t2281 VDD VSS.t2280 VSS.t2279 sg13_lv_nmos ad=0.1428p pd=1.52u as=0 ps=0 w=0.42u l=1u
X2745 sg13cmos5l_dfrbpq_1_2.RESET_B a_15870_15486# VDD VDD sg13_lv_pmos ad=0.3927p pd=2.99u as=2.8961p ps=18.25u w=1.155u l=0.13u
X2746 VSS.t160 a_7631_14845# a_8298_14484# VSS.t3282 sg13_lv_nmos ad=0.1406p pd=1.12u as=0.2516p ps=2.16u w=0.74u l=0.13u
X2747 VSS.t2766 VDD VSS.t2766 VSS.t199 sg13_lv_nmos ad=0.1428p pd=1.52u as=0 ps=0 w=0.42u l=1u
X2748 VDD VSS.t474 VDD VDD sg13_lv_pmos ad=0.34p pd=2.68u as=0 ps=0 w=1u l=1u
X2749 a_26638_15423# a_26753_15424# VSS.t19 VSS.t100 sg13_lv_nmos ad=0.1428p pd=1.52u as=0.1426p ps=1.16u w=0.42u l=0.5u
X2750 a_16068_14040# a_16587_13844# a_17327_13799# VSS.t141 sg13_lv_nmos ad=0.3473p pd=2.71u as=0.12665p ps=1.145u w=0.74u l=0.13u
X2751 VDD VSS.t3133 VDD VDD sg13_lv_pmos ad=0.34p pd=2.68u as=0 ps=0 w=1u l=1u
X2752 VSS.t2134 VDD VSS.t2136 VSS.t2135 sg13_lv_nmos ad=79.8f pd=0.8u as=0 ps=0 w=0.42u l=1u
X2753 VDD VSS.t356 VDD VDD sg13_lv_pmos ad=0.34p pd=2.68u as=0 ps=0 w=1u l=1u
X2754 VSS.t1052 VDD VSS.t1054 VSS.t1053 sg13_lv_nmos ad=79.8f pd=0.8u as=0 ps=0 w=0.42u l=1u
X2755 VDD VSS.t1304 VDD VDD sg13_lv_pmos ad=0.34p pd=2.68u as=0 ps=0 w=1u l=1u
X2756 VSS.t1697 VDD VSS.t1699 VSS.t1698 sg13_lv_nmos ad=79.8f pd=0.8u as=0 ps=0 w=0.42u l=1u
X2757 VDD VSS.t849 VDD VDD sg13_lv_pmos ad=0.19p pd=1.38u as=0 ps=0 w=1u l=1u
X2758 VDD VSS.t1041 VDD VDD sg13_lv_pmos ad=0.34p pd=2.68u as=0 ps=0 w=1u l=1u
X2759 VDD VSS.t1501 VDD VDD sg13_lv_pmos ad=0.34p pd=2.68u as=0 ps=0 w=1u l=1u
X2760 VSS.t1341 VDD VSS.t1341 VSS.t248 sg13_lv_nmos ad=79.8f pd=0.8u as=0 ps=0 w=0.42u l=1u
X2761 VDD VSS.t1764 VDD VDD sg13_lv_pmos ad=0.19p pd=1.38u as=0 ps=0 w=1u l=1u
X2762 VDD VSS.t655 VDD VDD sg13_lv_pmos ad=0.34p pd=2.68u as=0 ps=0 w=1u l=1u
X2763 VSS.t912 VDD VSS.t911 VSS.t910 sg13_lv_nmos ad=0.1428p pd=1.52u as=0 ps=0 w=0.42u l=1u
X2764 VSS.t1637 VDD VSS.t1636 VSS.t1635 sg13_lv_nmos ad=0.1428p pd=1.52u as=0 ps=0 w=0.42u l=1u
X2765 VDD VSS.t2535 VDD VDD sg13_lv_pmos ad=0.34p pd=2.68u as=0 ps=0 w=1u l=1u
X2766 VDD VSS.t2358 VDD VDD sg13_lv_pmos ad=0.19p pd=1.38u as=0 ps=0 w=1u l=1u
X2767 VSS.t1248 VDD VSS.t1249 VSS.t248 sg13_lv_nmos ad=79.8f pd=0.8u as=0 ps=0 w=0.42u l=1u
X2768 VDD VSS.t339 VDD VDD sg13_lv_pmos ad=0.34p pd=2.68u as=0 ps=0 w=1u l=1u
X2769 VDD a_6286_13911# sg13cmos5l_dlygate4sd3_1_0.X VDD sg13_lv_pmos ad=0.2254p pd=1.53u as=0.4256p ps=3u w=1.12u l=0.13u
X2770 a_26505_14113# a_26148_14040# VDD VDD sg13_lv_pmos ad=63f pd=0.72u as=0.1563p ps=1.22u w=0.42u l=0.13u
X2771 VSS.t1345 VDD VSS.t1347 VSS.t248 sg13_lv_nmos ad=79.8f pd=0.8u as=0 ps=0 w=0.42u l=1u
X2772 VDD VSS.t2111 VDD VDD sg13_lv_pmos ad=0.19p pd=1.38u as=0 ps=0 w=1u l=1u
X2773 VDD VSS.t570 VDD VDD sg13_lv_pmos ad=0.19p pd=1.38u as=0 ps=0 w=1u l=1u
X2774 VSS.t1 sg13cmos5l_o21ai_1_2.Y a_24824_15238# VSS.t48 sg13_lv_nmos ad=79.8f pd=0.8u as=0.1428p ps=1.52u w=0.42u l=0.13u
X2775 VDD VSS.t1886 VDD VDD sg13_lv_pmos ad=0.19p pd=1.38u as=0 ps=0 w=1u l=1u
X2776 VSS.t1929 VDD VSS.t1931 VSS.t1930 sg13_lv_nmos ad=79.8f pd=0.8u as=0 ps=0 w=0.42u l=1u
X2777 VSS.t90 sg13cmos5l_inv_1_0.Y a_16596_15280# VSS.t3258 sg13_lv_nmos ad=0.2272p pd=1.99u as=78.39999f ps=0.885u w=0.64u l=0.13u
X2778 VSS.t2471 VDD VSS.t2473 VSS.t2472 sg13_lv_nmos ad=79.8f pd=0.8u as=0 ps=0 w=0.42u l=1u
X2779 VDD VSS.t550 VDD VDD sg13_lv_pmos ad=0.34p pd=2.68u as=0 ps=0 w=1u l=1u
X2780 VDD VSS.t2413 VDD VDD sg13_lv_pmos ad=0.19p pd=1.38u as=0 ps=0 w=1u l=1u
X2781 a_15782_13722# sg13cmos5l_dfrbpq_1_2.D VDD VDD sg13_lv_pmos ad=79.8f pd=0.8u as=0.1428p ps=1.52u w=0.42u l=0.13u
X2782 VSS.t2749 VDD VSS.t2750 VSS.t199 sg13_lv_nmos ad=79.8f pd=0.8u as=0 ps=0 w=0.42u l=1u
X2783 a_4474_14448# sg13cmos5l_dlygate4sd3_1_3.A VDD VDD sg13_lv_pmos ad=0.1428p pd=1.52u as=0.1523p ps=1.38u w=0.42u l=0.13u
X2784 VDD VSS.t1004 VDD VDD sg13_lv_pmos ad=0.19p pd=1.38u as=0 ps=0 w=1u l=1u
X2785 VSS.t1492 VDD VSS.t1491 VSS.t1490 sg13_lv_nmos ad=0.1428p pd=1.52u as=0 ps=0 w=0.42u l=1u
X2786 VSS.t2019 VDD VSS.t2021 VSS.t2020 sg13_lv_nmos ad=79.8f pd=0.8u as=0 ps=0 w=0.42u l=1u
X2787 VSS.t872 VDD VSS.t874 VSS.t873 sg13_lv_nmos ad=79.8f pd=0.8u as=0 ps=0 w=0.42u l=1u
X2788 VDD VSS.t1244 VDD VDD sg13_lv_pmos ad=0.34p pd=2.68u as=0 ps=0 w=1u l=1u
X2789 VDD VSS.t2750 VDD VDD sg13_lv_pmos ad=0.34p pd=2.68u as=0 ps=0 w=1u l=1u
X2790 a_27500_15960# sg13cmos5l_dfrbpq_1_6.Q VDD VDD sg13_lv_pmos ad=0.2856p pd=2.36u as=0.2114p ps=1.54u w=0.84u l=0.13u
X2791 VSS.t2301 VDD VSS.t2300 VSS.t2299 sg13_lv_nmos ad=0.1428p pd=1.52u as=0 ps=0 w=0.42u l=1u
X2792 VDD VSS.t482 VDD VDD sg13_lv_pmos ad=0.19p pd=1.38u as=0 ps=0 w=1u l=1u
X2793 VDD VSS.t931 VDD VDD sg13_lv_pmos ad=0.34p pd=2.68u as=0 ps=0 w=1u l=1u
X2794 VSS.t2688 VDD VSS.t2690 VSS.t199 sg13_lv_nmos ad=79.8f pd=0.8u as=0 ps=0 w=0.42u l=1u
X2795 VSS.t2149 VDD VSS.t2148 VSS.t2147 sg13_lv_nmos ad=0.1428p pd=1.52u as=0 ps=0 w=0.42u l=1u
X2796 VSS.t1969 VDD VSS.t1971 VSS.t1970 sg13_lv_nmos ad=79.8f pd=0.8u as=0 ps=0 w=0.42u l=1u
X2797 VDD VSS.t105 VDD VDD sg13_lv_pmos ad=0.34p pd=2.68u as=0 ps=0 w=1u l=1u
X2798 VDD VSS.t670 VDD VDD sg13_lv_pmos ad=0.19p pd=1.38u as=0 ps=0 w=1u l=1u
X2799 VSS.t3054 VDD VSS.t3056 VSS.t3055 sg13_lv_nmos ad=79.8f pd=0.8u as=0 ps=0 w=0.42u l=1u
X2800 VDD sg13cmos5l_dfrbpq_1_6.RESET_B a_20774_14922# VDD sg13_lv_pmos ad=0.36237p pd=2.605u as=79.8f ps=0.8u w=0.42u l=0.13u
X2801 VSS.t664 VDD VSS.t664 VSS.t796 sg13_lv_nmos ad=0.1428p pd=1.52u as=0 ps=0 w=0.42u l=1u
X2802 VDD VSS.t2996 VDD VDD sg13_lv_pmos ad=0.19p pd=1.38u as=0 ps=0 w=1u l=1u
X2803 a_2516_14484# sg13cmos5l_buf_1_0.X VDD VDD sg13_lv_pmos ad=0.3808p pd=2.92u as=0.2128p ps=1.5u w=1.12u l=0.13u
X2804 VSS.t2491 VDD VSS.t2490 VSS.t2489 sg13_lv_nmos ad=0.1428p pd=1.52u as=0 ps=0 w=0.42u l=1u
X2805 VSS.t1752 VDD VSS.t1754 VSS.t1753 sg13_lv_nmos ad=79.8f pd=0.8u as=0 ps=0 w=0.42u l=1u
X2806 VSS.t608 VDD VSS.t610 VSS.t609 sg13_lv_nmos ad=79.8f pd=0.8u as=0 ps=0 w=0.42u l=1u
X2807 VDD VSS.t2405 VDD VDD sg13_lv_pmos ad=0.34p pd=2.68u as=0 ps=0 w=1u l=1u
X2808 a_26313_14531# a_25956_14488# VDD VDD sg13_lv_pmos ad=63f pd=0.72u as=0.1563p ps=1.22u w=0.42u l=0.13u
X2809 VSS.t1280 VDD VSS.t1281 VSS.t248 sg13_lv_nmos ad=79.8f pd=0.8u as=0 ps=0 w=0.42u l=1u
X2810 VDD VSS.t2063 VDD VDD sg13_lv_pmos ad=0.34p pd=2.68u as=0 ps=0 w=1u l=1u
X2811 VDD VSS.t3186 VDD VDD sg13_lv_pmos ad=0.19p pd=1.38u as=0 ps=0 w=1u l=1u
X2812 VDD VSS.t2712 VDD VDD sg13_lv_pmos ad=0.34p pd=2.68u as=0 ps=0 w=1u l=1u
X2813 VSS.t19 a_9737_14822# a_9658_14725# VSS.t257 sg13_lv_nmos ad=4.11262p pd=27.15u as=0.27427p ps=2.28u w=0.795u l=0.13u
X2814 VDD VSS.t1331 VDD VDD sg13_lv_pmos ad=0.34p pd=2.68u as=0 ps=0 w=1u l=1u
X2815 VSS.t1215 VDD VSS.t1214 VSS.t248 sg13_lv_nmos ad=0.1428p pd=1.52u as=0 ps=0 w=0.42u l=1u
X2816 VSS.t1622 VDD VSS.t1624 VSS.t1623 sg13_lv_nmos ad=79.8f pd=0.8u as=0 ps=0 w=0.42u l=1u
X2817 VSS.t1682 VDD VSS.t1684 VSS.t1683 sg13_lv_nmos ad=79.8f pd=0.8u as=0 ps=0 w=0.42u l=1u
X2818 VSS.t3204 VDD VSS.t3206 VSS.t3205 sg13_lv_nmos ad=79.8f pd=0.8u as=0 ps=0 w=0.42u l=1u
X2819 VSS.t2119 VDD VSS.t2121 VSS.t2120 sg13_lv_nmos ad=79.8f pd=0.8u as=0 ps=0 w=0.42u l=1u
X2820 VSS.t842 VDD VSS.t841 VSS.t840 sg13_lv_nmos ad=0.1428p pd=1.52u as=0 ps=0 w=0.42u l=1u
X2821 VSS.t2928 VDD VSS.t2809 VSS.t199 sg13_lv_nmos ad=0.1428p pd=1.52u as=0 ps=0 w=0.42u l=1u
X2822 VDD VSS.t462 VDD VDD sg13_lv_pmos ad=0.34p pd=2.68u as=0 ps=0 w=1u l=1u
X2823 VSS.t912 VDD VSS.t911 VSS.t910 sg13_lv_nmos ad=0.1428p pd=1.52u as=0 ps=0 w=0.42u l=1u
X2824 VSS.t1208 VDD VSS.t1209 VSS.t248 sg13_lv_nmos ad=79.8f pd=0.8u as=0 ps=0 w=0.42u l=1u
X2825 a_21549_14020# sg13cmos5l_or3_1_2.B a_21460_14020# VDD sg13_lv_pmos ad=0.19p pd=1.38u as=0.1575p ps=1.315u w=1u l=0.13u
X2826 VDD VSS.t1749 VDD VDD sg13_lv_pmos ad=0.19p pd=1.38u as=0 ps=0 w=1u l=1u
X2827 VSS.t2286 VDD VSS.t2285 VSS.t2284 sg13_lv_nmos ad=0.1428p pd=1.52u as=0 ps=0 w=0.42u l=1u
X2828 VSS.t727 VDD VSS.t729 VSS.t728 sg13_lv_nmos ad=79.8f pd=0.8u as=0 ps=0 w=0.42u l=1u
X2829 VDD VSS.t742 VDD VDD sg13_lv_pmos ad=0.34p pd=2.68u as=0 ps=0 w=1u l=1u
X2830 VDD VSS.t649 VDD VDD sg13_lv_pmos ad=0.34p pd=2.68u as=0 ps=0 w=1u l=1u
X2831 VDD VSS.t1034 VDD VDD sg13_lv_pmos ad=0.19p pd=1.38u as=0 ps=0 w=1u l=1u
X2832 VDD VSS.t1701 VDD VDD sg13_lv_pmos ad=0.34p pd=2.68u as=0 ps=0 w=1u l=1u
X2833 VSS.t2679 VDD VSS.t2681 VSS.t199 sg13_lv_nmos ad=79.8f pd=0.8u as=0 ps=0 w=0.42u l=1u
X2834 VSS.t2756 VDD VSS.t2756 VSS.t199 sg13_lv_nmos ad=0.1428p pd=1.52u as=0 ps=0 w=0.42u l=1u
X2835 VDD VSS.t2520 VDD VDD sg13_lv_pmos ad=0.34p pd=2.68u as=0 ps=0 w=1u l=1u
X2836 VSS.t1989 VDD VSS.t1991 VSS.t1990 sg13_lv_nmos ad=79.8f pd=0.8u as=0 ps=0 w=0.42u l=1u
X2837 VDD VSS.t318 VDD VDD sg13_lv_pmos ad=0.19p pd=1.38u as=0 ps=0 w=1u l=1u
X2838 VDD a_21251_13690# sg13cmos5l_or3_1_2.X VDD sg13_lv_pmos ad=0.3822p pd=1.84u as=0.3808p ps=2.92u w=1.12u l=0.13u
X2839 VDD VSS.t570 VDD VDD sg13_lv_pmos ad=0.19p pd=1.38u as=0 ps=0 w=1u l=1u
X2840 VSS.t210 VDD VSS.t50 VSS.t701 sg13_lv_nmos ad=0.1428p pd=1.52u as=0 ps=0 w=0.42u l=1u
X2841 VSS.t1262 VDD VSS.t1260 VSS.t248 sg13_lv_nmos ad=0.1428p pd=1.52u as=0 ps=0 w=0.42u l=1u
X2842 sg13cmos5l_xnor2_1_2.B sg13cmos5l_buf_1_0.X a_6202_15238# VSS.t279 sg13_lv_nmos ad=0.2516p pd=2.16u as=0.1406p ps=1.12u w=0.74u l=0.13u
X2843 sg13cmos5l_xnor2_1_0.Y a_7680_15549# a_7829_15238# VSS.t264 sg13_lv_nmos ad=0.2516p pd=2.16u as=0.1406p ps=1.12u w=0.74u l=0.13u
X2844 VDD VSS.t1355 VDD VDD sg13_lv_pmos ad=0.34p pd=2.68u as=0 ps=0 w=1u l=1u
X2845 VSS.t2999 VDD VSS.t3001 VSS.t3000 sg13_lv_nmos ad=79.8f pd=0.8u as=0 ps=0 w=0.42u l=1u
X2846 VDD VSS.t550 VDD VDD sg13_lv_pmos ad=0.34p pd=2.68u as=0 ps=0 w=1u l=1u
X2847 VDD VSS.t471 VDD VDD sg13_lv_pmos ad=0.34p pd=2.68u as=0 ps=0 w=1u l=1u
X2848 sg13cmos5l_a21oi_1_3.B1 sg13cmos5l_buf_1_10.X VDD VDD sg13_lv_pmos ad=0.3808p pd=2.92u as=0.3808p ps=2.92u w=1.12u l=0.13u
X2849 VDD VSS.t2744 VDD VDD sg13_lv_pmos ad=0.19p pd=1.38u as=0 ps=0 w=1u l=1u
X2850 VSS.t646 VDD VSS.t646 VSS.t647 sg13_lv_nmos ad=79.8f pd=0.8u as=0 ps=0 w=0.42u l=1u
X2851 VDD VSS.t1049 VDD VDD sg13_lv_pmos ad=0.19p pd=1.38u as=0 ps=0 w=1u l=1u
X2852 VDD VSS.t3138 VDD VDD sg13_lv_pmos ad=0.34p pd=2.68u as=0 ps=0 w=1u l=1u
X2853 VSS.t2411 VDD VSS.t2410 VSS.t2409 sg13_lv_nmos ad=0.1428p pd=1.52u as=0 ps=0 w=0.42u l=1u
X2854 VSS.t2104 VDD VSS.t2106 VSS.t2105 sg13_lv_nmos ad=79.8f pd=0.8u as=0 ps=0 w=0.42u l=1u
X2855 VDD VSS.t618 VDD VDD sg13_lv_pmos ad=0.34p pd=2.68u as=0 ps=0 w=1u l=1u
X2856 VSS.t872 VDD VSS.t874 VSS.t873 sg13_lv_nmos ad=79.8f pd=0.8u as=0 ps=0 w=0.42u l=1u
X2857 VDD VSS.t1506 VDD VDD sg13_lv_pmos ad=0.34p pd=2.68u as=0 ps=0 w=1u l=1u
X2858 VDD VSS.t2415 VDD VDD sg13_lv_pmos ad=0.34p pd=2.68u as=0 ps=0 w=1u l=1u
X2859 VSS.t593 VDD VSS.t592 VSS.t591 sg13_lv_nmos ad=0.1428p pd=1.52u as=0 ps=0 w=0.42u l=1u
X2860 VDD VSS.t1679 VDD VDD sg13_lv_pmos ad=0.19p pd=1.38u as=0 ps=0 w=1u l=1u
X2861 VDD VSS.t1734 VDD VDD sg13_lv_pmos ad=0.19p pd=1.38u as=0 ps=0 w=1u l=1u
X2862 VDD VSS.t1926 VDD VDD sg13_lv_pmos ad=0.19p pd=1.38u as=0 ps=0 w=1u l=1u
X2863 a_27034_15202# sg13cmos5l_dfrbpq_1_7.Q VSS.t19 VSS.t19 sg13_lv_nmos ad=0.1428p pd=1.52u as=79.8f ps=0.8u w=0.42u l=0.13u
X2864 VSS.t2024 VDD VSS.t2023 VSS.t2022 sg13_lv_nmos ad=0.1428p pd=1.52u as=0 ps=0 w=0.42u l=1u
X2865 VDD VSS.t1364 VDD VDD sg13_lv_pmos ad=0.34p pd=2.68u as=0 ps=0 w=1u l=1u
X2866 VSS.t568 VDD VSS.t570 VSS.t569 sg13_lv_nmos ad=79.8f pd=0.8u as=0 ps=0 w=0.42u l=1u
X2867 VDD VSS.t105 VDD VDD sg13_lv_pmos ad=0.34p pd=2.68u as=0 ps=0 w=1u l=1u
X2868 VSS.t2134 VDD VSS.t2133 VSS.t2132 sg13_lv_nmos ad=0.1428p pd=1.52u as=0 ps=0 w=0.42u l=1u
X2869 VSS.t747 VDD VSS.t623 VSS.t748 sg13_lv_nmos ad=79.8f pd=0.8u as=0 ps=0 w=0.42u l=1u
X2870 VSS.t1012 VDD VSS.t1011 VSS.t1010 sg13_lv_nmos ad=0.1428p pd=1.52u as=0 ps=0 w=0.42u l=1u
X2871 VSS.t1934 VDD VSS.t1936 VSS.t1935 sg13_lv_nmos ad=79.8f pd=0.8u as=0 ps=0 w=0.42u l=1u
X2872 VSS.t1443 VDD VSS.t1308 VSS.t248 sg13_lv_nmos ad=79.8f pd=0.8u as=0 ps=0 w=0.42u l=1u
X2873 VSS.t2784 VDD VSS.t2786 VSS.t199 sg13_lv_nmos ad=79.8f pd=0.8u as=0 ps=0 w=0.42u l=1u
X2874 VSS.t2476 VDD VSS.t2478 VSS.t2477 sg13_lv_nmos ad=79.8f pd=0.8u as=0 ps=0 w=0.42u l=1u
X2875 VDD VSS.t3171 VDD VDD sg13_lv_pmos ad=0.19p pd=1.38u as=0 ps=0 w=1u l=1u
X2876 a_20705_15260# sg13cmos5l_dlygate4sd3_1_9.X sg13cmos5l_a21oi_1_1.Y VSS.t87 sg13_lv_nmos ad=0.1406p pd=1.12u as=0.1406p ps=1.12u w=0.74u l=0.13u
X2877 VSS.t842 VDD VSS.t841 VSS.t840 sg13_lv_nmos ad=0.1428p pd=1.52u as=0 ps=0 w=0.42u l=1u
X2878 VSS.t2346 VDD VSS.t2345 VSS.t2344 sg13_lv_nmos ad=0.1428p pd=1.52u as=0 ps=0 w=0.42u l=1u
X2879 VSS.t1607 VDD VSS.t1609 VSS.t1608 sg13_lv_nmos ad=79.8f pd=0.8u as=0 ps=0 w=0.42u l=1u
X2880 VSS.t1072 VDD VSS.t1074 VSS.t1073 sg13_lv_nmos ad=79.8f pd=0.8u as=0 ps=0 w=0.42u l=1u
X2881 VDD VSS.t640 VDD VDD sg13_lv_pmos ad=0.34p pd=2.68u as=0 ps=0 w=1u l=1u
X2882 VDD VSS.t3041 VDD VDD sg13_lv_pmos ad=0.19p pd=1.38u as=0 ps=0 w=1u l=1u
X2883 VDD VSS.t1911 VDD VDD sg13_lv_pmos ad=0.19p pd=1.38u as=0 ps=0 w=1u l=1u
X2884 VDD VSS.t380 VDD VDD sg13_lv_pmos ad=0.34p pd=2.68u as=0 ps=0 w=1u l=1u
X2885 VDD sg13cmos5l_dfrbpq_1_3.RESET_B a_17578_14452# VDD sg13_lv_pmos ad=0.1563p pd=1.22u as=0.147p ps=1.54u w=0.42u l=0.13u
X2886 a_26122_13945# a_26565_13701# a_25862_13722# VSS.t201 sg13_lv_nmos ad=79.8f pd=0.8u as=0.1296p ps=1.52u w=0.42u l=0.13u
X2887 VSS.t1762 VDD VSS.t1764 VSS.t1763 sg13_lv_nmos ad=79.8f pd=0.8u as=0 ps=0 w=0.42u l=1u
X2888 VDD VSS.t1686 VDD VDD sg13_lv_pmos ad=0.34p pd=2.68u as=0 ps=0 w=1u l=1u
X2889 VSS.t2671 VDD VSS.t2672 VSS.t199 sg13_lv_nmos ad=79.8f pd=0.8u as=0 ps=0 w=0.42u l=1u
X2890 VSS.t2154 VDD VSS.t2153 VSS.t2152 sg13_lv_nmos ad=0.1428p pd=1.52u as=0 ps=0 w=0.42u l=1u
X2891 VSS.t1974 VDD VSS.t1976 VSS.t1975 sg13_lv_nmos ad=79.8f pd=0.8u as=0 ps=0 w=0.42u l=1u
X2892 VSS.t484 VDD VSS.t483 VSS.t19 sg13_lv_nmos ad=0.1428p pd=1.52u as=0 ps=0 w=0.42u l=1u
X2893 VSS.t3059 VDD VSS.t3061 VSS.t3060 sg13_lv_nmos ad=79.8f pd=0.8u as=0 ps=0 w=0.42u l=1u
X2894 VDD VSS.t2821 VDD VDD sg13_lv_pmos ad=0.19p pd=1.38u as=0 ps=0 w=1u l=1u
X2895 VSS.t160 sg13cmos5l_xnor2_1_0.Y a_8312_15238# VSS.t159 sg13_lv_nmos ad=79.8f pd=0.8u as=0.1428p ps=1.52u w=0.42u l=0.13u
X2896 VDD sg13cmos5l_buf_8_2.A a_19323_13726# VDD sg13_lv_pmos ad=0.2128p pd=1.5u as=0.2128p ps=1.5u w=1.12u l=0.13u
X2897 sg13cmos5l_a21oi_1_3.A2 a_24169_14508# VDD VDD sg13_lv_pmos ad=0.3808p pd=2.92u as=0.3822p ps=1.84u w=1.12u l=0.13u
X2898 VSS.t1289 VDD VSS.t1288 VSS.t248 sg13_lv_nmos ad=0.1428p pd=1.52u as=0 ps=0 w=0.42u l=1u
X2899 VSS.t1757 VDD VSS.t1759 VSS.t1758 sg13_lv_nmos ad=79.8f pd=0.8u as=0 ps=0 w=0.42u l=1u
X2900 VDD VSS.t2278 VDD VDD sg13_lv_pmos ad=0.19p pd=1.38u as=0 ps=0 w=1u l=1u
X2901 VDD VSS.t2375 VDD VDD sg13_lv_pmos ad=0.34p pd=2.68u as=0 ps=0 w=1u l=1u
X2902 VDD VSS.t2068 VDD VDD sg13_lv_pmos ad=0.34p pd=2.68u as=0 ps=0 w=1u l=1u
X2903 VDD VSS.t3191 VDD VDD sg13_lv_pmos ad=0.19p pd=1.38u as=0 ps=0 w=1u l=1u
X2904 VSS.t1884 VDD VSS.t1886 VSS.t1885 sg13_lv_nmos ad=79.8f pd=0.8u as=0 ps=0 w=0.42u l=1u
X2905 VSS.t98 a_22030_15423# sg13cmos5l_or3_1_2.A VSS.t277 sg13_lv_nmos ad=0.1426p pd=1.16u as=0.2516p ps=2.16u w=0.74u l=0.13u
X2906 VSS.t1332 VDD VSS.t1331 VSS.t248 sg13_lv_nmos ad=0.1428p pd=1.52u as=0 ps=0 w=0.42u l=1u
X2907 VDD VSS.t612 VDD VDD sg13_lv_pmos ad=0.34p pd=2.68u as=0 ps=0 w=1u l=1u
X2908 VSS.t105 a_16485_13701# a_16587_13844# VSS.t219 sg13_lv_nmos ad=15.38618p pd=0.10091m as=0.2516p ps=2.16u w=0.74u l=0.13u
X2909 VSS.t17 VDD VSS.t17 VSS.t698 sg13_lv_nmos ad=0.1428p pd=1.52u as=0 ps=0 w=0.42u l=1u
X2910 VDD VSS.t2016 VDD VDD sg13_lv_pmos ad=0.19p pd=1.38u as=0 ps=0 w=1u l=1u
X2911 VSS.t1042 VDD VSS.t1041 VSS.t1040 sg13_lv_nmos ad=0.1428p pd=1.52u as=0 ps=0 w=0.42u l=1u
X2912 VSS.t347 VDD VSS.t125 VSS.t346 sg13_lv_nmos ad=0.1428p pd=1.52u as=0 ps=0 w=0.42u l=1u
X2913 VSS.t305 a_12010_15202# sg13cmos5l_dfrbpq_1_2.CLK VSS.t304 sg13_lv_nmos ad=0.1406p pd=1.12u as=0.1406p ps=1.12u w=0.74u l=0.13u
X2914 VSS.t1949 VDD VSS.t1948 VSS.t1947 sg13_lv_nmos ad=0.1428p pd=1.52u as=0 ps=0 w=0.42u l=1u
X2915 VDD VSS.t906 VDD VDD sg13_lv_pmos ad=0.34p pd=2.68u as=0 ps=0 w=1u l=1u
X2916 VDD VSS.t1491 VDD VDD sg13_lv_pmos ad=0.34p pd=2.68u as=0 ps=0 w=1u l=1u
X2917 VSS.t2794 VDD VSS.t2793 VSS.t199 sg13_lv_nmos ad=0.1428p pd=1.52u as=0 ps=0 w=0.42u l=1u
X2918 VDD VSS.t884 VDD VDD sg13_lv_pmos ad=0.19p pd=1.38u as=0 ps=0 w=1u l=1u
X2919 a_11122_15234# sg13cmos5l_tiehi_1.L_HI VSS.t6 VSS.t5 sg13_lv_nmos ad=37.8f pd=0.6u as=79.8f ps=0.8u w=0.42u l=0.13u
X2920 VSS.t2291 VDD VSS.t2290 VSS.t2289 sg13_lv_nmos ad=0.1428p pd=1.52u as=0 ps=0 w=0.42u l=1u
X2921 sg13cmos5l_or3_1_2.C sg13cmos5l_dfrbpq_1_3.Q a_20218_15238# VSS.t87 sg13_lv_nmos ad=0.2516p pd=2.16u as=0.1406p ps=1.12u w=0.74u l=0.13u
X2922 VSS.t1747 VDD VSS.t1749 VSS.t1748 sg13_lv_nmos ad=79.8f pd=0.8u as=0 ps=0 w=0.42u l=1u
X2923 VSS.t1552 VDD VSS.t1554 VSS.t1553 sg13_lv_nmos ad=79.8f pd=0.8u as=0 ps=0 w=0.42u l=1u
X2924 VSS.t2461 VDD VSS.t2463 VSS.t2462 sg13_lv_nmos ad=79.8f pd=0.8u as=0 ps=0 w=0.42u l=1u
X2925 VSS.t2759 VDD VSS.t2758 VSS.t199 sg13_lv_nmos ad=0.1428p pd=1.52u as=0 ps=0 w=0.42u l=1u
X2926 a_16175_15238# sg13cmos5l_inv_1_0.Y VSS.t90 VSS.t3255 sg13_lv_nmos ad=0.2516p pd=2.16u as=0.1898p ps=1.36u w=0.74u l=0.13u
X2927 VSS.t1012 VDD VSS.t1011 VSS.t1010 sg13_lv_nmos ad=0.1428p pd=1.52u as=0 ps=0 w=0.42u l=1u
X2928 VDD VSS.t2986 VDD VDD sg13_lv_pmos ad=0.19p pd=1.38u as=0 ps=0 w=1u l=1u
X2929 VSS.t451 VDD VSS.t450 VSS.t19 sg13_lv_nmos ad=0.1428p pd=1.52u as=0 ps=0 w=0.42u l=1u
X2930 VDD VSS.t969 VDD VDD sg13_lv_pmos ad=0.19p pd=1.38u as=0 ps=0 w=1u l=1u
X2931 VSS.t917 VDD VSS.t919 VSS.t918 sg13_lv_nmos ad=79.8f pd=0.8u as=0 ps=0 w=0.42u l=1u
X2932 VDD VSS.t2443 VDD VDD sg13_lv_pmos ad=0.19p pd=1.38u as=0 ps=0 w=1u l=1u
X2933 VSS.t2104 VDD VSS.t2103 VSS.t2102 sg13_lv_nmos ad=0.1428p pd=1.52u as=0 ps=0 w=0.42u l=1u
X2934 VDD VSS.t2101 VDD VDD sg13_lv_pmos ad=0.19p pd=1.38u as=0 ps=0 w=1u l=1u
X2935 VSS.t433 VDD VSS.t435 VSS.t434 sg13_lv_nmos ad=79.8f pd=0.8u as=0 ps=0 w=0.42u l=1u
X2936 VSS.t1919 VDD VSS.t1921 VSS.t1920 sg13_lv_nmos ad=79.8f pd=0.8u as=0 ps=0 w=0.42u l=1u
X2937 VSS.t215 a_21251_13690# sg13cmos5l_or3_1_2.X VSS.t259 sg13_lv_nmos ad=0.13395p pd=1.12u as=0.2516p ps=2.16u w=0.74u l=0.13u
X2938 VDD VSS.t486 VDD VDD sg13_lv_pmos ad=0.34p pd=2.68u as=0 ps=0 w=1u l=1u
X2939 VDD VSS.t575 VDD VDD sg13_lv_pmos ad=0.19p pd=1.38u as=0 ps=0 w=1u l=1u
X2940 VDD a_4175_15311# a_4842_15532# VDD sg13_lv_pmos ad=0.2128p pd=1.5u as=0.3864p ps=2.93u w=1.12u l=0.13u
X2941 VDD a_10222_14751# sg13cmos5l_dlygate4sd3_1_8.X VDD sg13_lv_pmos ad=0.2254p pd=1.53u as=0.4256p ps=3u w=1.12u l=0.13u
X2942 VDD VSS.t1316 VDD VDD sg13_lv_pmos ad=0.34p pd=2.68u as=0 ps=0 w=1u l=1u
X2943 VDD VSS.t1549 VDD VDD sg13_lv_pmos ad=0.19p pd=1.38u as=0 ps=0 w=1u l=1u
X2944 VSS.t1072 VDD VSS.t1074 VSS.t1073 sg13_lv_nmos ad=79.8f pd=0.8u as=0 ps=0 w=0.42u l=1u
X2945 VSS.t300 a_12010_15202# sg13cmos5l_dfrbpq_1_2.CLK VSS.t299 sg13_lv_nmos ad=0.1406p pd=1.12u as=0.1406p ps=1.12u w=0.74u l=0.13u
X2946 VSS.t2706 VDD VSS.t2708 VSS.t199 sg13_lv_nmos ad=79.8f pd=0.8u as=0 ps=0 w=0.42u l=1u
X2947 VDD VSS.t667 VDD VDD sg13_lv_pmos ad=0.34p pd=2.68u as=0 ps=0 w=1u l=1u
X2948 VDD VSS.t1684 VDD VDD sg13_lv_pmos ad=0.19p pd=1.38u as=0 ps=0 w=1u l=1u
X2949 sg13cmos5l_dfrbpq_1_5.Q a_28074_14020# VDD VDD sg13_lv_pmos ad=0.3808p pd=2.92u as=0.2128p ps=1.5u w=1.12u l=0.13u
X2950 VDD VSS.t1739 VDD VDD sg13_lv_pmos ad=0.19p pd=1.38u as=0 ps=0 w=1u l=1u
X2951 VDD VSS.t3026 VDD VDD sg13_lv_pmos ad=0.19p pd=1.38u as=0 ps=0 w=1u l=1u
X2952 VDD VSS.t3203 VDD VDD sg13_lv_pmos ad=0.34p pd=2.68u as=0 ps=0 w=1u l=1u
X2953 VDD VSS.t1896 VDD VDD sg13_lv_pmos ad=0.19p pd=1.38u as=0 ps=0 w=1u l=1u
X2954 VSS.t2481 VDD VSS.t2483 VSS.t2482 sg13_lv_nmos ad=79.8f pd=0.8u as=0 ps=0 w=0.42u l=1u
X2955 VDD VSS.t2812 VDD VDD sg13_lv_pmos ad=0.19p pd=1.38u as=0 ps=0 w=1u l=1u
X2956 VSS.t2139 VDD VSS.t2138 VSS.t2137 sg13_lv_nmos ad=0.1428p pd=1.52u as=0 ps=0 w=0.42u l=1u
X2957 VDD VSS.t939 VDD VDD sg13_lv_pmos ad=0.19p pd=1.38u as=0 ps=0 w=1u l=1u
X2958 VSS.t1702 VDD VSS.t1701 VSS.t1700 sg13_lv_nmos ad=0.1428p pd=1.52u as=0 ps=0 w=0.42u l=1u
X2959 VDD VSS.t2428 VDD VDD sg13_lv_pmos ad=0.19p pd=1.38u as=0 ps=0 w=1u l=1u
X2960 VDD VSS.t47 VDD VDD sg13_lv_pmos ad=0.19p pd=1.38u as=0 ps=0 w=1u l=1u
X2961 VDD VSS.t105 VDD VDD sg13_lv_pmos ad=0.34p pd=2.68u as=0 ps=0 w=1u l=1u
X2962 VSS.t667 VDD VSS.t670 VSS.t799 sg13_lv_nmos ad=79.8f pd=0.8u as=0 ps=0 w=0.42u l=1u
X2963 VDD VSS.t2053 VDD VDD sg13_lv_pmos ad=0.34p pd=2.68u as=0 ps=0 w=1u l=1u
X2964 VSS.t1042 VDD VSS.t1041 VSS.t1040 sg13_lv_nmos ad=0.1428p pd=1.52u as=0 ps=0 w=0.42u l=1u
X2965 VDD VSS.t876 VDD VDD sg13_lv_pmos ad=0.34p pd=2.68u as=0 ps=0 w=1u l=1u
X2966 VDD VSS.t3176 VDD VDD sg13_lv_pmos ad=0.19p pd=1.38u as=0 ps=0 w=1u l=1u
X2967 VSS.t2446 VDD VSS.t2448 VSS.t2447 sg13_lv_nmos ad=79.8f pd=0.8u as=0 ps=0 w=0.42u l=1u
X2968 VDD VSS.t612 VDD VDD sg13_lv_pmos ad=0.34p pd=2.68u as=0 ps=0 w=1u l=1u
X2969 VDD VSS.t131 VDD VDD sg13_lv_pmos ad=0.19p pd=1.38u as=0 ps=0 w=1u l=1u
X2970 VDD VSS.t814 VDD VDD sg13_lv_pmos ad=0.19p pd=1.38u as=0 ps=0 w=1u l=1u
X2971 VSS.t1612 VDD VSS.t1614 VSS.t1613 sg13_lv_nmos ad=79.8f pd=0.8u as=0 ps=0 w=0.42u l=1u
X2972 sg13cmos5l_buf_8_2.X a_19323_13726# VDD VDD sg13_lv_pmos ad=0.2128p pd=1.5u as=0.2128p ps=1.5u w=1.12u l=0.13u
X2973 VSS.t1934 VDD VSS.t1933 VSS.t1932 sg13_lv_nmos ad=0.1428p pd=1.52u as=0 ps=0 w=0.42u l=1u
X2974 VDD VSS.t418 VDD VDD sg13_lv_pmos ad=0.19p pd=1.38u as=0 ps=0 w=1u l=1u
X2975 VSS.t1397 VDD VSS.t1241 VSS.t248 sg13_lv_nmos ad=0.1428p pd=1.52u as=0 ps=0 w=0.42u l=1u
X2976 VDD VSS.t1888 VDD VDD sg13_lv_pmos ad=0.34p pd=2.68u as=0 ps=0 w=1u l=1u
X2977 sg13cmos5l_dlygate4sd3_1_0.A a_6540_13238# VDD VDD sg13_lv_pmos ad=0.2408p pd=1.55u as=0.3808p ps=2.92u w=1.12u l=0.13u
X2978 VDD VSS.t31 VDD VDD sg13_lv_pmos ad=0.19p pd=1.38u as=0 ps=0 w=1u l=1u
X2979 a_8685_14832# sg13cmos5l_buf_1_10.X VDD VDD sg13_lv_pmos ad=0.1596p pd=1.22u as=0.2856p ps=2.36u w=0.84u l=0.13u
X2980 a_21060_14488# a_21579_14495# a_22319_14845# VSS.t0 sg13_lv_nmos ad=0.3473p pd=2.71u as=0.12665p ps=1.145u w=0.74u l=0.13u
X2981 VDD VSS.t1334 VDD VDD sg13_lv_pmos ad=0.34p pd=2.68u as=0 ps=0 w=1u l=1u
X2982 VSS.t2276 VDD VSS.t2275 VSS.t2274 sg13_lv_nmos ad=0.1428p pd=1.52u as=0 ps=0 w=0.42u l=1u
X2983 VSS.t664 VDD VSS.t661 VSS.t663 sg13_lv_nmos ad=0.1428p pd=1.52u as=0 ps=0 w=0.42u l=1u
X2984 VDD VSS.t1691 VDD VDD sg13_lv_pmos ad=0.34p pd=2.68u as=0 ps=0 w=1u l=1u
X2985 VSS.t1732 VDD VSS.t1734 VSS.t1733 sg13_lv_nmos ad=79.8f pd=0.8u as=0 ps=0 w=0.42u l=1u
X2986 VSS.t2674 VDD VSS.t2675 VSS.t199 sg13_lv_nmos ad=79.8f pd=0.8u as=0 ps=0 w=0.42u l=1u
X2987 VSS.t2751 VDD VSS.t2751 VSS.t199 sg13_lv_nmos ad=0.1428p pd=1.52u as=0 ps=0 w=0.42u l=1u
X2988 VSS.t917 VDD VSS.t919 VSS.t918 sg13_lv_nmos ad=79.8f pd=0.8u as=0 ps=0 w=0.42u l=1u
X2989 VSS.t3064 VDD VSS.t3066 VSS.t3065 sg13_lv_nmos ad=79.8f pd=0.8u as=0 ps=0 w=0.42u l=1u
X2990 VDD VSS.t2971 VDD VDD sg13_lv_pmos ad=0.19p pd=1.38u as=0 ps=0 w=1u l=1u
X2991 a_21166_16263# a_21281_16262# VDD VDD sg13_lv_pmos ad=0.34p pd=2.68u as=0.2254p ps=1.53u w=1u l=0.5u
X2992 VDD a_5687_15315# a_5687_15549# VDD sg13_lv_pmos ad=2.8961p pd=18.25u as=0.2442p ps=2.06u w=0.66u l=0.13u
X2993 VDD VSS.t2380 VDD VDD sg13_lv_pmos ad=0.34p pd=2.68u as=0 ps=0 w=1u l=1u
X2994 VDD VSS.t2038 VDD VDD sg13_lv_pmos ad=0.34p pd=2.68u as=0 ps=0 w=1u l=1u
X2995 VDD a_22508_15960# counter_value_o[4] VDD sg13_lv_pmos ad=0.2114p pd=1.54u as=0.42p ps=2.99u w=1.12u l=0.13u
X2996 VDD VSS.t640 VDD VDD sg13_lv_pmos ad=0.19p pd=1.38u as=0 ps=0 w=1u l=1u
X2997 VSS.t568 VDD VSS.t570 VSS.t569 sg13_lv_nmos ad=79.8f pd=0.8u as=0 ps=0 w=0.42u l=1u
X2998 VDD VSS.t575 VDD VDD sg13_lv_pmos ad=0.19p pd=1.38u as=0 ps=0 w=1u l=1u
X2999 VDD VSS.t1365 VDD VDD sg13_lv_pmos ad=0.19p pd=1.38u as=0 ps=0 w=1u l=1u
X3000 VDD VSS.t1260 VDD VDD sg13_lv_pmos ad=0.19p pd=1.38u as=0 ps=0 w=1u l=1u
X3001 VSS.t1226 VDD VSS.t1225 VSS.t248 sg13_lv_nmos ad=0.1428p pd=1.52u as=0 ps=0 w=0.42u l=1u
X3002 VDD VSS.t3161 VDD VDD sg13_lv_pmos ad=0.19p pd=1.38u as=0 ps=0 w=1u l=1u
X3003 VDD VSS.t2739 VDD VDD sg13_lv_pmos ad=0.19p pd=1.38u as=0 ps=0 w=1u l=1u
X3004 VDD VSS.t1956 VDD VDD sg13_lv_pmos ad=0.19p pd=1.38u as=0 ps=0 w=1u l=1u
X3005 VSS.t2401 VDD VSS.t2400 VSS.t2399 sg13_lv_nmos ad=0.1428p pd=1.52u as=0 ps=0 w=0.42u l=1u
X3006 a_27664_13942# sg13cmos5l_dfrbpq_1_5.RESET_B VDD VDD sg13_lv_pmos ad=79.8f pd=0.8u as=2.42015p ps=15.68u w=0.42u l=0.13u
X3007 VSS.t1378 VDD VSS.t1220 VSS.t248 sg13_lv_nmos ad=79.8f pd=0.8u as=0 ps=0 w=0.42u l=1u
X3008 sg13cmos5l_nand4_1_0.Y sg13cmos5l_xor2_1_0.B VDD VDD sg13_lv_pmos ad=0.2128p pd=1.5u as=0.3808p ps=2.92u w=1.12u l=0.13u
X3009 VSS.t481 VDD VSS.t482 VSS.t19 sg13_lv_nmos ad=79.8f pd=0.8u as=0 ps=0 w=0.42u l=1u
X3010 VDD VSS.t474 VDD VDD sg13_lv_pmos ad=0.34p pd=2.68u as=0 ps=0 w=1u l=1u
X3011 a_15782_13722# a_16587_13844# a_16042_13945# VDD sg13_lv_pmos ad=0.1428p pd=1.52u as=79.8f ps=0.8u w=0.42u l=0.13u
X3012 VSS.t2797 VDD VSS.t2796 VSS.t199 sg13_lv_nmos ad=0.1428p pd=1.52u as=0 ps=0 w=0.42u l=1u
X3013 VDD VSS.t2081 VDD VDD sg13_lv_pmos ad=0.19p pd=1.38u as=0 ps=0 w=1u l=1u
X3014 VDD VSS.t3188 VDD VDD sg13_lv_pmos ad=0.34p pd=2.68u as=0 ps=0 w=1u l=1u
X3015 VDD VSS.t328 VDD VDD sg13_lv_pmos ad=0.19p pd=1.38u as=0 ps=0 w=1u l=1u
X3016 VDD VSS.t1724 VDD VDD sg13_lv_pmos ad=0.19p pd=1.38u as=0 ps=0 w=1u l=1u
X3017 VSS.t2466 VDD VSS.t2468 VSS.t2467 sg13_lv_nmos ad=79.8f pd=0.8u as=0 ps=0 w=0.42u l=1u
X3018 a_10222_14751# a_10337_14750# VDD VDD sg13_lv_pmos ad=0.34p pd=2.68u as=0.2254p ps=1.53u w=1u l=0.5u
X3019 VDD VSS.t1764 VDD VDD sg13_lv_pmos ad=0.19p pd=1.38u as=0 ps=0 w=1u l=1u
X3020 VSS.t1964 VDD VSS.t1966 VSS.t1965 sg13_lv_nmos ad=79.8f pd=0.8u as=0 ps=0 w=0.42u l=1u
X3021 VDD VSS.t2991 VDD VDD sg13_lv_pmos ad=0.19p pd=1.38u as=0 ps=0 w=1u l=1u
X3022 VDD VSS.t1594 VDD VDD sg13_lv_pmos ad=0.19p pd=1.38u as=0 ps=0 w=1u l=1u
X3023 VDD a_26565_13701# a_26667_13844# VDD sg13_lv_pmos ad=2.42015p pd=15.68u as=0.3864p ps=2.93u w=1.12u l=0.13u
X3024 VDD VSS.t105 VDD VDD sg13_lv_pmos ad=0.34p pd=2.68u as=0 ps=0 w=1u l=1u
X3025 VSS.t19 a_21477_14495# a_21579_14495# VSS.t95 sg13_lv_nmos ad=4.11262p pd=27.15u as=0.2516p ps=2.16u w=0.74u l=0.13u
X3026 VDD VSS.t370 VDD VDD sg13_lv_pmos ad=0.34p pd=2.68u as=0 ps=0 w=1u l=1u
X3027 VSS.t1317 VDD VSS.t1316 VSS.t248 sg13_lv_nmos ad=0.1428p pd=1.52u as=0 ps=0 w=0.42u l=1u
X3028 VDD VSS.t1356 VDD VDD sg13_lv_pmos ad=0.19p pd=1.38u as=0 ps=0 w=1u l=1u
X3029 VSS.t2683 VDD VSS.t2682 VSS.t199 sg13_lv_nmos ad=0.1428p pd=1.52u as=0 ps=0 w=0.42u l=1u
X3030 VDD VSS.t623 VDD VDD sg13_lv_pmos ad=0.34p pd=2.68u as=0 ps=0 w=1u l=1u
X3031 VDD VSS.t2735 VDD VDD sg13_lv_pmos ad=0.19p pd=1.38u as=0 ps=0 w=1u l=1u
X3032 VDD VSS.t2408 VDD VDD sg13_lv_pmos ad=0.19p pd=1.38u as=0 ps=0 w=1u l=1u
X3033 VSS.t463 VDD VSS.t462 VSS.t19 sg13_lv_nmos ad=0.1428p pd=1.52u as=0 ps=0 w=0.42u l=1u
X3034 a_4474_14448# sg13cmos5l_dlygate4sd3_1_3.A VSS.t41 VSS.t285 sg13_lv_nmos ad=0.1428p pd=1.52u as=79.8f ps=0.8u w=0.42u l=0.13u
X3035 VSS.t45 VDD VSS.t414 VSS.t413 sg13_lv_nmos ad=79.8f pd=0.8u as=0 ps=0 w=0.42u l=1u
X3036 VSS.t630 VDD VSS.t633 VSS.t632 sg13_lv_nmos ad=79.8f pd=0.8u as=0 ps=0 w=0.42u l=1u
X3037 VSS.t2710 VDD VSS.t2711 VSS.t199 sg13_lv_nmos ad=79.8f pd=0.8u as=0 ps=0 w=0.42u l=1u
X3038 VSS.t2744 VDD VSS.t2745 VSS.t199 sg13_lv_nmos ad=79.8f pd=0.8u as=0 ps=0 w=0.42u l=1u
X3039 VSS.t1353 VDD VSS.t1354 VSS.t248 sg13_lv_nmos ad=79.8f pd=0.8u as=0 ps=0 w=0.42u l=1u
X3040 VDD VSS.t1744 VDD VDD sg13_lv_pmos ad=0.19p pd=1.38u as=0 ps=0 w=1u l=1u
X3041 VDD VSS.t3031 VDD VDD sg13_lv_pmos ad=0.19p pd=1.38u as=0 ps=0 w=1u l=1u
X3042 VDD VSS.t1901 VDD VDD sg13_lv_pmos ad=0.19p pd=1.38u as=0 ps=0 w=1u l=1u
X3043 VSS.t1904 VDD VSS.t1903 VSS.t1902 sg13_lv_nmos ad=0.1428p pd=1.52u as=0 ps=0 w=0.42u l=1u
X3044 VSS.t334 VDD VSS.t334 VSS.t336 sg13_lv_nmos ad=0.1428p pd=1.52u as=0 ps=0 w=0.42u l=1u
X3045 VDD VSS.t305 VDD VDD sg13_lv_pmos ad=0.19p pd=1.38u as=0 ps=0 w=1u l=1u
X3046 VDD VSS.t254 VDD VDD sg13_lv_pmos ad=0.34p pd=2.68u as=0 ps=0 w=1u l=1u
X3047 VDD VSS.t2745 VDD VDD sg13_lv_pmos ad=0.34p pd=2.68u as=0 ps=0 w=1u l=1u
X3048 a_27215_14845# a_26373_14495# a_25956_14488# VDD sg13_lv_pmos ad=0.2048p pd=1.63u as=0.34p ps=2.68u w=1u l=0.13u
X3049 VSS.t3049 VDD VSS.t3051 VSS.t3050 sg13_lv_nmos ad=79.8f pd=0.8u as=0 ps=0 w=0.42u l=1u
X3050 VDD VSS.t2815 VDD VDD sg13_lv_pmos ad=0.19p pd=1.38u as=0 ps=0 w=1u l=1u
X3051 VSS.t2109 VDD VSS.t2108 VSS.t2107 sg13_lv_nmos ad=0.1428p pd=1.52u as=0 ps=0 w=0.42u l=1u
X3052 VSS.t630 VDD VSS.t630 VSS.t757 sg13_lv_nmos ad=79.8f pd=0.8u as=0 ps=0 w=0.42u l=1u
X3053 VDD VSS.t458 VDD VDD sg13_lv_pmos ad=0.19p pd=1.38u as=0 ps=0 w=1u l=1u
X3054 VDD VSS.t1076 VDD VDD sg13_lv_pmos ad=0.34p pd=2.68u as=0 ps=0 w=1u l=1u
X3055 VDD VSS.t667 VDD VDD sg13_lv_pmos ad=0.19p pd=1.38u as=0 ps=0 w=1u l=1u
X3056 VSS.t1362 VDD VSS.t1363 VSS.t248 sg13_lv_nmos ad=79.8f pd=0.8u as=0 ps=0 w=0.42u l=1u
X3057 VSS.t2451 VDD VSS.t2453 VSS.t2452 sg13_lv_nmos ad=79.8f pd=0.8u as=0 ps=0 w=0.42u l=1u
X3058 VDD VSS.t1539 VDD VDD sg13_lv_pmos ad=0.19p pd=1.38u as=0 ps=0 w=1u l=1u
X3059 VDD VSS.t3003 VDD VDD sg13_lv_pmos ad=0.34p pd=2.68u as=0 ps=0 w=1u l=1u
X3060 VDD VSS.t643 VDD VDD sg13_lv_pmos ad=0.34p pd=2.68u as=0 ps=0 w=1u l=1u
X3061 VSS.t1617 VDD VSS.t1619 VSS.t1618 sg13_lv_nmos ad=79.8f pd=0.8u as=0 ps=0 w=0.42u l=1u
X3062 VDD VSS.t2118 VDD VDD sg13_lv_pmos ad=0.34p pd=2.68u as=0 ps=0 w=1u l=1u
X3063 VSS.t882 VDD VSS.t884 VSS.t883 sg13_lv_nmos ad=79.8f pd=0.8u as=0 ps=0 w=0.42u l=1u
X3064 VSS.t1939 VDD VSS.t1938 VSS.t1937 sg13_lv_nmos ad=0.1428p pd=1.52u as=0 ps=0 w=0.42u l=1u
X3065 a_4078_14751# a_4193_14750# VSS.t26 VSS.t25 sg13_lv_nmos ad=0.1428p pd=1.52u as=0.1426p ps=1.16u w=0.42u l=0.5u
X3066 VSS.t2787 VDD VSS.t2787 VSS.t199 sg13_lv_nmos ad=0.1428p pd=1.52u as=0 ps=0 w=0.42u l=1u
X3067 VDD VSS.t2703 VDD VDD sg13_lv_pmos ad=0.19p pd=1.38u as=0 ps=0 w=1u l=1u
X3068 a_21286_14909# sg13cmos5l_dfrbpq_1_6.RESET_B VSS.t23 VSS.t3289 sg13_lv_nmos ad=37.8f pd=0.6u as=0.1701p ps=1.65u w=0.42u l=0.13u
X3069 VDD VSS.t1278 VDD VDD sg13_lv_pmos ad=0.19p pd=1.38u as=0 ps=0 w=1u l=1u
X3070 VDD VSS.t2066 VDD VDD sg13_lv_pmos ad=0.19p pd=1.38u as=0 ps=0 w=1u l=1u
X3071 VSS.t2481 VDD VSS.t2480 VSS.t2479 sg13_lv_nmos ad=0.1428p pd=1.52u as=0 ps=0 w=0.42u l=1u
X3072 VDD VSS.t2018 VDD VDD sg13_lv_pmos ad=0.34p pd=2.68u as=0 ps=0 w=1u l=1u
X3073 VSS.t1737 VDD VSS.t1739 VSS.t1738 sg13_lv_nmos ad=79.8f pd=0.8u as=0 ps=0 w=0.42u l=1u
X3074 VDD VSS.t1749 VDD VDD sg13_lv_pmos ad=0.19p pd=1.38u as=0 ps=0 w=1u l=1u
X3075 VSS.t2129 VDD VSS.t2128 VSS.t2127 sg13_lv_nmos ad=0.1428p pd=1.52u as=0 ps=0 w=0.42u l=1u
X3076 VSS.t1949 VDD VSS.t1951 VSS.t1950 sg13_lv_nmos ad=79.8f pd=0.8u as=0 ps=0 w=0.42u l=1u
X3077 a_16955_14484# sg13cmos5l_a21oi_1_0.A2 VDD VDD sg13_lv_pmos ad=0.3808p pd=2.92u as=0.2128p ps=1.5u w=1.12u l=0.13u
X3078 VDD VSS.t2976 VDD VDD sg13_lv_pmos ad=0.19p pd=1.38u as=0 ps=0 w=1u l=1u
X3079 VSS.t3034 VDD VSS.t3036 VSS.t3035 sg13_lv_nmos ad=79.8f pd=0.8u as=0 ps=0 w=0.42u l=1u
X3080 VDD VSS.t1701 VDD VDD sg13_lv_pmos ad=0.34p pd=2.68u as=0 ps=0 w=1u l=1u
X3081 VSS.t2546 VDD VSS.t2548 VSS.t2547 sg13_lv_nmos ad=79.8f pd=0.8u as=0 ps=0 w=0.42u l=1u
X3082 a_2942_14484# sg13cmos5l_xor2_1_0.B a_2490_14447# VDD sg13_lv_pmos ad=0.1225p pd=1.245u as=0.34p ps=2.68u w=1u l=0.13u
X3083 VSS.t90 a_15579_14854# sg13cmos5l_buf_8_2.A VSS.t157 sg13_lv_nmos ad=0.2516p pd=2.16u as=0.1406p ps=1.12u w=0.74u l=0.13u
X3084 VDD VSS.t851 VDD VDD sg13_lv_pmos ad=0.34p pd=2.68u as=0 ps=0 w=1u l=1u
X3085 VDD VSS.t1579 VDD VDD sg13_lv_pmos ad=0.19p pd=1.38u as=0 ps=0 w=1u l=1u
X3086 VDD VSS.t1756 VDD VDD sg13_lv_pmos ad=0.34p pd=2.68u as=0 ps=0 w=1u l=1u
X3087 VDD VSS.t646 VDD VDD sg13_lv_pmos ad=0.34p pd=2.68u as=0 ps=0 w=1u l=1u
X3088 a_5613_14832# sg13cmos5l_buf_1_10.X VDD VDD sg13_lv_pmos ad=0.1596p pd=1.22u as=0.2856p ps=2.36u w=0.84u l=0.13u
X3089 VSS.t1344 VDD VSS.t1343 VSS.t248 sg13_lv_nmos ad=0.1428p pd=1.52u as=0 ps=0 w=0.42u l=1u
X3090 VDD VSS.t2385 VDD VDD sg13_lv_pmos ad=0.34p pd=2.68u as=0 ps=0 w=1u l=1u
X3091 a_18665_15180# a_18789_15277# VDD VDD sg13_lv_pmos ad=0.2442p pd=2.06u as=2.8961p ps=18.25u w=0.66u l=0.13u
X3092 VDD sg13cmos5l_buf_1_0.X sg13cmos5l_xnor2_1_2.B VDD sg13_lv_pmos ad=0.3808p pd=2.92u as=0.2128p ps=1.5u w=1.12u l=0.13u
X3093 VSS.t15 VDD VSS.t131 VSS.t437 sg13_lv_nmos ad=79.8f pd=0.8u as=0 ps=0 w=0.42u l=1u
X3094 VDD VSS.t682 VDD VDD sg13_lv_pmos ad=0.34p pd=2.68u as=0 ps=0 w=1u l=1u
X3095 VSS.t1467 VDD VSS.t1338 VSS.t248 sg13_lv_nmos ad=79.8f pd=0.8u as=0 ps=0 w=0.42u l=1u
X3096 VDD VSS.t1961 VDD VDD sg13_lv_pmos ad=0.19p pd=1.38u as=0 ps=0 w=1u l=1u
X3097 VSS.t367 VDD VSS.t366 VSS.t365 sg13_lv_nmos ad=0.1428p pd=1.52u as=0 ps=0 w=0.42u l=1u
X3098 a_5886_15486# a_5687_15549# VSS.t19 VSS.t127 sg13_lv_nmos ad=0.27427p pd=2.28u as=4.11262p ps=27.15u w=0.795u l=0.13u
X3099 VDD VSS.t491 VDD VDD sg13_lv_pmos ad=0.19p pd=1.38u as=0 ps=0 w=1u l=1u
X3100 VDD VSS.t904 VDD VDD sg13_lv_pmos ad=0.19p pd=1.38u as=0 ps=0 w=1u l=1u
X3101 VDD VSS.t2280 VDD VDD sg13_lv_pmos ad=0.34p pd=2.68u as=0 ps=0 w=1u l=1u
X3102 VSS.t2799 VDD VSS.t2799 VSS.t199 sg13_lv_nmos ad=0.1428p pd=1.52u as=0 ps=0 w=0.42u l=1u
X3103 VSS.t23 a_21070_15423# sg13cmos5l_dlygate4sd3_1_9.X VSS.t22 sg13_lv_nmos ad=0.1426p pd=1.16u as=0.2516p ps=2.16u w=0.74u l=0.13u
X3104 VDD VSS.t1320 VDD VDD sg13_lv_pmos ad=0.19p pd=1.38u as=0 ps=0 w=1u l=1u
X3105 VDD VSS.t1269 VDD VDD sg13_lv_pmos ad=0.19p pd=1.38u as=0 ps=0 w=1u l=1u
X3106 VDD VSS.t2772 VDD VDD sg13_lv_pmos ad=0.19p pd=1.38u as=0 ps=0 w=1u l=1u
X3107 VDD VSS.t2086 VDD VDD sg13_lv_pmos ad=0.19p pd=1.38u as=0 ps=0 w=1u l=1u
X3108 VDD VSS.t3193 VDD VDD sg13_lv_pmos ad=0.34p pd=2.68u as=0 ps=0 w=1u l=1u
X3109 VSS.t2466 VDD VSS.t2465 VSS.t2464 sg13_lv_nmos ad=0.1428p pd=1.52u as=0 ps=0 w=0.42u l=1u
X3110 VSS.t1889 VDD VSS.t1888 VSS.t1887 sg13_lv_nmos ad=0.1428p pd=1.52u as=0 ps=0 w=0.42u l=1u
X3111 VDD a_7822_13911# sg13cmos5l_xnor2_1_2.A VDD sg13_lv_pmos ad=0.2254p pd=1.53u as=0.4256p ps=3u w=1.12u l=0.13u
X3112 VSS.t620 VDD VSS.t742 VSS.t741 sg13_lv_nmos ad=79.8f pd=0.8u as=0 ps=0 w=0.42u l=1u
X3113 VSS.t646 VDD VSS.t649 VSS.t785 sg13_lv_nmos ad=79.8f pd=0.8u as=0 ps=0 w=0.42u l=1u
X3114 VDD VSS.t1729 VDD VDD sg13_lv_pmos ad=0.19p pd=1.38u as=0 ps=0 w=1u l=1u
X3115 VSS.t2746 VDD VSS.t2746 VSS.t199 sg13_lv_nmos ad=0.1428p pd=1.52u as=0 ps=0 w=0.42u l=1u
X3116 VSS.t23 sg13cmos5l_or3_1_2.X a_20705_15260# VSS.t87 sg13_lv_nmos ad=0.2516p pd=2.16u as=0.1406p ps=1.12u w=0.74u l=0.13u
X3117 VDD VSS.t1734 VDD VDD sg13_lv_pmos ad=0.19p pd=1.38u as=0 ps=0 w=1u l=1u
X3118 VSS.t937 VDD VSS.t939 VSS.t938 sg13_lv_nmos ad=79.8f pd=0.8u as=0 ps=0 w=0.42u l=1u
X3119 VSS.t1692 VDD VSS.t1691 VSS.t1690 sg13_lv_nmos ad=0.1428p pd=1.52u as=0 ps=0 w=0.42u l=1u
X3120 VSS.t3214 VDD VSS.t3213 VSS.t3212 sg13_lv_nmos ad=0.1428p pd=1.52u as=0 ps=0 w=0.42u l=1u
X3121 VSS.t2531 VDD VSS.t2533 VSS.t2532 sg13_lv_nmos ad=79.8f pd=0.8u as=0 ps=0 w=0.42u l=1u
X3122 VDD VSS.t2418 VDD VDD sg13_lv_pmos ad=0.19p pd=1.38u as=0 ps=0 w=1u l=1u
X3123 a_22508_15960# sg13cmos5l_dfrbpq_1_3.Q VSS.t122 VSS.t121 sg13_lv_nmos ad=0.187p pd=1.78u as=0.14875p ps=1.16u w=0.55u l=0.13u
X3124 a_7631_14845# a_6789_14495# a_7537_14845# VSS.t80 sg13_lv_nmos ad=0.12665p pd=1.145u as=0.1428p ps=1.52u w=0.42u l=0.13u
X3125 VSS.t877 VDD VSS.t876 VSS.t875 sg13_lv_nmos ad=0.1428p pd=1.52u as=0 ps=0 w=0.42u l=1u
X3126 VSS.t2685 VDD VSS.t2685 VSS.t199 sg13_lv_nmos ad=0.1428p pd=1.52u as=0 ps=0 w=0.42u l=1u
X3127 VSS.t812 VDD VSS.t814 VSS.t813 sg13_lv_nmos ad=79.8f pd=0.8u as=0 ps=0 w=0.42u l=1u
X3128 VSS.t2779 VDD VSS.t2780 VSS.t199 sg13_lv_nmos ad=79.8f pd=0.8u as=0 ps=0 w=0.42u l=1u
X3129 VDD VSS.t2737 VDD VDD sg13_lv_pmos ad=0.19p pd=1.38u as=0 ps=0 w=1u l=1u
X3130 VSS.t2436 VDD VSS.t2438 VSS.t2437 sg13_lv_nmos ad=79.8f pd=0.8u as=0 ps=0 w=0.42u l=1u
X3131 VSS.t1999 VDD VSS.t1998 VSS.t1997 sg13_lv_nmos ad=0.1428p pd=1.52u as=0 ps=0 w=0.42u l=1u
X3132 VDD VSS.t1524 VDD VDD sg13_lv_pmos ad=0.19p pd=1.38u as=0 ps=0 w=1u l=1u
X3133 VDD VSS.t2988 VDD VDD sg13_lv_pmos ad=0.34p pd=2.68u as=0 ps=0 w=1u l=1u
X3134 VDD VSS.t670 VDD VDD sg13_lv_pmos ad=0.34p pd=2.68u as=0 ps=0 w=1u l=1u
X3135 VSS.t882 VDD VSS.t884 VSS.t883 sg13_lv_nmos ad=79.8f pd=0.8u as=0 ps=0 w=0.42u l=1u
X3136 VSS.t1278 VDD VSS.t1277 VSS.t248 sg13_lv_nmos ad=0.1428p pd=1.52u as=0 ps=0 w=0.42u l=1u
X3137 a_21562_15960# sg13cmos5l_a21oi_1_1.Y VDD VDD sg13_lv_pmos ad=0.1428p pd=1.52u as=0.1523p ps=1.38u w=0.42u l=0.13u
X3138 VSS.t1602 VDD VSS.t1604 VSS.t1603 sg13_lv_nmos ad=79.8f pd=0.8u as=0 ps=0 w=0.42u l=1u
X3139 VDD VSS.t2103 VDD VDD sg13_lv_pmos ad=0.34p pd=2.68u as=0 ps=0 w=1u l=1u
X3140 VSS.t11 sg13cmos5l_or3_1_1.X a_25025_16344# VSS.t138 sg13_lv_nmos ad=0.2516p pd=2.16u as=0.1406p ps=1.12u w=0.74u l=0.13u
X3141 VDD VSS.t403 VDD VDD sg13_lv_pmos ad=0.19p pd=1.38u as=0 ps=0 w=1u l=1u
X3142 a_17604_14488# a_18123_14495# a_18863_14845# VSS.t52 sg13_lv_nmos ad=0.3473p pd=2.71u as=0.12665p ps=1.145u w=0.74u l=0.13u
X3143 VDD VSS.t2473 VDD VDD sg13_lv_pmos ad=0.19p pd=1.38u as=0 ps=0 w=1u l=1u
X3144 VDD VSS.t1906 VDD VDD sg13_lv_pmos ad=0.19p pd=1.38u as=0 ps=0 w=1u l=1u
X3145 VSS.t1283 VDD VSS.t1282 VSS.t248 sg13_lv_nmos ad=0.1428p pd=1.52u as=0 ps=0 w=0.42u l=1u
X3146 VDD VSS.t1714 VDD VDD sg13_lv_pmos ad=0.19p pd=1.38u as=0 ps=0 w=1u l=1u
X3147 VSS.t2079 VDD VSS.t2081 VSS.t2080 sg13_lv_nmos ad=79.8f pd=0.8u as=0 ps=0 w=0.42u l=1u
X3148 VSS.t907 VDD VSS.t906 VSS.t905 sg13_lv_nmos ad=0.1428p pd=1.52u as=0 ps=0 w=0.42u l=1u
X3149 VDD VSS.t2003 VDD VDD sg13_lv_pmos ad=0.34p pd=2.68u as=0 ps=0 w=1u l=1u
X3150 VSS.t1206 VDD VSS.t1205 VSS.t248 sg13_lv_nmos ad=0.1428p pd=1.52u as=0 ps=0 w=0.42u l=1u
X3151 VSS.t1244 VDD VSS.t1246 VSS.t248 sg13_lv_nmos ad=79.8f pd=0.8u as=0 ps=0 w=0.42u l=1u
X3152 VSS.t2114 VDD VSS.t2113 VSS.t2112 sg13_lv_nmos ad=0.1428p pd=1.52u as=0 ps=0 w=0.42u l=1u
X3153 VSS.t3199 VDD VSS.t3198 VSS.t3197 sg13_lv_nmos ad=0.1428p pd=1.52u as=0 ps=0 w=0.42u l=1u
X3154 VDD VSS.t1084 VDD VDD sg13_lv_pmos ad=0.19p pd=1.38u as=0 ps=0 w=1u l=1u
X3155 sg13cmos5l_buf_1_10.X a_1192_9948# VDD VDD sg13_lv_pmos ad=0.42p pd=2.99u as=0.2114p ps=1.54u w=1.12u l=0.13u
X3156 VSS.t667 VDD VSS.t667 VSS.t668 sg13_lv_nmos ad=79.8f pd=0.8u as=0 ps=0 w=0.42u l=1u
X3157 VSS.t679 VDD VSS.t682 VSS.t807 sg13_lv_nmos ad=79.8f pd=0.8u as=0 ps=0 w=0.42u l=1u
X3158 VDD VSS.t1686 VDD VDD sg13_lv_pmos ad=0.34p pd=2.68u as=0 ps=0 w=1u l=1u
X3159 VSS.t1211 VDD VSS.t1210 VSS.t248 sg13_lv_nmos ad=0.1428p pd=1.52u as=0 ps=0 w=0.42u l=1u
X3160 VDD VSS.t1741 VDD VDD sg13_lv_pmos ad=0.34p pd=2.68u as=0 ps=0 w=1u l=1u
X3161 VSS.t1592 VDD VSS.t1594 VSS.t1593 sg13_lv_nmos ad=79.8f pd=0.8u as=0 ps=0 w=0.42u l=1u
X3162 VSS.t2486 VDD VSS.t2485 VSS.t2484 sg13_lv_nmos ad=0.1428p pd=1.52u as=0 ps=0 w=0.42u l=1u
X3163 a_27417_14607# a_26475_14495# a_27215_14845# VDD sg13_lv_pmos ad=93.45f pd=0.865u as=0.2048p ps=1.63u w=0.42u l=0.13u
X3164 VDD VSS.t735 VDD VDD sg13_lv_pmos ad=0.34p pd=2.68u as=0 ps=0 w=1u l=1u
X3165 VSS.t967 VDD VSS.t969 VSS.t968 sg13_lv_nmos ad=79.8f pd=0.8u as=0 ps=0 w=0.42u l=1u
X3166 VDD VSS.t2370 VDD VDD sg13_lv_pmos ad=0.34p pd=2.68u as=0 ps=0 w=1u l=1u
X3167 VSS.t732 VDD VSS.t731 VSS.t730 sg13_lv_nmos ad=0.1428p pd=1.52u as=0 ps=0 w=0.42u l=1u
X3168 VDD VSS.t834 VDD VDD sg13_lv_pmos ad=0.19p pd=1.38u as=0 ps=0 w=1u l=1u
X3169 VDD VSS.t1544 VDD VDD sg13_lv_pmos ad=0.19p pd=1.38u as=0 ps=0 w=1u l=1u
X3170 VSS.t2667 VDD VSS.t2668 VSS.t199 sg13_lv_nmos ad=79.8f pd=0.8u as=0 ps=0 w=0.42u l=1u
X3171 VSS.t334 VDD VSS.t334 VSS.t335 sg13_lv_nmos ad=79.8f pd=0.8u as=0 ps=0 w=0.42u l=1u
X3172 VSS.t1587 VDD VSS.t1589 VSS.t1588 sg13_lv_nmos ad=79.8f pd=0.8u as=0 ps=0 w=0.42u l=1u
X3173 VDD VSS.t2123 VDD VDD sg13_lv_pmos ad=0.34p pd=2.68u as=0 ps=0 w=1u l=1u
X3174 VSS.t1944 VDD VSS.t1943 VSS.t1942 sg13_lv_nmos ad=0.1428p pd=1.52u as=0 ps=0 w=0.42u l=1u
X3175 VDD a_12010_15202# sg13cmos5l_dfrbpq_1_2.CLK VDD sg13_lv_pmos ad=0.2128p pd=1.5u as=0.2128p ps=1.5u w=1.12u l=0.13u
X3176 VDD VSS.t1346 VDD VDD sg13_lv_pmos ad=0.34p pd=2.68u as=0 ps=0 w=1u l=1u
X3177 VSS.t1228 VDD VSS.t1228 VSS.t248 sg13_lv_nmos ad=0.1428p pd=1.52u as=0 ps=0 w=0.42u l=1u
X3178 VSS.t2790 VDD VSS.t2790 VSS.t199 sg13_lv_nmos ad=0.1428p pd=1.52u as=0 ps=0 w=0.42u l=1u
X3179 VDD VSS.t2668 VDD VDD sg13_lv_pmos ad=0.34p pd=2.68u as=0 ps=0 w=1u l=1u
X3180 VSS.t105 VDD VSS.t105 VSS.t561 sg13_lv_nmos ad=79.8f pd=0.8u as=0 ps=0 w=0.42u l=1u
X3181 VDD VSS.t1260 VDD VDD sg13_lv_pmos ad=0.19p pd=1.38u as=0 ps=0 w=1u l=1u
X3182 VDD VSS.t2765 VDD VDD sg13_lv_pmos ad=0.19p pd=1.38u as=0 ps=0 w=1u l=1u
X3183 VSS.t2451 VDD VSS.t2450 VSS.t2449 sg13_lv_nmos ad=0.1428p pd=1.52u as=0 ps=0 w=0.42u l=1u
X3184 VSS.t937 VDD VSS.t939 VSS.t938 sg13_lv_nmos ad=79.8f pd=0.8u as=0 ps=0 w=0.42u l=1u
X3185 VSS.t1296 VDD VSS.t1295 VSS.t248 sg13_lv_nmos ad=0.1428p pd=1.52u as=0 ps=0 w=0.42u l=1u
X3186 VSS.t490 VDD VSS.t489 VSS.t19 sg13_lv_nmos ad=0.1428p pd=1.52u as=0 ps=0 w=0.42u l=1u
X3187 VSS.t1742 VDD VSS.t1744 VSS.t1743 sg13_lv_nmos ad=79.8f pd=0.8u as=0 ps=0 w=0.42u l=1u
X3188 VDD sg13cmos5l_dfrbpq_1_3.Q sg13cmos5l_or3_1_2.C VDD sg13_lv_pmos ad=0.3808p pd=2.92u as=0.2128p ps=1.5u w=1.12u l=0.13u
X3189 VDD sg13cmos5l_inv_1_0.Y a_16314_15532# VDD sg13_lv_pmos ad=0.2891p pd=1.695u as=0.1428p ps=1.375u w=1.12u l=0.13u
X3190 VDD VSS.t1051 VDD VDD sg13_lv_pmos ad=0.34p pd=2.68u as=0 ps=0 w=1u l=1u
X3191 VSS.t2516 VDD VSS.t2518 VSS.t2517 sg13_lv_nmos ad=79.8f pd=0.8u as=0 ps=0 w=0.42u l=1u
X3192 VSS.t877 VDD VSS.t876 VSS.t875 sg13_lv_nmos ad=0.1428p pd=1.52u as=0 ps=0 w=0.42u l=1u
X3193 VDD VSS.t1584 VDD VDD sg13_lv_pmos ad=0.19p pd=1.38u as=0 ps=0 w=1u l=1u
X3194 VSS.t2789 VDD VSS.t2788 VSS.t199 sg13_lv_nmos ad=0.1428p pd=1.52u as=0 ps=0 w=0.42u l=1u
X3195 VDD VSS.t1918 VDD VDD sg13_lv_pmos ad=0.34p pd=2.68u as=0 ps=0 w=1u l=1u
X3196 a_24841_13726# sg13cmos5l_or3_1_1.B VSS.t77 VSS.t261 sg13_lv_nmos ad=0.198p pd=1.27u as=0.1045p ps=0.93u w=0.55u l=0.13u
X3197 VSS.t812 VDD VSS.t814 VSS.t813 sg13_lv_nmos ad=79.8f pd=0.8u as=0 ps=0 w=0.42u l=1u
X3198 VDD VSS.t1273 VDD VDD sg13_lv_pmos ad=0.19p pd=1.38u as=0 ps=0 w=1u l=1u
X3199 VSS.t1237 VDD VSS.t1236 VSS.t248 sg13_lv_nmos ad=0.1428p pd=1.52u as=0 ps=0 w=0.42u l=1u
X3200 sg13cmos5l_or3_1_1.C sg13cmos5l_dfrbpq_1_6.Q VDD VDD sg13_lv_pmos ad=0.2128p pd=1.5u as=0.2128p ps=1.5u w=1.12u l=0.13u
X3201 a_23378_15242# sg13cmos5l_dfrbpq_1_2.Q VSS.t267 VSS.t48 sg13_lv_nmos ad=0.1406p pd=1.12u as=0.2886p ps=2.26u w=0.74u l=0.13u
X3202 VDD a_19120_14726# a_19065_14607# VDD sg13_lv_pmos ad=2.42015p pd=15.68u as=93.45f ps=0.865u w=0.42u l=0.13u
X3203 VDD VSS.t989 VDD VDD sg13_lv_pmos ad=0.19p pd=1.38u as=0 ps=0 w=1u l=1u
X3204 VSS.t2829 VDD VSS.t2828 VSS.t199 sg13_lv_nmos ad=0.1428p pd=1.52u as=0 ps=0 w=0.42u l=1u
X3205 VDD VSS.t2730 VDD VDD sg13_lv_pmos ad=0.19p pd=1.38u as=0 ps=0 w=1u l=1u
X3206 VDD sg13cmos5l_dfrbpq_1_0.RESET_B a_2630_15234# VDD sg13_lv_pmos ad=0.36237p pd=2.605u as=79.8f ps=0.8u w=0.42u l=0.13u
X3207 VSS.t3069 VDD VSS.t3068 VSS.t3067 sg13_lv_nmos ad=0.1428p pd=1.52u as=0 ps=0 w=0.42u l=1u
X3208 VDD VSS.t486 VDD VDD sg13_lv_pmos ad=0.34p pd=2.68u as=0 ps=0 w=1u l=1u
X3209 VSS.t1537 VDD VSS.t1539 VSS.t1538 sg13_lv_nmos ad=79.8f pd=0.8u as=0 ps=0 w=0.42u l=1u
X3210 VDD VSS.t388 VDD VDD sg13_lv_pmos ad=0.34p pd=2.68u as=0 ps=0 w=1u l=1u
X3211 VSS.t1767 VDD VSS.t1766 VSS.t1765 sg13_lv_nmos ad=0.1428p pd=1.52u as=0 ps=0 w=0.42u l=1u
X3212 VDD VSS.t1549 VDD VDD sg13_lv_pmos ad=0.19p pd=1.38u as=0 ps=0 w=1u l=1u
X3213 VDD VSS.t2458 VDD VDD sg13_lv_pmos ad=0.19p pd=1.38u as=0 ps=0 w=1u l=1u
X3214 VSS.t1929 VDD VSS.t1928 VSS.t1927 sg13_lv_nmos ad=0.1428p pd=1.52u as=0 ps=0 w=0.42u l=1u
X3215 VSS.t623 VDD VSS.t623 VSS.t749 sg13_lv_nmos ad=0.1428p pd=1.52u as=0 ps=0 w=0.42u l=1u
X3216 VDD VSS.t1272 VDD VDD sg13_lv_pmos ad=0.19p pd=1.38u as=0 ps=0 w=1u l=1u
X3217 VDD VSS.t2775 VDD VDD sg13_lv_pmos ad=0.19p pd=1.38u as=0 ps=0 w=1u l=1u
X3218 VDD VSS.t2056 VDD VDD sg13_lv_pmos ad=0.19p pd=1.38u as=0 ps=0 w=1u l=1u
X3219 VDD a_12010_15202# sg13cmos5l_dfrbpq_1_2.CLK VDD sg13_lv_pmos ad=0.2128p pd=1.5u as=0.2128p ps=1.5u w=1.12u l=0.13u
X3220 VSS.t907 VDD VSS.t906 VSS.t905 sg13_lv_nmos ad=0.1428p pd=1.52u as=0 ps=0 w=0.42u l=1u
X3221 VSS.t1446 VDD VSS.t1308 VSS.t248 sg13_lv_nmos ad=0.1428p pd=1.52u as=0 ps=0 w=0.42u l=1u
X3222 VDD VSS.t2410 VDD VDD sg13_lv_pmos ad=0.34p pd=2.68u as=0 ps=0 w=1u l=1u
X3223 VSS.t2471 VDD VSS.t2470 VSS.t2469 sg13_lv_nmos ad=0.1428p pd=1.52u as=0 ps=0 w=0.42u l=1u
X3224 VSS.t635 VDD VSS.t637 VSS.t636 sg13_lv_nmos ad=79.8f pd=0.8u as=0 ps=0 w=0.42u l=1u
X3225 VDD VSS.t1556 VDD VDD sg13_lv_pmos ad=0.34p pd=2.68u as=0 ps=0 w=1u l=1u
X3226 VDD VSS.t3163 VDD VDD sg13_lv_pmos ad=0.34p pd=2.68u as=0 ps=0 w=1u l=1u
X3227 VDD VSS.t1891 VDD VDD sg13_lv_pmos ad=0.19p pd=1.38u as=0 ps=0 w=1u l=1u
X3228 VSS.t394 VDD VSS.t86 VSS.t395 sg13_lv_nmos ad=79.8f pd=0.8u as=0 ps=0 w=0.42u l=1u
X3229 VDD VSS.t1739 VDD VDD sg13_lv_pmos ad=0.19p pd=1.38u as=0 ps=0 w=1u l=1u
X3230 VSS.t2019 VDD VSS.t2018 VSS.t2017 sg13_lv_nmos ad=0.1428p pd=1.52u as=0 ps=0 w=0.42u l=1u
X3231 a_21060_14488# a_21034_14452# VSS.t23 VSS.t306 sg13_lv_nmos ad=0.2516p pd=2.16u as=0.1626p ps=1.415u w=0.74u l=0.13u
X3232 sg13cmos5l_buf_8_2.A a_15579_14854# VDD VDD sg13_lv_pmos ad=0.2128p pd=1.5u as=0.2128p ps=1.5u w=1.12u l=0.13u
X3233 sg13cmos5l_dfrbpq_1_2.CLK a_12010_15202# VSS.t295 VSS.t294 sg13_lv_nmos ad=0.1406p pd=1.12u as=0.2516p ps=2.16u w=0.74u l=0.13u
X3234 VSS.t1077 VDD VSS.t1076 VSS.t1075 sg13_lv_nmos ad=0.1428p pd=1.52u as=0 ps=0 w=0.42u l=1u
X3235 VDD VSS.t2423 VDD VDD sg13_lv_pmos ad=0.19p pd=1.38u as=0 ps=0 w=1u l=1u
X3236 VSS.t967 VDD VSS.t969 VSS.t968 sg13_lv_nmos ad=79.8f pd=0.8u as=0 ps=0 w=0.42u l=1u
X3237 VDD VSS.t1254 VDD VDD sg13_lv_pmos ad=0.34p pd=2.68u as=0 ps=0 w=1u l=1u
X3238 VDD VSS.t585 VDD VDD sg13_lv_pmos ad=0.19p pd=1.38u as=0 ps=0 w=1u l=1u
X3239 VDD VSS.t941 VDD VDD sg13_lv_pmos ad=0.34p pd=2.68u as=0 ps=0 w=1u l=1u
X3240 a_6682_13690# sg13cmos5l_dlygate4sd3_1_0.A VSS.t17 VSS.t16 sg13_lv_nmos ad=0.1428p pd=1.52u as=79.8f ps=0.8u w=0.42u l=0.13u
X3241 VSS.t1577 VDD VSS.t1579 VSS.t1578 sg13_lv_nmos ad=79.8f pd=0.8u as=0 ps=0 w=0.42u l=1u
X3242 VSS.t1757 VDD VSS.t1756 VSS.t1755 sg13_lv_nmos ad=0.1428p pd=1.52u as=0 ps=0 w=0.42u l=1u
X3243 VSS.t2688 VDD VSS.t2688 VSS.t199 sg13_lv_nmos ad=0.1428p pd=1.52u as=0 ps=0 w=0.42u l=1u
X3244 VSS.t2781 VDD VSS.t2783 VSS.t199 sg13_lv_nmos ad=79.8f pd=0.8u as=0 ps=0 w=0.42u l=1u
X3245 VDD VSS.t2740 VDD VDD sg13_lv_pmos ad=0.19p pd=1.38u as=0 ps=0 w=1u l=1u
X3246 VSS.t1969 VDD VSS.t1968 VSS.t1967 sg13_lv_nmos ad=0.1428p pd=1.52u as=0 ps=0 w=0.42u l=1u
X3247 VSS.t475 VDD VSS.t474 VSS.t19 sg13_lv_nmos ad=0.1428p pd=1.52u as=0 ps=0 w=0.42u l=1u
X3248 VDD VSS.t1529 VDD VDD sg13_lv_pmos ad=0.19p pd=1.38u as=0 ps=0 w=1u l=1u
X3249 VDD VSS.t2993 VDD VDD sg13_lv_pmos ad=0.34p pd=2.68u as=0 ps=0 w=1u l=1u
X3250 VDD VSS.t45 VDD VDD sg13_lv_pmos ad=0.34p pd=2.68u as=0 ps=0 w=1u l=1u
X3251 VDD VSS.t461 VDD VDD sg13_lv_pmos ad=0.19p pd=1.38u as=0 ps=0 w=1u l=1u
X3252 VDD VSS.t1291 VDD VDD sg13_lv_pmos ad=0.19p pd=1.38u as=0 ps=0 w=1u l=1u
X3253 VSS.t1365 VDD VSS.t1366 VSS.t248 sg13_lv_nmos ad=79.8f pd=0.8u as=0 ps=0 w=0.42u l=1u
X3254 VSS.t1752 VDD VSS.t1751 VSS.t1750 sg13_lv_nmos ad=0.1428p pd=1.52u as=0 ps=0 w=0.42u l=1u
X3255 VDD VSS.t2478 VDD VDD sg13_lv_pmos ad=0.19p pd=1.38u as=0 ps=0 w=1u l=1u
X3256 VSS.t2501 VDD VSS.t2503 VSS.t2502 sg13_lv_nmos ad=79.8f pd=0.8u as=0 ps=0 w=0.42u l=1u
X3257 VDD VSS.t816 VDD VDD sg13_lv_pmos ad=0.34p pd=2.68u as=0 ps=0 w=1u l=1u
X3258 VSS.t772 VDD VSS.t774 VSS.t773 sg13_lv_nmos ad=79.8f pd=0.8u as=0 ps=0 w=0.42u l=1u
X3259 VDD VSS.t1357 VDD VDD sg13_lv_pmos ad=0.34p pd=2.68u as=0 ps=0 w=1u l=1u
X3260 VDD VSS.t3006 VDD VDD sg13_lv_pmos ad=0.19p pd=1.38u as=0 ps=0 w=1u l=1u
X3261 VSS.t2084 VDD VSS.t2086 VSS.t2085 sg13_lv_nmos ad=79.8f pd=0.8u as=0 ps=0 w=0.42u l=1u
X3262 VDD VSS.t2008 VDD VDD sg13_lv_pmos ad=0.34p pd=2.68u as=0 ps=0 w=1u l=1u
X3263 VSS.t36 a_27664_13942# a_27313_13799# VSS.t96 sg13_lv_nmos ad=79.8f pd=0.8u as=0.1428p ps=1.52u w=0.42u l=0.13u
X3264 VSS.t1727 VDD VSS.t1729 VSS.t1728 sg13_lv_nmos ad=79.8f pd=0.8u as=0 ps=0 w=0.42u l=1u
X3265 VSS.t295 VDD VSS.t506 VSS.t505 sg13_lv_nmos ad=0.1428p pd=1.52u as=0 ps=0 w=0.42u l=1u
X3266 VDD VSS.t312 VDD VDD sg13_lv_pmos ad=0.34p pd=2.68u as=0 ps=0 w=1u l=1u
X3267 VDD VSS.t1232 VDD VDD sg13_lv_pmos ad=0.19p pd=1.38u as=0 ps=0 w=1u l=1u
X3268 VSS.t2712 VDD VSS.t2712 VSS.t199 sg13_lv_nmos ad=0.1428p pd=1.52u as=0 ps=0 w=0.42u l=1u
X3269 VDD VSS.t470 VDD VDD sg13_lv_pmos ad=0.19p pd=1.38u as=0 ps=0 w=1u l=1u
X3270 sg13cmos5l_buf_8_2.A a_15579_14854# VDD VDD sg13_lv_pmos ad=0.2128p pd=1.5u as=0.2128p ps=1.5u w=1.12u l=0.13u
X3271 a_6714_12972# sg13cmos5l_xnor2_1_2.B sg13cmos5l_dlygate4sd3_1_0.A VDD sg13_lv_pmos ad=0.1428p pd=1.375u as=0.2408p ps=1.55u w=1.12u l=0.13u
X3272 VDD VSS.t1691 VDD VDD sg13_lv_pmos ad=0.34p pd=2.68u as=0 ps=0 w=1u l=1u
X3273 a_25094_15238# a_24824_15238# VDD VDD sg13_lv_pmos ad=0.34p pd=2.68u as=0.1523p ps=1.38u w=1u l=0.5u
X3274 VDD VSS.t1300 VDD VDD sg13_lv_pmos ad=0.19p pd=1.38u as=0 ps=0 w=1u l=1u
X3275 VDD VSS.t1746 VDD VDD sg13_lv_pmos ad=0.34p pd=2.68u as=0 ps=0 w=1u l=1u
X3276 VSS.t1597 VDD VSS.t1599 VSS.t1598 sg13_lv_nmos ad=79.8f pd=0.8u as=0 ps=0 w=0.42u l=1u
X3277 VSS.t3119 VDD VSS.t3121 VSS.t3120 sg13_lv_nmos ad=79.8f pd=0.8u as=0 ps=0 w=0.42u l=1u
X3278 VSS.t2331 VDD VSS.t2333 VSS.t2332 sg13_lv_nmos ad=79.8f pd=0.8u as=0 ps=0 w=0.42u l=1u
X3279 VDD VSS.t1903 VDD VDD sg13_lv_pmos ad=0.34p pd=2.68u as=0 ps=0 w=1u l=1u
X3280 a_6575_13342# sg13cmos5l_xnor2_1_2.A VSS.t17 VSS.t255 sg13_lv_nmos ad=0.2516p pd=2.16u as=0.1898p ps=1.36u w=0.74u l=0.13u
X3281 a_26244_14909# a_26475_14495# a_25930_14452# VSS.t167 sg13_lv_nmos ad=0.2373p pd=1.97u as=79.8f ps=0.8u w=0.42u l=0.13u
X3282 VDD VSS.t2816 VDD VDD sg13_lv_pmos ad=0.34p pd=2.68u as=0 ps=0 w=1u l=1u
X3283 VSS.t902 VDD VSS.t904 VSS.t903 sg13_lv_nmos ad=79.8f pd=0.8u as=0 ps=0 w=0.42u l=1u
X3284 a_25670_14922# sg13cmos5l_dfrbpq_1_7.D VDD VDD sg13_lv_pmos ad=79.8f pd=0.8u as=0.1428p ps=1.52u w=0.42u l=0.13u
X3285 VSS.t1347 VDD VSS.t1346 VSS.t248 sg13_lv_nmos ad=0.1428p pd=1.52u as=0 ps=0 w=0.42u l=1u
X3286 VDD VSS.t2435 VDD VDD sg13_lv_pmos ad=0.34p pd=2.68u as=0 ps=0 w=1u l=1u
X3287 VDD VSS.t6 VDD VDD sg13_lv_pmos ad=0.34p pd=2.68u as=0 ps=0 w=1u l=1u
X3288 VDD VSS.t625 VDD VDD sg13_lv_pmos ad=0.34p pd=2.68u as=0 ps=0 w=1u l=1u
X3289 VDD VSS.t971 VDD VDD sg13_lv_pmos ad=0.34p pd=2.68u as=0 ps=0 w=1u l=1u
X3290 VDD VSS.t2671 VDD VDD sg13_lv_pmos ad=0.34p pd=2.68u as=0 ps=0 w=1u l=1u
X3291 VSS.t1914 VDD VSS.t1913 VSS.t1912 sg13_lv_nmos ad=0.1428p pd=1.52u as=0 ps=0 w=0.42u l=1u
X3292 VDD VSS.t1263 VDD VDD sg13_lv_pmos ad=0.19p pd=1.38u as=0 ps=0 w=1u l=1u
X3293 VDD VSS.t2767 VDD VDD sg13_lv_pmos ad=0.19p pd=1.38u as=0 ps=0 w=1u l=1u
X3294 VDD VSS.t2041 VDD VDD sg13_lv_pmos ad=0.19p pd=1.38u as=0 ps=0 w=1u l=1u
X3295 a_24169_14508# sg13cmos5l_or3_1_2.B VSS.t276 VSS.t0 sg13_lv_nmos ad=0.198p pd=1.27u as=0.1045p ps=0.93u w=0.55u l=0.13u
X3296 VSS.t77 VDD VSS.t77 VSS.t763 sg13_lv_nmos ad=0.1428p pd=1.52u as=0 ps=0 w=0.42u l=1u
X3297 VSS.t2456 VDD VSS.t2455 VSS.t2454 sg13_lv_nmos ad=0.1428p pd=1.52u as=0 ps=0 w=0.42u l=1u
X3298 VDD VSS.t909 VDD VDD sg13_lv_pmos ad=0.19p pd=1.38u as=0 ps=0 w=1u l=1u
X3299 VDD VSS.t1541 VDD VDD sg13_lv_pmos ad=0.34p pd=2.68u as=0 ps=0 w=1u l=1u
X3300 VDD VSS.t2395 VDD VDD sg13_lv_pmos ad=0.34p pd=2.68u as=0 ps=0 w=1u l=1u
X3301 VDD VSS.t577 VDD VDD sg13_lv_pmos ad=0.34p pd=2.68u as=0 ps=0 w=1u l=1u
X3302 VSS.t1712 VDD VSS.t1714 VSS.t1713 sg13_lv_nmos ad=79.8f pd=0.8u as=0 ps=0 w=0.42u l=1u
X3303 VSS.t1622 VDD VSS.t1621 VSS.t1620 sg13_lv_nmos ad=0.1428p pd=1.52u as=0 ps=0 w=0.42u l=1u
X3304 a_18106_15960# sg13cmos5l_dlygate4sd3_1_5.A VSS.t197 VSS.t3266 sg13_lv_nmos ad=0.1428p pd=1.52u as=79.8f ps=0.8u w=0.42u l=0.13u
X3305 VDD VSS.t550 VDD VDD sg13_lv_pmos ad=0.19p pd=1.38u as=0 ps=0 w=1u l=1u
X3306 a_6996_13320# sg13cmos5l_xnor2_1_2.B a_6540_13238# VSS.t3261 sg13_lv_nmos ad=78.39999f pd=0.885u as=0.2176p ps=1.96u w=0.64u l=0.13u
X3307 VDD VSS.t871 VDD VDD sg13_lv_pmos ad=0.34p pd=2.68u as=0 ps=0 w=1u l=1u
X3308 VSS.t1077 VDD VSS.t1076 VSS.t1075 sg13_lv_nmos ad=0.1428p pd=1.52u as=0 ps=0 w=0.42u l=1u
X3309 VDD VSS.t1724 VDD VDD sg13_lv_pmos ad=0.19p pd=1.38u as=0 ps=0 w=1u l=1u
X3310 VDD VSS.t658 VDD VDD sg13_lv_pmos ad=0.34p pd=2.68u as=0 ps=0 w=1u l=1u
X3311 VSS.t649 VDD VSS.t652 VSS.t787 sg13_lv_nmos ad=79.8f pd=0.8u as=0 ps=0 w=0.42u l=1u
X3312 sg13cmos5l_buf_1_0.X a_1192_3900# VSS.t200 VSS.t199 sg13_lv_nmos ad=0.2886p pd=2.26u as=0.14875p ps=1.16u w=0.74u l=0.13u
X3313 VSS.t2521 VDD VSS.t2523 VSS.t2522 sg13_lv_nmos ad=79.8f pd=0.8u as=0 ps=0 w=0.42u l=1u
X3314 VDD VSS.t3053 VDD VDD sg13_lv_pmos ad=0.34p pd=2.68u as=0 ps=0 w=1u l=1u
X3315 VDD VSS.t1923 VDD VDD sg13_lv_pmos ad=0.34p pd=2.68u as=0 ps=0 w=1u l=1u
X3316 VDD VSS.t585 VDD VDD sg13_lv_pmos ad=0.19p pd=1.38u as=0 ps=0 w=1u l=1u
X3317 VDD VSS.t2096 VDD VDD sg13_lv_pmos ad=0.19p pd=1.38u as=0 ps=0 w=1u l=1u
X3318 VSS.t1742 VDD VSS.t1741 VSS.t1740 sg13_lv_nmos ad=0.1428p pd=1.52u as=0 ps=0 w=0.42u l=1u
X3319 VDD VSS.t1594 VDD VDD sg13_lv_pmos ad=0.19p pd=1.38u as=0 ps=0 w=1u l=1u
X3320 VSS.t2679 VDD VSS.t2679 VSS.t199 sg13_lv_nmos ad=0.1428p pd=1.52u as=0 ps=0 w=0.42u l=1u
X3321 VDD VSS.t2732 VDD VDD sg13_lv_pmos ad=0.19p pd=1.38u as=0 ps=0 w=1u l=1u
X3322 VSS.t3 a_8582_15238# a_8694_15302# VSS.t139 sg13_lv_nmos ad=0.1426p pd=1.16u as=0.1428p ps=1.52u w=0.42u l=0.5u
X3323 VDD VSS.t924 VDD VDD sg13_lv_pmos ad=0.19p pd=1.38u as=0 ps=0 w=1u l=1u
X3324 VSS.t3039 VDD VSS.t3038 VSS.t3037 sg13_lv_nmos ad=0.1428p pd=1.52u as=0 ps=0 w=0.42u l=1u
X3325 VSS.t1542 VDD VSS.t1544 VSS.t1543 sg13_lv_nmos ad=79.8f pd=0.8u as=0 ps=0 w=0.42u l=1u
X3326 VSS.t658 VDD VSS.t661 VSS.t793 sg13_lv_nmos ad=79.8f pd=0.8u as=0 ps=0 w=0.42u l=1u
X3327 VSS.t817 VDD VSS.t819 VSS.t818 sg13_lv_nmos ad=79.8f pd=0.8u as=0 ps=0 w=0.42u l=1u
X3328 VDD VSS.t2061 VDD VDD sg13_lv_pmos ad=0.19p pd=1.38u as=0 ps=0 w=1u l=1u
X3329 VDD VSS.t861 VDD VDD sg13_lv_pmos ad=0.34p pd=2.68u as=0 ps=0 w=1u l=1u
X3330 VSS.t1281 VDD VSS.t1280 VSS.t248 sg13_lv_nmos ad=0.1428p pd=1.52u as=0 ps=0 w=0.42u l=1u
X3331 VDD VSS.t673 VDD VDD sg13_lv_pmos ad=0.34p pd=2.68u as=0 ps=0 w=1u l=1u
X3332 VDD VSS.t3168 VDD VDD sg13_lv_pmos ad=0.34p pd=2.68u as=0 ps=0 w=1u l=1u
X3333 VSS.t2678 VDD VSS.t2677 VSS.t199 sg13_lv_nmos ad=0.1428p pd=1.52u as=0 ps=0 w=0.42u l=1u
X3334 a_9158_15234# a_9963_15356# a_9418_15457# VDD sg13_lv_pmos ad=0.1428p pd=1.52u as=79.8f ps=0.8u w=0.42u l=0.13u
X3335 VSS.t114 sg13cmos5l_dfrbpq_1_1.RESET_B a_6180_14922# VSS.t3222 sg13_lv_nmos ad=0.1626p pd=1.415u as=60.89999f ps=0.71u w=0.42u l=0.13u
X3336 sg13cmos5l_o21ai_1_2.Y sg13cmos5l_o21ai_1_2.A2 a_23736_14464# VDD sg13_lv_pmos ad=0.2128p pd=1.5u as=0.2128p ps=1.5u w=1.12u l=0.15u
X3337 VDD VSS.t1744 VDD VDD sg13_lv_pmos ad=0.19p pd=1.38u as=0 ps=0 w=1u l=1u
X3338 VDD a_17327_13799# a_17994_14020# VDD sg13_lv_pmos ad=0.2128p pd=1.5u as=0.3864p ps=2.93u w=1.12u l=0.13u
X3339 VSS.t105 VDD VSS.t105 VSS.t561 sg13_lv_nmos ad=79.8f pd=0.8u as=0 ps=0 w=0.42u l=1u
X3340 VDD VSS.t2088 VDD VDD sg13_lv_pmos ad=0.34p pd=2.68u as=0 ps=0 w=1u l=1u
X3341 VSS.t1209 VDD VSS.t1208 VSS.t248 sg13_lv_nmos ad=0.1428p pd=1.52u as=0 ps=0 w=0.42u l=1u
X3342 VSS.t1239 VDD VSS.t1240 VSS.t248 sg13_lv_nmos ad=79.8f pd=0.8u as=0 ps=0 w=0.42u l=1u
X3343 a_23858_15242# sg13cmos5l_dfrbpq_1_2.Q VSS.t266 VSS.t48 sg13_lv_nmos ad=0.1406p pd=1.12u as=0.2516p ps=2.16u w=0.74u l=0.13u
X3344 VSS.t2476 VDD VSS.t2475 VSS.t2474 sg13_lv_nmos ad=0.1428p pd=1.52u as=0 ps=0 w=0.42u l=1u
X3345 VSS.t2316 VDD VSS.t2318 VSS.t2317 sg13_lv_nmos ad=79.8f pd=0.8u as=0 ps=0 w=0.42u l=1u
X3346 VDD VSS.t31 VDD VDD sg13_lv_pmos ad=0.34p pd=2.68u as=0 ps=0 w=1u l=1u
X3347 a_7643_15280# sg13cmos5l_dlygate4sd3_1_8.X VSS.t162 VSS.t245 sg13_lv_nmos ad=78.39999f pd=0.885u as=0.2272p ps=1.99u w=0.64u l=0.13u
X3348 VSS.t832 VDD VSS.t834 VSS.t833 sg13_lv_nmos ad=79.8f pd=0.8u as=0 ps=0 w=0.42u l=1u
X3349 VSS.t1582 VDD VSS.t1584 VSS.t1583 sg13_lv_nmos ad=79.8f pd=0.8u as=0 ps=0 w=0.42u l=1u
X3350 VSS.t1762 VDD VSS.t1761 VSS.t1760 sg13_lv_nmos ad=0.1428p pd=1.52u as=0 ps=0 w=0.42u l=1u
X3351 VSS.t3104 VDD VSS.t3106 VSS.t3105 sg13_lv_nmos ad=79.8f pd=0.8u as=0 ps=0 w=0.42u l=1u
X3352 VDD VSS.t458 VDD VDD sg13_lv_pmos ad=0.19p pd=1.38u as=0 ps=0 w=1u l=1u
X3353 VDD VSS.t1089 VDD VDD sg13_lv_pmos ad=0.19p pd=1.38u as=0 ps=0 w=1u l=1u
X3354 VSS.t902 VDD VSS.t904 VSS.t903 sg13_lv_nmos ad=79.8f pd=0.8u as=0 ps=0 w=0.42u l=1u
X3355 VDD VSS.t891 VDD VDD sg13_lv_pmos ad=0.34p pd=2.68u as=0 ps=0 w=1u l=1u
X3356 VDD VSS.t2724 VDD VDD sg13_lv_pmos ad=0.19p pd=1.38u as=0 ps=0 w=1u l=1u
X3357 VSS.t1974 VDD VSS.t1973 VSS.t1972 sg13_lv_nmos ad=0.1428p pd=1.52u as=0 ps=0 w=0.42u l=1u
X3358 VSS.t39 a_27898_15202# a_27617_15424# VSS.t19 sg13_lv_nmos ad=79.8f pd=0.8u as=0.1428p ps=1.52u w=0.42u l=0.5u
X3359 VDD VSS.t2998 VDD VDD sg13_lv_pmos ad=0.34p pd=2.68u as=0 ps=0 w=1u l=1u
X3360 VSS.t3059 VDD VSS.t3058 VSS.t3057 sg13_lv_nmos ad=0.1428p pd=1.52u as=0 ps=0 w=0.42u l=1u
X3361 VSS.t90 sg13cmos5l_inv_1_0.A sg13cmos5l_inv_1_0.Y VSS.t149 sg13_lv_nmos ad=0.2516p pd=2.16u as=0.2516p ps=2.16u w=0.74u l=0.13u
X3362 VSS.t47 VDD VSS.t47 VSS.t424 sg13_lv_nmos ad=79.8f pd=0.8u as=0 ps=0 w=0.42u l=1u
X3363 VDD VSS.t620 VDD VDD sg13_lv_pmos ad=0.19p pd=1.38u as=0 ps=0 w=1u l=1u
X3364 VDD VSS.t2420 VDD VDD sg13_lv_pmos ad=0.34p pd=2.68u as=0 ps=0 w=1u l=1u
X3365 VSS.t736 VDD VSS.t735 VSS.t734 sg13_lv_nmos ad=0.1428p pd=1.52u as=0 ps=0 w=0.42u l=1u
X3366 VDD VSS.t1539 VDD VDD sg13_lv_pmos ad=0.19p pd=1.38u as=0 ps=0 w=1u l=1u
X3367 VDD VSS.t2448 VDD VDD sg13_lv_pmos ad=0.19p pd=1.38u as=0 ps=0 w=1u l=1u
X3368 VSS.t2506 VDD VSS.t2508 VSS.t2507 sg13_lv_nmos ad=79.8f pd=0.8u as=0 ps=0 w=0.42u l=1u
X3369 VDD a_17806_15423# sg13cmos5l_inv_1_0.A VDD sg13_lv_pmos ad=0.2254p pd=1.53u as=0.4256p ps=3u w=1.12u l=0.13u
X3370 VSS.t334 VDD VSS.t334 VSS.t337 sg13_lv_nmos ad=79.8f pd=0.8u as=0 ps=0 w=0.42u l=1u
X3371 VSS.t598 VDD VSS.t597 VSS.t596 sg13_lv_nmos ad=0.1428p pd=1.52u as=0 ps=0 w=0.42u l=1u
X3372 a_25956_14488# a_26475_14495# a_27215_14845# VSS.t19 sg13_lv_nmos ad=0.3473p pd=2.71u as=0.12665p ps=1.145u w=0.74u l=0.13u
X3373 VDD VSS.t577 VDD VDD sg13_lv_pmos ad=0.34p pd=2.68u as=0 ps=0 w=1u l=1u
X3374 VDD VSS.t954 VDD VDD sg13_lv_pmos ad=0.19p pd=1.38u as=0 ps=0 w=1u l=1u
X3375 VDD VSS.t1253 VDD VDD sg13_lv_pmos ad=0.19p pd=1.38u as=0 ps=0 w=1u l=1u
X3376 VSS.t1218 VDD VSS.t1217 VSS.t248 sg13_lv_nmos ad=0.1428p pd=1.52u as=0 ps=0 w=0.42u l=1u
X3377 VSS.t1326 VDD VSS.t1327 VSS.t248 sg13_lv_nmos ad=79.8f pd=0.8u as=0 ps=0 w=0.42u l=1u
X3378 VDD VSS.t1360 VDD VDD sg13_lv_pmos ad=0.34p pd=2.68u as=0 ps=0 w=1u l=1u
X3379 VSS.t1672 VDD VSS.t1674 VSS.t1673 sg13_lv_nmos ad=79.8f pd=0.8u as=0 ps=0 w=0.42u l=1u
X3380 VSS.t2054 VDD VSS.t2056 VSS.t2055 sg13_lv_nmos ad=79.8f pd=0.8u as=0 ps=0 w=0.42u l=1u
X3381 sg13cmos5l_nand3_1_0.Y sg13cmos5l_dlygate4sd3_1_3.A VDD VDD sg13_lv_pmos ad=0.2128p pd=1.5u as=0.3808p ps=2.92u w=1.12u l=0.13u
X3382 VSS.t1256 VDD VSS.t1257 VSS.t248 sg13_lv_nmos ad=79.8f pd=0.8u as=0 ps=0 w=0.42u l=1u
X3383 VDD VSS.t1350 VDD VDD sg13_lv_pmos ad=0.19p pd=1.38u as=0 ps=0 w=1u l=1u
X3384 VSS.t1557 VDD VSS.t1556 VSS.t1555 sg13_lv_nmos ad=0.1428p pd=1.52u as=0 ps=0 w=0.42u l=1u
X3385 VDD VSS.t2735 VDD VDD sg13_lv_pmos ad=0.34p pd=2.68u as=0 ps=0 w=1u l=1u
X3386 VDD VSS.t550 VDD VDD sg13_lv_pmos ad=0.19p pd=1.38u as=0 ps=0 w=1u l=1u
X3387 a_15876_13722# sg13cmos5l_dfrbpq_1_2.D a_15782_13722# VSS.t3248 sg13_lv_nmos ad=60.89999f pd=0.71u as=0.1428p ps=1.52u w=0.42u l=0.13u
X3388 VSS.t679 VDD VSS.t679 VSS.t680 sg13_lv_nmos ad=79.8f pd=0.8u as=0 ps=0 w=0.42u l=1u
X3389 VSS.t1222 VDD VSS.t1221 VSS.t248 sg13_lv_nmos ad=0.1428p pd=1.52u as=0 ps=0 w=0.42u l=1u
X3390 VDD VSS.t2073 VDD VDD sg13_lv_pmos ad=0.34p pd=2.68u as=0 ps=0 w=1u l=1u
X3391 VSS.t987 VDD VSS.t989 VSS.t988 sg13_lv_nmos ad=79.8f pd=0.8u as=0 ps=0 w=0.42u l=1u
X3392 VDD VSS.t1716 VDD VDD sg13_lv_pmos ad=0.34p pd=2.68u as=0 ps=0 w=1u l=1u
X3393 VDD VSS.t1908 VDD VDD sg13_lv_pmos ad=0.34p pd=2.68u as=0 ps=0 w=1u l=1u
X3394 VSS.t41 VDD VSS.t114 VSS.t500 sg13_lv_nmos ad=79.8f pd=0.8u as=0 ps=0 w=0.42u l=1u
X3395 VSS.t3089 VDD VSS.t3091 VSS.t3090 sg13_lv_nmos ad=79.8f pd=0.8u as=0 ps=0 w=0.42u l=1u
X3396 VSS.t2301 VDD VSS.t2303 VSS.t2302 sg13_lv_nmos ad=79.8f pd=0.8u as=0 ps=0 w=0.42u l=1u
X3397 VDD VSS.t1579 VDD VDD sg13_lv_pmos ad=0.19p pd=1.38u as=0 ps=0 w=1u l=1u
X3398 VDD VSS.t1756 VDD VDD sg13_lv_pmos ad=0.34p pd=2.68u as=0 ps=0 w=1u l=1u
X3399 VDD VSS.t2819 VDD VDD sg13_lv_pmos ad=0.34p pd=2.68u as=0 ps=0 w=1u l=1u
X3400 VSS.t2376 VDD VSS.t2378 VSS.t2377 sg13_lv_nmos ad=79.8f pd=0.8u as=0 ps=0 w=0.42u l=1u
X3401 VSS.t817 VDD VSS.t819 VSS.t818 sg13_lv_nmos ad=79.8f pd=0.8u as=0 ps=0 w=0.42u l=1u
X3402 VDD VSS.t2440 VDD VDD sg13_lv_pmos ad=0.34p pd=2.68u as=0 ps=0 w=1u l=1u
X3403 VDD VSS.t2098 VDD VDD sg13_lv_pmos ad=0.34p pd=2.68u as=0 ps=0 w=1u l=1u
X3404 VSS.t1527 VDD VSS.t1529 VSS.t1528 sg13_lv_nmos ad=79.8f pd=0.8u as=0 ps=0 w=0.42u l=1u
X3405 a_9732_15247# a_9444_15552# a_9670_15247# VSS.t2 sg13_lv_nmos ad=0.1428p pd=1.52u as=37.8f ps=0.6u w=0.42u l=0.13u
X3406 sg13cmos5l_buf_8_2.A a_15579_14854# VSS.t90 VSS.t154 sg13_lv_nmos ad=0.1406p pd=1.12u as=0.1406p ps=1.12u w=0.74u l=0.13u
X3407 VSS.t1308 VDD VSS.t1307 VSS.t248 sg13_lv_nmos ad=0.1428p pd=1.52u as=0 ps=0 w=0.42u l=1u
X3408 VDD VSS.t1266 VDD VDD sg13_lv_pmos ad=0.19p pd=1.38u as=0 ps=0 w=1u l=1u
X3409 VDD VSS.t2770 VDD VDD sg13_lv_pmos ad=0.19p pd=1.38u as=0 ps=0 w=1u l=1u
X3410 VDD VSS.t2046 VDD VDD sg13_lv_pmos ad=0.19p pd=1.38u as=0 ps=0 w=1u l=1u
X3411 a_17604_14488# a_17578_14452# VSS.t13 VSS.t82 sg13_lv_nmos ad=0.2516p pd=2.16u as=0.1626p ps=1.415u w=0.74u l=0.13u
X3412 VDD VSS.t491 VDD VDD sg13_lv_pmos ad=0.19p pd=1.38u as=0 ps=0 w=1u l=1u
X3413 VSS.t2461 VDD VSS.t2460 VSS.t2459 sg13_lv_nmos ad=0.1428p pd=1.52u as=0 ps=0 w=0.42u l=1u
X3414 VDD VSS.t393 VDD VDD sg13_lv_pmos ad=0.34p pd=2.68u as=0 ps=0 w=1u l=1u
X3415 VDD VSS.t1546 VDD VDD sg13_lv_pmos ad=0.34p pd=2.68u as=0 ps=0 w=1u l=1u
X3416 VSS.t2670 VDD VSS.t2669 VSS.t199 sg13_lv_nmos ad=0.1428p pd=1.52u as=0 ps=0 w=0.42u l=1u
X3417 VDD VSS.t2400 VDD VDD sg13_lv_pmos ad=0.34p pd=2.68u as=0 ps=0 w=1u l=1u
X3418 a_16140_15424# sg13cmos5l_or3_1_2.B VDD VDD sg13_lv_pmos ad=0.1596p pd=1.22u as=0.2891p ps=1.695u w=0.84u l=0.13u
X3419 VDD VSS.t361 VDD VDD sg13_lv_pmos ad=0.34p pd=2.68u as=0 ps=0 w=1u l=1u
X3420 VSS.t661 VDD VSS.t658 VSS.t660 sg13_lv_nmos ad=0.1428p pd=1.52u as=0 ps=0 w=0.42u l=1u
X3421 VSS.t2009 VDD VSS.t2008 VSS.t2007 sg13_lv_nmos ad=0.1428p pd=1.52u as=0 ps=0 w=0.42u l=1u
X3422 a_22319_14845# a_21477_14495# a_22225_14845# VSS.t0 sg13_lv_nmos ad=0.12665p pd=1.145u as=0.1428p ps=1.52u w=0.42u l=0.13u
X3423 VSS.t1313 VDD VSS.t1312 VSS.t248 sg13_lv_nmos ad=0.1428p pd=1.52u as=0 ps=0 w=0.42u l=1u
X3424 VSS.t1592 VDD VSS.t1591 VSS.t1590 sg13_lv_nmos ad=0.1428p pd=1.52u as=0 ps=0 w=0.42u l=1u
X3425 VDD VSS.t1729 VDD VDD sg13_lv_pmos ad=0.19p pd=1.38u as=0 ps=0 w=1u l=1u
X3426 VSS.t414 VDD VSS.t414 VSS.t415 sg13_lv_nmos ad=0.1428p pd=1.52u as=0 ps=0 w=0.42u l=1u
X3427 a_25774_15423# a_25889_15424# VSS.t108 VSS.t170 sg13_lv_nmos ad=0.1428p pd=1.52u as=0.1426p ps=1.16u w=0.42u l=0.5u
X3428 a_19282_14922# sg13cmos5l_dfrbpq_1_3.RESET_B VSS.t73 VSS.t52 sg13_lv_nmos ad=37.8f pd=0.6u as=79.8f ps=0.8u w=0.42u l=0.13u
X3429 VSS.t635 VDD VSS.t635 VSS.t634 sg13_lv_nmos ad=0.1428p pd=1.52u as=0 ps=0 w=0.42u l=1u
X3430 VSS.t2526 VDD VSS.t2528 VSS.t2527 sg13_lv_nmos ad=79.8f pd=0.8u as=0 ps=0 w=0.42u l=1u
X3431 a_8582_15238# a_8312_15238# VDD VDD sg13_lv_pmos ad=0.34p pd=2.68u as=0.1523p ps=1.38u w=1u l=0.5u
X3432 VSS.t832 VDD VSS.t834 VSS.t833 sg13_lv_nmos ad=79.8f pd=0.8u as=0 ps=0 w=0.42u l=1u
X3433 VSS.t1344 VDD VSS.t1345 VSS.t248 sg13_lv_nmos ad=79.8f pd=0.8u as=0 ps=0 w=0.42u l=1u
X3434 VDD VSS.t1559 VDD VDD sg13_lv_pmos ad=0.19p pd=1.38u as=0 ps=0 w=1u l=1u
X3435 VDD VSS.t3023 VDD VDD sg13_lv_pmos ad=0.34p pd=2.68u as=0 ps=0 w=1u l=1u
X3436 VDD VSS.t1893 VDD VDD sg13_lv_pmos ad=0.34p pd=2.68u as=0 ps=0 w=1u l=1u
X3437 VDD a_4078_14751# sg13cmos5l_xor2_1_0.B VDD sg13_lv_pmos ad=0.2254p pd=1.53u as=0.4256p ps=3u w=1.12u l=0.13u
X3438 VSS.t1747 VDD VSS.t1746 VSS.t1745 sg13_lv_nmos ad=0.1428p pd=1.52u as=0 ps=0 w=0.42u l=1u
X3439 VSS.t497 VDD VSS.t26 VSS.t498 sg13_lv_nmos ad=79.8f pd=0.8u as=0 ps=0 w=0.42u l=1u
X3440 VDD VSS.t2811 VDD VDD sg13_lv_pmos ad=0.34p pd=2.68u as=0 ps=0 w=1u l=1u
X3441 VDD VSS.t2715 VDD VDD sg13_lv_pmos ad=0.19p pd=1.38u as=0 ps=0 w=1u l=1u
X3442 VSS.t1959 VDD VSS.t1958 VSS.t1957 sg13_lv_nmos ad=0.1428p pd=1.52u as=0 ps=0 w=0.42u l=1u
X3443 VDD VSS.t2983 VDD VDD sg13_lv_pmos ad=0.34p pd=2.68u as=0 ps=0 w=1u l=1u
X3444 VSS.t3044 VDD VSS.t3043 VSS.t3042 sg13_lv_nmos ad=0.1428p pd=1.52u as=0 ps=0 w=0.42u l=1u
X3445 VDD a_18586_15455# sg13cmos5l_dfrbpq_1_3.RESET_B VDD sg13_lv_pmos ad=2.8961p pd=18.25u as=0.3927p ps=2.99u w=1.155u l=0.13u
X3446 VSS.t555 VDD VSS.t555 VSS.t556 sg13_lv_nmos ad=0.1428p pd=1.52u as=0 ps=0 w=0.42u l=1u
X3447 VDD VSS.t946 VDD VDD sg13_lv_pmos ad=0.34p pd=2.68u as=0 ps=0 w=1u l=1u
X3448 sg13cmos5l_o21ai_1_3.Y sg13cmos5l_or3_1_1.A a_24310_15230# VSS.t48 sg13_lv_nmos ad=0.2516p pd=2.16u as=0.1406p ps=1.12u w=0.74u l=0.15u
X3449 VSS.t633 VDD VSS.t630 VSS.t758 sg13_lv_nmos ad=0.1428p pd=1.52u as=0 ps=0 w=0.42u l=1u
X3450 VDD VSS.t1213 VDD VDD sg13_lv_pmos ad=0.19p pd=1.38u as=0 ps=0 w=1u l=1u
X3451 VSS.t478 VDD VSS.t479 VSS.t19 sg13_lv_nmos ad=79.8f pd=0.8u as=0 ps=0 w=0.42u l=1u
X3452 VDD VSS.t869 VDD VDD sg13_lv_pmos ad=0.19p pd=1.38u as=0 ps=0 w=1u l=1u
X3453 VDD VSS.t1061 VDD VDD sg13_lv_pmos ad=0.34p pd=2.68u as=0 ps=0 w=1u l=1u
X3454 VSS.t1322 VDD VSS.t1320 VSS.t248 sg13_lv_nmos ad=0.1428p pd=1.52u as=0 ps=0 w=0.42u l=1u
X3455 VDD VSS.t1524 VDD VDD sg13_lv_pmos ad=0.19p pd=1.38u as=0 ps=0 w=1u l=1u
X3456 VSS.t2491 VDD VSS.t2493 VSS.t2492 sg13_lv_nmos ad=79.8f pd=0.8u as=0 ps=0 w=0.42u l=1u
X3457 VSS.t318 VDD VSS.t318 VSS.t317 sg13_lv_nmos ad=0.1428p pd=1.52u as=0 ps=0 w=0.42u l=1u
X3458 VDD sg13cmos5l_dfrbpq_1_5.RESET_B a_26122_13945# VDD sg13_lv_pmos ad=0.1563p pd=1.22u as=0.147p ps=1.54u w=0.42u l=0.13u
X3459 VSS.t254 sg13cmos5l_xnor2_1_2.A a_6996_13320# VSS.t253 sg13_lv_nmos ad=0.2272p pd=1.99u as=78.39999f ps=0.885u w=0.64u l=0.13u
X3460 VDD VSS.t2433 VDD VDD sg13_lv_pmos ad=0.19p pd=1.38u as=0 ps=0 w=1u l=1u
X3461 VDD VSS.t2762 VDD VDD sg13_lv_pmos ad=0.19p pd=1.38u as=0 ps=0 w=1u l=1u
X3462 VSS.t2321 VDD VSS.t2323 VSS.t2322 sg13_lv_nmos ad=79.8f pd=0.8u as=0 ps=0 w=0.42u l=1u
X3463 VSS.t2446 VDD VSS.t2445 VSS.t2444 sg13_lv_nmos ad=0.1428p pd=1.52u as=0 ps=0 w=0.42u l=1u
X3464 VSS.t1657 VDD VSS.t1659 VSS.t1658 sg13_lv_nmos ad=79.8f pd=0.8u as=0 ps=0 w=0.42u l=1u
X3465 VSS.t2775 VDD VSS.t2776 VSS.t199 sg13_lv_nmos ad=79.8f pd=0.8u as=0 ps=0 w=0.42u l=1u
X3466 VSS.t77 sg13cmos5l_or3_1_1.C a_24841_13726# VSS.t275 sg13_lv_nmos ad=0.1045p pd=0.93u as=0.187p ps=1.78u w=0.55u l=0.13u
X3467 VDD VSS.t36 VDD VDD sg13_lv_pmos ad=0.34p pd=2.68u as=0 ps=0 w=1u l=1u
X3468 VDD VSS.t821 VDD VDD sg13_lv_pmos ad=0.34p pd=2.68u as=0 ps=0 w=1u l=1u
X3469 VSS.t1612 VDD VSS.t1611 VSS.t1610 sg13_lv_nmos ad=0.1428p pd=1.52u as=0 ps=0 w=0.42u l=1u
X3470 VSS.t1542 VDD VSS.t1541 VSS.t1540 sg13_lv_nmos ad=0.1428p pd=1.52u as=0 ps=0 w=0.42u l=1u
X3471 VDD VSS.t1714 VDD VDD sg13_lv_pmos ad=0.19p pd=1.38u as=0 ps=0 w=1u l=1u
X3472 a_37484_15960# sg13cmos5l_dfrbpq_1_5.Q VDD VDD sg13_lv_pmos ad=0.2856p pd=2.36u as=0.2114p ps=1.54u w=0.84u l=0.13u
X3473 VSS.t987 VDD VSS.t989 VSS.t988 sg13_lv_nmos ad=79.8f pd=0.8u as=0 ps=0 w=0.42u l=1u
X3474 VDD VSS.t1265 VDD VDD sg13_lv_pmos ad=0.34p pd=2.68u as=0 ps=0 w=1u l=1u
X3475 VSS.t1358 VDD VSS.t1359 VSS.t248 sg13_lv_nmos ad=79.8f pd=0.8u as=0 ps=0 w=0.42u l=1u
X3476 VDD VSS.t605 VDD VDD sg13_lv_pmos ad=0.19p pd=1.38u as=0 ps=0 w=1u l=1u
X3477 VDD VSS.t1273 VDD VDD sg13_lv_pmos ad=0.34p pd=2.68u as=0 ps=0 w=1u l=1u
X3478 VDD VSS.t2776 VDD VDD sg13_lv_pmos ad=0.34p pd=2.68u as=0 ps=0 w=1u l=1u
X3479 VDD VSS.t2058 VDD VDD sg13_lv_pmos ad=0.34p pd=2.68u as=0 ps=0 w=1u l=1u
X3480 VSS.t620 VDD VSS.t620 VSS.t619 sg13_lv_nmos ad=0.1428p pd=1.52u as=0 ps=0 w=0.42u l=1u
X3481 VSS.t143 a_14261_15238# sg13cmos5l_or3_1_1.B VSS.t146 sg13_lv_nmos ad=0.2516p pd=2.16u as=0.1406p ps=1.12u w=0.74u l=0.13u
X3482 VSS.t300 VDD VSS.t300 VSS.t508 sg13_lv_nmos ad=0.1428p pd=1.52u as=0 ps=0 w=0.42u l=1u
X3483 VSS.t2286 VDD VSS.t2288 VSS.t2287 sg13_lv_nmos ad=79.8f pd=0.8u as=0 ps=0 w=0.42u l=1u
X3484 VSS.t1979 VDD VSS.t1978 VSS.t1977 sg13_lv_nmos ad=0.1428p pd=1.52u as=0 ps=0 w=0.42u l=1u
X3485 VDD VSS.t673 VDD VDD sg13_lv_pmos ad=0.19p pd=1.38u as=0 ps=0 w=1u l=1u
X3486 VDD VSS.t1741 VDD VDD sg13_lv_pmos ad=0.34p pd=2.68u as=0 ps=0 w=1u l=1u
X3487 VDD VSS.t1303 VDD VDD sg13_lv_pmos ad=0.19p pd=1.38u as=0 ps=0 w=1u l=1u
X3488 VDD VSS.t2968 VDD VDD sg13_lv_pmos ad=0.34p pd=2.68u as=0 ps=0 w=1u l=1u
X3489 VSS.t2541 VDD VSS.t2540 VSS.t2539 sg13_lv_nmos ad=0.1428p pd=1.52u as=0 ps=0 w=0.42u l=1u
X3490 VSS.t2361 VDD VSS.t2363 VSS.t2362 sg13_lv_nmos ad=79.8f pd=0.8u as=0 ps=0 w=0.42u l=1u
X3491 VDD sg13cmos5l_a21oi_1_2.A1 a_24923_15996# VDD sg13_lv_pmos ad=0.2128p pd=1.5u as=0.2128p ps=1.5u w=1.12u l=0.13u
X3492 VDD VSS.t836 VDD VDD sg13_lv_pmos ad=0.34p pd=2.68u as=0 ps=0 w=1u l=1u
X3493 VDD VSS.t1024 VDD VDD sg13_lv_pmos ad=0.19p pd=1.38u as=0 ps=0 w=1u l=1u
X3494 VDD VSS.t1606 VDD VDD sg13_lv_pmos ad=0.34p pd=2.68u as=0 ps=0 w=1u l=1u
X3495 VDD VSS.t2425 VDD VDD sg13_lv_pmos ad=0.34p pd=2.68u as=0 ps=0 w=1u l=1u
X3496 VDD VSS.t1544 VDD VDD sg13_lv_pmos ad=0.19p pd=1.38u as=0 ps=0 w=1u l=1u
X3497 VDD VSS.t2453 VDD VDD sg13_lv_pmos ad=0.19p pd=1.38u as=0 ps=0 w=1u l=1u
X3498 VSS.t907 VDD VSS.t909 VSS.t908 sg13_lv_nmos ad=79.8f pd=0.8u as=0 ps=0 w=0.42u l=1u
X3499 VSS.t1642 VDD VSS.t1644 VSS.t1643 sg13_lv_nmos ad=79.8f pd=0.8u as=0 ps=0 w=0.42u l=1u
X3500 VDD VSS.t2741 VDD VDD sg13_lv_pmos ad=0.34p pd=2.68u as=0 ps=0 w=1u l=1u
X3501 VSS.t2059 VDD VSS.t2061 VSS.t2060 sg13_lv_nmos ad=79.8f pd=0.8u as=0 ps=0 w=0.42u l=1u
X3502 a_6372_14488# a_6346_14452# VDD VDD sg13_lv_pmos ad=0.34p pd=2.68u as=0.36237p ps=2.605u w=1u l=0.13u
X3503 VDD VSS.t339 VDD VDD sg13_lv_pmos ad=0.19p pd=1.38u as=0 ps=0 w=1u l=1u
X3504 VDD sg13cmos5l_dfrbpq_1_7.RESET_B a_25930_14452# VDD sg13_lv_pmos ad=0.1563p pd=1.22u as=0.147p ps=1.54u w=0.42u l=0.13u
X3505 VSS.t1470 VDD VSS.t1338 VSS.t248 sg13_lv_nmos ad=0.1428p pd=1.52u as=0 ps=0 w=0.42u l=1u
X3506 a_4432_15454# sg13cmos5l_dfrbpq_1_0.RESET_B VDD VDD sg13_lv_pmos ad=79.8f pd=0.8u as=2.8961p ps=18.25u w=0.42u l=0.13u
X3507 VDD VSS.t2480 VDD VDD sg13_lv_pmos ad=0.34p pd=2.68u as=0 ps=0 w=1u l=1u
X3508 VSS.t2511 VDD VSS.t2513 VSS.t2512 sg13_lv_nmos ad=79.8f pd=0.8u as=0 ps=0 w=0.42u l=1u
X3509 VSS.t732 VDD VSS.t733 VSS.t730 sg13_lv_nmos ad=79.8f pd=0.8u as=0 ps=0 w=0.42u l=1u
X3510 VDD VSS.t1721 VDD VDD sg13_lv_pmos ad=0.34p pd=2.68u as=0 ps=0 w=1u l=1u
X3511 VDD VSS.t3008 VDD VDD sg13_lv_pmos ad=0.34p pd=2.68u as=0 ps=0 w=1u l=1u
X3512 VSS.t2089 VDD VSS.t2088 VSS.t2087 sg13_lv_nmos ad=0.1428p pd=1.52u as=0 ps=0 w=0.42u l=1u
X3513 VDD VSS.t652 VDD VDD sg13_lv_pmos ad=0.34p pd=2.68u as=0 ps=0 w=1u l=1u
X3514 VSS.t1260 VDD VSS.t1259 VSS.t248 sg13_lv_nmos ad=0.1428p pd=1.52u as=0 ps=0 w=0.42u l=1u
X3515 VSS.t1572 VDD VSS.t1574 VSS.t1573 sg13_lv_nmos ad=79.8f pd=0.8u as=0 ps=0 w=0.42u l=1u
X3516 VSS.t3094 VDD VSS.t3096 VSS.t3095 sg13_lv_nmos ad=79.8f pd=0.8u as=0 ps=0 w=0.42u l=1u
X3517 VSS.t2306 VDD VSS.t2308 VSS.t2307 sg13_lv_nmos ad=79.8f pd=0.8u as=0 ps=0 w=0.42u l=1u
X3518 a_22576_14726# a_22319_14845# a_22738_14922# VSS.t0 sg13_lv_nmos ad=0.1428p pd=1.52u as=37.8f ps=0.6u w=0.42u l=0.13u
X3519 VDD VSS.t1584 VDD VDD sg13_lv_pmos ad=0.19p pd=1.38u as=0 ps=0 w=1u l=1u
X3520 VSS.t922 VDD VSS.t924 VSS.t923 sg13_lv_nmos ad=79.8f pd=0.8u as=0 ps=0 w=0.42u l=1u
X3521 VDD VSS.t1283 VDD VDD sg13_lv_pmos ad=0.34p pd=2.68u as=0 ps=0 w=1u l=1u
X3522 VDD VSS.t2803 VDD VDD sg13_lv_pmos ad=0.34p pd=2.68u as=0 ps=0 w=1u l=1u
X3523 VDD VSS.t991 VDD VDD sg13_lv_pmos ad=0.34p pd=2.68u as=0 ps=0 w=1u l=1u
X3524 VSS.t2381 VDD VSS.t2383 VSS.t2382 sg13_lv_nmos ad=79.8f pd=0.8u as=0 ps=0 w=0.42u l=1u
X3525 VSS.t862 VDD VSS.t861 VSS.t860 sg13_lv_nmos ad=0.1428p pd=1.52u as=0 ps=0 w=0.42u l=1u
X3526 VDD VSS.t2754 VDD VDD sg13_lv_pmos ad=0.19p pd=1.38u as=0 ps=0 w=1u l=1u
X3527 VSS.t2431 VDD VSS.t2430 VSS.t2429 sg13_lv_nmos ad=0.1428p pd=1.52u as=0 ps=0 w=0.42u l=1u
X3528 VDD VSS.t1551 VDD VDD sg13_lv_pmos ad=0.34p pd=2.68u as=0 ps=0 w=1u l=1u
X3529 VDD VSS.t105 VDD VDD sg13_lv_pmos ad=0.19p pd=1.38u as=0 ps=0 w=1u l=1u
X3530 VDD VSS.t661 VDD VDD sg13_lv_pmos ad=0.34p pd=2.68u as=0 ps=0 w=1u l=1u
X3531 VDD VSS.t1054 VDD VDD sg13_lv_pmos ad=0.19p pd=1.38u as=0 ps=0 w=1u l=1u
X3532 VDD VSS.t2111 VDD VDD sg13_lv_pmos ad=0.19p pd=1.38u as=0 ps=0 w=1u l=1u
X3533 VSS.t1597 VDD VSS.t1596 VSS.t1595 sg13_lv_nmos ad=0.1428p pd=1.52u as=0 ps=0 w=0.42u l=1u
X3534 VDD VSS.t1556 VDD VDD sg13_lv_pmos ad=0.34p pd=2.68u as=0 ps=0 w=1u l=1u
X3535 VSS.t2744 VDD VSS.t2743 VSS.t199 sg13_lv_nmos ad=0.1428p pd=1.52u as=0 ps=0 w=0.42u l=1u
X3536 VDD VSS.t2465 VDD VDD sg13_lv_pmos ad=0.34p pd=2.68u as=0 ps=0 w=1u l=1u
X3537 VSS.t2346 VDD VSS.t2348 VSS.t2347 sg13_lv_nmos ad=79.8f pd=0.8u as=0 ps=0 w=0.42u l=1u
X3538 VSS.t463 VDD VSS.t464 VSS.t19 sg13_lv_nmos ad=79.8f pd=0.8u as=0 ps=0 w=0.42u l=1u
X3539 VDD VSS.t605 VDD VDD sg13_lv_pmos ad=0.19p pd=1.38u as=0 ps=0 w=1u l=1u
X3540 VSS.t598 VDD VSS.t597 VSS.t596 sg13_lv_nmos ad=0.1428p pd=1.52u as=0 ps=0 w=0.42u l=1u
X3541 VSS.t2496 VDD VSS.t2498 VSS.t2497 sg13_lv_nmos ad=79.8f pd=0.8u as=0 ps=0 w=0.42u l=1u
X3542 VSS.t1237 VDD VSS.t1238 VSS.t248 sg13_lv_nmos ad=79.8f pd=0.8u as=0 ps=0 w=0.42u l=1u
X3543 VSS.t1274 VDD VSS.t1273 VSS.t248 sg13_lv_nmos ad=0.1428p pd=1.52u as=0 ps=0 w=0.42u l=1u
X3544 VDD VSS.t3028 VDD VDD sg13_lv_pmos ad=0.34p pd=2.68u as=0 ps=0 w=1u l=1u
X3545 VDD VSS.t1898 VDD VDD sg13_lv_pmos ad=0.34p pd=2.68u as=0 ps=0 w=1u l=1u
X3546 VSS.t2074 VDD VSS.t2073 VSS.t2072 sg13_lv_nmos ad=0.1428p pd=1.52u as=0 ps=0 w=0.42u l=1u
X3547 sg13cmos5l_dfrbpq_1_2.CLK a_12010_15202# VDD VDD sg13_lv_pmos ad=0.2128p pd=1.5u as=0.3864p ps=2.93u w=1.12u l=0.13u
X3548 VSS.t892 VDD VSS.t891 VSS.t890 sg13_lv_nmos ad=0.1428p pd=1.52u as=0 ps=0 w=0.42u l=1u
X3549 VDD VSS.t2413 VDD VDD sg13_lv_pmos ad=0.19p pd=1.38u as=0 ps=0 w=1u l=1u
X3550 VDD VSS.t2071 VDD VDD sg13_lv_pmos ad=0.19p pd=1.38u as=0 ps=0 w=1u l=1u
X3551 VSS.t1717 VDD VSS.t1716 VSS.t1715 sg13_lv_nmos ad=0.1428p pd=1.52u as=0 ps=0 w=0.42u l=1u
X3552 VDD VSS.t944 VDD VDD sg13_lv_pmos ad=0.19p pd=1.38u as=0 ps=0 w=1u l=1u
X3553 VSS.t1964 VDD VSS.t1963 VSS.t1962 sg13_lv_nmos ad=0.1428p pd=1.52u as=0 ps=0 w=0.42u l=1u
X3554 VDD VSS.t1330 VDD VDD sg13_lv_pmos ad=0.19p pd=1.38u as=0 ps=0 w=1u l=1u
X3555 VSS.t3049 VDD VSS.t3048 VSS.t3047 sg13_lv_nmos ad=0.1428p pd=1.52u as=0 ps=0 w=0.42u l=1u
X3556 a_9861_15213# sg13cmos5l_dfrbpq_1_2.CLK VSS.t19 VSS.t63 sg13_lv_nmos ad=0.2516p pd=2.16u as=3.8707p ps=25.555u w=0.74u l=0.13u
X3557 VDD VSS.t1069 VDD VDD sg13_lv_pmos ad=0.19p pd=1.38u as=0 ps=0 w=1u l=1u
X3558 VSS.t2526 VDD VSS.t2525 VSS.t2524 sg13_lv_nmos ad=0.1428p pd=1.52u as=0 ps=0 w=0.42u l=1u
X3559 VDD a_15579_14854# sg13cmos5l_buf_8_2.A VDD sg13_lv_pmos ad=0.2128p pd=1.5u as=0.2128p ps=1.5u w=1.12u l=0.13u
X3560 VSS.t658 VDD VSS.t658 VSS.t659 sg13_lv_nmos ad=79.8f pd=0.8u as=0 ps=0 w=0.42u l=1u
X3561 VDD a_22576_14726# a_22521_14607# VDD sg13_lv_pmos ad=2.42015p pd=15.68u as=93.45f ps=0.865u w=0.42u l=0.13u
X3562 VSS.t907 VDD VSS.t909 VSS.t908 sg13_lv_nmos ad=79.8f pd=0.8u as=0 ps=0 w=0.42u l=1u
X3563 VDD VSS.t1529 VDD VDD sg13_lv_pmos ad=0.19p pd=1.38u as=0 ps=0 w=1u l=1u
X3564 VSS.t2931 VDD VSS.t2814 VSS.t199 sg13_lv_nmos ad=79.8f pd=0.8u as=0 ps=0 w=0.42u l=1u
X3565 VDD VSS.t461 VDD VDD sg13_lv_pmos ad=0.19p pd=1.38u as=0 ps=0 w=1u l=1u
X3566 VSS.t952 VDD VSS.t954 VSS.t953 sg13_lv_nmos ad=79.8f pd=0.8u as=0 ps=0 w=0.42u l=1u
X3567 VDD VSS.t2438 VDD VDD sg13_lv_pmos ad=0.19p pd=1.38u as=0 ps=0 w=1u l=1u
X3568 VDD sg13cmos5l_a21oi_1_0.Y a_16856_15238# VDD sg13_lv_pmos ad=0.1523p pd=1.38u as=0.1428p ps=1.52u w=0.42u l=0.13u
X3569 VSS.t2326 VDD VSS.t2328 VSS.t2327 sg13_lv_nmos ad=79.8f pd=0.8u as=0 ps=0 w=0.42u l=1u
X3570 VSS.t270 VDD VSS.t515 VSS.t52 sg13_lv_nmos ad=0.1428p pd=1.52u as=0 ps=0 w=0.42u l=1u
X3571 VDD VSS.t819 VDD VDD sg13_lv_pmos ad=0.19p pd=1.38u as=0 ps=0 w=1u l=1u
X3572 VSS.t2044 VDD VSS.t2046 VSS.t2045 sg13_lv_nmos ad=79.8f pd=0.8u as=0 ps=0 w=0.42u l=1u
X3573 VDD VSS.t492 VDD VDD sg13_lv_pmos ad=0.34p pd=2.68u as=0 ps=0 w=1u l=1u
X3574 VSS.t2777 VDD VSS.t2778 VSS.t199 sg13_lv_nmos ad=79.8f pd=0.8u as=0 ps=0 w=0.42u l=1u
X3575 sg13cmos5l_a21oi_1_3.A1 a_25206_15302# VDD VDD sg13_lv_pmos ad=0.4256p pd=3u as=0.2254p ps=1.53u w=1.12u l=0.13u
X3576 a_6086_14922# sg13cmos5l_and2_1_1.X VDD VDD sg13_lv_pmos ad=79.8f pd=0.8u as=0.1428p ps=1.52u w=0.42u l=0.13u
X3577 a_21034_14452# a_21477_14495# a_21417_14531# VDD sg13_lv_pmos ad=79.8f pd=0.8u as=63f ps=0.72u w=0.42u l=0.13u
X3578 VSS.t50 VDD VSS.t50 VSS.t700 sg13_lv_nmos ad=79.8f pd=0.8u as=0 ps=0 w=0.42u l=1u
X3579 VSS.t1547 VDD VSS.t1546 VSS.t1545 sg13_lv_nmos ad=0.1428p pd=1.52u as=0 ps=0 w=0.42u l=1u
X3580 VDD sg13cmos5l_dfrbpq_1_7.RESET_B a_25670_14922# VDD sg13_lv_pmos ad=0.36237p pd=2.605u as=79.8f ps=0.8u w=0.42u l=0.13u
X3581 VSS.t1220 VDD VSS.t1220 VSS.t248 sg13_lv_nmos ad=0.1428p pd=1.52u as=0 ps=0 w=0.42u l=1u
X3582 VSS.t550 VDD VSS.t555 VSS.t554 sg13_lv_nmos ad=79.8f pd=0.8u as=0 ps=0 w=0.42u l=1u
X3583 VDD VSS.t1276 VDD VDD sg13_lv_pmos ad=0.34p pd=2.68u as=0 ps=0 w=1u l=1u
X3584 VDD VSS.t2778 VDD VDD sg13_lv_pmos ad=0.34p pd=2.68u as=0 ps=0 w=1u l=1u
X3585 VDD VSS.t2063 VDD VDD sg13_lv_pmos ad=0.34p pd=2.68u as=0 ps=0 w=1u l=1u
X3586 VSS.t747 a_19323_13726# sg13cmos5l_buf_8_2.X VSS.t3235 sg13_lv_nmos ad=0.1406p pd=1.12u as=0.1406p ps=1.12u w=0.74u l=0.13u
X3587 VSS.t922 VDD VSS.t924 VSS.t923 sg13_lv_nmos ad=79.8f pd=0.8u as=0 ps=0 w=0.42u l=1u
X3588 VDD VSS.t470 VDD VDD sg13_lv_pmos ad=0.19p pd=1.38u as=0 ps=0 w=1u l=1u
X3589 VSS.t682 VDD VSS.t682 VSS.t683 sg13_lv_nmos ad=79.8f pd=0.8u as=0 ps=0 w=0.42u l=1u
X3590 VSS.t1557 VDD VSS.t1559 VSS.t1558 sg13_lv_nmos ad=79.8f pd=0.8u as=0 ps=0 w=0.42u l=1u
X3591 VSS.t1737 VDD VSS.t1736 VSS.t1735 sg13_lv_nmos ad=0.1428p pd=1.52u as=0 ps=0 w=0.42u l=1u
X3592 VSS.t3079 VDD VSS.t3081 VSS.t3080 sg13_lv_nmos ad=79.8f pd=0.8u as=0 ps=0 w=0.42u l=1u
X3593 VSS.t2291 VDD VSS.t2293 VSS.t2292 sg13_lv_nmos ad=79.8f pd=0.8u as=0 ps=0 w=0.42u l=1u
X3594 VDD VSS.t45 VDD VDD sg13_lv_pmos ad=0.19p pd=1.38u as=0 ps=0 w=1u l=1u
X3595 a_19065_14607# a_18123_14495# a_18863_14845# VDD sg13_lv_pmos ad=93.45f pd=0.865u as=0.2048p ps=1.63u w=0.42u l=0.13u
X3596 VDD VSS.t1746 VDD VDD sg13_lv_pmos ad=0.34p pd=2.68u as=0 ps=0 w=1u l=1u
X3597 VSS.t2546 VDD VSS.t2545 VSS.t2544 sg13_lv_nmos ad=0.1428p pd=1.52u as=0 ps=0 w=0.42u l=1u
X3598 VSS.t2366 VDD VSS.t2368 VSS.t2367 sg13_lv_nmos ad=79.8f pd=0.8u as=0 ps=0 w=0.42u l=1u
X3599 VSS.t197 sg13cmos5l_dlygate4sd3_1_4.X a_16969_16020# VSS.t271 sg13_lv_nmos ad=0.13395p pd=1.12u as=0.198p ps=1.27u w=0.55u l=0.13u
X3600 a_2916_15552# a_2890_15457# VSS.t165 VSS.t3270 sg13_lv_nmos ad=0.2516p pd=2.16u as=0.1626p ps=1.415u w=0.74u l=0.13u
X3601 VDD VSS.t440 VDD VDD sg13_lv_pmos ad=0.34p pd=2.68u as=0 ps=0 w=1u l=1u
X3602 sg13cmos5l_o21ai_1_2.A2 sg13cmos5l_dfrbpq_1_6.Q VDD VDD sg13_lv_pmos ad=0.3808p pd=2.92u as=0.2128p ps=1.5u w=1.12u l=0.13u
X3603 VSS.t862 VDD VSS.t861 VSS.t860 sg13_lv_nmos ad=0.1428p pd=1.52u as=0 ps=0 w=0.42u l=1u
X3604 VSS.t1292 VDD VSS.t1291 VSS.t248 sg13_lv_nmos ad=0.1428p pd=1.52u as=0 ps=0 w=0.42u l=1u
X3605 VDD VSS.t3146 VDD VDD sg13_lv_pmos ad=0.19p pd=1.38u as=0 ps=0 w=1u l=1u
X3606 VDD VSS.t1576 VDD VDD sg13_lv_pmos ad=0.34p pd=2.68u as=0 ps=0 w=1u l=1u
X3607 VDD VSS.t1264 VDD VDD sg13_lv_pmos ad=0.19p pd=1.38u as=0 ps=0 w=1u l=1u
X3608 VDD VSS.t974 VDD VDD sg13_lv_pmos ad=0.19p pd=1.38u as=0 ps=0 w=1u l=1u
X3609 VSS.t1647 VDD VSS.t1649 VSS.t1648 sg13_lv_nmos ad=79.8f pd=0.8u as=0 ps=0 w=0.42u l=1u
X3610 VDD VSS.t2724 VDD VDD sg13_lv_pmos ad=0.34p pd=2.68u as=0 ps=0 w=1u l=1u
X3611 VSS.t295 VDD VSS.t297 VSS.t507 sg13_lv_nmos ad=79.8f pd=0.8u as=0 ps=0 w=0.42u l=1u
X3612 VDD VSS.t105 VDD VDD sg13_lv_pmos ad=0.19p pd=1.38u as=0 ps=0 w=1u l=1u
X3613 VSS.t555 VDD VSS.t555 VSS.t556 sg13_lv_nmos ad=0.1428p pd=1.52u as=0 ps=0 w=0.42u l=1u
X3614 VDD VSS.t1536 VDD VDD sg13_lv_pmos ad=0.34p pd=2.68u as=0 ps=0 w=1u l=1u
X3615 VSS.t1233 VDD VSS.t1232 VSS.t248 sg13_lv_nmos ad=0.1428p pd=1.52u as=0 ps=0 w=0.42u l=1u
X3616 VDD VSS.t1296 VDD VDD sg13_lv_pmos ad=0.19p pd=1.38u as=0 ps=0 w=1u l=1u
X3617 VDD VSS.t2798 VDD VDD sg13_lv_pmos ad=0.19p pd=1.38u as=0 ps=0 w=1u l=1u
X3618 VSS.t399 VDD VSS.t399 VSS.t400 sg13_lv_nmos ad=0.1428p pd=1.52u as=0 ps=0 w=0.42u l=1u
X3619 VDD VSS.t911 VDD VDD sg13_lv_pmos ad=0.34p pd=2.68u as=0 ps=0 w=1u l=1u
X3620 VDD VSS.t1541 VDD VDD sg13_lv_pmos ad=0.34p pd=2.68u as=0 ps=0 w=1u l=1u
X3621 VSS.t2511 VDD VSS.t2510 VSS.t2509 sg13_lv_nmos ad=0.1428p pd=1.52u as=0 ps=0 w=0.42u l=1u
X3622 a_2646_14842# sg13cmos5l_xor2_1_0.B sg13cmos5l_xor2_1_0.X VSS.t163 sg13_lv_nmos ad=88.8f pd=0.98u as=0.1628p ps=1.18u w=0.74u l=0.13u
X3623 VDD VSS.t2450 VDD VDD sg13_lv_pmos ad=0.34p pd=2.68u as=0 ps=0 w=1u l=1u
X3624 VSS.t457 VDD VSS.t458 VSS.t19 sg13_lv_nmos ad=79.8f pd=0.8u as=0 ps=0 w=0.42u l=1u
X3625 VSS.t892 VDD VSS.t891 VSS.t890 sg13_lv_nmos ad=0.1428p pd=1.52u as=0 ps=0 w=0.42u l=1u
X3626 VSS.t1301 VDD VSS.t1300 VSS.t248 sg13_lv_nmos ad=0.1428p pd=1.52u as=0 ps=0 w=0.42u l=1u
X3627 VSS.t2341 VDD VSS.t2340 VSS.t2339 sg13_lv_nmos ad=0.1428p pd=1.52u as=0 ps=0 w=0.42u l=1u
X3628 VDD VSS.t3013 VDD VDD sg13_lv_pmos ad=0.34p pd=2.68u as=0 ps=0 w=1u l=1u
X3629 VDD VSS.t1883 VDD VDD sg13_lv_pmos ad=0.34p pd=2.68u as=0 ps=0 w=1u l=1u
X3630 VSS.t2059 VDD VSS.t2058 VSS.t2057 sg13_lv_nmos ad=0.1428p pd=1.52u as=0 ps=0 w=0.42u l=1u
X3631 VSS.t418 VDD VSS.t414 VSS.t417 sg13_lv_nmos ad=0.1428p pd=1.52u as=0 ps=0 w=0.42u l=1u
X3632 a_23638_14862# sg13cmos5l_o21ai_1_2.A2 VSS.t266 VSS.t0 sg13_lv_nmos ad=0.1406p pd=1.12u as=0.1406p ps=1.12u w=0.74u l=0.15u
X3633 VSS.t618 VDD VSS.t617 VSS.t616 sg13_lv_nmos ad=0.1428p pd=1.52u as=0 ps=0 w=0.42u l=1u
X3634 a_3273_15625# a_2916_15552# VDD VDD sg13_lv_pmos ad=63f pd=0.72u as=0.1563p ps=1.22u w=0.42u l=0.13u
X3635 VSS.t1062 VDD VSS.t1061 VSS.t1060 sg13_lv_nmos ad=0.1428p pd=1.52u as=0 ps=0 w=0.42u l=1u
X3636 VDD VSS.t2415 VDD VDD sg13_lv_pmos ad=0.34p pd=2.68u as=0 ps=0 w=1u l=1u
X3637 VSS.t952 VDD VSS.t954 VSS.t953 sg13_lv_nmos ad=79.8f pd=0.8u as=0 ps=0 w=0.42u l=1u
X3638 VDD VSS.t1245 VDD VDD sg13_lv_pmos ad=0.34p pd=2.68u as=0 ps=0 w=1u l=1u
X3639 VSS.t1320 VDD VSS.t1319 VSS.t248 sg13_lv_nmos ad=0.1428p pd=1.52u as=0 ps=0 w=0.42u l=1u
X3640 VDD VSS.t1926 VDD VDD sg13_lv_pmos ad=0.19p pd=1.38u as=0 ps=0 w=1u l=1u
X3641 VDD VSS.t2760 VDD VDD sg13_lv_pmos ad=0.19p pd=1.38u as=0 ps=0 w=1u l=1u
X3642 a_17578_14452# a_18021_14495# a_17961_14531# VDD sg13_lv_pmos ad=79.8f pd=0.8u as=63f ps=0.72u w=0.42u l=0.13u
X3643 VSS.t1607 VDD VSS.t1606 VSS.t1605 sg13_lv_nmos ad=0.1428p pd=1.52u as=0 ps=0 w=0.42u l=1u
X3644 a_9861_15213# sg13cmos5l_dfrbpq_1_2.CLK VDD VDD sg13_lv_pmos ad=0.4088p pd=2.97u as=2.77542p ps=17.49u w=1.12u l=0.13u
X3645 VSS.t2311 VDD VSS.t2313 VSS.t2312 sg13_lv_nmos ad=79.8f pd=0.8u as=0 ps=0 w=0.42u l=1u
X3646 VSS.t761 VDD VSS.t635 VSS.t760 sg13_lv_nmos ad=0.1428p pd=1.52u as=0 ps=0 w=0.42u l=1u
X3647 VSS.t1325 VDD VSS.t1324 VSS.t248 sg13_lv_nmos ad=0.1428p pd=1.52u as=0 ps=0 w=0.42u l=1u
X3648 VDD VSS.t1521 VDD VDD sg13_lv_pmos ad=0.34p pd=2.68u as=0 ps=0 w=1u l=1u
X3649 VDD VSS.t874 VDD VDD sg13_lv_pmos ad=0.19p pd=1.38u as=0 ps=0 w=1u l=1u
X3650 VSS.t2159 VDD VSS.t2161 VSS.t2160 sg13_lv_nmos ad=79.8f pd=0.8u as=0 ps=0 w=0.42u l=1u
X3651 VDD a_26554_16237# sg13cmos5l_dfrbpq_1_5.RESET_B VDD sg13_lv_pmos ad=2.8961p pd=18.25u as=0.3927p ps=2.99u w=1.155u l=0.13u
X3652 VSS.t1356 VDD VSS.t1357 VSS.t248 sg13_lv_nmos ad=79.8f pd=0.8u as=0 ps=0 w=0.42u l=1u
X3653 VSS.t1602 VDD VSS.t1601 VSS.t1600 sg13_lv_nmos ad=0.1428p pd=1.52u as=0 ps=0 w=0.42u l=1u
X3654 VSS.t2351 VDD VSS.t2353 VSS.t2352 sg13_lv_nmos ad=79.8f pd=0.8u as=0 ps=0 w=0.42u l=1u
X3655 VDD VSS.t1266 VDD VDD sg13_lv_pmos ad=0.34p pd=2.68u as=0 ps=0 w=1u l=1u
X3656 VDD VSS.t2771 VDD VDD sg13_lv_pmos ad=0.34p pd=2.68u as=0 ps=0 w=1u l=1u
X3657 VSS.t2079 VDD VSS.t2078 VSS.t2077 sg13_lv_nmos ad=0.1428p pd=1.52u as=0 ps=0 w=0.42u l=1u
X3658 VDD VSS.t2076 VDD VDD sg13_lv_pmos ad=0.19p pd=1.38u as=0 ps=0 w=1u l=1u
X3659 VSS.t31 a_7532_15960# counter_value_o[1] VSS.t30 sg13_lv_nmos ad=0.14875p pd=1.16u as=0.2886p ps=2.26u w=0.74u l=0.13u
X3660 VSS.t1722 VDD VSS.t1721 VSS.t1720 sg13_lv_nmos ad=0.1428p pd=1.52u as=0 ps=0 w=0.42u l=1u
X3661 VDD VSS.t610 VDD VDD sg13_lv_pmos ad=0.19p pd=1.38u as=0 ps=0 w=1u l=1u
X3662 VDD VSS.t1224 VDD VDD sg13_lv_pmos ad=0.19p pd=1.38u as=0 ps=0 w=1u l=1u
X3663 VDD VSS.t1081 VDD VDD sg13_lv_pmos ad=0.34p pd=2.68u as=0 ps=0 w=1u l=1u
X3664 VSS.t2531 VDD VSS.t2530 VSS.t2529 sg13_lv_nmos ad=0.1428p pd=1.52u as=0 ps=0 w=0.42u l=1u
X3665 VSS.t328 VDD VSS.t323 VSS.t327 sg13_lv_nmos ad=0.1428p pd=1.52u as=0 ps=0 w=0.42u l=1u
X3666 VSS.t490 VDD VSS.t491 VSS.t19 sg13_lv_nmos ad=79.8f pd=0.8u as=0 ps=0 w=0.42u l=1u
X3667 VDD VSS.t1561 VDD VDD sg13_lv_pmos ad=0.34p pd=2.68u as=0 ps=0 w=1u l=1u
X3668 VDD VSS.t1911 VDD VDD sg13_lv_pmos ad=0.19p pd=1.38u as=0 ps=0 w=1u l=1u
X3669 VSS.t2816 VDD VSS.t2817 VSS.t199 sg13_lv_nmos ad=79.8f pd=0.8u as=0 ps=0 w=0.42u l=1u
X3670 VDD VSS.t2752 VDD VDD sg13_lv_pmos ad=0.19p pd=1.38u as=0 ps=0 w=1u l=1u
X3671 VSS.t2029 VDD VSS.t2028 VSS.t2027 sg13_lv_nmos ad=0.1428p pd=1.52u as=0 ps=0 w=0.42u l=1u
X3672 VDD VSS.t679 VDD VDD sg13_lv_pmos ad=0.34p pd=2.68u as=0 ps=0 w=1u l=1u
X3673 VDD VSS.t841 VDD VDD sg13_lv_pmos ad=0.34p pd=2.68u as=0 ps=0 w=1u l=1u
X3674 VSS.t1632 VDD VSS.t1634 VSS.t1633 sg13_lv_nmos ad=79.8f pd=0.8u as=0 ps=0 w=0.42u l=1u
X3675 VSS.t2762 VDD VSS.t2763 VSS.t199 sg13_lv_nmos ad=79.8f pd=0.8u as=0 ps=0 w=0.42u l=1u
X3676 VSS.t1338 VDD VSS.t1337 VSS.t248 sg13_lv_nmos ad=0.1428p pd=1.52u as=0 ps=0 w=0.42u l=1u
X3677 VDD VSS.t2503 VDD VDD sg13_lv_pmos ad=0.19p pd=1.38u as=0 ps=0 w=1u l=1u
X3678 VDD a_19054_15423# sg13cmos5l_dlygate4sd3_1_4.X VDD sg13_lv_pmos ad=0.2254p pd=1.53u as=0.4256p ps=3u w=1.12u l=0.13u
X3679 VSS.t448 VDD VSS.t449 VSS.t19 sg13_lv_nmos ad=79.8f pd=0.8u as=0 ps=0 w=0.42u l=1u
X3680 VDD VSS.t956 VDD VDD sg13_lv_pmos ad=0.34p pd=2.68u as=0 ps=0 w=1u l=1u
X3681 VSS.t1552 VDD VSS.t1551 VSS.t1550 sg13_lv_nmos ad=0.1428p pd=1.52u as=0 ps=0 w=0.42u l=1u
X3682 VDD VSS.t2278 VDD VDD sg13_lv_pmos ad=0.19p pd=1.38u as=0 ps=0 w=1u l=1u
X3683 VSS.t2109 VDD VSS.t2111 VSS.t2110 sg13_lv_nmos ad=79.8f pd=0.8u as=0 ps=0 w=0.42u l=1u
X3684 VDD VSS.t1279 VDD VDD sg13_lv_pmos ad=0.34p pd=2.68u as=0 ps=0 w=1u l=1u
X3685 VDD VSS.t2068 VDD VDD sg13_lv_pmos ad=0.34p pd=2.68u as=0 ps=0 w=1u l=1u
X3686 VDD VSS.t2763 VDD VDD sg13_lv_pmos ad=0.34p pd=2.68u as=0 ps=0 w=1u l=1u
X3687 VSS.t2326 VDD VSS.t2325 VSS.t2324 sg13_lv_nmos ad=0.1428p pd=1.52u as=0 ps=0 w=0.42u l=1u
X3688 VSS.t19 a_5687_15315# a_5687_15315# VSS.t256 sg13_lv_nmos ad=4.11262p pd=27.15u as=0.111p ps=1.34u w=0.3u l=0.13u
X3689 VDD VSS.t894 VDD VDD sg13_lv_pmos ad=0.19p pd=1.38u as=0 ps=0 w=1u l=1u
X3690 VSS.t3084 VDD VSS.t3086 VSS.t3085 sg13_lv_nmos ad=79.8f pd=0.8u as=0 ps=0 w=0.42u l=1u
X3691 VSS.t2704 VDD VSS.t2705 VSS.t199 sg13_lv_nmos ad=79.8f pd=0.8u as=0 ps=0 w=0.42u l=1u
X3692 VSS.t2296 VDD VSS.t2298 VSS.t2297 sg13_lv_nmos ad=79.8f pd=0.8u as=0 ps=0 w=0.42u l=1u
X3693 a_21251_13690# sg13cmos5l_or3_1_2.C VSS.t215 VSS.t214 sg13_lv_nmos ad=0.187p pd=1.78u as=0.1045p ps=0.93u w=0.55u l=0.13u
X3694 VDD VSS.t1315 VDD VDD sg13_lv_pmos ad=0.19p pd=1.38u as=0 ps=0 w=1u l=1u
X3695 VDD VSS.t856 VDD VDD sg13_lv_pmos ad=0.34p pd=2.68u as=0 ps=0 w=1u l=1u
X3696 VSS.t1062 VDD VSS.t1061 VSS.t1060 sg13_lv_nmos ad=0.1428p pd=1.52u as=0 ps=0 w=0.42u l=1u
X3697 VDD VSS.t1716 VDD VDD sg13_lv_pmos ad=0.34p pd=2.68u as=0 ps=0 w=1u l=1u
X3698 VSS.t643 VDD VSS.t643 VSS.t644 sg13_lv_nmos ad=79.8f pd=0.8u as=0 ps=0 w=0.42u l=1u
X3699 VSS.t1263 VDD VSS.t1264 VSS.t248 sg13_lv_nmos ad=79.8f pd=0.8u as=0 ps=0 w=0.42u l=1u
X3700 VSS.t339 VDD VSS.t339 VSS.t342 sg13_lv_nmos ad=79.8f pd=0.8u as=0 ps=0 w=0.42u l=1u
X3701 VDD VSS.t1581 VDD VDD sg13_lv_pmos ad=0.34p pd=2.68u as=0 ps=0 w=1u l=1u
X3702 VSS.t1939 VDD VSS.t1941 VSS.t1940 sg13_lv_nmos ad=79.8f pd=0.8u as=0 ps=0 w=0.42u l=1u
X3703 VDD VSS.t2728 VDD VDD sg13_lv_pmos ad=0.34p pd=2.68u as=0 ps=0 w=1u l=1u
X3704 VSS.t1352 VDD VSS.t1350 VSS.t248 sg13_lv_nmos ad=0.1428p pd=1.52u as=0 ps=0 w=0.42u l=1u
X3705 VDD VSS.t592 VDD VDD sg13_lv_pmos ad=0.34p pd=2.68u as=0 ps=0 w=1u l=1u
X3706 VSS.t867 VDD VSS.t869 VSS.t868 sg13_lv_nmos ad=79.8f pd=0.8u as=0 ps=0 w=0.42u l=1u
X3707 a_9158_15234# sg13cmos5l_and2_1_2.X VDD VDD sg13_lv_pmos ad=79.8f pd=0.8u as=0.1428p ps=1.52u w=0.42u l=0.13u
X3708 VSS.t15 sg13cmos5l_xor2_1_0.X a_2059_14832# VSS.t14 sg13_lv_nmos ad=0.1331p pd=1.12u as=0.1216p ps=1.02u w=0.64u l=0.13u
X3709 VDD VSS.t926 VDD VDD sg13_lv_pmos ad=0.34p pd=2.68u as=0 ps=0 w=1u l=1u
X3710 VDD VSS.t1299 VDD VDD sg13_lv_pmos ad=0.19p pd=1.38u as=0 ps=0 w=1u l=1u
X3711 VSS.t1537 VDD VSS.t1536 VSS.t1535 sg13_lv_nmos ad=0.1428p pd=1.52u as=0 ps=0 w=0.42u l=1u
X3712 VSS.t2144 VDD VSS.t2146 VSS.t2145 sg13_lv_nmos ad=79.8f pd=0.8u as=0 ps=0 w=0.42u l=1u
X3713 VDD VSS.t2101 VDD VDD sg13_lv_pmos ad=0.19p pd=1.38u as=0 ps=0 w=1u l=1u
X3714 VDD VSS.t1546 VDD VDD sg13_lv_pmos ad=0.34p pd=2.68u as=0 ps=0 w=1u l=1u
X3715 VSS.t2516 VDD VSS.t2515 VSS.t2514 sg13_lv_nmos ad=0.1428p pd=1.52u as=0 ps=0 w=0.42u l=1u
X3716 VSS.t744 VDD VSS.t744 VSS.t745 sg13_lv_nmos ad=79.8f pd=0.8u as=0 ps=0 w=0.42u l=1u
X3717 VSS.t2739 VDD VSS.t2738 VSS.t199 sg13_lv_nmos ad=0.1428p pd=1.52u as=0 ps=0 w=0.42u l=1u
X3718 VDD VSS.t2455 VDD VDD sg13_lv_pmos ad=0.34p pd=2.68u as=0 ps=0 w=1u l=1u
X3719 VDD VSS.t664 VDD VDD sg13_lv_pmos ad=0.34p pd=2.68u as=0 ps=0 w=1u l=1u
X3720 VDD VSS.t3018 VDD VDD sg13_lv_pmos ad=0.34p pd=2.68u as=0 ps=0 w=1u l=1u
X3721 a_10222_14751# a_10337_14750# VSS.t6 VSS.t239 sg13_lv_nmos ad=0.1428p pd=1.52u as=0.1426p ps=1.16u w=0.42u l=0.5u
X3722 VSS.t2281 VDD VSS.t2283 VSS.t2282 sg13_lv_nmos ad=79.8f pd=0.8u as=0 ps=0 w=0.42u l=1u
X3723 VSS.t2064 VDD VSS.t2063 VSS.t2062 sg13_lv_nmos ad=0.1428p pd=1.52u as=0 ps=0 w=0.42u l=1u
X3724 VDD VSS.t610 VDD VDD sg13_lv_pmos ad=0.19p pd=1.38u as=0 ps=0 w=1u l=1u
X3725 VDD VSS.t1011 VDD VDD sg13_lv_pmos ad=0.34p pd=2.68u as=0 ps=0 w=1u l=1u
X3726 VSS.t2014 VDD VSS.t2016 VSS.t2015 sg13_lv_nmos ad=79.8f pd=0.8u as=0 ps=0 w=0.42u l=1u
X3727 VDD VSS.t1559 VDD VDD sg13_lv_pmos ad=0.19p pd=1.38u as=0 ps=0 w=1u l=1u
X3728 VSS.t2356 VDD VSS.t2358 VSS.t2357 sg13_lv_nmos ad=79.8f pd=0.8u as=0 ps=0 w=0.42u l=1u
X3729 VSS.t550 VDD VSS.t555 VSS.t554 sg13_lv_nmos ad=79.8f pd=0.8u as=0 ps=0 w=0.42u l=1u
X3730 VDD VSS.t2156 VDD VDD sg13_lv_pmos ad=0.19p pd=1.38u as=0 ps=0 w=1u l=1u
X3731 VDD VSS.t45 VDD VDD sg13_lv_pmos ad=0.34p pd=2.68u as=0 ps=0 w=1u l=1u
X3732 a_25037_14020# sg13cmos5l_or3_1_1.B a_24935_14020# VDD sg13_lv_pmos ad=0.1575p pd=1.315u as=0.19p ps=1.38u w=1u l=0.13u
X3733 VDD VSS.t1896 VDD VDD sg13_lv_pmos ad=0.19p pd=1.38u as=0 ps=0 w=1u l=1u
X3734 VSS.t2808 VDD VSS.t2809 VSS.t199 sg13_lv_nmos ad=79.8f pd=0.8u as=0 ps=0 w=0.42u l=1u
X3735 VDD VSS.t2687 VDD VDD sg13_lv_pmos ad=0.19p pd=1.38u as=0 ps=0 w=1u l=1u
X3736 VDD VSS.t375 VDD VDD sg13_lv_pmos ad=0.34p pd=2.68u as=0 ps=0 w=1u l=1u
X3737 VDD VSS.t1333 VDD VDD sg13_lv_pmos ad=0.19p pd=1.38u as=0 ps=0 w=1u l=1u
X3738 VSS.t1577 VDD VSS.t1576 VSS.t1575 sg13_lv_nmos ad=0.1428p pd=1.52u as=0 ps=0 w=0.42u l=1u
X3739 VSS.t3099 VDD VSS.t3098 VSS.t3097 sg13_lv_nmos ad=0.1428p pd=1.52u as=0 ps=0 w=0.42u l=1u
X3740 VSS.t2311 VDD VSS.t2310 VSS.t2309 sg13_lv_nmos ad=0.1428p pd=1.52u as=0 ps=0 w=0.42u l=1u
X3741 a_7262_15242# sg13cmos5l_buf_1_0.X a_7160_15242# VSS.t281 sg13_lv_nmos ad=0.1406p pd=1.12u as=0.1406p ps=1.12u w=0.74u l=0.13u
X3742 VDD a_26638_15423# sg13cmos5l_o21ai_1_2.B1 VDD sg13_lv_pmos ad=0.2254p pd=1.53u as=0.4256p ps=3u w=1.12u l=0.13u
X3743 VDD a_6682_13690# a_6401_13912# VDD sg13_lv_pmos ad=0.1523p pd=1.38u as=0.34p ps=2.68u w=1u l=0.5u
X3744 VSS.t2781 VDD VSS.t2781 VSS.t199 sg13_lv_nmos ad=0.1428p pd=1.52u as=0 ps=0 w=0.42u l=1u
X3745 VSS.t661 VDD VSS.t661 VSS.t662 sg13_lv_nmos ad=79.8f pd=0.8u as=0 ps=0 w=0.42u l=1u
X3746 VDD VSS.t1074 VDD VDD sg13_lv_pmos ad=0.19p pd=1.38u as=0 ps=0 w=1u l=1u
X3747 VDD sg13cmos5l_inv_1_0.A sg13cmos5l_inv_1_0.Y VDD sg13_lv_pmos ad=0.3808p pd=2.92u as=0.3808p ps=2.92u w=1.12u l=0.13u
X3748 VSS.t414 VDD VSS.t414 VSS.t416 sg13_lv_nmos ad=79.8f pd=0.8u as=0 ps=0 w=0.42u l=1u
X3749 VSS.t475 VDD VSS.t476 VSS.t19 sg13_lv_nmos ad=79.8f pd=0.8u as=0 ps=0 w=0.42u l=1u
X3750 VDD VSS.t729 VDD VDD sg13_lv_pmos ad=0.19p pd=1.38u as=0 ps=0 w=1u l=1u
X3751 VDD VSS.t1699 VDD VDD sg13_lv_pmos ad=0.19p pd=1.38u as=0 ps=0 w=1u l=1u
X3752 VSS.t617 VDD VSS.t618 VSS.t723 sg13_lv_nmos ad=0.1428p pd=1.52u as=0 ps=0 w=0.42u l=1u
X3753 VDD VSS.t2053 VDD VDD sg13_lv_pmos ad=0.34p pd=2.68u as=0 ps=0 w=1u l=1u
X3754 VDD VSS.t50 VDD VDD sg13_lv_pmos ad=0.34p pd=2.68u as=0 ps=0 w=1u l=1u
X3755 VDD VSS.t1341 VDD VDD sg13_lv_pmos ad=0.19p pd=1.38u as=0 ps=0 w=1u l=1u
X3756 VDD a_14261_15238# sg13cmos5l_or3_1_1.B VDD sg13_lv_pmos ad=0.3808p pd=2.92u as=0.2128p ps=1.5u w=1.12u l=0.13u
X3757 a_22738_14922# sg13cmos5l_dfrbpq_1_6.RESET_B VSS.t135 VSS.t0 sg13_lv_nmos ad=37.8f pd=0.6u as=79.8f ps=0.8u w=0.42u l=0.13u
X3758 VSS.t670 VDD VSS.t670 VSS.t671 sg13_lv_nmos ad=79.8f pd=0.8u as=0 ps=0 w=0.42u l=1u
X3759 VDD a_4175_15311# a_4432_15454# VDD sg13_lv_pmos ad=2.8961p pd=18.25u as=79.8f ps=0.8u w=0.42u l=0.13u
X3760 VSS.t1214 VDD VSS.t1373 VSS.t248 sg13_lv_nmos ad=0.1428p pd=1.52u as=0 ps=0 w=0.42u l=1u
X3761 VSS.t1322 VDD VSS.t1323 VSS.t248 sg13_lv_nmos ad=79.8f pd=0.8u as=0 ps=0 w=0.42u l=1u
X3762 VDD VSS.t2318 VDD VDD sg13_lv_pmos ad=0.19p pd=1.38u as=0 ps=0 w=1u l=1u
X3763 VSS.t2501 VDD VSS.t2500 VSS.t2499 sg13_lv_nmos ad=0.1428p pd=1.52u as=0 ps=0 w=0.42u l=1u
X3764 a_26565_13701# sg13cmos5l_buf_8_2.X VDD VDD sg13_lv_pmos ad=0.4088p pd=2.97u as=2.3367p ps=15.135u w=1.12u l=0.13u
X3765 VSS.t972 VDD VSS.t974 VSS.t973 sg13_lv_nmos ad=79.8f pd=0.8u as=0 ps=0 w=0.42u l=1u
X3766 VDD VSS.t1566 VDD VDD sg13_lv_pmos ad=0.34p pd=2.68u as=0 ps=0 w=1u l=1u
X3767 sg13cmos5l_buf_8_2.X a_19323_13726# VSS.t744 VSS.t3230 sg13_lv_nmos ad=0.1406p pd=1.12u as=0.1406p ps=1.12u w=0.74u l=0.13u
X3768 VDD VSS.t1041 VDD VDD sg13_lv_pmos ad=0.34p pd=2.68u as=0 ps=0 w=1u l=1u
X3769 VSS.t2799 VDD VSS.t2801 VSS.t199 sg13_lv_nmos ad=79.8f pd=0.8u as=0 ps=0 w=0.42u l=1u
X3770 VDD VSS.t318 VDD VDD sg13_lv_pmos ad=0.34p pd=2.68u as=0 ps=0 w=1u l=1u
X3771 sg13cmos5l_or3_1_1.B a_14261_15238# VSS.t143 VSS.t142 sg13_lv_nmos ad=0.1406p pd=1.12u as=0.3293p ps=1.63u w=0.74u l=0.13u
X3772 VSS.t1924 VDD VSS.t1926 VSS.t1925 sg13_lv_nmos ad=79.8f pd=0.8u as=0 ps=0 w=0.42u l=1u
X3773 VSS.t457 VDD VSS.t456 VSS.t19 sg13_lv_nmos ad=0.1428p pd=1.52u as=0 ps=0 w=0.42u l=1u
X3774 VSS.t867 VDD VSS.t869 VSS.t868 sg13_lv_nmos ad=79.8f pd=0.8u as=0 ps=0 w=0.42u l=1u
X3775 VDD VSS.t1606 VDD VDD sg13_lv_pmos ad=0.34p pd=2.68u as=0 ps=0 w=1u l=1u
X3776 VDD VSS.t592 VDD VDD sg13_lv_pmos ad=0.34p pd=2.68u as=0 ps=0 w=1u l=1u
X3777 VSS.t1637 VDD VSS.t1639 VSS.t1638 sg13_lv_nmos ad=79.8f pd=0.8u as=0 ps=0 w=0.42u l=1u
X3778 VSS.t2765 VDD VSS.t2766 VSS.t199 sg13_lv_nmos ad=79.8f pd=0.8u as=0 ps=0 w=0.42u l=1u
X3779 VSS.t1522 VDD VSS.t1521 VSS.t1520 sg13_lv_nmos ad=0.1428p pd=1.52u as=0 ps=0 w=0.42u l=1u
X3780 a_12524_15960# sg13cmos5l_dlygate4sd3_1_8.A VDD VDD sg13_lv_pmos ad=0.2856p pd=2.36u as=0.2114p ps=1.54u w=0.84u l=0.13u
X3781 VDD VSS.t1290 VDD VDD sg13_lv_pmos ad=0.19p pd=1.38u as=0 ps=0 w=1u l=1u
X3782 VSS.t2114 VDD VSS.t2116 VSS.t2115 sg13_lv_nmos ad=79.8f pd=0.8u as=0 ps=0 w=0.42u l=1u
X3783 a_17529_14037# a_16587_13844# a_17327_13799# VDD sg13_lv_pmos ad=93.45f pd=0.865u as=0.2048p ps=1.63u w=0.42u l=0.13u
X3784 VDD VSS.t1260 VDD VDD sg13_lv_pmos ad=0.34p pd=2.68u as=0 ps=0 w=1u l=1u
X3785 VDD VSS.t2766 VDD VDD sg13_lv_pmos ad=0.34p pd=2.68u as=0 ps=0 w=1u l=1u
X3786 VSS.t2331 VDD VSS.t2330 VSS.t2329 sg13_lv_nmos ad=0.1428p pd=1.52u as=0 ps=0 w=0.42u l=1u
X3787 VDD VSS.t2038 VDD VDD sg13_lv_pmos ad=0.34p pd=2.68u as=0 ps=0 w=1u l=1u
X3788 VSS.t403 VDD VSS.t399 VSS.t402 sg13_lv_nmos ad=0.1428p pd=1.52u as=0 ps=0 w=0.42u l=1u
X3789 VDD VSS.t623 VDD VDD sg13_lv_pmos ad=0.19p pd=1.38u as=0 ps=0 w=1u l=1u
X3790 VSS.t2780 VDD VSS.t2779 VSS.t199 sg13_lv_nmos ad=0.1428p pd=1.52u as=0 ps=0 w=0.42u l=1u
X3791 VSS.t29 a_10703_15311# a_11370_15532# VSS.t28 sg13_lv_nmos ad=0.1406p pd=1.12u as=0.2516p ps=2.16u w=0.74u l=0.13u
X3792 a_18789_15277# a_18789_15277# VSS.t19 VSS.t87 sg13_lv_nmos ad=0.111p pd=1.34u as=4.11262p ps=27.15u w=0.3u l=0.13u
X3793 VSS.t652 VDD VSS.t649 VSS.t651 sg13_lv_nmos ad=0.1428p pd=1.52u as=0 ps=0 w=0.42u l=1u
X3794 VDD VSS.t1956 VDD VDD sg13_lv_pmos ad=0.19p pd=1.38u as=0 ps=0 w=1u l=1u
X3795 VSS.t1999 VDD VSS.t2001 VSS.t2000 sg13_lv_nmos ad=79.8f pd=0.8u as=0 ps=0 w=0.42u l=1u
X3796 VSS.t460 VDD VSS.t461 VSS.t19 sg13_lv_nmos ad=79.8f pd=0.8u as=0 ps=0 w=0.42u l=1u
X3797 VSS.t1304 VDD VSS.t1303 VSS.t248 sg13_lv_nmos ad=0.1428p pd=1.52u as=0 ps=0 w=0.42u l=1u
X3798 VDD VSS.t1721 VDD VDD sg13_lv_pmos ad=0.34p pd=2.68u as=0 ps=0 w=1u l=1u
X3799 a_6346_14452# a_6789_14495# a_6086_14922# VSS.t78 sg13_lv_nmos ad=79.8f pd=0.8u as=0.1296p ps=1.52u w=0.42u l=0.13u
X3800 VDD VSS.t2303 VDD VDD sg13_lv_pmos ad=0.19p pd=1.38u as=0 ps=0 w=1u l=1u
X3801 VSS.t2521 VDD VSS.t2520 VSS.t2519 sg13_lv_nmos ad=0.1428p pd=1.52u as=0 ps=0 w=0.42u l=1u
X3802 VSS.t2341 VDD VSS.t2343 VSS.t2342 sg13_lv_nmos ad=79.8f pd=0.8u as=0 ps=0 w=0.42u l=1u
X3803 VDD VSS.t2141 VDD VDD sg13_lv_pmos ad=0.19p pd=1.38u as=0 ps=0 w=1u l=1u
X3804 VDD VSS.t2093 VDD VDD sg13_lv_pmos ad=0.34p pd=2.68u as=0 ps=0 w=1u l=1u
X3805 VSS.t1909 VDD VSS.t1911 VSS.t1910 sg13_lv_nmos ad=79.8f pd=0.8u as=0 ps=0 w=0.42u l=1u
X3806 VDD VSS.t3216 VDD VDD sg13_lv_pmos ad=0.19p pd=1.38u as=0 ps=0 w=1u l=1u
X3807 VDD VSS.t2731 VDD VDD sg13_lv_pmos ad=0.34p pd=2.68u as=0 ps=0 w=1u l=1u
X3808 VSS.t2774 VDD VSS.t2773 VSS.t199 sg13_lv_nmos ad=0.1428p pd=1.52u as=0 ps=0 w=0.42u l=1u
X3809 VSS.t548 VDD VSS.t548 VSS.t547 sg13_lv_nmos ad=0.1428p pd=1.52u as=0 ps=0 w=0.42u l=1u
X3810 VDD VSS.t931 VDD VDD sg13_lv_pmos ad=0.34p pd=2.68u as=0 ps=0 w=1u l=1u
X3811 VSS.t752 VDD VSS.t215 VSS.t751 sg13_lv_nmos ad=0.1428p pd=1.52u as=0 ps=0 w=0.42u l=1u
X3812 VSS.t2149 VDD VSS.t2151 VSS.t2150 sg13_lv_nmos ad=79.8f pd=0.8u as=0 ps=0 w=0.42u l=1u
X3813 VSS.t469 VDD VSS.t470 VSS.t19 sg13_lv_nmos ad=79.8f pd=0.8u as=0 ps=0 w=0.42u l=1u
X3814 VDD VSS.t1551 VDD VDD sg13_lv_pmos ad=0.34p pd=2.68u as=0 ps=0 w=1u l=1u
X3815 VDD VSS.t2460 VDD VDD sg13_lv_pmos ad=0.34p pd=2.68u as=0 ps=0 w=1u l=1u
X3816 VDD a_17126_15238# a_17238_15302# VDD sg13_lv_pmos ad=0.2254p pd=1.53u as=0.34p ps=2.68u w=1u l=0.5u
X3817 sg13cmos5l_dlygate4sd3_1_3.A a_4842_15532# VDD VDD sg13_lv_pmos ad=0.3808p pd=2.92u as=0.2128p ps=1.5u w=1.12u l=0.13u
X3818 VSS.t1652 VDD VSS.t1651 VSS.t1650 sg13_lv_nmos ad=0.1428p pd=1.52u as=0 ps=0 w=0.42u l=1u
X3819 VDD VSS.t2408 VDD VDD sg13_lv_pmos ad=0.19p pd=1.38u as=0 ps=0 w=1u l=1u
X3820 VSS.t2069 VDD VSS.t2068 VSS.t2067 sg13_lv_nmos ad=0.1428p pd=1.52u as=0 ps=0 w=0.42u l=1u
X3821 VSS.t2772 VDD VSS.t2772 VSS.t199 sg13_lv_nmos ad=0.1428p pd=1.52u as=0 ps=0 w=0.42u l=1u
X3822 VSS.t942 VDD VSS.t944 VSS.t943 sg13_lv_nmos ad=79.8f pd=0.8u as=0 ps=0 w=0.42u l=1u
X3823 VSS.t972 VDD VSS.t974 VSS.t973 sg13_lv_nmos ad=79.8f pd=0.8u as=0 ps=0 w=0.42u l=1u
X3824 VDD VSS.t1256 VDD VDD sg13_lv_pmos ad=0.34p pd=2.68u as=0 ps=0 w=1u l=1u
X3825 VDD VSS.t165 VDD VDD sg13_lv_pmos ad=0.34p pd=2.68u as=0 ps=0 w=1u l=1u
X3826 a_7631_14845# a_6789_14495# a_6372_14488# VDD sg13_lv_pmos ad=0.2048p pd=1.63u as=0.34p ps=2.68u w=1u l=0.13u
X3827 VDD VSS.t2126 VDD VDD sg13_lv_pmos ad=0.19p pd=1.38u as=0 ps=0 w=1u l=1u
X3828 sg13cmos5l_buf_8_2.X a_19323_13726# VSS.t747 VSS.t3236 sg13_lv_nmos ad=0.1406p pd=1.12u as=0.1406p ps=1.12u w=0.74u l=0.13u
X3829 VDD VSS.t1901 VDD VDD sg13_lv_pmos ad=0.19p pd=1.38u as=0 ps=0 w=1u l=1u
X3830 VDD VSS.t2690 VDD VDD sg13_lv_pmos ad=0.19p pd=1.38u as=0 ps=0 w=1u l=1u
X3831 VDD VSS.t2747 VDD VDD sg13_lv_pmos ad=0.19p pd=1.38u as=0 ps=0 w=1u l=1u
X3832 VSS.t1944 VDD VSS.t1946 VSS.t1945 sg13_lv_nmos ad=79.8f pd=0.8u as=0 ps=0 w=0.42u l=1u
X3833 VSS.t1582 VDD VSS.t1581 VSS.t1580 sg13_lv_nmos ad=0.1428p pd=1.52u as=0 ps=0 w=0.42u l=1u
X3834 VSS.t3104 VDD VSS.t3103 VSS.t3102 sg13_lv_nmos ad=0.1428p pd=1.52u as=0 ps=0 w=0.42u l=1u
X3835 VSS.t2316 VDD VSS.t2315 VSS.t2314 sg13_lv_nmos ad=0.1428p pd=1.52u as=0 ps=0 w=0.42u l=1u
X3836 VSS.t2486 VDD VSS.t2488 VSS.t2487 sg13_lv_nmos ad=79.8f pd=0.8u as=0 ps=0 w=0.42u l=1u
X3837 VDD VSS.t90 VDD VDD sg13_lv_pmos ad=0.34p pd=2.68u as=0 ps=0 w=1u l=1u
X3838 VDD VSS.t1294 VDD VDD sg13_lv_pmos ad=0.19p pd=1.38u as=0 ps=0 w=1u l=1u
X3839 VSS.t2391 VDD VSS.t2390 VSS.t2389 sg13_lv_nmos ad=0.1428p pd=1.52u as=0 ps=0 w=0.42u l=1u
X3840 VSS.t2756 VDD VSS.t2757 VSS.t199 sg13_lv_nmos ad=79.8f pd=0.8u as=0 ps=0 w=0.42u l=1u
X3841 VDD VSS.t2493 VDD VDD sg13_lv_pmos ad=0.19p pd=1.38u as=0 ps=0 w=1u l=1u
X3842 VSS.t56 a_21166_16263# sg13cmos5l_dfrbpq_1_6.D VSS.t55 sg13_lv_nmos ad=0.1426p pd=1.16u as=0.2516p ps=2.16u w=0.74u l=0.13u
X3843 VSS.t1243 VDD VSS.t1244 VSS.t248 sg13_lv_nmos ad=79.8f pd=0.8u as=0 ps=0 w=0.42u l=1u
X3844 counter_value_o[3] a_16552_15996# VDD VDD sg13_lv_pmos ad=0.42p pd=2.99u as=0.2114p ps=1.54u w=1.12u l=0.13u
X3845 a_25786_15960# sg13cmos5l_o21ai_1_3.Y VSS.t11 VSS.t119 sg13_lv_nmos ad=0.1428p pd=1.52u as=79.8f ps=0.8u w=0.42u l=0.13u
X3846 VDD VSS.t646 VDD VDD sg13_lv_pmos ad=0.19p pd=1.38u as=0 ps=0 w=1u l=1u
X3847 VSS.t2099 VDD VSS.t2101 VSS.t2100 sg13_lv_nmos ad=79.8f pd=0.8u as=0 ps=0 w=0.42u l=1u
X3848 VDD sg13cmos5l_o21ai_1_2.B1 sg13cmos5l_o21ai_1_2.Y VDD sg13_lv_pmos ad=0.3808p pd=2.92u as=0.2128p ps=1.5u w=1.12u l=0.15u
X3849 VDD VSS.t1253 VDD VDD sg13_lv_pmos ad=0.34p pd=2.68u as=0 ps=0 w=1u l=1u
X3850 VDD VSS.t2757 VDD VDD sg13_lv_pmos ad=0.34p pd=2.68u as=0 ps=0 w=1u l=1u
X3851 VSS.t2054 VDD VSS.t2053 VSS.t2052 sg13_lv_nmos ad=0.1428p pd=1.52u as=0 ps=0 w=0.42u l=1u
X3852 VSS.t2697 VDD VSS.t2699 VSS.t199 sg13_lv_nmos ad=79.8f pd=0.8u as=0 ps=0 w=0.42u l=1u
X3853 VDD a_18202_15202# a_17921_15424# VDD sg13_lv_pmos ad=0.1523p pd=1.38u as=0.34p ps=2.68u w=1u l=0.5u
X3854 VSS.t1331 VDD VSS.t1330 VSS.t248 sg13_lv_nmos ad=0.1428p pd=1.52u as=0 ps=0 w=0.42u l=1u
X3855 VDD VSS.t2118 VDD VDD sg13_lv_pmos ad=0.34p pd=2.68u as=0 ps=0 w=1u l=1u
X3856 VSS.t362 VDD VSS.t364 VSS.t363 sg13_lv_nmos ad=79.8f pd=0.8u as=0 ps=0 w=0.42u l=1u
X3857 VDD VSS.t1308 VDD VDD sg13_lv_pmos ad=0.34p pd=2.68u as=0 ps=0 w=1u l=1u
X3858 VDD VSS.t2809 VDD VDD sg13_lv_pmos ad=0.34p pd=2.68u as=0 ps=0 w=1u l=1u
X3859 VSS.t2506 VDD VSS.t2505 VSS.t2504 sg13_lv_nmos ad=0.1428p pd=1.52u as=0 ps=0 w=0.42u l=1u
X3860 VDD VSS.t1571 VDD VDD sg13_lv_pmos ad=0.34p pd=2.68u as=0 ps=0 w=1u l=1u
X3861 VDD VSS.t2288 VDD VDD sg13_lv_pmos ad=0.19p pd=1.38u as=0 ps=0 w=1u l=1u
X3862 VSS.t2920 VDD VSS.t2803 VSS.t199 sg13_lv_nmos ad=79.8f pd=0.8u as=0 ps=0 w=0.42u l=1u
X3863 VDD VSS.t2078 VDD VDD sg13_lv_pmos ad=0.34p pd=2.68u as=0 ps=0 w=1u l=1u
X3864 VSS.t1894 VDD VSS.t1896 VSS.t1895 sg13_lv_nmos ad=79.8f pd=0.8u as=0 ps=0 w=0.42u l=1u
X3865 VDD VSS.t839 VDD VDD sg13_lv_pmos ad=0.19p pd=1.38u as=0 ps=0 w=1u l=1u
X3866 VDD VSS.t1576 VDD VDD sg13_lv_pmos ad=0.34p pd=2.68u as=0 ps=0 w=1u l=1u
X3867 VDD VSS.t3201 VDD VDD sg13_lv_pmos ad=0.19p pd=1.38u as=0 ps=0 w=1u l=1u
X3868 VDD VSS.t2722 VDD VDD sg13_lv_pmos ad=0.34p pd=2.68u as=0 ps=0 w=1u l=1u
X3869 VSS.t927 VDD VSS.t926 VSS.t925 sg13_lv_nmos ad=0.1428p pd=1.52u as=0 ps=0 w=0.42u l=1u
X3870 a_26148_14040# a_26667_13844# a_27407_13799# VSS.t181 sg13_lv_nmos ad=0.3473p pd=2.71u as=0.12665p ps=1.145u w=0.74u l=0.13u
X3871 VSS.t2819 VDD VSS.t2818 VSS.t199 sg13_lv_nmos ad=0.1428p pd=1.52u as=0 ps=0 w=0.42u l=1u
X3872 VDD VSS.t1536 VDD VDD sg13_lv_pmos ad=0.34p pd=2.68u as=0 ps=0 w=1u l=1u
X3873 VDD VSS.t2445 VDD VDD sg13_lv_pmos ad=0.34p pd=2.68u as=0 ps=0 w=1u l=1u
X3874 VSS.t2336 VDD VSS.t2335 VSS.t2334 sg13_lv_nmos ad=0.1428p pd=1.52u as=0 ps=0 w=0.42u l=1u
X3875 VSS.t942 VDD VSS.t944 VSS.t943 sg13_lv_nmos ad=79.8f pd=0.8u as=0 ps=0 w=0.42u l=1u
X3876 VDD VSS.t550 VDD VDD sg13_lv_pmos ad=0.19p pd=1.38u as=0 ps=0 w=1u l=1u
X3877 VDD VSS.t1961 VDD VDD sg13_lv_pmos ad=0.19p pd=1.38u as=0 ps=0 w=1u l=1u
X3878 VSS.t2765 VDD VSS.t2764 VSS.t199 sg13_lv_nmos ad=0.1428p pd=1.52u as=0 ps=0 w=0.42u l=1u
X3879 VSS.t2004 VDD VSS.t2006 VSS.t2005 sg13_lv_nmos ad=79.8f pd=0.8u as=0 ps=0 w=0.42u l=1u
X3880 VDD VSS.t854 VDD VDD sg13_lv_pmos ad=0.19p pd=1.38u as=0 ps=0 w=1u l=1u
X3881 VSS.t1275 VDD VSS.t1276 VSS.t248 sg13_lv_nmos ad=79.8f pd=0.8u as=0 ps=0 w=0.42u l=1u
X3882 VDD VSS.t2280 VDD VDD sg13_lv_pmos ad=0.34p pd=2.68u as=0 ps=0 w=1u l=1u
X3883 VDD VSS.t118 VDD VDD sg13_lv_pmos ad=0.34p pd=2.68u as=0 ps=0 w=1u l=1u
X3884 VSS.t1240 VDD VSS.t1239 VSS.t248 sg13_lv_nmos ad=0.1428p pd=1.52u as=0 ps=0 w=0.42u l=1u
X3885 VDD VSS.t2681 VDD VDD sg13_lv_pmos ad=0.19p pd=1.38u as=0 ps=0 w=1u l=1u
X3886 VDD VSS.t432 VDD VDD sg13_lv_pmos ad=0.34p pd=2.68u as=0 ps=0 w=1u l=1u
X3887 VSS.t1567 VDD VSS.t1566 VSS.t1565 sg13_lv_nmos ad=0.1428p pd=1.52u as=0 ps=0 w=0.42u l=1u
X3888 VSS.t3089 VDD VSS.t3088 VSS.t3087 sg13_lv_nmos ad=0.1428p pd=1.52u as=0 ps=0 w=0.42u l=1u
X3889 VSS.t2301 VDD VSS.t2300 VSS.t2299 sg13_lv_nmos ad=0.1428p pd=1.52u as=0 ps=0 w=0.42u l=1u
X3890 VSS.t1914 VDD VSS.t1916 VSS.t1915 sg13_lv_nmos ad=79.8f pd=0.8u as=0 ps=0 w=0.42u l=1u
X3891 VSS.t102 a_27407_13799# a_28074_14020# VSS.t185 sg13_lv_nmos ad=0.1406p pd=1.12u as=0.2516p ps=2.16u w=0.74u l=0.13u
X3892 VSS.t1203 VDD VSS.t1204 VSS.t248 sg13_lv_nmos ad=79.8f pd=0.8u as=0 ps=0 w=0.42u l=1u
X3893 VSS.t399 VDD VSS.t399 VSS.t401 sg13_lv_nmos ad=79.8f pd=0.8u as=0 ps=0 w=0.42u l=1u
X3894 VSS.t162 sg13cmos5l_dlygate4sd3_1_8.X a_7829_15238# VSS.t246 sg13_lv_nmos ad=0.1898p pd=1.36u as=0.2516p ps=2.16u w=0.74u l=0.13u
X3895 VDD VSS.t1284 VDD VDD sg13_lv_pmos ad=0.19p pd=1.38u as=0 ps=0 w=1u l=1u
X3896 VDD VSS.t2786 VDD VDD sg13_lv_pmos ad=0.19p pd=1.38u as=0 ps=0 w=1u l=1u
X3897 VDD VSS.t676 VDD VDD sg13_lv_pmos ad=0.34p pd=2.68u as=0 ps=0 w=1u l=1u
X3898 VDD VSS.t1521 VDD VDD sg13_lv_pmos ad=0.34p pd=2.68u as=0 ps=0 w=1u l=1u
X3899 VSS.t2712 VDD VSS.t2714 VSS.t199 sg13_lv_nmos ad=79.8f pd=0.8u as=0 ps=0 w=0.42u l=1u
X3900 VDD VSS.t2430 VDD VDD sg13_lv_pmos ad=0.34p pd=2.68u as=0 ps=0 w=1u l=1u
X3901 VSS.t2491 VDD VSS.t2490 VSS.t2489 sg13_lv_nmos ad=0.1428p pd=1.52u as=0 ps=0 w=0.42u l=1u
X3902 VDD VSS.t455 VDD VDD sg13_lv_pmos ad=0.19p pd=1.38u as=0 ps=0 w=1u l=1u
X3903 VSS.t2321 VDD VSS.t2320 VSS.t2319 sg13_lv_nmos ad=0.1428p pd=1.52u as=0 ps=0 w=0.42u l=1u
X3904 VSS.t957 VDD VSS.t956 VSS.t955 sg13_lv_nmos ad=0.1428p pd=1.52u as=0 ps=0 w=0.42u l=1u
X3905 VDD VSS.t1941 VDD VDD sg13_lv_pmos ad=0.19p pd=1.38u as=0 ps=0 w=1u l=1u
X3906 VSS.t1657 VDD VSS.t1656 VSS.t1655 sg13_lv_nmos ad=0.1428p pd=1.52u as=0 ps=0 w=0.42u l=1u
X3907 VSS.t2039 VDD VSS.t2038 VSS.t2037 sg13_lv_nmos ad=0.1428p pd=1.52u as=0 ps=0 w=0.42u l=1u
X3908 VDD VSS.t1009 VDD VDD sg13_lv_pmos ad=0.19p pd=1.38u as=0 ps=0 w=1u l=1u
X3909 VSS.t1257 VDD VSS.t1256 VSS.t248 sg13_lv_nmos ad=0.1428p pd=1.52u as=0 ps=0 w=0.42u l=1u
X3910 VSS.t2775 VDD VSS.t2774 VSS.t199 sg13_lv_nmos ad=0.1428p pd=1.52u as=0 ps=0 w=0.42u l=1u
X3911 VDD VSS.t2348 VDD VDD sg13_lv_pmos ad=0.19p pd=1.38u as=0 ps=0 w=1u l=1u
X3912 VSS.t588 VDD VSS.t590 VSS.t589 sg13_lv_nmos ad=79.8f pd=0.8u as=0 ps=0 w=0.42u l=1u
X3913 VDD VSS.t421 VDD VDD sg13_lv_pmos ad=0.34p pd=2.68u as=0 ps=0 w=1u l=1u
X3914 VDD VSS.t1300 VDD VDD sg13_lv_pmos ad=0.34p pd=2.68u as=0 ps=0 w=1u l=1u
X3915 VDD VSS.t2103 VDD VDD sg13_lv_pmos ad=0.34p pd=2.68u as=0 ps=0 w=1u l=1u
X3916 VDD VSS.t2473 VDD VDD sg13_lv_pmos ad=0.19p pd=1.38u as=0 ps=0 w=1u l=1u
X3917 VDD VSS.t2131 VDD VDD sg13_lv_pmos ad=0.19p pd=1.38u as=0 ps=0 w=1u l=1u
X3918 VSS.t1954 VDD VSS.t1956 VSS.t1955 sg13_lv_nmos ad=79.8f pd=0.8u as=0 ps=0 w=0.42u l=1u
X3919 VDD VSS.t334 VDD VDD sg13_lv_pmos ad=0.34p pd=2.68u as=0 ps=0 w=1u l=1u
X3920 sg13cmos5l_and2_1_2.X a_8685_14832# VSS.t3 VSS.t236 sg13_lv_nmos ad=0.2516p pd=2.16u as=0.1331p ps=1.12u w=0.74u l=0.13u
X3921 VDD VSS.t1906 VDD VDD sg13_lv_pmos ad=0.19p pd=1.38u as=0 ps=0 w=1u l=1u
X3922 VDD VSS.t2750 VDD VDD sg13_lv_pmos ad=0.19p pd=1.38u as=0 ps=0 w=1u l=1u
X3923 VSS.t673 VDD VSS.t673 VSS.t674 sg13_lv_nmos ad=79.8f pd=0.8u as=0 ps=0 w=0.42u l=1u
X3924 VSS.t1587 VDD VSS.t1586 VSS.t1585 sg13_lv_nmos ad=0.1428p pd=1.52u as=0 ps=0 w=0.42u l=1u
X3925 VSS.t2794 VDD VSS.t2795 VSS.t199 sg13_lv_nmos ad=79.8f pd=0.8u as=0 ps=0 w=0.42u l=1u
X3926 VDD VSS.t2672 VDD VDD sg13_lv_pmos ad=0.19p pd=1.38u as=0 ps=0 w=1u l=1u
X3927 VSS.t2286 VDD VSS.t2285 VSS.t2284 sg13_lv_nmos ad=0.1428p pd=1.52u as=0 ps=0 w=0.42u l=1u
X3928 sg13cmos5l_a21oi_1_3.Y sg13cmos5l_a21oi_1_3.A1 a_25203_13320# VSS.t32 sg13_lv_nmos ad=0.1406p pd=1.12u as=0.1406p ps=1.12u w=0.74u l=0.13u
X3929 VSS.t927 VDD VSS.t926 VSS.t925 sg13_lv_nmos ad=0.1428p pd=1.52u as=0 ps=0 w=0.42u l=1u
X3930 VSS.t1293 VDD VSS.t1294 VSS.t248 sg13_lv_nmos ad=79.8f pd=0.8u as=0 ps=0 w=0.42u l=1u
X3931 VSS.t47 VDD VSS.t47 VSS.t426 sg13_lv_nmos ad=79.8f pd=0.8u as=0 ps=0 w=0.42u l=1u
X3932 VSS.t487 VDD VSS.t488 VSS.t19 sg13_lv_nmos ad=79.8f pd=0.8u as=0 ps=0 w=0.42u l=1u
X3933 VDD VSS.t742 VDD VDD sg13_lv_pmos ad=0.19p pd=1.38u as=0 ps=0 w=1u l=1u
X3934 VDD VSS.t884 VDD VDD sg13_lv_pmos ad=0.19p pd=1.38u as=0 ps=0 w=1u l=1u
X3935 VDD VSS.t1561 VDD VDD sg13_lv_pmos ad=0.34p pd=2.68u as=0 ps=0 w=1u l=1u
X3936 a_18202_15202# sg13cmos5l_dfrbpq_1_2.Q VDD VDD sg13_lv_pmos ad=0.1428p pd=1.52u as=0.1523p ps=1.38u w=0.42u l=0.13u
X3937 sg13cmos5l_buf_8_2.A a_15579_14854# VSS.t90 VSS.t150 sg13_lv_nmos ad=0.1406p pd=1.12u as=0.1406p ps=1.12u w=0.74u l=0.13u
X3938 VSS.t620 VDD VSS.t9 VSS.t738 sg13_lv_nmos ad=0.1428p pd=1.52u as=0 ps=0 w=0.42u l=1u
X3939 VSS.t2361 VDD VSS.t2360 VSS.t2359 sg13_lv_nmos ad=0.1428p pd=1.52u as=0 ps=0 w=0.42u l=1u
X3940 VSS.t2724 VDD VSS.t2726 VSS.t199 sg13_lv_nmos ad=79.8f pd=0.8u as=0 ps=0 w=0.42u l=1u
X3941 VDD VSS.t323 VDD VDD sg13_lv_pmos ad=0.34p pd=2.68u as=0 ps=0 w=1u l=1u
X3942 VSS.t263 sg13cmos5l_or3_1_1.B a_16168_15996# VSS.t262 sg13_lv_nmos ad=0.14875p pd=1.16u as=0.187p ps=1.78u w=0.55u l=0.13u
X3943 a_23736_14464# sg13cmos5l_or3_1_2.B VDD VDD sg13_lv_pmos ad=0.2128p pd=1.5u as=0.3808p ps=2.92u w=1.12u l=0.15u
X3944 VDD VSS.t643 VDD VDD sg13_lv_pmos ad=0.34p pd=2.68u as=0 ps=0 w=1u l=1u
X3945 VDD VSS.t1769 VDD VDD sg13_lv_pmos ad=0.19p pd=1.38u as=0 ps=0 w=1u l=1u
X3946 VDD VSS.t3056 VDD VDD sg13_lv_pmos ad=0.19p pd=1.38u as=0 ps=0 w=1u l=1u
X3947 VSS.t2792 VDD VSS.t2793 VSS.t199 sg13_lv_nmos ad=79.8f pd=0.8u as=0 ps=0 w=0.42u l=1u
X3948 VDD VSS.t550 VDD VDD sg13_lv_pmos ad=0.19p pd=1.38u as=0 ps=0 w=1u l=1u
X3949 VDD VSS.t976 VDD VDD sg13_lv_pmos ad=0.34p pd=2.68u as=0 ps=0 w=1u l=1u
X3950 a_24935_14020# sg13cmos5l_or3_1_1.C a_24841_13726# VDD sg13_lv_pmos ad=0.19p pd=1.38u as=0.34p ps=2.68u w=1u l=0.13u
X3951 VSS.t548 VDD VSS.t548 VSS.t547 sg13_lv_nmos ad=0.1428p pd=1.52u as=0 ps=0 w=0.42u l=1u
X3952 VSS.t2700 VDD VSS.t2702 VSS.t199 sg13_lv_nmos ad=79.8f pd=0.8u as=0 ps=0 w=0.42u l=1u
X3953 VDD VSS.t2123 VDD VDD sg13_lv_pmos ad=0.34p pd=2.68u as=0 ps=0 w=1u l=1u
X3954 VDD VSS.t1291 VDD VDD sg13_lv_pmos ad=0.34p pd=2.68u as=0 ps=0 w=1u l=1u
X3955 VDD VSS.t2793 VDD VDD sg13_lv_pmos ad=0.34p pd=2.68u as=0 ps=0 w=1u l=1u
X3956 VSS.t3074 VDD VSS.t3076 VSS.t3075 sg13_lv_nmos ad=79.8f pd=0.8u as=0 ps=0 w=0.42u l=1u
X3957 VDD VSS.t386 VDD VDD sg13_lv_pmos ad=0.19p pd=1.38u as=0 ps=0 w=1u l=1u
X3958 a_2890_15457# a_3333_15213# a_2630_15234# VSS.t241 sg13_lv_nmos ad=79.8f pd=0.8u as=0.1296p ps=1.52u w=0.42u l=0.13u
X3959 VDD VSS.t473 VDD VDD sg13_lv_pmos ad=0.19p pd=1.38u as=0 ps=0 w=1u l=1u
X3960 a_22030_15423# a_22145_15424# VSS.t98 VSS.t97 sg13_lv_nmos ad=0.1428p pd=1.52u as=0.1426p ps=1.16u w=0.42u l=0.5u
X3961 VDD VSS.t354 VDD VDD sg13_lv_pmos ad=0.19p pd=1.38u as=0 ps=0 w=1u l=1u
X3962 VSS.t682 VDD VSS.t809 VSS.t808 sg13_lv_nmos ad=0.1428p pd=1.52u as=0 ps=0 w=0.42u l=1u
X3963 VDD VSS.t2293 VDD VDD sg13_lv_pmos ad=0.19p pd=1.38u as=0 ps=0 w=1u l=1u
X3964 VDD VSS.t1039 VDD VDD sg13_lv_pmos ad=0.19p pd=1.38u as=0 ps=0 w=1u l=1u
X3965 VDD VSS.t2083 VDD VDD sg13_lv_pmos ad=0.34p pd=2.68u as=0 ps=0 w=1u l=1u
X3966 VSS.t469 VDD VSS.t468 VSS.t19 sg13_lv_nmos ad=0.1428p pd=1.52u as=0 ps=0 w=0.42u l=1u
X3967 VSS.t627 VDD VSS.t627 VSS.t628 sg13_lv_nmos ad=0.1428p pd=1.52u as=0 ps=0 w=0.42u l=1u
X3968 VSS.t1899 VDD VSS.t1901 VSS.t1900 sg13_lv_nmos ad=79.8f pd=0.8u as=0 ps=0 w=0.42u l=1u
X3969 VSS.t643 VDD VSS.t646 VSS.t783 sg13_lv_nmos ad=79.8f pd=0.8u as=0 ps=0 w=0.42u l=1u
X3970 VDD VSS.t1581 VDD VDD sg13_lv_pmos ad=0.34p pd=2.68u as=0 ps=0 w=1u l=1u
X3971 VDD VSS.t3206 VDD VDD sg13_lv_pmos ad=0.19p pd=1.38u as=0 ps=0 w=1u l=1u
X3972 VSS.t2699 VDD VSS.t2700 VSS.t199 sg13_lv_nmos ad=79.8f pd=0.8u as=0 ps=0 w=0.42u l=1u
X3973 VSS.t384 VDD VSS.t122 VSS.t383 sg13_lv_nmos ad=0.1428p pd=1.52u as=0 ps=0 w=0.42u l=1u
X3974 a_21477_14495# sg13cmos5l_buf_8_2.X VDD VDD sg13_lv_pmos ad=0.4088p pd=2.97u as=2.3367p ps=15.135u w=1.12u l=0.13u
X3975 VDD VSS.t270 VDD VDD sg13_lv_pmos ad=0.34p pd=2.68u as=0 ps=0 w=1u l=1u
X3976 VDD VSS.t1918 VDD VDD sg13_lv_pmos ad=0.34p pd=2.68u as=0 ps=0 w=1u l=1u
X3977 VDD VSS.t2756 VDD VDD sg13_lv_pmos ad=0.34p pd=2.68u as=0 ps=0 w=1u l=1u
X3978 VSS.t957 VDD VSS.t956 VSS.t955 sg13_lv_nmos ad=0.1428p pd=1.52u as=0 ps=0 w=0.42u l=1u
X3979 VSS.t2920 VDD VSS.t2802 VSS.t199 sg13_lv_nmos ad=0.1428p pd=1.52u as=0 ps=0 w=0.42u l=1u
X3980 VDD VSS.t630 VDD VDD sg13_lv_pmos ad=0.19p pd=1.38u as=0 ps=0 w=1u l=1u
X3981 VDD VSS.t939 VDD VDD sg13_lv_pmos ad=0.19p pd=1.38u as=0 ps=0 w=1u l=1u
X3982 VSS.t627 VDD VSS.t625 VSS.t754 sg13_lv_nmos ad=0.1428p pd=1.52u as=0 ps=0 w=0.42u l=1u
X3983 VSS.t2306 VDD VSS.t2305 VSS.t2304 sg13_lv_nmos ad=0.1428p pd=1.52u as=0 ps=0 w=0.42u l=1u
X3984 VSS.t1451 VDD VSS.t1315 VSS.t248 sg13_lv_nmos ad=0.1428p pd=1.52u as=0 ps=0 w=0.42u l=1u
X3985 VDD VSS.t1332 VDD VDD sg13_lv_pmos ad=0.19p pd=1.38u as=0 ps=0 w=1u l=1u
X3986 VSS.t1642 VDD VSS.t1641 VSS.t1640 sg13_lv_nmos ad=0.1428p pd=1.52u as=0 ps=0 w=0.42u l=1u
X3987 VSS.t2691 VDD VSS.t2693 VSS.t199 sg13_lv_nmos ad=79.8f pd=0.8u as=0 ps=0 w=0.42u l=1u
X3988 VSS.t2767 VDD VSS.t2767 VSS.t199 sg13_lv_nmos ad=0.1428p pd=1.52u as=0 ps=0 w=0.42u l=1u
X3989 VDD VSS.t2510 VDD VDD sg13_lv_pmos ad=0.34p pd=2.68u as=0 ps=0 w=1u l=1u
X3990 VSS.t2009 VDD VSS.t2011 VSS.t2010 sg13_lv_nmos ad=79.8f pd=0.8u as=0 ps=0 w=0.42u l=1u
X3991 VDD VSS.t2708 VDD VDD sg13_lv_pmos ad=0.19p pd=1.38u as=0 ps=0 w=1u l=1u
X3992 VSS.t2346 VDD VSS.t2345 VSS.t2344 sg13_lv_nmos ad=0.1428p pd=1.52u as=0 ps=0 w=0.42u l=1u
X3993 a_6682_13690# sg13cmos5l_dlygate4sd3_1_0.A VDD VDD sg13_lv_pmos ad=0.1428p pd=1.52u as=0.1523p ps=1.38u w=0.42u l=0.13u
X3994 VDD VSS.t661 VDD VDD sg13_lv_pmos ad=0.34p pd=2.68u as=0 ps=0 w=1u l=1u
X3995 VDD VSS.t876 VDD VDD sg13_lv_pmos ad=0.34p pd=2.68u as=0 ps=0 w=1u l=1u
X3996 VDD VSS.t3001 VDD VDD sg13_lv_pmos ad=0.19p pd=1.38u as=0 ps=0 w=1u l=1u
X3997 VSS.t1359 VDD VSS.t1358 VSS.t248 sg13_lv_nmos ad=0.1428p pd=1.52u as=0 ps=0 w=0.42u l=1u
X3998 VDD VSS.t2458 VDD VDD sg13_lv_pmos ad=0.19p pd=1.38u as=0 ps=0 w=1u l=1u
X3999 VDD VSS.t2116 VDD VDD sg13_lv_pmos ad=0.19p pd=1.38u as=0 ps=0 w=1u l=1u
X4000 VSS.t2119 VDD VSS.t2118 VSS.t2117 sg13_lv_nmos ad=0.1428p pd=1.52u as=0 ps=0 w=0.42u l=1u
X4001 VDD VSS.t814 VDD VDD sg13_lv_pmos ad=0.19p pd=1.38u as=0 ps=0 w=1u l=1u
X4002 VDD VSS.t440 VDD VDD sg13_lv_pmos ad=0.34p pd=2.68u as=0 ps=0 w=1u l=1u
X4003 VSS.t92 VDD VSS.t92 VSS.t764 sg13_lv_nmos ad=0.1428p pd=1.52u as=0 ps=0 w=0.42u l=1u
X4004 VDD VSS.t1891 VDD VDD sg13_lv_pmos ad=0.19p pd=1.38u as=0 ps=0 w=1u l=1u
X4005 VDD VSS.t2410 VDD VDD sg13_lv_pmos ad=0.34p pd=2.68u as=0 ps=0 w=1u l=1u
X4006 VSS.t1572 VDD VSS.t1571 VSS.t1570 sg13_lv_nmos ad=0.1428p pd=1.52u as=0 ps=0 w=0.42u l=1u
X4007 VSS.t45 VDD VSS.t403 VSS.t407 sg13_lv_nmos ad=0.1428p pd=1.52u as=0 ps=0 w=0.42u l=1u
X4008 VDD VSS.t595 VDD VDD sg13_lv_pmos ad=0.19p pd=1.38u as=0 ps=0 w=1u l=1u
X4009 VDD VSS.t443 VDD VDD sg13_lv_pmos ad=0.34p pd=2.68u as=0 ps=0 w=1u l=1u
X4010 VSS.t503 VDD VSS.t29 VSS.t504 sg13_lv_nmos ad=79.8f pd=0.8u as=0 ps=0 w=0.42u l=1u
X4011 VDD VSS.t929 VDD VDD sg13_lv_pmos ad=0.19p pd=1.38u as=0 ps=0 w=1u l=1u
X4012 VDD VSS.t1986 VDD VDD sg13_lv_pmos ad=0.19p pd=1.38u as=0 ps=0 w=1u l=1u
X4013 VDD VSS.t1225 VDD VDD sg13_lv_pmos ad=0.34p pd=2.68u as=0 ps=0 w=1u l=1u
X4014 VDD a_7631_14845# a_7888_14726# VDD sg13_lv_pmos ad=2.42015p pd=15.68u as=79.8f ps=0.8u w=0.42u l=0.13u
X4015 VSS.t661 VDD VSS.t664 VSS.t795 sg13_lv_nmos ad=79.8f pd=0.8u as=0 ps=0 w=0.42u l=1u
X4016 VSS.t2931 VDD VSS.t2812 VSS.t199 sg13_lv_nmos ad=0.1428p pd=1.52u as=0 ps=0 w=0.42u l=1u
X4017 VSS.t2716 VDD VSS.t2717 VSS.t199 sg13_lv_nmos ad=79.8f pd=0.8u as=0 ps=0 w=0.42u l=1u
X4018 VDD VSS.t1699 VDD VDD sg13_lv_pmos ad=0.19p pd=1.38u as=0 ps=0 w=1u l=1u
X4019 sg13cmos5l_dlygate4sd3_1_1.A a_8298_14484# VDD VDD sg13_lv_pmos ad=0.3808p pd=2.92u as=0.2128p ps=1.5u w=1.12u l=0.13u
X4020 VDD VSS.t1754 VDD VDD sg13_lv_pmos ad=0.19p pd=1.38u as=0 ps=0 w=1u l=1u
X4021 VDD VSS.t2353 VDD VDD sg13_lv_pmos ad=0.19p pd=1.38u as=0 ps=0 w=1u l=1u
X4022 a_17710_16263# a_17825_16262# VSS.t197 VSS.t196 sg13_lv_nmos ad=0.1428p pd=1.52u as=0.1426p ps=1.16u w=0.42u l=0.5u
X4023 VDD VSS.t2478 VDD VDD sg13_lv_pmos ad=0.19p pd=1.38u as=0 ps=0 w=1u l=1u
X4024 VDD VSS.t2136 VDD VDD sg13_lv_pmos ad=0.19p pd=1.38u as=0 ps=0 w=1u l=1u
X4025 VSS.t1959 VDD VSS.t1961 VSS.t1960 sg13_lv_nmos ad=79.8f pd=0.8u as=0 ps=0 w=0.42u l=1u
X4026 VSS.t837 VDD VSS.t839 VSS.t838 sg13_lv_nmos ad=79.8f pd=0.8u as=0 ps=0 w=0.42u l=1u
X4027 VDD VSS.t2675 VDD VDD sg13_lv_pmos ad=0.19p pd=1.38u as=0 ps=0 w=1u l=1u
X4028 VSS.t2291 VDD VSS.t2290 VSS.t2289 sg13_lv_nmos ad=0.1428p pd=1.52u as=0 ps=0 w=0.42u l=1u
X4029 VSS.t11 a_25390_16263# sg13cmos5l_a21oi_1_2.A1 VSS.t10 sg13_lv_nmos ad=0.1426p pd=1.16u as=0.2516p ps=2.16u w=0.74u l=0.13u
X4030 a_24310_15230# sg13cmos5l_or3_1_1.C VSS.t276 VSS.t48 sg13_lv_nmos ad=0.1406p pd=1.12u as=0.1406p ps=1.12u w=0.74u l=0.15u
X4031 VDD VSS.t896 VDD VDD sg13_lv_pmos ad=0.34p pd=2.68u as=0 ps=0 w=1u l=1u
X4032 VSS.t3079 VDD VSS.t3078 VSS.t3077 sg13_lv_nmos ad=0.1428p pd=1.52u as=0 ps=0 w=0.42u l=1u
X4033 VSS.t2461 VDD VSS.t2463 VSS.t2462 sg13_lv_nmos ad=79.8f pd=0.8u as=0 ps=0 w=0.42u l=1u
X4034 sg13cmos5l_dlygate4sd3_1_8.A a_11370_15532# VSS.t29 VSS.t3262 sg13_lv_nmos ad=0.2516p pd=2.16u as=0.1406p ps=1.12u w=0.74u l=0.13u
X4035 VDD VSS.t1566 VDD VDD sg13_lv_pmos ad=0.34p pd=2.68u as=0 ps=0 w=1u l=1u
X4036 VSS.t2690 VDD VSS.t2691 VSS.t199 sg13_lv_nmos ad=79.8f pd=0.8u as=0 ps=0 w=0.42u l=1u
X4037 sg13cmos5l_or3_1_1.B a_14261_15238# VDD VDD sg13_lv_pmos ad=0.2128p pd=1.5u as=0.203p ps=1.5u w=1.12u l=0.13u
X4038 VSS.t165 sg13cmos5l_buf_1_0.X a_2646_14842# VSS.t282 sg13_lv_nmos ad=0.15245p pd=1.17u as=88.8f ps=0.98u w=0.74u l=0.13u
X4039 a_6660_14909# a_6891_14495# a_6346_14452# VSS.t78 sg13_lv_nmos ad=0.2373p pd=1.97u as=79.8f ps=0.8u w=0.42u l=0.13u
X4040 VDD VSS.t649 VDD VDD sg13_lv_pmos ad=0.19p pd=1.38u as=0 ps=0 w=1u l=1u
X4041 VSS.t1254 VDD VSS.t1255 VSS.t248 sg13_lv_nmos ad=79.8f pd=0.8u as=0 ps=0 w=0.42u l=1u
X4042 VSS.t2366 VDD VSS.t2365 VSS.t2364 sg13_lv_nmos ad=0.1428p pd=1.52u as=0 ps=0 w=0.42u l=1u
X4043 VSS.t105 a_26565_13701# a_26667_13844# VSS.t202 sg13_lv_nmos ad=15.38618p pd=0.10091m as=0.2516p ps=2.16u w=0.74u l=0.13u
X4044 VSS.t646 VDD VSS.t643 VSS.t645 sg13_lv_nmos ad=0.1428p pd=1.52u as=0 ps=0 w=0.42u l=1u
X4045 VSS.t1627 VDD VSS.t1629 VSS.t1628 sg13_lv_nmos ad=79.8f pd=0.8u as=0 ps=0 w=0.42u l=1u
X4046 VDD VSS.t1903 VDD VDD sg13_lv_pmos ad=0.34p pd=2.68u as=0 ps=0 w=1u l=1u
X4047 sg13cmos5l_and2_1_1.X a_5613_14832# VSS.t114 VSS.t127 sg13_lv_nmos ad=0.2516p pd=2.16u as=0.1331p ps=1.12u w=0.74u l=0.13u
X4048 VDD VSS.t633 VDD VDD sg13_lv_pmos ad=0.19p pd=1.38u as=0 ps=0 w=1u l=1u
X4049 VDD VSS.t2748 VDD VDD sg13_lv_pmos ad=0.34p pd=2.68u as=0 ps=0 w=1u l=1u
X4050 VSS.t742 sg13cmos5l_buf_8_2.A a_19323_13726# VSS.t3286 sg13_lv_nmos ad=0.1406p pd=1.12u as=0.2553p ps=2.17u w=0.74u l=0.13u
X4051 VSS.t932 VDD VSS.t931 VSS.t930 sg13_lv_nmos ad=0.1428p pd=1.52u as=0 ps=0 w=0.42u l=1u
X4052 VDD VSS.t3061 VDD VDD sg13_lv_pmos ad=0.19p pd=1.38u as=0 ps=0 w=1u l=1u
X4053 VSS.t2795 VDD VSS.t2796 VSS.t199 sg13_lv_nmos ad=79.8f pd=0.8u as=0 ps=0 w=0.42u l=1u
X4054 VDD VSS.t1931 VDD VDD sg13_lv_pmos ad=0.19p pd=1.38u as=0 ps=0 w=1u l=1u
X4055 VSS.t1259 VDD VSS.t1260 VSS.t248 sg13_lv_nmos ad=79.8f pd=0.8u as=0 ps=0 w=0.42u l=1u
X4056 VSS.t852 VDD VSS.t854 VSS.t853 sg13_lv_nmos ad=79.8f pd=0.8u as=0 ps=0 w=0.42u l=1u
X4057 a_25390_16263# a_25505_16262# VSS.t11 VSS.t3279 sg13_lv_nmos ad=0.1428p pd=1.52u as=0.1426p ps=1.16u w=0.42u l=0.5u
X4058 VSS.t2683 VDD VSS.t2684 VSS.t199 sg13_lv_nmos ad=79.8f pd=0.8u as=0 ps=0 w=0.42u l=1u
X4059 VDD VSS.t2495 VDD VDD sg13_lv_pmos ad=0.34p pd=2.68u as=0 ps=0 w=1u l=1u
X4060 VSS.t1994 VDD VSS.t1996 VSS.t1995 sg13_lv_nmos ad=79.8f pd=0.8u as=0 ps=0 w=0.42u l=1u
X4061 VDD VSS.t1294 VDD VDD sg13_lv_pmos ad=0.34p pd=2.68u as=0 ps=0 w=1u l=1u
X4062 VDD VSS.t2796 VDD VDD sg13_lv_pmos ad=0.34p pd=2.68u as=0 ps=0 w=1u l=1u
X4063 VDD a_19323_13726# sg13cmos5l_buf_8_2.X VDD sg13_lv_pmos ad=0.2128p pd=1.5u as=0.2128p ps=1.5u w=1.12u l=0.13u
X4064 VDD VSS.t2298 VDD VDD sg13_lv_pmos ad=0.19p pd=1.38u as=0 ps=0 w=1u l=1u
X4065 VDD VSS.t859 VDD VDD sg13_lv_pmos ad=0.19p pd=1.38u as=0 ps=0 w=1u l=1u
X4066 VDD VSS.t2395 VDD VDD sg13_lv_pmos ad=0.34p pd=2.68u as=0 ps=0 w=1u l=1u
X4067 VDD clock_i a_15579_14854# VDD sg13_lv_pmos ad=0.2128p pd=1.5u as=0.2128p ps=1.5u w=1.12u l=0.13u
X4068 VDD VSS.t595 VDD VDD sg13_lv_pmos ad=0.19p pd=1.38u as=0 ps=0 w=1u l=1u
X4069 VSS.t2481 VDD VSS.t2483 VSS.t2482 sg13_lv_nmos ad=79.8f pd=0.8u as=0 ps=0 w=0.42u l=1u
X4070 VSS.t1904 VDD VSS.t1906 VSS.t1905 sg13_lv_nmos ad=79.8f pd=0.8u as=0 ps=0 w=0.42u l=1u
X4071 a_7822_13911# a_7937_13912# VSS.t50 VSS.t206 sg13_lv_nmos ad=0.1428p pd=1.52u as=0.1426p ps=1.16u w=0.42u l=0.5u
X4072 VSS.t588 VDD VSS.t590 VSS.t589 sg13_lv_nmos ad=79.8f pd=0.8u as=0 ps=0 w=0.42u l=1u
X4073 VSS.t2681 VDD VSS.t2682 VSS.t199 sg13_lv_nmos ad=79.8f pd=0.8u as=0 ps=0 w=0.42u l=1u
X4074 VDD VSS.t1363 VDD VDD sg13_lv_pmos ad=0.19p pd=1.38u as=0 ps=0 w=1u l=1u
X4075 VDD VSS.t2148 VDD VDD sg13_lv_pmos ad=0.34p pd=2.68u as=0 ps=0 w=1u l=1u
X4076 VDD VSS.t1971 VDD VDD sg13_lv_pmos ad=0.19p pd=1.38u as=0 ps=0 w=1u l=1u
X4077 a_6286_13911# a_6401_13912# VSS.t17 VSS.t291 sg13_lv_nmos ad=0.1428p pd=1.52u as=0.1426p ps=1.16u w=0.42u l=0.5u
X4078 VSS.t47 VDD VSS.t47 VSS.t428 sg13_lv_nmos ad=0.1428p pd=1.52u as=0 ps=0 w=0.42u l=1u
X4079 sg13cmos5l_nand3_1_0.Y sg13cmos5l_buf_1_0.X a_6680_15242# VSS.t280 sg13_lv_nmos ad=0.2516p pd=2.16u as=0.1406p ps=1.12u w=0.74u l=0.13u
X4080 VDD VSS.t1923 VDD VDD sg13_lv_pmos ad=0.34p pd=2.68u as=0 ps=0 w=1u l=1u
X4081 VDD VSS.t2758 VDD VDD sg13_lv_pmos ad=0.34p pd=2.68u as=0 ps=0 w=1u l=1u
X4082 VSS.t1206 VDD VSS.t1207 VSS.t248 sg13_lv_nmos ad=79.8f pd=0.8u as=0 ps=0 w=0.42u l=1u
X4083 VSS.t2923 VDD VSS.t2804 VSS.t199 sg13_lv_nmos ad=0.1428p pd=1.52u as=0 ps=0 w=0.42u l=1u
X4084 VDD VSS.t2682 VDD VDD sg13_lv_pmos ad=0.34p pd=2.68u as=0 ps=0 w=1u l=1u
X4085 VDD VSS.t2096 VDD VDD sg13_lv_pmos ad=0.19p pd=1.38u as=0 ps=0 w=1u l=1u
X4086 VDD a_2540_15960# counter_value_o[0] VDD sg13_lv_pmos ad=0.2114p pd=1.54u as=0.42p ps=2.99u w=1.12u l=0.13u
X4087 VSS.t1007 VDD VSS.t1009 VSS.t1008 sg13_lv_nmos ad=79.8f pd=0.8u as=0 ps=0 w=0.42u l=1u
X4088 VSS.t2939 VDD VSS.t2941 VSS.t2940 sg13_lv_nmos ad=79.8f pd=0.8u as=0 ps=0 w=0.42u l=1u
X4089 sg13cmos5l_dlygate4sd3_1_1.A a_8298_14484# VSS.t160 VSS.t220 sg13_lv_nmos ad=0.2516p pd=2.16u as=0.1406p ps=1.12u w=0.74u l=0.13u
X4090 VDD VSS.t1076 VDD VDD sg13_lv_pmos ad=0.34p pd=2.68u as=0 ps=0 w=1u l=1u
X4091 VSS.t1767 VDD VSS.t1769 VSS.t1768 sg13_lv_nmos ad=79.8f pd=0.8u as=0 ps=0 w=0.42u l=1u
X4092 VSS.t466 VDD VSS.t467 VSS.t19 sg13_lv_nmos ad=79.8f pd=0.8u as=0 ps=0 w=0.42u l=1u
X4093 VDD VSS.t682 VDD VDD sg13_lv_pmos ad=0.19p pd=1.38u as=0 ps=0 w=1u l=1u
X4094 VSS.t2770 VDD VSS.t2769 VSS.t199 sg13_lv_nmos ad=0.1428p pd=1.52u as=0 ps=0 w=0.42u l=1u
X4095 VDD VSS.t2515 VDD VDD sg13_lv_pmos ad=0.34p pd=2.68u as=0 ps=0 w=1u l=1u
X4096 VSS.t1979 VDD VSS.t1981 VSS.t1980 sg13_lv_nmos ad=79.8f pd=0.8u as=0 ps=0 w=0.42u l=1u
X4097 VSS.t676 VDD VSS.t676 VSS.t804 sg13_lv_nmos ad=0.1428p pd=1.52u as=0 ps=0 w=0.42u l=1u
X4098 VSS.t440 VDD VSS.t440 VSS.t439 sg13_lv_nmos ad=0.1428p pd=1.52u as=0 ps=0 w=0.42u l=1u
X4099 VDD VSS.t731 VDD VDD sg13_lv_pmos ad=0.34p pd=2.68u as=0 ps=0 w=1u l=1u
X4100 VDD VSS.t2121 VDD VDD sg13_lv_pmos ad=0.19p pd=1.38u as=0 ps=0 w=1u l=1u
X4101 VSS.t2124 VDD VSS.t2123 VSS.t2122 sg13_lv_nmos ad=0.1428p pd=1.52u as=0 ps=0 w=0.42u l=1u
X4102 sg13cmos5l_o21ai_1_2.Y sg13cmos5l_o21ai_1_2.B1 a_23638_14862# VSS.t0 sg13_lv_nmos ad=0.2516p pd=2.16u as=0.1406p ps=1.12u w=0.74u l=0.15u
X4103 VSS.t837 VDD VSS.t839 VSS.t838 sg13_lv_nmos ad=79.8f pd=0.8u as=0 ps=0 w=0.42u l=1u
X4104 VDD VSS.t826 VDD VDD sg13_lv_pmos ad=0.34p pd=2.68u as=0 ps=0 w=1u l=1u
X4105 VDD VSS.t1609 VDD VDD sg13_lv_pmos ad=0.19p pd=1.38u as=0 ps=0 w=1u l=1u
X4106 VSS.t31 VDD VSS.t31 VSS.t331 sg13_lv_nmos ad=0.1428p pd=1.52u as=0 ps=0 w=0.42u l=1u
X4107 VSS.t593 VDD VSS.t595 VSS.t594 sg13_lv_nmos ad=79.8f pd=0.8u as=0 ps=0 w=0.42u l=1u
X4108 VDD VSS.t47 VDD VDD sg13_lv_pmos ad=0.34p pd=2.68u as=0 ps=0 w=1u l=1u
X4109 VSS.t1215 VDD VSS.t1216 VSS.t248 sg13_lv_nmos ad=79.8f pd=0.8u as=0 ps=0 w=0.42u l=1u
X4110 VSS.t2276 VDD VSS.t2275 VSS.t2274 sg13_lv_nmos ad=0.1428p pd=1.52u as=0 ps=0 w=0.42u l=1u
X4111 VSS.t1889 VDD VSS.t1891 VSS.t1890 sg13_lv_nmos ad=79.8f pd=0.8u as=0 ps=0 w=0.42u l=1u
X4112 VDD VSS.t1343 VDD VDD sg13_lv_pmos ad=0.34p pd=2.68u as=0 ps=0 w=1u l=1u
X4113 VDD VSS.t1215 VDD VDD sg13_lv_pmos ad=0.19p pd=1.38u as=0 ps=0 w=1u l=1u
X4114 VSS.t673 VDD VSS.t670 VSS.t672 sg13_lv_nmos ad=0.1428p pd=1.52u as=0 ps=0 w=0.42u l=1u
X4115 VSS.t1637 VDD VSS.t1636 VSS.t1635 sg13_lv_nmos ad=0.1428p pd=1.52u as=0 ps=0 w=0.42u l=1u
X4116 VSS.t3159 VDD VSS.t3158 VSS.t3157 sg13_lv_nmos ad=0.1428p pd=1.52u as=0 ps=0 w=0.42u l=1u
X4117 VSS.t2351 VDD VSS.t2350 VSS.t2349 sg13_lv_nmos ad=0.1428p pd=1.52u as=0 ps=0 w=0.42u l=1u
X4118 a_1965_14832# sg13cmos5l_buf_1_10.X VDD VDD sg13_lv_pmos ad=0.1596p pd=1.22u as=0.2856p ps=2.36u w=0.84u l=0.13u
X4119 VSS.t932 VDD VSS.t931 VSS.t930 sg13_lv_nmos ad=0.1428p pd=1.52u as=0 ps=0 w=0.42u l=1u
X4120 VDD VSS.t2310 VDD VDD sg13_lv_pmos ad=0.34p pd=2.68u as=0 ps=0 w=1u l=1u
X4121 a_25094_15238# a_24824_15238# VSS.t1 VSS.t48 sg13_lv_nmos ad=0.1428p pd=1.52u as=79.8f ps=0.8u w=0.42u l=0.5u
X4122 VSS.t2718 VDD VSS.t2720 VSS.t199 sg13_lv_nmos ad=79.8f pd=0.8u as=0 ps=0 w=0.42u l=1u
X4123 VSS.t977 VDD VSS.t976 VSS.t975 sg13_lv_nmos ad=0.1428p pd=1.52u as=0 ps=0 w=0.42u l=1u
X4124 VSS.t852 VDD VSS.t854 VSS.t853 sg13_lv_nmos ad=79.8f pd=0.8u as=0 ps=0 w=0.42u l=1u
X4125 VSS.t1286 VDD VSS.t1287 VSS.t248 sg13_lv_nmos ad=79.8f pd=0.8u as=0 ps=0 w=0.42u l=1u
X4126 VDD VSS.t1759 VDD VDD sg13_lv_pmos ad=0.19p pd=1.38u as=0 ps=0 w=1u l=1u
X4127 VDD VSS.t3046 VDD VDD sg13_lv_pmos ad=0.19p pd=1.38u as=0 ps=0 w=1u l=1u
X4128 VSS.t2786 VDD VSS.t2787 VSS.t199 sg13_lv_nmos ad=79.8f pd=0.8u as=0 ps=0 w=0.42u l=1u
X4129 VDD VSS.t1916 VDD VDD sg13_lv_pmos ad=0.19p pd=1.38u as=0 ps=0 w=1u l=1u
X4130 VSS.t1919 VDD VSS.t1918 VSS.t1917 sg13_lv_nmos ad=0.1428p pd=1.52u as=0 ps=0 w=0.42u l=1u
X4131 VSS.t1632 VDD VSS.t1631 VSS.t1630 sg13_lv_nmos ad=0.1428p pd=1.52u as=0 ps=0 w=0.42u l=1u
X4132 VDD sg13cmos5l_dfrbpq_1_2.RESET_B a_15782_13722# VDD sg13_lv_pmos ad=0.36237p pd=2.605u as=79.8f ps=0.8u w=0.42u l=0.13u
X4133 VSS.t77 sg13cmos5l_or3_1_1.A a_24841_13726# VSS.t278 sg13_lv_nmos ad=0.13395p pd=1.12u as=0.198p ps=1.27u w=0.55u l=0.13u
X4134 VSS.t2762 VDD VSS.t2761 VSS.t199 sg13_lv_nmos ad=0.1428p pd=1.52u as=0 ps=0 w=0.42u l=1u
X4135 VSS.t2159 VDD VSS.t2158 VSS.t2157 sg13_lv_nmos ad=0.1428p pd=1.52u as=0 ps=0 w=0.42u l=1u
X4136 VDD VSS.t1285 VDD VDD sg13_lv_pmos ad=0.34p pd=2.68u as=0 ps=0 w=1u l=1u
X4137 VDD VSS.t2787 VDD VDD sg13_lv_pmos ad=0.34p pd=2.68u as=0 ps=0 w=1u l=1u
X4138 VDD VSS.t2448 VDD VDD sg13_lv_pmos ad=0.19p pd=1.38u as=0 ps=0 w=1u l=1u
X4139 VDD sg13cmos5l_a21oi_1_3.A2 a_25109_12972# VDD sg13_lv_pmos ad=0.2128p pd=1.5u as=0.3808p ps=2.92u w=1.12u l=0.13u
X4140 VSS.t1037 VDD VSS.t1039 VSS.t1038 sg13_lv_nmos ad=79.8f pd=0.8u as=0 ps=0 w=0.42u l=1u
X4141 VDD VSS.t2106 VDD VDD sg13_lv_pmos ad=0.19p pd=1.38u as=0 ps=0 w=1u l=1u
X4142 a_18021_14495# sg13cmos5l_buf_8_2.X VDD VDD sg13_lv_pmos ad=0.4088p pd=2.97u as=2.3367p ps=15.135u w=1.12u l=0.13u
X4143 VSS.t1305 VDD VSS.t1306 VSS.t248 sg13_lv_nmos ad=79.8f pd=0.8u as=0 ps=0 w=0.42u l=1u
X4144 VDD VSS.t2283 VDD VDD sg13_lv_pmos ad=0.19p pd=1.38u as=0 ps=0 w=1u l=1u
X4145 VDD VSS.t904 VDD VDD sg13_lv_pmos ad=0.19p pd=1.38u as=0 ps=0 w=1u l=1u
X4146 VSS.t2704 VDD VSS.t2703 VSS.t199 sg13_lv_nmos ad=0.1428p pd=1.52u as=0 ps=0 w=0.42u l=1u
X4147 VSS.t2466 VDD VSS.t2468 VSS.t2467 sg13_lv_nmos ad=79.8f pd=0.8u as=0 ps=0 w=0.42u l=1u
X4148 VDD VSS.t1571 VDD VDD sg13_lv_pmos ad=0.34p pd=2.68u as=0 ps=0 w=1u l=1u
X4149 VDD a_17710_16263# sg13cmos5l_a21oi_1_0.A1 VDD sg13_lv_pmos ad=0.2254p pd=1.53u as=0.4256p ps=3u w=1.12u l=0.13u
X4150 a_10703_15311# a_9861_15213# a_9444_15552# VDD sg13_lv_pmos ad=0.2048p pd=1.63u as=0.34p ps=2.68u w=1u l=0.13u
X4151 VDD VSS.t1554 VDD VDD sg13_lv_pmos ad=0.19p pd=1.38u as=0 ps=0 w=1u l=1u
X4152 VSS.t2672 VDD VSS.t2673 VSS.t199 sg13_lv_nmos ad=79.8f pd=0.8u as=0 ps=0 w=0.42u l=1u
X4153 VDD VSS.t359 VDD VDD sg13_lv_pmos ad=0.19p pd=1.38u as=0 ps=0 w=1u l=1u
X4154 VDD a_15671_15315# a_15671_15549# VDD sg13_lv_pmos ad=2.8961p pd=18.25u as=0.2442p ps=2.06u w=0.66u l=0.13u
X4155 VDD VSS.t39 VDD VDD sg13_lv_pmos ad=0.34p pd=2.68u as=0 ps=0 w=1u l=1u
X4156 VSS.t2371 VDD VSS.t2370 VSS.t2369 sg13_lv_nmos ad=0.1428p pd=1.52u as=0 ps=0 w=0.42u l=1u
X4157 VDD VSS.t2133 VDD VDD sg13_lv_pmos ad=0.34p pd=2.68u as=0 ps=0 w=1u l=1u
X4158 a_16068_14040# a_16042_13945# VSS.t59 VSS.t136 sg13_lv_nmos ad=0.2516p pd=2.16u as=0.1626p ps=1.415u w=0.74u l=0.13u
X4159 VDD VSS.t1277 VDD VDD sg13_lv_pmos ad=0.34p pd=2.68u as=0 ps=0 w=1u l=1u
X4160 VDD VSS.t1908 VDD VDD sg13_lv_pmos ad=0.34p pd=2.68u as=0 ps=0 w=1u l=1u
X4161 VSS.t1007 VDD VSS.t1009 VSS.t1008 sg13_lv_nmos ad=79.8f pd=0.8u as=0 ps=0 w=0.42u l=1u
X4162 VDD VSS.t996 VDD VDD sg13_lv_pmos ad=0.34p pd=2.68u as=0 ps=0 w=1u l=1u
X4163 VDD VSS.t2673 VDD VDD sg13_lv_pmos ad=0.34p pd=2.68u as=0 ps=0 w=1u l=1u
X4164 VDD VSS.t2751 VDD VDD sg13_lv_pmos ad=0.34p pd=2.68u as=0 ps=0 w=1u l=1u
X4165 a_10960_15454# a_10703_15311# a_11122_15234# VSS.t27 sg13_lv_nmos ad=0.1428p pd=1.52u as=37.8f ps=0.6u w=0.42u l=0.13u
X4166 VDD VSS.t3066 VDD VDD sg13_lv_pmos ad=0.19p pd=1.38u as=0 ps=0 w=1u l=1u
X4167 VDD VSS.t1936 VDD VDD sg13_lv_pmos ad=0.19p pd=1.38u as=0 ps=0 w=1u l=1u
X4168 VSS.t1752 VDD VSS.t1754 VSS.t1753 sg13_lv_nmos ad=79.8f pd=0.8u as=0 ps=0 w=0.42u l=1u
X4169 VDD VSS.t485 VDD VDD sg13_lv_pmos ad=0.19p pd=1.38u as=0 ps=0 w=1u l=1u
X4170 VSS.t2144 VDD VSS.t2143 VSS.t2142 sg13_lv_nmos ad=0.1428p pd=1.52u as=0 ps=0 w=0.42u l=1u
X4171 VDD VSS.t2098 VDD VDD sg13_lv_pmos ad=0.34p pd=2.68u as=0 ps=0 w=1u l=1u
X4172 VDD VSS.t1205 VDD VDD sg13_lv_pmos ad=0.34p pd=2.68u as=0 ps=0 w=1u l=1u
X4173 VDD sg13cmos5l_or3_1_1.A sg13cmos5l_o21ai_1_3.Y VDD sg13_lv_pmos ad=0.3808p pd=2.92u as=0.2128p ps=1.5u w=1.12u l=0.15u
X4174 VDD VSS.t1059 VDD VDD sg13_lv_pmos ad=0.19p pd=1.38u as=0 ps=0 w=1u l=1u
X4175 VSS.t1454 VDD VSS.t1320 VSS.t248 sg13_lv_nmos ad=79.8f pd=0.8u as=0 ps=0 w=0.42u l=1u
X4176 VSS.t13 sg13cmos5l_dfrbpq_1_3.RESET_B a_17412_14922# VSS.t111 sg13_lv_nmos ad=0.1626p pd=1.415u as=60.89999f ps=0.71u w=0.42u l=0.13u
X4177 VSS.t1622 VDD VSS.t1624 VSS.t1623 sg13_lv_nmos ad=79.8f pd=0.8u as=0 ps=0 w=0.42u l=1u
X4178 VDD VSS.t2400 VDD VDD sg13_lv_pmos ad=0.34p pd=2.68u as=0 ps=0 w=1u l=1u
X4179 a_21251_13690# sg13cmos5l_or3_1_2.C a_21549_14020# VDD sg13_lv_pmos ad=0.34p pd=2.68u as=0.19p ps=1.38u w=1u l=0.13u
X4180 VSS.t45 a_32492_15960# counter_value_o[6] VSS.t109 sg13_lv_nmos ad=0.14875p pd=1.16u as=0.2886p ps=2.26u w=0.74u l=0.13u
X4181 VSS.t927 VDD VSS.t929 VSS.t928 sg13_lv_nmos ad=79.8f pd=0.8u as=0 ps=0 w=0.42u l=1u
X4182 VSS.t1492 VDD VSS.t1494 VSS.t1493 sg13_lv_nmos ad=79.8f pd=0.8u as=0 ps=0 w=0.42u l=1u
X4183 VSS.t2684 VDD VSS.t2685 VSS.t199 sg13_lv_nmos ad=79.8f pd=0.8u as=0 ps=0 w=0.42u l=1u
X4184 a_21070_15423# a_21185_15424# VSS.t23 VSS.t273 sg13_lv_nmos ad=0.1428p pd=1.52u as=0.1426p ps=1.16u w=0.42u l=0.5u
X4185 VDD VSS.t432 VDD VDD sg13_lv_pmos ad=0.34p pd=2.68u as=0 ps=0 w=1u l=1u
X4186 VDD VSS.t774 VDD VDD sg13_lv_pmos ad=0.19p pd=1.38u as=0 ps=0 w=1u l=1u
X4187 VDD VSS.t1976 VDD VDD sg13_lv_pmos ad=0.19p pd=1.38u as=0 ps=0 w=1u l=1u
X4188 sg13cmos5l_and2_1_2.B a_8694_15302# VDD VDD sg13_lv_pmos ad=0.4256p pd=3u as=0.2254p ps=1.53u w=1.12u l=0.13u
X4189 VSS.t977 VDD VSS.t976 VSS.t975 sg13_lv_nmos ad=0.1428p pd=1.52u as=0 ps=0 w=0.42u l=1u
X4190 VDD VSS.t1206 VDD VDD sg13_lv_pmos ad=0.19p pd=1.38u as=0 ps=0 w=1u l=1u
X4191 VDD VSS.t2295 VDD VDD sg13_lv_pmos ad=0.34p pd=2.68u as=0 ps=0 w=1u l=1u
X4192 a_7923_15532# sg13cmos5l_dlygate4sd3_1_8.X VDD VDD sg13_lv_pmos ad=0.1428p pd=1.375u as=0.2891p ps=1.695u w=1.12u l=0.13u
X4193 VDD VSS.t1893 VDD VDD sg13_lv_pmos ad=0.34p pd=2.68u as=0 ps=0 w=1u l=1u
X4194 VSS.t2808 VDD VSS.t2807 VSS.t199 sg13_lv_nmos ad=0.1428p pd=1.52u as=0 ps=0 w=0.42u l=1u
X4195 VDD VSS.t2685 VDD VDD sg13_lv_pmos ad=0.34p pd=2.68u as=0 ps=0 w=1u l=1u
X4196 VDD VSS.t2780 VDD VDD sg13_lv_pmos ad=0.19p pd=1.38u as=0 ps=0 w=1u l=1u
X4197 VDD sg13cmos5l_o21ai_1_2.B1 a_24365_14508# VDD sg13_lv_pmos ad=0.3822p pd=1.84u as=0.1575p ps=1.315u w=1u l=0.13u
X4198 VSS.t92 sg13cmos5l_a21oi_1_3.B1 sg13cmos5l_a21oi_1_3.Y VSS.t91 sg13_lv_nmos ad=0.2516p pd=2.16u as=0.1406p ps=1.12u w=0.74u l=0.13u
X4199 VDD VSS.t3208 VDD VDD sg13_lv_pmos ad=0.34p pd=2.68u as=0 ps=0 w=1u l=1u
X4200 a_27502_15423# a_27617_15424# VDD VDD sg13_lv_pmos ad=0.34p pd=2.68u as=0.2254p ps=1.53u w=1u l=0.5u
X4201 VDD VSS.t465 VDD VDD sg13_lv_pmos ad=0.34p pd=2.68u as=0 ps=0 w=1u l=1u
X4202 VSS.t197 sg13cmos5l_or3_1_2.B a_16969_16020# VSS.t3242 sg13_lv_nmos ad=0.1045p pd=0.93u as=0.187p ps=1.78u w=0.55u l=0.13u
X4203 VDD VSS.t455 VDD VDD sg13_lv_pmos ad=0.19p pd=1.38u as=0 ps=0 w=1u l=1u
X4204 VDD VSS.t105 VDD VDD sg13_lv_pmos ad=0.19p pd=1.38u as=0 ps=0 w=1u l=1u
X4205 VDD VSS.t673 VDD VDD sg13_lv_pmos ad=0.34p pd=2.68u as=0 ps=0 w=1u l=1u
X4206 VSS.t2754 VDD VSS.t2753 VSS.t199 sg13_lv_nmos ad=0.1428p pd=1.52u as=0 ps=0 w=0.42u l=1u
X4207 VSS.t1037 VDD VSS.t1039 VSS.t1038 sg13_lv_nmos ad=79.8f pd=0.8u as=0 ps=0 w=0.42u l=1u
X4208 VDD VSS.t1295 VDD VDD sg13_lv_pmos ad=0.34p pd=2.68u as=0 ps=0 w=1u l=1u
X4209 a_32492_15960# sg13cmos5l_dfrbpq_1_7.Q VSS.t45 VSS.t44 sg13_lv_nmos ad=0.187p pd=1.78u as=0.14875p ps=1.16u w=0.55u l=0.13u
X4210 VDD a_27034_15202# a_26753_15424# VDD sg13_lv_pmos ad=0.1523p pd=1.38u as=0.34p ps=2.68u w=1u l=0.5u
X4211 VDD VSS.t834 VDD VDD sg13_lv_pmos ad=0.19p pd=1.38u as=0 ps=0 w=1u l=1u
X4212 VDD VSS.t1026 VDD VDD sg13_lv_pmos ad=0.34p pd=2.68u as=0 ps=0 w=1u l=1u
X4213 VSS.t266 sg13cmos5l_or3_1_2.B a_23638_14862# VSS.t0 sg13_lv_nmos ad=0.1406p pd=1.12u as=0.2516p ps=2.16u w=0.74u l=0.15u
X4214 VSS.t1712 VDD VSS.t1711 VSS.t1710 sg13_lv_nmos ad=0.1428p pd=1.52u as=0 ps=0 w=0.42u l=1u
X4215 VDD VSS.t2433 VDD VDD sg13_lv_pmos ad=0.19p pd=1.38u as=0 ps=0 w=1u l=1u
X4216 VSS.t102 VDD VSS.t102 VSS.t778 sg13_lv_nmos ad=0.1428p pd=1.52u as=0 ps=0 w=0.42u l=1u
X4217 VDD VSS.t1614 VDD VDD sg13_lv_pmos ad=0.19p pd=1.38u as=0 ps=0 w=1u l=1u
X4218 VSS.t2708 VDD VSS.t2709 VSS.t199 sg13_lv_nmos ad=79.8f pd=0.8u as=0 ps=0 w=0.42u l=1u
X4219 VDD VSS.t1948 VDD VDD sg13_lv_pmos ad=0.34p pd=2.68u as=0 ps=0 w=1u l=1u
X4220 VSS.t313 VDD VSS.t315 VSS.t314 sg13_lv_nmos ad=79.8f pd=0.8u as=0 ps=0 w=0.42u l=1u
X4221 VSS.t897 VDD VSS.t896 VSS.t895 sg13_lv_nmos ad=0.1428p pd=1.52u as=0 ps=0 w=0.42u l=1u
X4222 VDD a_10960_15454# a_10905_15549# VDD sg13_lv_pmos ad=2.8961p pd=18.25u as=93.45f ps=0.865u w=0.42u l=0.13u
X4223 VDD VSS.t949 VDD VDD sg13_lv_pmos ad=0.19p pd=1.38u as=0 ps=0 w=1u l=1u
X4224 VSS.t2694 VDD VSS.t2694 VSS.t199 sg13_lv_nmos ad=0.1428p pd=1.52u as=0 ps=0 w=0.42u l=1u
X4225 VDD VSS.t2745 VDD VDD sg13_lv_pmos ad=0.19p pd=1.38u as=0 ps=0 w=1u l=1u
X4226 VSS.t2014 VDD VSS.t2013 VSS.t2012 sg13_lv_nmos ad=0.1428p pd=1.52u as=0 ps=0 w=0.42u l=1u
X4227 VSS.t347 VDD VSS.t349 VSS.t348 sg13_lv_nmos ad=79.8f pd=0.8u as=0 ps=0 w=0.42u l=1u
X4228 VSS.t443 VDD VSS.t443 VSS.t513 sg13_lv_nmos ad=79.8f pd=0.8u as=0 ps=0 w=0.42u l=1u
X4229 VDD VSS.t1236 VDD VDD sg13_lv_pmos ad=0.34p pd=2.68u as=0 ps=0 w=1u l=1u
X4230 VSS.t2356 VDD VSS.t2355 VSS.t2354 sg13_lv_nmos ad=0.1428p pd=1.52u as=0 ps=0 w=0.42u l=1u
X4231 a_2540_15960# sg13cmos5l_dlygate4sd3_1_3.A VSS.t287 VSS.t286 sg13_lv_nmos ad=0.187p pd=1.78u as=0.14875p ps=1.16u w=0.55u l=0.13u
X4232 VSS.t673 VDD VSS.t676 VSS.t803 sg13_lv_nmos ad=79.8f pd=0.8u as=0 ps=0 w=0.42u l=1u
X4233 VDD VSS.t2315 VDD VDD sg13_lv_pmos ad=0.34p pd=2.68u as=0 ps=0 w=1u l=1u
X4234 VSS.t2546 VDD VSS.t2548 VSS.t2547 sg13_lv_nmos ad=79.8f pd=0.8u as=0 ps=0 w=0.42u l=1u
X4235 VSS.t2722 VDD VSS.t2723 VSS.t199 sg13_lv_nmos ad=79.8f pd=0.8u as=0 ps=0 w=0.42u l=1u
X4236 VDD VSS.t2488 VDD VDD sg13_lv_pmos ad=0.19p pd=1.38u as=0 ps=0 w=1u l=1u
X4237 VDD VSS.t652 VDD VDD sg13_lv_pmos ad=0.19p pd=1.38u as=0 ps=0 w=1u l=1u
X4238 VDD VSS.t824 VDD VDD sg13_lv_pmos ad=0.19p pd=1.38u as=0 ps=0 w=1u l=1u
X4239 VSS.t1257 VDD VSS.t1257 VSS.t248 sg13_lv_nmos ad=79.8f pd=0.8u as=0 ps=0 w=0.42u l=1u
X4240 VDD VSS.t3051 VDD VDD sg13_lv_pmos ad=0.19p pd=1.38u as=0 ps=0 w=1u l=1u
X4241 VDD VSS.t1921 VDD VDD sg13_lv_pmos ad=0.19p pd=1.38u as=0 ps=0 w=1u l=1u
X4242 VSS.t1924 VDD VSS.t1923 VSS.t1922 sg13_lv_nmos ad=0.1428p pd=1.52u as=0 ps=0 w=0.42u l=1u
X4243 VSS.t451 VDD VSS.t452 VSS.t19 sg13_lv_nmos ad=79.8f pd=0.8u as=0 ps=0 w=0.42u l=1u
X4244 VSS.t2094 VDD VSS.t2096 VSS.t2095 sg13_lv_nmos ad=79.8f pd=0.8u as=0 ps=0 w=0.42u l=1u
X4245 VDD VSS.t989 VDD VDD sg13_lv_pmos ad=0.19p pd=1.38u as=0 ps=0 w=1u l=1u
X4246 VDD VSS.t1769 VDD VDD sg13_lv_pmos ad=0.19p pd=1.38u as=0 ps=0 w=1u l=1u
X4247 VDD VSS.t637 VDD VDD sg13_lv_pmos ad=0.19p pd=1.38u as=0 ps=0 w=1u l=1u
X4248 VDD VSS.t1288 VDD VDD sg13_lv_pmos ad=0.34p pd=2.68u as=0 ps=0 w=1u l=1u
X4249 VDD VSS.t2790 VDD VDD sg13_lv_pmos ad=0.34p pd=2.68u as=0 ps=0 w=1u l=1u
X4250 VDD VSS.t2453 VDD VDD sg13_lv_pmos ad=0.19p pd=1.38u as=0 ps=0 w=1u l=1u
X4251 VSS.t857 VDD VSS.t859 VSS.t858 sg13_lv_nmos ad=79.8f pd=0.8u as=0 ps=0 w=0.42u l=1u
X4252 VDD a_27500_15960# counter_value_o[5] VDD sg13_lv_pmos ad=0.2114p pd=1.54u as=0.42p ps=2.99u w=1.12u l=0.13u
X4253 VSS.t927 VDD VSS.t929 VSS.t928 sg13_lv_nmos ad=79.8f pd=0.8u as=0 ps=0 w=0.42u l=1u
X4254 VSS.t2959 VDD VSS.t2958 VSS.t2957 sg13_lv_nmos ad=0.1428p pd=1.52u as=0 ps=0 w=0.42u l=1u
X4255 VDD VSS.t473 VDD VDD sg13_lv_pmos ad=0.19p pd=1.38u as=0 ps=0 w=1u l=1u
X4256 a_26436_13735# a_26667_13844# a_26122_13945# VSS.t180 sg13_lv_nmos ad=0.2373p pd=1.97u as=79.8f ps=0.8u w=0.42u l=0.13u
X4257 a_26374_13735# sg13cmos5l_dfrbpq_1_5.RESET_B VSS.t34 VSS.t37 sg13_lv_nmos ad=37.8f pd=0.6u as=0.1701p ps=1.65u w=0.42u l=0.13u
X4258 VDD VSS.t916 VDD VDD sg13_lv_pmos ad=0.34p pd=2.68u as=0 ps=0 w=1u l=1u
X4259 VSS.t1607 VDD VSS.t1609 VSS.t1608 sg13_lv_nmos ad=79.8f pd=0.8u as=0 ps=0 w=0.42u l=1u
X4260 VSS.t1266 VDD VSS.t1266 VSS.t248 sg13_lv_nmos ad=79.8f pd=0.8u as=0 ps=0 w=0.42u l=1u
X4261 VSS.t339 VDD VSS.t339 VSS.t344 sg13_lv_nmos ad=79.8f pd=0.8u as=0 ps=0 w=0.42u l=1u
X4262 VSS.t59 sg13cmos5l_dfrbpq_1_2.RESET_B a_15876_13722# VSS.t58 sg13_lv_nmos ad=0.1626p pd=1.415u as=60.89999f ps=0.71u w=0.42u l=0.13u
X4263 VSS.t655 VDD VSS.t655 VSS.t790 sg13_lv_nmos ad=0.1428p pd=1.52u as=0 ps=0 w=0.42u l=1u
X4264 VDD VSS.t661 VDD VDD sg13_lv_pmos ad=0.19p pd=1.38u as=0 ps=0 w=1u l=1u
X4265 VSS.t2675 VDD VSS.t2676 VSS.t199 sg13_lv_nmos ad=79.8f pd=0.8u as=0 ps=0 w=0.42u l=1u
X4266 VSS.t19 a_27472_14726# a_27121_14845# VSS.t19 sg13_lv_nmos ad=79.8f pd=0.8u as=0.1428p ps=1.52u w=0.42u l=0.13u
X4267 VDD VSS.t2480 VDD VDD sg13_lv_pmos ad=0.34p pd=2.68u as=0 ps=0 w=1u l=1u
X4268 VDD VSS.t2138 VDD VDD sg13_lv_pmos ad=0.34p pd=2.68u as=0 ps=0 w=1u l=1u
X4269 VSS.t2531 VDD VSS.t2533 VSS.t2532 sg13_lv_nmos ad=79.8f pd=0.8u as=0 ps=0 w=0.42u l=1u
X4270 a_8582_15238# a_8312_15238# VSS.t160 VSS.t3225 sg13_lv_nmos ad=0.1428p pd=1.52u as=79.8f ps=0.8u w=0.42u l=0.5u
X4271 sg13cmos5l_buf_8_2.X a_19323_13726# VDD VDD sg13_lv_pmos ad=0.2128p pd=1.5u as=0.2128p ps=1.5u w=1.12u l=0.13u
X4272 VSS.t593 VDD VSS.t595 VSS.t594 sg13_lv_nmos ad=79.8f pd=0.8u as=0 ps=0 w=0.42u l=1u
X4273 VSS.t1231 VDD VSS.t1230 VSS.t248 sg13_lv_nmos ad=0.1428p pd=1.52u as=0 ps=0 w=0.42u l=1u
X4274 VSS.t1271 VDD VSS.t1272 VSS.t248 sg13_lv_nmos ad=79.8f pd=0.8u as=0 ps=0 w=0.42u l=1u
X4275 VDD VSS.t2828 VDD VDD sg13_lv_pmos ad=0.34p pd=2.68u as=0 ps=0 w=1u l=1u
X4276 a_15870_15486# a_15671_15549# VSS.t19 VSS.t166 sg13_lv_nmos ad=0.27427p pd=2.28u as=4.11262p ps=27.15u w=0.795u l=0.13u
X4277 VDD VSS.t3036 VDD VDD sg13_lv_pmos ad=0.19p pd=1.38u as=0 ps=0 w=1u l=1u
X4278 VDD VSS.t105 VDD VDD sg13_lv_pmos ad=0.19p pd=1.38u as=0 ps=0 w=1u l=1u
X4279 VDD VSS.t1366 VDD VDD sg13_lv_pmos ad=0.19p pd=1.38u as=0 ps=0 w=1u l=1u
X4280 a_27472_14726# a_27215_14845# a_27634_14922# VSS.t19 sg13_lv_nmos ad=0.1428p pd=1.52u as=37.8f ps=0.6u w=0.42u l=0.13u
X4281 VSS.t1757 VDD VSS.t1759 VSS.t1758 sg13_lv_nmos ad=79.8f pd=0.8u as=0 ps=0 w=0.42u l=1u
X4282 a_12010_15202# sg13cmos5l_buf_8_2.A VSS.t305 VSS.t3283 sg13_lv_nmos ad=0.1406p pd=1.12u as=0.1406p ps=1.12u w=0.74u l=0.13u
X4283 VSS.t827 VDD VSS.t826 VSS.t825 sg13_lv_nmos ad=0.1428p pd=1.52u as=0 ps=0 w=0.42u l=1u
X4284 VSS.t2730 VDD VSS.t2730 VSS.t199 sg13_lv_nmos ad=0.1428p pd=1.52u as=0 ps=0 w=0.42u l=1u
X4285 VSS.t897 VDD VSS.t896 VSS.t895 sg13_lv_nmos ad=0.1428p pd=1.52u as=0 ps=0 w=0.42u l=1u
X4286 VDD VSS.t1599 VDD VDD sg13_lv_pmos ad=0.19p pd=1.38u as=0 ps=0 w=1u l=1u
X4287 VSS.t2798 VDD VSS.t2797 VSS.t199 sg13_lv_nmos ad=0.1428p pd=1.52u as=0 ps=0 w=0.42u l=1u
X4288 VDD VSS.t1933 VDD VDD sg13_lv_pmos ad=0.34p pd=2.68u as=0 ps=0 w=1u l=1u
X4289 VSS.t2064 VDD VSS.t2066 VSS.t2065 sg13_lv_nmos ad=79.8f pd=0.8u as=0 ps=0 w=0.42u l=1u
X4290 a_26122_13945# a_26565_13701# a_26505_14113# VDD sg13_lv_pmos ad=79.8f pd=0.8u as=63f ps=0.72u w=0.42u l=0.13u
X4291 VDD VSS.t994 VDD VDD sg13_lv_pmos ad=0.19p pd=1.38u as=0 ps=0 w=1u l=1u
X4292 VSS.t1249 VDD VSS.t1248 VSS.t248 sg13_lv_nmos ad=0.1428p pd=1.52u as=0 ps=0 w=0.42u l=1u
X4293 VDD VSS.t2465 VDD VDD sg13_lv_pmos ad=0.34p pd=2.68u as=0 ps=0 w=1u l=1u
X4294 VSS.t1552 VDD VSS.t1554 VSS.t1553 sg13_lv_nmos ad=79.8f pd=0.8u as=0 ps=0 w=0.42u l=1u
X4295 VSS.t1406 VDD VSS.t1253 VSS.t248 sg13_lv_nmos ad=0.1428p pd=1.52u as=0 ps=0 w=0.42u l=1u
X4296 VDD VSS.t2300 VDD VDD sg13_lv_pmos ad=0.34p pd=2.68u as=0 ps=0 w=1u l=1u
X4297 VDD VSS.t1898 VDD VDD sg13_lv_pmos ad=0.34p pd=2.68u as=0 ps=0 w=1u l=1u
X4298 VDD VSS.t2746 VDD VDD sg13_lv_pmos ad=0.34p pd=2.68u as=0 ps=0 w=1u l=1u
X4299 VDD sg13cmos5l_dfrbpq_1_0.RESET_B a_2890_15457# VDD sg13_lv_pmos ad=0.1563p pd=1.22u as=0.147p ps=1.54u w=0.42u l=0.13u
X4300 a_21251_13690# sg13cmos5l_or3_1_2.A VSS.t215 VSS.t292 sg13_lv_nmos ad=0.198p pd=1.27u as=0.13395p ps=1.12u w=0.55u l=0.13u
X4301 VSS.t1284 VDD VSS.t1285 VSS.t248 sg13_lv_nmos ad=79.8f pd=0.8u as=0 ps=0 w=0.42u l=1u
X4302 VDD VSS.t1281 VDD VDD sg13_lv_pmos ad=0.19p pd=1.38u as=0 ps=0 w=1u l=1u
X4303 VDD VSS.t2783 VDD VDD sg13_lv_pmos ad=0.19p pd=1.38u as=0 ps=0 w=1u l=1u
X4304 VDD VSS.t2071 VDD VDD sg13_lv_pmos ad=0.19p pd=1.38u as=0 ps=0 w=1u l=1u
X4305 VSS.t3 sg13cmos5l_tiehi_1.L_HI a_9252_15234# VSS.t2 sg13_lv_nmos ad=0.1626p pd=1.415u as=60.89999f ps=0.71u w=0.42u l=0.13u
X4306 a_16068_14040# a_16042_13945# VDD VDD sg13_lv_pmos ad=0.34p pd=2.68u as=0.36237p ps=2.605u w=1u l=0.13u
X4307 VSS.t676 VDD VSS.t673 VSS.t675 sg13_lv_nmos ad=0.1428p pd=1.52u as=0 ps=0 w=0.42u l=1u
X4308 VDD VSS.t3213 VDD VDD sg13_lv_pmos ad=0.34p pd=2.68u as=0 ps=0 w=1u l=1u
X4309 VSS.t2486 VDD VSS.t2485 VSS.t2484 sg13_lv_nmos ad=0.1428p pd=1.52u as=0 ps=0 w=0.42u l=1u
X4310 VSS.t1909 VDD VSS.t1908 VSS.t1907 sg13_lv_nmos ad=0.1428p pd=1.52u as=0 ps=0 w=0.42u l=1u
X4311 VDD VSS.t2490 VDD VDD sg13_lv_pmos ad=0.34p pd=2.68u as=0 ps=0 w=1u l=1u
X4312 VSS.t982 VDD VSS.t981 VSS.t980 sg13_lv_nmos ad=0.1428p pd=1.52u as=0 ps=0 w=0.42u l=1u
X4313 VDD VSS.t1754 VDD VDD sg13_lv_pmos ad=0.19p pd=1.38u as=0 ps=0 w=1u l=1u
X4314 VSS.t857 VDD VSS.t859 VSS.t858 sg13_lv_nmos ad=79.8f pd=0.8u as=0 ps=0 w=0.42u l=1u
X4315 VSS.t1289 VDD VSS.t1290 VSS.t248 sg13_lv_nmos ad=79.8f pd=0.8u as=0 ps=0 w=0.42u l=1u
X4316 sg13cmos5l_dfrbpq_1_2.CLK a_12010_15202# VSS.t300 VSS.t301 sg13_lv_nmos ad=0.1406p pd=1.12u as=0.1406p ps=1.12u w=0.74u l=0.13u
X4317 VSS.t2551 VDD VSS.t2553 VSS.t2552 sg13_lv_nmos ad=79.8f pd=0.8u as=0 ps=0 w=0.42u l=1u
X4318 VDD VSS.t2438 VDD VDD sg13_lv_pmos ad=0.19p pd=1.38u as=0 ps=0 w=1u l=1u
X4319 VSS.t2099 VDD VSS.t2098 VSS.t2097 sg13_lv_nmos ad=0.1428p pd=1.52u as=0 ps=0 w=0.42u l=1u
X4320 VDD VSS.t1619 VDD VDD sg13_lv_pmos ad=0.19p pd=1.38u as=0 ps=0 w=1u l=1u
X4321 VSS.t2711 VDD VSS.t2712 VSS.t199 sg13_lv_nmos ad=79.8f pd=0.8u as=0 ps=0 w=0.42u l=1u
X4322 VDD VSS.t961 VDD VDD sg13_lv_pmos ad=0.34p pd=2.68u as=0 ps=0 w=1u l=1u
X4323 VSS.t2944 VDD VSS.t2943 VSS.t2942 sg13_lv_nmos ad=0.1428p pd=1.52u as=0 ps=0 w=0.42u l=1u
X4324 VSS.t2697 VDD VSS.t2697 VSS.t199 sg13_lv_nmos ad=0.1428p pd=1.52u as=0 ps=0 w=0.42u l=1u
X4325 VDD VSS.t2712 VDD VDD sg13_lv_pmos ad=0.34p pd=2.68u as=0 ps=0 w=1u l=1u
X4326 VSS.t1984 VDD VSS.t1983 VSS.t1982 sg13_lv_nmos ad=0.1428p pd=1.52u as=0 ps=0 w=0.42u l=1u
X4327 VDD VSS.t464 VDD VDD sg13_lv_pmos ad=0.19p pd=1.38u as=0 ps=0 w=1u l=1u
X4328 VSS.t118 VDD VSS.t399 VSS.t398 sg13_lv_nmos ad=79.8f pd=0.8u as=0 ps=0 w=0.42u l=1u
X4329 VDD VSS.t909 VDD VDD sg13_lv_pmos ad=0.19p pd=1.38u as=0 ps=0 w=1u l=1u
X4330 a_25930_14452# a_26373_14495# a_26313_14531# VDD sg13_lv_pmos ad=79.8f pd=0.8u as=63f ps=0.72u w=0.42u l=0.13u
X4331 sg13cmos5l_buf_8_2.X a_19323_13726# VDD VDD sg13_lv_pmos ad=0.2128p pd=1.5u as=0.2128p ps=1.5u w=1.12u l=0.13u
X4332 VSS.t997 VDD VSS.t996 VSS.t995 sg13_lv_nmos ad=0.1428p pd=1.52u as=0 ps=0 w=0.42u l=1u
X4333 VDD VSS.t2285 VDD VDD sg13_lv_pmos ad=0.34p pd=2.68u as=0 ps=0 w=1u l=1u
X4334 VSS.t1298 VDD VSS.t1299 VSS.t248 sg13_lv_nmos ad=79.8f pd=0.8u as=0 ps=0 w=0.42u l=1u
X4335 VSS.t2516 VDD VSS.t2518 VSS.t2517 sg13_lv_nmos ad=79.8f pd=0.8u as=0 ps=0 w=0.42u l=1u
X4336 a_21348_14909# a_21060_14488# a_21286_14909# VSS.t133 sg13_lv_nmos ad=0.1428p pd=1.52u as=37.8f ps=0.6u w=0.42u l=0.13u
X4337 VSS.t460 VDD VSS.t459 VSS.t19 sg13_lv_nmos ad=0.1428p pd=1.52u as=0 ps=0 w=0.42u l=1u
X4338 VSS.t1512 VDD VSS.t1511 VSS.t1510 sg13_lv_nmos ad=0.1428p pd=1.52u as=0 ps=0 w=0.42u l=1u
X4339 VDD VSS.t3021 VDD VDD sg13_lv_pmos ad=0.19p pd=1.38u as=0 ps=0 w=1u l=1u
X4340 VDD VSS.t3198 VDD VDD sg13_lv_pmos ad=0.34p pd=2.68u as=0 ps=0 w=1u l=1u
X4341 VSS.t2421 VDD VSS.t2420 VSS.t2419 sg13_lv_nmos ad=0.1428p pd=1.52u as=0 ps=0 w=0.42u l=1u
X4342 VSS.t1894 VDD VSS.t1893 VSS.t1892 sg13_lv_nmos ad=0.1428p pd=1.52u as=0 ps=0 w=0.42u l=1u
X4343 VSS.t827 VDD VSS.t826 VSS.t825 sg13_lv_nmos ad=0.1428p pd=1.52u as=0 ps=0 w=0.42u l=1u
X4344 VDD VSS.t1280 VDD VDD sg13_lv_pmos ad=0.34p pd=2.68u as=0 ps=0 w=1u l=1u
X4345 a_17057_14832# sg13cmos5l_a21oi_1_0.A1 sg13cmos5l_a21oi_1_0.Y VSS.t137 sg13_lv_nmos ad=0.1406p pd=1.12u as=0.1406p ps=1.12u w=0.74u l=0.13u
X4346 VSS.t17 a_6682_13690# a_6401_13912# VSS.t293 sg13_lv_nmos ad=79.8f pd=0.8u as=0.1428p ps=1.52u w=0.42u l=0.5u
X4347 VSS.t568 VDD VSS.t567 VSS.t566 sg13_lv_nmos ad=0.1428p pd=1.52u as=0 ps=0 w=0.42u l=1u
X4348 VSS.t1057 VDD VSS.t1059 VSS.t1058 sg13_lv_nmos ad=79.8f pd=0.8u as=0 ps=0 w=0.42u l=1u
X4349 VDD VSS.t1235 VDD VDD sg13_lv_pmos ad=0.19p pd=1.38u as=0 ps=0 w=1u l=1u
X4350 VSS.t2722 VDD VSS.t2859 VSS.t199 sg13_lv_nmos ad=0.1428p pd=1.52u as=0 ps=0 w=0.42u l=1u
R0 VSS.t78 VSS.n758 2.277e+06
R1 VSS.t158 VSS.n770 1.34743e+06
R2 VSS.t199 VSS.n398 4108.7
R3 VSS.n398 VSS.n455 4108.7
R4 VSS.n455 VSS.n512 4108.7
R5 VSS.n512 VSS.t248 4108.7
R6 VSS.t248 VSS.n602 4108.7
R7 VSS.n602 VSS.n125 4108.7
R8 VSS.n125 VSS.n720 4108.7
R9 VSS.t2945 VSS.n123 183.805
R10 VSS.t2950 VSS.n123 183.805
R11 VSS.n123 VSS.t2970 183.805
R12 VSS.n123 VSS.t2980 183.805
R13 VSS.n123 VSS.t2990 183.805
R14 VSS.n123 VSS.t2995 183.806
R15 VSS.n123 VSS.t3010 183.806
R16 VSS.t3040 VSS.n123 183.806
R17 VSS.t3045 VSS.n123 183.805
R18 VSS.t3060 VSS.n123 183.805
R19 VSS.t3080 VSS.n123 183.806
R20 VSS.t3085 VSS.n123 183.805
R21 VSS.t3090 VSS.n123 183.806
R22 VSS.n123 VSS.t3110 183.805
R23 VSS.n123 VSS.t3140 183.805
R24 VSS.n123 VSS.t3160 183.806
R25 VSS.t3165 VSS.n123 183.805
R26 VSS.n123 VSS.t3180 183.805
R27 VSS.n123 VSS.t3200 183.805
R28 VSS.n123 VSS.t3210 183.805
R29 VSS.t199 VSS.n123 4435.04
R30 VSS.t239 VSS.t257 612.602
R31 VSS.n103 VSS.t2367 109.992
R32 VSS.t2282 VSS.n103 109.992
R33 VSS.t2292 VSS.n103 109.986
R34 VSS.t2317 VSS.n103 109.992
R35 VSS.n103 VSS.t2332 109.993
R36 VSS.t2387 VSS.n103 109.992
R37 VSS.t2397 VSS.n103 109.992
R38 VSS.t2407 VSS.n103 109.992
R39 VSS.t2417 VSS.n103 109.992
R40 VSS.t2437 VSS.n103 109.992
R41 VSS.t2457 VSS.n103 109.992
R42 VSS.n103 VSS.t2482 109.992
R43 VSS.n103 VSS.t2502 109.992
R44 VSS.n103 VSS.t2532 109.992
R45 VSS.t1895 VSS.n102 109.992
R46 VSS.t1920 VSS.n102 109.993
R47 VSS.n102 VSS.t1947 108.999
R48 VSS.n102 VSS.t1972 108.999
R49 VSS.t1990 VSS.n102 109.992
R50 VSS.t2010 VSS.n102 109.992
R51 VSS.t2080 VSS.n102 109.992
R52 VSS.n102 VSS.t2085 109.993
R53 VSS.t2090 VSS.n102 109.992
R54 VSS.t2100 VSS.n102 109.992
R55 VSS.t2110 VSS.n102 109.993
R56 VSS.t2150 VSS.n102 109.993
R57 VSS.t1503 VSS.n101 109.992
R58 VSS.t1528 VSS.n101 109.993
R59 VSS.n101 VSS.t1555 108.999
R60 VSS.n101 VSS.t1618 109.992
R61 VSS.t1633 VSS.n101 109.993
R62 VSS.t1643 VSS.n101 109.993
R63 VSS.t1688 VSS.n101 109.992
R64 VSS.t1708 VSS.n101 109.992
R65 VSS.t1718 VSS.n101 109.993
R66 VSS.t1743 VSS.n101 109.992
R67 VSS.n101 VSS.t1758 109.993
R68 VSS.t1763 VSS.n101 109.992
R69 VSS.n106 VSS.t825 109.062
R70 VSS.t828 VSS.n106 109.986
R71 VSS.t853 VSS.n106 109.992
R72 VSS.n106 VSS.t875 108.999
R73 VSS.n106 VSS.t885 108.999
R74 VSS.n106 VSS.t900 108.999
R75 VSS.t913 VSS.n106 109.992
R76 VSS.t918 VSS.n106 109.993
R77 VSS.t923 VSS.n106 109.992
R78 VSS.t943 VSS.n106 109.992
R79 VSS.t973 VSS.n106 109.992
R80 VSS.t983 VSS.n106 109.992
R81 VSS.t993 VSS.n106 109.992
R82 VSS.t1018 VSS.n106 109.993
R83 VSS.t1043 VSS.n106 109.992
R84 VSS.t1053 VSS.n106 109.992
R85 VSS.t1063 VSS.n106 109.992
R86 VSS.t1073 VSS.n106 109.992
R87 VSS.t1083 VSS.n106 109.992
R88 VSS.n134 VSS.t105 1.11651
R89 VSS.t3286 VSS.n142 93.684
R90 VSS.t574 VSS.t105 109.992
R91 VSS.t579 VSS.t105 109.992
R92 VSS.t584 VSS.t105 109.992
R93 VSS.t594 VSS.t105 109.992
R94 VSS.t105 VSS.t614 109.998
R95 VSS.n141 VSS.t3262 60.3116
R96 VSS.t434 VSS.t19 109.986
R97 VSS.n6 VSS.t280 424.017
R98 VSS.t105 VSS.t808 8.00267
R99 VSS.n29 VSS.t91 418.56
R100 VSS.t105 VSS.t768 237.142
R101 VSS.n137 VSS.t237 66.199
R102 VSS.n103 VSS.n398 427.5
R103 VSS.n102 VSS.n455 427.5
R104 VSS.n101 VSS.n512 427.5
R105 VSS.n106 VSS.n602 427.5
R106 VSS.n267 VSS.t101 75.7034
R107 VSS.t644 VSS.n266 242.846
R108 VSS.t650 VSS.n265 242.846
R109 VSS.t653 VSS.n168 242.846
R110 VSS.t656 VSS.n264 242.846
R111 VSS.t662 VSS.n263 242.846
R112 VSS.t668 VSS.n262 242.846
R113 VSS.t671 VSS.n234 242.846
R114 VSS.t674 VSS.n261 242.846
R115 VSS.t680 VSS.n260 242.846
R116 VSS.t259 VSS.n152 420.111
R117 VSS.t753 VSS.n173 242.846
R118 VSS.t755 VSS.n269 242.846
R119 VSS.t757 VSS.n231 242.846
R120 VSS.t759 VSS.n268 242.846
R121 VSS.n229 VSS.t700 242.846
R122 VSS.t514 VSS.n208 221.417
R123 VSS.t19 VSS.n720 427.5
R124 VSS.t281 VSS.n748 408.31
R125 VSS.n797 VSS.t3233 407.144
R126 VSS.n944 VSS.t301 407.144
R127 VSS.t149 VSS.n879 407.144
R128 VSS.t153 VSS.n871 407.144
R129 VSS.n123 VSS.t2952 182.042
R130 VSS.t2962 VSS.n123 182.042
R131 VSS.t2972 VSS.n123 182.042
R132 VSS.t2997 VSS.n123 182.042
R133 VSS.t3012 VSS.n123 182.042
R134 VSS.t3017 VSS.n123 182.042
R135 VSS.t3022 VSS.n123 182.042
R136 VSS.n123 VSS.t3032 182.042
R137 VSS.n123 VSS.t3052 182.042
R138 VSS.n123 VSS.t3062 182.042
R139 VSS.n123 VSS.t3067 182.042
R140 VSS.n123 VSS.t3102 182.042
R141 VSS.n123 VSS.t3112 182.042
R142 VSS.t3117 VSS.n123 182.042
R143 VSS.n123 VSS.t3132 182.042
R144 VSS.t3147 VSS.n123 182.042
R145 VSS.n123 VSS.t3172 182.042
R146 VSS.n123 VSS.t3182 182.042
R147 VSS.t3187 VSS.n123 182.042
R148 VSS.n123 VSS.t3202 182.042
R149 VSS.n123 VSS.t3212 182.042
R150 VSS.n788 VSS.t253 402.858
R151 VSS.t140 VSS.n270 249.002
R152 VSS.n134 VSS.t181 26.1545
R153 VSS.n926 VSS.t141 398.572
R154 VSS.t176 VSS.n768 398.572
R155 VSS.t191 VSS.t142 398.572
R156 VSS.n8 VSS.t285 398.228
R157 VSS.t3265 VSS.n12 397.132
R158 VSS.n867 VSS.t12 397.132
R159 VSS.n808 VSS.t32 394.286
R160 VSS.n123 VSS.t2940 183.804
R161 VSS.n762 VSS.t252 391.118
R162 VSS.n924 VSS.t3232 390
R163 VSS.t302 VSS.n938 390
R164 VSS.t127 VSS.n146 36.5344
R165 VSS.t175 VSS.n19 386.526
R166 VSS.n802 VSS.t292 385.714
R167 VSS.n739 VSS.t229 385.714
R168 VSS.n11 VSS.t246 385.334
R169 VSS.t3238 VSS.n864 384.274
R170 VSS.t16 VSS.n781 381.43
R171 VSS.n945 VSS.t299 381.43
R172 VSS.t163 VSS.n740 381.43
R173 VSS.n10 VSS.t288 381.036
R174 VSS.t161 VSS.n6 381.036
R175 VSS.t3260 VSS.n783 377.144
R176 VSS.t144 VSS.n775 377.144
R177 VSS.n873 VSS.t3239 377.144
R178 VSS.t202 VSS.n144 43.6455
R179 VSS.t95 VSS.n19 376.724
R180 VSS.t214 VSS.n796 368.572
R181 VSS.t275 VSS.n809 368.572
R182 VSS.n810 VSS.t225 368.572
R183 VSS.n786 VSS.t255 368.572
R184 VSS.t3255 VSS.n870 368.572
R185 VSS.t80 VSS.n5 368.142
R186 VSS.n4 VSS.t264 368.142
R187 VSS.n940 VSS.t303 364.286
R188 VSS.n875 VSS.t151 364.286
R189 VSS.n948 VSS.t242 361.033
R190 VSS.t79 VSS.n749 361.033
R191 VSS.t14 VSS.n738 360
R192 VSS.n799 VSS.t3235 355.714
R193 VSS.n946 VSS.t298 355.714
R194 VSS.t89 VSS.n881 355.714
R195 VSS.t155 VSS.n869 355.714
R196 VSS.t203 VSS.n814 351.43
R197 VSS.t101 VSS.n819 351.43
R198 VSS.t3295 VSS.n791 351.43
R199 VSS.n784 VSS.t169 351.43
R200 VSS.n141 VSS.t28 99.148
R201 VSS.t145 VSS.n774 351.43
R202 VSS.n874 VSS.t147 351.43
R203 VSS.t190 VSS.n3 350.95
R204 VSS.n765 VSS.t171 348.139
R205 VSS.t148 VSS.n792 347.144
R206 VSS.n773 VSS.t3254 347.144
R207 VSS.n810 VSS.t261 342.858
R208 VSS.t67 VSS.n8 342.354
R209 VSS.t3282 VSS.n4 342.354
R210 VSS.n150 VSS.t8 65.92
R211 VSS.t54 VSS.n743 339.543
R212 VSS.n795 VSS.t3230 338.572
R213 VSS.n161 VSS.t70 67.9
R214 VSS.t49 VSS.n779 338.572
R215 VSS.n876 VSS.t150 338.572
R216 VSS.t99 VSS.n887 337.046
R217 VSS.t189 VSS.n759 335.245
R218 VSS.t2985 VSS.n123 183.806
R219 VSS.t3000 VSS.n123 183.806
R220 VSS.t3015 VSS.n123 183.806
R221 VSS.t3025 VSS.n123 183.806
R222 VSS.t3055 VSS.n123 183.806
R223 VSS.t3095 VSS.n123 183.806
R224 VSS.t3105 VSS.n123 183.806
R225 VSS.t3120 VSS.n123 183.806
R226 VSS.t3145 VSS.n123 183.806
R227 VSS.t3170 VSS.n123 183.806
R228 VSS.t3175 VSS.n123 183.806
R229 VSS.t3215 VSS.n123 183.806
R230 VSS.t268 VSS.t232 330.947
R231 VSS.n800 VSS.t3236 330
R232 VSS.t129 VSS.n880 330
R233 VSS.t33 VSS.n137 167.082
R234 VSS.n930 VSS.t136 329.168
R235 VSS.t306 VSS.n854 329.168
R236 VSS.t22 VSS.n853 329.168
R237 VSS.n140 VSS.t82 66.199
R238 VSS.n742 VSS.t3270 329.168
R239 VSS.t279 VSS.t113 326.649
R240 VSS.t185 VSS.n818 325.714
R241 VSS.n855 VSS.t146 325.714
R242 VSS.t19 VSS.t3271 321.486
R243 VSS.n143 VSS.t3277 77.4642
R244 VSS.n27 VSS.t178 319.99
R245 VSS.t157 VSS.n867 319.99
R246 VSS.t130 VSS.n1 319.99
R247 VSS.n123 VSS.t3207 182.042
R248 VSS.n123 VSS.t3205 183.806
R249 VSS.n123 VSS.t3197 182.042
R250 VSS.t3192 VSS.n123 182.042
R251 VSS.t3190 VSS.n123 183.805
R252 VSS.n123 VSS.t3185 183.806
R253 VSS.n123 VSS.t3177 182.042
R254 VSS.n123 VSS.t3167 182.042
R255 VSS.t3162 VSS.n123 182.042
R256 VSS.n123 VSS.t3157 182.042
R257 VSS.t3152 VSS.n123 182.042
R258 VSS.t3150 VSS.n123 183.806
R259 VSS.t3142 VSS.n123 182.042
R260 VSS.n123 VSS.t3137 182.042
R261 VSS.n123 VSS.t3135 183.806
R262 VSS.n123 VSS.t3127 182.042
R263 VSS.t3122 VSS.n123 182.042
R264 VSS.n123 VSS.t3115 183.806
R265 VSS.n123 VSS.t3107 182.042
R266 VSS.t3097 VSS.n123 182.042
R267 VSS.t3092 VSS.n123 182.042
R268 VSS.t3087 VSS.n123 182.042
R269 VSS.t3082 VSS.n123 182.042
R270 VSS.t3077 VSS.n123 182.042
R271 VSS.t3072 VSS.n123 182.042
R272 VSS.n123 VSS.t3070 183.806
R273 VSS.n123 VSS.t3065 183.806
R274 VSS.t3057 VSS.n123 182.042
R275 VSS.t3047 VSS.n123 182.042
R276 VSS.t3042 VSS.n123 182.042
R277 VSS.t3037 VSS.n123 182.042
R278 VSS.n123 VSS.t3035 183.806
R279 VSS.n123 VSS.t3027 182.042
R280 VSS.t3020 VSS.n123 183.805
R281 VSS.n123 VSS.t3007 182.042
R282 VSS.n123 VSS.t3002 182.042
R283 VSS.n123 VSS.t2992 182.042
R284 VSS.n123 VSS.t2987 182.042
R285 VSS.n123 VSS.t2982 182.042
R286 VSS.n123 VSS.t2977 182.042
R287 VSS.t2975 VSS.n123 183.806
R288 VSS.n123 VSS.t2967 182.042
R289 VSS.t2965 VSS.n123 183.805
R290 VSS.n123 VSS.t2957 182.042
R291 VSS.n123 VSS.t2955 183.806
R292 VSS.n123 VSS.t2947 182.042
R293 VSS.t2942 VSS.n123 182.042
R294 VSS.n123 VSS.t2937 181.875
R295 VSS.n764 VSS.t3252 313.755
R296 VSS.n770 VSS.t220 313.755
R297 VSS.t3288 VSS.n794 312.858
R298 VSS.n787 VSS.t3261 312.858
R299 VSS.n941 VSS.t3283 312.858
R300 VSS.n877 VSS.t3251 312.858
R301 VSS.t3243 VSS.n868 312.858
R302 VSS.t773 VSS.n813 305.159
R303 VSS.n758 VSS.n754 305.159
R304 VSS.n154 VSS.t3248 312.969
R305 VSS.t100 VSS.n887 292.264
R306 VSS.n886 VSS.t97 292.264
R307 VSS.n755 VSS.t25 292.264
R308 VSS.t291 VSS.n161 304.37
R309 VSS.t206 VSS.n779 291.43
R310 VSS.n5 VSS.t218 290.779
R311 VSS.t3284 VSS.n936 287.144
R312 VSS.n741 VSS.t282 287.144
R313 VSS.n889 VSS.t170 283.334
R314 VSS.t273 VSS.n853 283.334
R315 VSS.n862 VSS.t234 283.334
R316 VSS.t18 VSS.t87 279.37
R317 VSS.t243 VSS.t183 279.37
R318 VSS.n813 VSS.t104 275.072
R319 VSS.n886 VSS.t103 275.072
R320 VSS.t107 VSS.n856 275.072
R321 VSS.n754 VSS.t217 275.072
R322 VSS.n3 VSS.t3225 273.587
R323 VSS.n26 VSS.t209 272.846
R324 VSS.t193 VSS.t66 266.476
R325 VSS.n760 VSS.t256 266.476
R326 VSS.t132 VSS.t3224 266.476
R327 VSS.t3223 VSS.t3281 266.476
R328 VSS.t184 VSS.t35 265.714
R329 VSS.n878 VSS.t57 265.714
R330 VSS.n942 VSS.t3285 261.43
R331 VSS.n879 VSS.t3249 261.43
R332 VSS.n922 VSS.t201 258.334
R333 VSS.t60 VSS.t307 258.334
R334 VSS.t3293 VSS.n927 258.334
R335 VSS.n888 VSS.t223 258.334
R336 VSS.t3289 VSS.t133 258.334
R337 VSS.t231 VSS.n860 258.334
R338 VSS.t205 VSS.t194 258.334
R339 VSS.n124 VSS.t106 288.68
R340 VSS.n948 VSS.t498 257.88
R341 VSS.n785 VSS.t293 257.144
R342 VSS.n771 VSS.t3268 257.144
R343 VSS.t71 VSS.n865 257.144
R344 VSS.t3222 VSS.n751 253.583
R345 VSS.t105 VSS.t553 108.999
R346 VSS.t556 VSS.t105 108.999
R347 VSS.t560 VSS.t105 109.001
R348 VSS.t105 VSS.t562 108.999
R349 VSS.n38 VSS.t639 251.417
R350 VSS.n43 VSS.t642 251.417
R351 VSS.n46 VSS.t645 251.417
R352 VSS.n42 VSS.t648 251.417
R353 VSS.n39 VSS.t651 251.417
R354 VSS.n56 VSS.t654 251.417
R355 VSS.n53 VSS.t657 251.417
R356 VSS.n57 VSS.t660 251.417
R357 VSS.n60 VSS.t663 251.417
R358 VSS.n65 VSS.t666 251.417
R359 VSS.n68 VSS.t669 251.417
R360 VSS.n64 VSS.t672 251.417
R361 VSS.n61 VSS.t675 251.417
R362 VSS.n52 VSS.t678 251.417
R363 VSS.n50 VSS.t681 251.417
R364 VSS.n33 VSS.t754 251.417
R365 VSS.n36 VSS.t756 251.417
R366 VSS.n32 VSS.t758 251.417
R367 VSS.t760 VSS.n30 251.417
R368 VSS.t547 VSS.t105 108.722
R369 VSS.n24 VSS.t699 251.417
R370 VSS.n14 VSS.t439 251.417
R371 VSS.n16 VSS.t512 251.417
R372 VSS.n931 VSS.t58 250.952
R373 VSS.n863 VSS.t111 250.952
R374 VSS.t195 VSS.n736 250.952
R375 VSS.n859 VSS.t221 250
R376 VSS.t167 VSS.n22 249.002
R377 VSS.n0 VSS.t207 249.002
R378 VSS.t78 VSS.n9 243.5
R379 VSS.t105 VSS.t549 109.986
R380 VSS.t105 VSS.t748 243.47
R381 VSS.n37 VSS.t779 242.846
R382 VSS.n44 VSS.t781 242.846
R383 VSS.n45 VSS.t783 242.846
R384 VSS.n41 VSS.t785 242.846
R385 VSS.n40 VSS.t787 242.846
R386 VSS.n55 VSS.t789 242.846
R387 VSS.n54 VSS.t791 242.846
R388 VSS.n58 VSS.t793 242.846
R389 VSS.n59 VSS.t795 242.846
R390 VSS.n66 VSS.t797 242.846
R391 VSS.n67 VSS.t799 242.846
R392 VSS.n63 VSS.t801 242.846
R393 VSS.n62 VSS.t803 242.846
R394 VSS.n51 VSS.t805 242.846
R395 VSS.n34 VSS.t626 242.846
R396 VSS.n35 VSS.t629 242.846
R397 VSS.n31 VSS.t632 242.846
R398 VSS.n25 VSS.t565 242.846
R399 VSS.n15 VSS.t511 242.846
R400 VSS.n16 VSS.t441 242.846
R401 VSS.n130 VSS.t19 9.30614
R402 VSS.n1 VSS.t437 242.846
R403 VSS.t139 VSS.t42 240.689
R404 VSS.n144 VSS.t770 238.357
R405 VSS.n757 VSS.t499 236.391
R406 VSS.n103 VSS.t2274 108.722
R407 VSS.n103 VSS.t2284 109.013
R408 VSS.t2319 VSS.n103 108.999
R409 VSS.t2339 VSS.n103 108.999
R410 VSS.n103 VSS.t2344 109.001
R411 VSS.n103 VSS.t2354 109.001
R412 VSS.t2369 VSS.n103 108.999
R413 VSS.t2389 VSS.n103 108.999
R414 VSS.t2399 VSS.n103 108.999
R415 VSS.t2409 VSS.n103 108.999
R416 VSS.t2419 VSS.n103 108.999
R417 VSS.t2429 VSS.n103 108.999
R418 VSS.t2439 VSS.n103 108.999
R419 VSS.t2449 VSS.n103 108.999
R420 VSS.t2459 VSS.n103 108.999
R421 VSS.n103 VSS.t2464 108.999
R422 VSS.n103 VSS.t2484 108.999
R423 VSS.n103 VSS.t2504 108.999
R424 VSS.t2509 VSS.n103 108.999
R425 VSS.n103 VSS.t2524 108.999
R426 VSS.n103 VSS.t2534 109.001
R427 VSS.t2549 VSS.n103 108.999
R428 VSS.n102 VSS.t1887 109.001
R429 VSS.n102 VSS.t1992 108.999
R430 VSS.n102 VSS.t2002 108.999
R431 VSS.n102 VSS.t2012 108.999
R432 VSS.n102 VSS.t2032 108.999
R433 VSS.n102 VSS.t2037 108.999
R434 VSS.n102 VSS.t2042 108.999
R435 VSS.n102 VSS.t2057 108.999
R436 VSS.t2062 VSS.n102 108.999
R437 VSS.t2072 VSS.n102 108.999
R438 VSS.t2092 VSS.n102 108.999
R439 VSS.t2102 VSS.n102 108.999
R440 VSS.t2112 VSS.n102 109.001
R441 VSS.n102 VSS.t2127 108.999
R442 VSS.n102 VSS.t2137 109.001
R443 VSS.t2152 VSS.n102 109.001
R444 VSS.n102 VSS.t2157 108.999
R445 VSS.n101 VSS.t1495 109.001
R446 VSS.n101 VSS.t1515 108.999
R447 VSS.n101 VSS.t1530 108.999
R448 VSS.n101 VSS.t1590 108.999
R449 VSS.t1595 VSS.n101 108.999
R450 VSS.n101 VSS.t1600 108.999
R451 VSS.n101 VSS.t1610 108.999
R452 VSS.n101 VSS.t1620 108.999
R453 VSS.t1625 VSS.n101 108.999
R454 VSS.t1645 VSS.n101 109.001
R455 VSS.n101 VSS.t1650 109.001
R456 VSS.n101 VSS.t1665 108.999
R457 VSS.n101 VSS.t1670 108.999
R458 VSS.n101 VSS.t1680 108.999
R459 VSS.n101 VSS.t1690 108.999
R460 VSS.n101 VSS.t1695 108.999
R461 VSS.n101 VSS.t1700 108.999
R462 VSS.n101 VSS.t1710 108.999
R463 VSS.n101 VSS.t1720 109.001
R464 VSS.t1735 VSS.n101 108.999
R465 VSS.t1745 VSS.n101 108.999
R466 VSS.t1765 VSS.n101 108.999
R467 VSS.n106 VSS.t820 108.993
R468 VSS.n106 VSS.t830 109.001
R469 VSS.n106 VSS.t845 108.999
R470 VSS.n106 VSS.t855 108.999
R471 VSS.n106 VSS.t865 108.999
R472 VSS.n106 VSS.t925 108.999
R473 VSS.n106 VSS.t945 108.999
R474 VSS.n106 VSS.t950 109.001
R475 VSS.n106 VSS.t955 108.999
R476 VSS.n106 VSS.t965 108.999
R477 VSS.n106 VSS.t985 108.999
R478 VSS.n106 VSS.t995 108.999
R479 VSS.n106 VSS.t1020 108.999
R480 VSS.n106 VSS.t1035 108.999
R481 VSS.t1055 VSS.n106 108.999
R482 VSS.t1065 VSS.n106 108.999
R483 VSS.t1075 VSS.n106 108.999
R484 VSS.t1085 VSS.n106 108.999
R485 VSS.n267 VSS.t778 251.417
R486 VSS.n182 VSS.t780 251.417
R487 VSS.n266 VSS.t782 251.417
R488 VSS.n232 VSS.t784 251.417
R489 VSS.n265 VSS.t786 251.417
R490 VSS.n168 VSS.t788 251.417
R491 VSS.n264 VSS.t790 251.417
R492 VSS.n233 VSS.t792 251.417
R493 VSS.n263 VSS.t794 251.417
R494 VSS.n181 VSS.t796 251.417
R495 VSS.n262 VSS.t798 251.417
R496 VSS.n234 VSS.t800 251.417
R497 VSS.n261 VSS.t802 251.417
R498 VSS.n174 VSS.t804 251.417
R499 VSS.n260 VSS.t806 251.417
R500 VSS.n925 VSS.t734 235.714
R501 VSS.t738 VSS.n150 238.992
R502 VSS.t619 VSS.n148 105.683
R503 VSS.n142 VSS.t743 241.448
R504 VSS.n153 VSS.t622 107.358
R505 VSS.n802 VSS.t751 235.714
R506 VSS.n173 VSS.t624 251.417
R507 VSS.n269 VSS.t628 251.417
R508 VSS.n231 VSS.t631 251.417
R509 VSS.n268 VSS.t634 251.417
R510 VSS.n811 VSS.t764 235.714
R511 VSS.n788 VSS.t564 235.714
R512 VSS.n789 VSS.t701 235.714
R513 VSS.t3229 VSS.n156 26.8308
R514 VSS.t105 VSS.t586 109.001
R515 VSS.t606 VSS.t105 109.001
R516 VSS.t505 VSS.t19 108.635
R517 VSS.n943 VSS.t508 235.714
R518 VSS.n942 VSS.t510 235.714
R519 VSS.t19 VSS.t436 252.065
R520 VSS.n885 VSS.t3296 233.333
R521 VSS.t51 VSS.n859 233.333
R522 VSS.n2 VSS.t283 232.335
R523 VSS.n929 VSS.t726 229.167
R524 VSS.n149 VSS.t500 102.749
R525 VSS.n103 VSS.t2297 109.992
R526 VSS.n103 VSS.t2362 109.993
R527 VSS.n102 VSS.t1900 109.986
R528 VSS.n102 VSS.t1910 109.993
R529 VSS.n102 VSS.t1925 109.993
R530 VSS.n102 VSS.t1940 109.993
R531 VSS.n102 VSS.t1945 109.992
R532 VSS.n102 VSS.t1955 109.993
R533 VSS.n102 VSS.t1965 109.993
R534 VSS.n102 VSS.t1970 109.992
R535 VSS.n101 VSS.t1508 109.986
R536 VSS.n101 VSS.t1523 109.992
R537 VSS.n101 VSS.t1548 109.993
R538 VSS.n101 VSS.t1553 109.992
R539 VSS.n101 VSS.t1563 109.993
R540 VSS.n101 VSS.t1573 109.993
R541 VSS.n101 VSS.t1578 109.992
R542 VSS.n106 VSS.t813 109.986
R543 VSS.n106 VSS.t873 109.992
R544 VSS.n106 VSS.t893 109.993
R545 VSS.n106 VSS.t898 109.992
R546 VSS.n818 VSS.t777 227.143
R547 VSS.n182 VSS.t641 242.846
R548 VSS.n232 VSS.t647 242.846
R549 VSS.n233 VSS.t659 242.846
R550 VSS.n181 VSS.t665 242.846
R551 VSS.n174 VSS.t677 242.846
R552 VSS.n97 VSS.t683 109.579
R553 VSS.t105 VSS.t762 109.644
R554 VSS.t509 VSS.n937 227.143
R555 VSS.t235 VSS.t93 225
R556 VSS.t105 VSS.t698 111.022
R557 VSS.t105 VSS.n161 3.41028
R558 VSS.t438 VSS.n9 222.011
R559 VSS.t638 VSS.n29 221.417
R560 VSS.n13 VSS.t442 221.417
R561 VSS.t444 VSS.n882 221.417
R562 VSS.n928 VSS.t728 220.833
R563 VSS.t182 VSS.t3299 212.5
R564 VSS.n149 VSS.t438 214.988
R565 VSS.t746 VSS.t3234 205.714
R566 VSS.n166 VSS.t105 8.48859
R567 VSS.n166 VSS.t763 102.707
R568 VSS.n811 VSS.t638 205.714
R569 VSS.n155 VSS.t105 96.0268
R570 VSS.t442 VSS.n130 212.761
R571 VSS.t514 VSS.n855 205.714
R572 VSS.n208 VSS.t444 221.417
R573 VSS.n149 VSS.t19 7.66894
R574 VSS.t741 VSS.t105 109.966
R575 VSS.t2277 VSS.n103 109.986
R576 VSS.t2302 VSS.n103 109.993
R577 VSS.t2312 VSS.n103 109.993
R578 VSS.t2352 VSS.n103 109.993
R579 VSS.t2372 VSS.n103 109.993
R580 VSS.t2382 VSS.n103 109.993
R581 VSS.t2392 VSS.n103 109.993
R582 VSS.t2442 VSS.n103 109.993
R583 VSS.t2467 VSS.n103 109.993
R584 VSS.t2477 VSS.n103 109.993
R585 VSS.t2497 VSS.n103 109.993
R586 VSS.t2507 VSS.n103 109.993
R587 VSS.t2512 VSS.n103 109.993
R588 VSS.t2517 VSS.n103 109.993
R589 VSS.t2527 VSS.n103 109.993
R590 VSS.t2542 VSS.n103 109.993
R591 VSS.t2552 VSS.n103 109.993
R592 VSS.t1885 VSS.n102 109.986
R593 VSS.t1935 VSS.n102 109.993
R594 VSS.t1950 VSS.n102 109.993
R595 VSS.n102 VSS.t1975 109.993
R596 VSS.t1985 VSS.n102 109.993
R597 VSS.t2005 VSS.n102 109.993
R598 VSS.t2020 VSS.n102 109.993
R599 VSS.t2025 VSS.n102 109.993
R600 VSS.n102 VSS.t2045 109.993
R601 VSS.t2075 VSS.n102 109.993
R602 VSS.t2095 VSS.n102 109.993
R603 VSS.t2120 VSS.n102 109.993
R604 VSS.t2130 VSS.n102 109.993
R605 VSS.t2160 VSS.n102 109.993
R606 VSS.t1493 VSS.n101 109.986
R607 VSS.t1533 VSS.n101 109.993
R608 VSS.t1543 VSS.n101 109.993
R609 VSS.t1558 VSS.n101 109.993
R610 VSS.t1583 VSS.n101 109.993
R611 VSS.t1593 VSS.n101 109.993
R612 VSS.t1613 VSS.n101 109.993
R613 VSS.t1628 VSS.n101 109.993
R614 VSS.t1658 VSS.n101 109.993
R615 VSS.t1683 VSS.n101 109.993
R616 VSS.t1703 VSS.n101 109.993
R617 VSS.n101 VSS.t1728 109.993
R618 VSS.t1738 VSS.n101 109.993
R619 VSS.t1748 VSS.n101 109.993
R620 VSS.t1768 VSS.n101 109.993
R621 VSS.t818 VSS.n106 109.993
R622 VSS.t838 VSS.n106 109.993
R623 VSS.t858 VSS.n106 109.993
R624 VSS.t888 VSS.n106 109.993
R625 VSS.t908 VSS.n106 109.993
R626 VSS.t928 VSS.n106 109.993
R627 VSS.t938 VSS.n106 109.993
R628 VSS.t958 VSS.n106 109.993
R629 VSS.t978 VSS.n106 109.993
R630 VSS.t998 VSS.n106 109.993
R631 VSS.t1003 VSS.n106 109.993
R632 VSS.t1013 VSS.n106 109.993
R633 VSS.t1023 VSS.n106 109.993
R634 VSS.n106 VSS.t1048 109.993
R635 VSS.t1078 VSS.n106 109.993
R636 VSS.t1088 VSS.n106 109.993
R637 VSS.n148 VSS.t739 106.677
R638 VSS.t105 VSS.n147 86.7544
R639 VSS.t750 VSS.n152 102.457
R640 VSS.t105 VSS.t552 109.993
R641 VSS.t559 VSS.t105 109.993
R642 VSS.t569 VSS.t105 109.986
R643 VSS.t724 VSS.n154 102.457
R644 VSS.t504 VSS.t19 200.613
R645 VSS.t777 VSS.n817 199.989
R646 VSS.t641 VSS.n37 199.989
R647 VSS.t644 VSS.n44 199.989
R648 VSS.t647 VSS.n45 199.989
R649 VSS.t650 VSS.n41 199.989
R650 VSS.t653 VSS.n40 199.989
R651 VSS.t656 VSS.n55 199.989
R652 VSS.t659 VSS.n54 199.989
R653 VSS.t662 VSS.n58 199.989
R654 VSS.t665 VSS.n59 199.989
R655 VSS.t668 VSS.n66 199.989
R656 VSS.t671 VSS.n67 199.989
R657 VSS.t674 VSS.n63 199.989
R658 VSS.t677 VSS.n62 199.989
R659 VSS.t680 VSS.n51 199.989
R660 VSS.n97 VSS.t807 243.139
R661 VSS.t753 VSS.n47 199.989
R662 VSS.t755 VSS.n34 199.989
R663 VSS.t757 VSS.n35 199.989
R664 VSS.t759 VSS.n31 199.989
R665 VSS.n98 VSS.t636 100.822
R666 VSS.n25 VSS.t700 199.989
R667 VSS.t441 VSS.n15 199.989
R668 VSS.t40 VSS.t68 193.411
R669 VSS.t2544 VSS.n103 109.001
R670 VSS.n103 VSS.t2539 108.999
R671 VSS.n103 VSS.t2537 109.992
R672 VSS.n103 VSS.t2529 109.001
R673 VSS.n103 VSS.t2519 109.001
R674 VSS.t2514 VSS.n103 108.999
R675 VSS.n103 VSS.t2499 109.001
R676 VSS.t2494 VSS.n103 108.999
R677 VSS.n103 VSS.t2489 109.001
R678 VSS.n103 VSS.t2487 109.993
R679 VSS.n103 VSS.t2479 109.001
R680 VSS.t2474 VSS.n103 108.999
R681 VSS.n103 VSS.t2469 109.001
R682 VSS.t2462 VSS.n103 109.993
R683 VSS.t2454 VSS.n103 109.001
R684 VSS.t2452 VSS.n103 109.993
R685 VSS.t2444 VSS.n103 109.001
R686 VSS.t2434 VSS.n103 109.001
R687 VSS.t2432 VSS.n103 109.993
R688 VSS.t2424 VSS.n103 109.001
R689 VSS.t2422 VSS.n103 109.993
R690 VSS.t2414 VSS.n103 109.001
R691 VSS.t2412 VSS.n103 109.993
R692 VSS.t2404 VSS.n103 109.001
R693 VSS.t2402 VSS.n103 109.993
R694 VSS.t2394 VSS.n103 109.001
R695 VSS.t2384 VSS.n103 109.001
R696 VSS.n103 VSS.t2379 108.999
R697 VSS.t2374 VSS.n103 109.001
R698 VSS.n103 VSS.t2359 108.999
R699 VSS.n103 VSS.t2357 109.992
R700 VSS.n103 VSS.t2349 108.999
R701 VSS.n103 VSS.t2347 109.992
R702 VSS.t2342 VSS.n103 109.993
R703 VSS.t2334 VSS.n103 109.001
R704 VSS.n103 VSS.t2329 108.999
R705 VSS.t2324 VSS.n103 109.001
R706 VSS.t2322 VSS.n103 109.993
R707 VSS.t2314 VSS.n103 109.001
R708 VSS.n103 VSS.t2309 108.999
R709 VSS.t2304 VSS.n103 109.001
R710 VSS.n103 VSS.t2299 108.999
R711 VSS.n103 VSS.t2294 109.001
R712 VSS.t2289 VSS.n103 108.996
R713 VSS.n103 VSS.t2287 109.992
R714 VSS.t2279 VSS.n103 109.001
R715 VSS.n103 VSS.t2364 109.001
R716 VSS.t2155 VSS.n102 109.992
R717 VSS.t2147 VSS.n102 108.999
R718 VSS.n102 VSS.t2142 109.001
R719 VSS.n102 VSS.t2140 109.992
R720 VSS.n102 VSS.t2132 109.001
R721 VSS.n102 VSS.t2122 109.001
R722 VSS.t2117 VSS.n102 108.999
R723 VSS.t2115 VSS.n102 109.992
R724 VSS.t2107 VSS.n102 108.999
R725 VSS.t2105 VSS.n102 109.993
R726 VSS.t2097 VSS.n102 109.001
R727 VSS.t2087 VSS.n102 109.001
R728 VSS.n102 VSS.t2082 108.999
R729 VSS.t2077 VSS.n102 109.001
R730 VSS.t2067 VSS.n102 109.001
R731 VSS.t2065 VSS.n102 109.993
R732 VSS.n102 VSS.t2060 109.993
R733 VSS.n102 VSS.t2052 109.001
R734 VSS.t2047 VSS.n102 109.001
R735 VSS.n102 VSS.t2040 109.993
R736 VSS.n102 VSS.t2035 109.993
R737 VSS.t2027 VSS.n102 109.001
R738 VSS.t2022 VSS.n102 108.999
R739 VSS.t2017 VSS.n102 108.999
R740 VSS.n102 VSS.t2015 109.993
R741 VSS.t2007 VSS.n102 109.001
R742 VSS.t1997 VSS.n102 109.001
R743 VSS.n102 VSS.t1995 109.993
R744 VSS.t1987 VSS.n102 109.001
R745 VSS.t1982 VSS.n102 108.999
R746 VSS.t1977 VSS.n102 109.001
R747 VSS.t1967 VSS.n102 109.001
R748 VSS.t1962 VSS.n102 108.999
R749 VSS.t1957 VSS.n102 109.001
R750 VSS.t1952 VSS.n102 108.999
R751 VSS.t1942 VSS.n102 109.001
R752 VSS.t1937 VSS.n102 108.999
R753 VSS.t1932 VSS.n102 108.999
R754 VSS.t1927 VSS.n102 109.001
R755 VSS.t1922 VSS.n102 108.999
R756 VSS.t1917 VSS.n102 108.999
R757 VSS.t1912 VSS.n102 109.001
R758 VSS.t1907 VSS.n102 108.999
R759 VSS.t1902 VSS.n102 109.001
R760 VSS.t1897 VSS.n102 108.996
R761 VSS.t1892 VSS.n102 109.013
R762 VSS.n102 VSS.t1890 109.992
R763 VSS.t1882 VSS.n102 108.722
R764 VSS.t1760 VSS.n101 109.001
R765 VSS.n101 VSS.t1755 108.999
R766 VSS.t1750 VSS.n101 109.001
R767 VSS.t1740 VSS.n101 109.001
R768 VSS.t1730 VSS.n101 109.001
R769 VSS.t1725 VSS.n101 108.999
R770 VSS.n101 VSS.t1723 109.992
R771 VSS.t1715 VSS.n101 108.999
R772 VSS.n101 VSS.t1713 109.993
R773 VSS.t1705 VSS.n101 109.001
R774 VSS.n101 VSS.t1698 109.993
R775 VSS.n101 VSS.t1693 109.993
R776 VSS.t1685 VSS.n101 109.001
R777 VSS.t1675 VSS.n101 109.001
R778 VSS.n101 VSS.t1673 109.993
R779 VSS.n101 VSS.t1668 109.993
R780 VSS.t1660 VSS.n101 109.001
R781 VSS.n101 VSS.t1655 108.999
R782 VSS.n101 VSS.t1653 109.992
R783 VSS.t1648 VSS.n101 109.992
R784 VSS.t1640 VSS.n101 108.999
R785 VSS.n101 VSS.t1635 109.001
R786 VSS.t1630 VSS.n101 108.999
R787 VSS.n101 VSS.t1623 109.993
R788 VSS.n101 VSS.t1615 109.001
R789 VSS.n101 VSS.t1605 109.001
R790 VSS.n101 VSS.t1603 109.993
R791 VSS.t1598 VSS.n101 109.993
R792 VSS.n101 VSS.t1585 109.001
R793 VSS.t1575 VSS.n101 109.001
R794 VSS.t1570 VSS.n101 108.999
R795 VSS.t1565 VSS.n101 109.001
R796 VSS.t1560 VSS.n101 108.999
R797 VSS.t1550 VSS.n101 109.001
R798 VSS.t1545 VSS.n101 108.999
R799 VSS.t1540 VSS.n101 108.999
R800 VSS.t1535 VSS.n101 109.001
R801 VSS.t1525 VSS.n101 108.999
R802 VSS.t1520 VSS.n101 109.001
R803 VSS.n101 VSS.t1518 109.993
R804 VSS.t1510 VSS.n101 109.001
R805 VSS.t1505 VSS.n101 108.996
R806 VSS.t1500 VSS.n101 109.013
R807 VSS.n101 VSS.t1498 109.992
R808 VSS.t1490 VSS.n101 108.722
R809 VSS.n101 VSS.t1580 108.999
R810 VSS.t1080 VSS.n106 109.001
R811 VSS.t1070 VSS.n106 109.001
R812 VSS.t1068 VSS.n106 109.993
R813 VSS.t1060 VSS.n106 109.001
R814 VSS.t1058 VSS.n106 109.993
R815 VSS.t1050 VSS.n106 109.001
R816 VSS.t1045 VSS.n106 108.999
R817 VSS.t1040 VSS.n106 109.001
R818 VSS.n106 VSS.t1038 109.993
R819 VSS.t1030 VSS.n106 109.001
R820 VSS.t1025 VSS.n106 109.001
R821 VSS.t1015 VSS.n106 108.999
R822 VSS.t1010 VSS.n106 108.999
R823 VSS.t1005 VSS.n106 109.001
R824 VSS.t1000 VSS.n106 108.999
R825 VSS.t990 VSS.n106 109.001
R826 VSS.n106 VSS.t988 109.993
R827 VSS.t980 VSS.n106 109.001
R828 VSS.t975 VSS.n106 108.999
R829 VSS.t970 VSS.n106 109.001
R830 VSS.n106 VSS.t968 109.993
R831 VSS.t960 VSS.n106 109.001
R832 VSS.n106 VSS.t953 109.992
R833 VSS.n106 VSS.t948 109.993
R834 VSS.t940 VSS.n106 109.001
R835 VSS.t935 VSS.n106 108.999
R836 VSS.t930 VSS.n106 109.001
R837 VSS.t920 VSS.n106 109.001
R838 VSS.t915 VSS.n106 108.999
R839 VSS.t910 VSS.n106 109.001
R840 VSS.t905 VSS.n106 108.999
R841 VSS.t895 VSS.n106 109.001
R842 VSS.t890 VSS.n106 108.999
R843 VSS.t880 VSS.n106 109.001
R844 VSS.n106 VSS.t878 109.993
R845 VSS.t870 VSS.n106 109.001
R846 VSS.n106 VSS.t868 109.993
R847 VSS.t860 VSS.n106 109.001
R848 VSS.t850 VSS.n106 109.001
R849 VSS.n106 VSS.t848 109.993
R850 VSS.t840 VSS.n106 109.001
R851 VSS.t835 VSS.n106 108.999
R852 VSS.n106 VSS.t833 109.992
R853 VSS.n106 VSS.t823 109.972
R854 VSS.t815 VSS.n106 108.999
R855 VSS.t810 VSS.n106 108.722
R856 VSS.n106 VSS.t903 109.993
R857 VSS.n155 VSS.t723 12.9737
R858 VSS.t105 VSS.t611 108.996
R859 VSS.t609 VSS.t105 109.992
R860 VSS.t596 VSS.t105 109.001
R861 VSS.t591 VSS.t105 109.001
R862 VSS.t105 VSS.t589 109.992
R863 VSS.t581 VSS.t105 109.001
R864 VSS.t576 VSS.t105 109.001
R865 VSS.t571 VSS.t105 109.001
R866 VSS.t566 VSS.t105 108.993
R867 VSS.t105 VSS.n148 3.31704
R868 VSS.n153 VSS.t749 105.329
R869 VSS.t105 VSS.t563 109.993
R870 VSS.t561 VSS.t105 109.992
R871 VSS.t558 VSS.t105 108.999
R872 VSS.t557 VSS.t105 109.993
R873 VSS.t105 VSS.t554 109.993
R874 VSS.t105 VSS.t551 108.999
R875 VSS.t105 VSS.t601 109.001
R876 VSS.t431 VSS.t19 108.722
R877 VSS.t740 VSS.n147 22.241
R878 VSS.t766 VSS.t37 191.667
R879 VSS.t778 VSS.n38 191.417
R880 VSS.n43 VSS.t780 191.417
R881 VSS.n46 VSS.t782 191.417
R882 VSS.n42 VSS.t784 191.417
R883 VSS.n39 VSS.t786 191.417
R884 VSS.n56 VSS.t788 191.417
R885 VSS.n53 VSS.t790 191.417
R886 VSS.n57 VSS.t792 191.417
R887 VSS.n60 VSS.t794 191.417
R888 VSS.n65 VSS.t796 191.417
R889 VSS.n68 VSS.t798 191.417
R890 VSS.n64 VSS.t800 191.417
R891 VSS.n61 VSS.t802 191.417
R892 VSS.n52 VSS.t804 191.417
R893 VSS.n50 VSS.t806 191.417
R894 VSS.n48 VSS.t734 191.417
R895 VSS.n33 VSS.t624 191.417
R896 VSS.n36 VSS.t628 191.417
R897 VSS.n32 VSS.t631 191.417
R898 VSS.n30 VSS.t634 191.417
R899 VSS.t764 VSS.n27 191.417
R900 VSS.t564 VSS.n24 191.417
R901 VSS.t701 VSS.n26 191.417
R902 VSS.t294 VSS.n23 77.2144
R903 VSS.t510 VSS.n14 191.417
R904 VSS.t512 VSS.n13 191.417
R905 VSS.n49 VSS.t726 186.502
R906 VSS.n759 VSS.t78 184.815
R907 VSS.n143 VSS.t2 188.911
R908 VSS.t779 VSS.n815 184.286
R909 VSS.t781 VSS.n820 184.286
R910 VSS.t783 VSS.n821 184.286
R911 VSS.t785 VSS.n822 184.286
R912 VSS.t787 VSS.n823 184.286
R913 VSS.t789 VSS.n824 184.286
R914 VSS.t791 VSS.n825 184.286
R915 VSS.t793 VSS.n826 184.286
R916 VSS.t795 VSS.n827 184.286
R917 VSS.t797 VSS.n915 184.286
R918 VSS.t799 VSS.n916 184.286
R919 VSS.t801 VSS.n917 184.286
R920 VSS.t803 VSS.n918 184.286
R921 VSS.t805 VSS.n919 184.286
R922 VSS.t807 VSS.n920 184.286
R923 VSS.t745 VSS.n793 184.286
R924 VSS.t626 VSS.n803 184.286
R925 VSS.t629 VSS.n804 184.286
R926 VSS.t632 VSS.n806 184.286
R927 VSS.t760 VSS.n98 182.764
R928 VSS.t765 VSS.n807 184.286
R929 VSS.t565 VSS.n780 184.286
R930 VSS.t702 VSS.n778 184.286
R931 VSS.t507 VSS.n23 188.386
R932 VSS.t511 VSS.n935 184.286
R933 VSS.n130 VSS.t513 100.871
R934 VSS.t72 VSS.t115 184.286
R935 VSS.t437 VSS.n737 184.286
R936 VSS.t283 VSS.n735 183.333
R937 VSS.t3231 VSS.t745 180
R938 VSS.t728 VSS.n790 179.167
R939 VSS.t770 VSS.n812 176.219
R940 VSS.n816 VSS.t775 175.714
R941 VSS.t639 VSS.n815 175.714
R942 VSS.t642 VSS.n820 175.714
R943 VSS.t645 VSS.n821 175.714
R944 VSS.t648 VSS.n822 175.714
R945 VSS.t651 VSS.n823 175.714
R946 VSS.t654 VSS.n824 175.714
R947 VSS.t657 VSS.n825 175.714
R948 VSS.t660 VSS.n826 175.714
R949 VSS.t663 VSS.n827 175.714
R950 VSS.t666 VSS.n915 175.714
R951 VSS.t669 VSS.n916 175.714
R952 VSS.t672 VSS.n917 175.714
R953 VSS.t675 VSS.n918 175.714
R954 VSS.t678 VSS.n919 175.714
R955 VSS.t681 VSS.n920 175.714
R956 VSS.n798 VSS.t746 175.714
R957 VSS.t754 VSS.n803 175.714
R958 VSS.t756 VSS.n804 175.714
R959 VSS.t758 VSS.n806 175.714
R960 VSS.t699 VSS.n780 175.714
R961 VSS.n939 VSS.t508 175.714
R962 VSS.t439 VSS.n935 175.714
R963 VSS.t257 VSS.t158 171.53
R964 VSS.t775 VSS.t96 171.429
R965 VSS.t7 VSS.t737 171.429
R966 VSS.t496 VSS.n734 170.833
R967 VSS.t180 VSS.n922 166.667
R968 VSS.n927 VSS.t140 166.667
R969 VSS.n888 VSS.t167 166.667
R970 VSS.t3296 VSS.n852 166.667
R971 VSS.n860 VSS.t51 166.667
R972 VSS.t207 VSS.n734 166.667
R973 VSS.t221 VSS.n858 165.692
R974 VSS.t498 VSS.n0 165.669
R975 VSS.n761 VSS.t3222 159.026
R976 VSS.t201 VSS.n921 157.335
R977 VSS.n18 VSS.t94 157.335
R978 VSS.n756 VSS.t40 154.728
R979 VSS.t3225 VSS.n744 154.728
R980 VSS.t293 VSS.n782 154.286
R981 VSS.t209 VSS.n778 154.286
R982 VSS.n930 VSS.t58 154.167
R983 VSS.t3298 VSS.n889 154.167
R984 VSS.t3290 VSS.n854 154.167
R985 VSS.t106 VSS.n20 153.243
R986 VSS.n857 VSS.t107 153.243
R987 VSS.n947 VSS.t217 153.243
R988 VSS.n270 VSS.t730 165.669
R989 VSS.t173 VSS.n852 150
R990 VSS.t3285 VSS.n936 150
R991 VSS.t3249 VSS.n878 150
R992 VSS.t502 VSS.t5 145.714
R993 VSS.t296 VSS.t507 145.714
R994 VSS.n928 VSS.t3293 141.667
R995 VSS.n861 VSS.t231 141.667
R996 VSS.n258 VSS.t241 157.335
R997 VSS.t28 VSS.t504 141.429
R998 VSS.t104 VSS.n812 137.536
R999 VSS.t137 VSS.t71 137.143
R1000 VSS.n864 VSS.t72 135.703
R1001 VSS.t3287 VSS.n794 124.287
R1002 VSS.n941 VSS.t3284 124.287
R1003 VSS.t3250 VSS.n877 124.287
R1004 VSS.n767 VSS.t139 120.344
R1005 VSS.n784 VSS.t291 120.001
R1006 VSS.n789 VSS.t206 120.001
R1007 VSS.t27 VSS.t502 120.001
R1008 VSS.n921 VSS.t126 119.835
R1009 VSS.n21 VSS.t227 119.835
R1010 VSS.t133 VSS.n18 119.835
R1011 VSS.n884 VSS.t273 116.668
R1012 VSS.t234 VSS.n861 116.668
R1013 VSS.t499 VSS.t3292 116.046
R1014 VSS.t3259 VSS.t738 115.715
R1015 VSS.t223 VSS.t3274 112.501
R1016 VSS.t304 VSS.t509 111.43
R1017 VSS.t94 VSS.t173 108.334
R1018 VSS.n758 VSS.n753 107.451
R1019 VSS.t25 VSS.t208 107.451
R1020 VSS.t218 VSS.t244 107.451
R1021 VSS.n814 VSS.t773 107.144
R1022 VSS.n791 VSS.t730 107.144
R1023 VSS.t3237 VSS.n800 107.144
R1024 VSS.t751 VSS.t3246 107.144
R1025 VSS.t178 VSS.n807 107.144
R1026 VSS.t3248 VSS.n931 107.144
R1027 VSS.n771 VSS.t239 107.144
R1028 VSS.t115 VSS.n863 107.144
R1029 VSS.n740 VSS.t130 107.144
R1030 VSS.t53 VSS.n736 107.144
R1031 VSS.t307 VSS.n790 104.168
R1032 VSS.t93 VSS.n862 104.168
R1033 VSS.n258 VSS.t205 119.835
R1034 VSS.t164 VSS.t195 100.001
R1035 VSS.n795 VSS.t3288 98.5719
R1036 VSS.n781 VSS.t3261 98.5719
R1037 VSS.t3283 VSS.n937 98.5719
R1038 VSS.t3258 VSS.t157 98.5719
R1039 VSS.t436 VSS.t188 98.5719
R1040 VSS.t256 VSS.t179 94.5564
R1041 VSS.t3271 VSS.t284 94.5564
R1042 VSS.t737 VSS.t61 94.2862
R1043 VSS.t3268 VSS.t64 94.2862
R1044 VSS.t21 VSS.n162 4.38457
R1045 VSS.n135 VSS.t21 4.63044
R1046 VSS.n756 VSS.t193 90.2584
R1047 VSS.t35 VSS.n816 90.0005
R1048 VSS.t61 VSS.n792 90.0005
R1049 VSS.t5 VSS.n773 90.0005
R1050 VSS.n139 VSS.t314 26.1613
R1051 VSS.t21 VSS.n127 0.219019
R1052 VSS.t363 VSS.n129 26.2524
R1053 VSS.n318 VSS.t262 72.8451
R1054 VSS.t372 VSS.n131 26.2517
R1055 VSS.t377 VSS.n132 26.2524
R1056 VSS.t21 VSS.n138 0.219019
R1057 VSS.t21 VSS.n69 0.121827
R1058 VSS.t85 VSS.n378 89.7897
R1059 VSS.t277 VSS.n17 88.7727
R1060 VSS.t113 VSS.n10 88.7727
R1061 VSS.t241 VSS.t496 87.5005
R1062 VSS.n140 VSS.t19 3.41984
R1063 VSS.t19 VSS.t226 87.1423
R1064 VSS.n22 VSS.t99 86.5025
R1065 VSS.n757 VSS.t67 85.9604
R1066 VSS.t3228 VSS.t132 85.9604
R1067 VSS.t3252 VSS.t120 85.9604
R1068 VSS.t211 VSS.n842 85.7543
R1069 VSS.n80 VSS.t119 85.7543
R1070 VSS.n819 VSS.t185 85.7148
R1071 VSS.t146 VSS.n774 85.7148
R1072 VSS.t3266 VSS.n846 83.6281
R1073 VSS.t111 VSS.t238 83.3338
R1074 VSS.t138 VSS.n71 83.3336
R1075 VSS.t3236 VSS.n799 81.4291
R1076 VSS.n946 VSS.t296 81.4291
R1077 VSS.n881 VSS.t129 81.4291
R1078 VSS.n869 VSS.t156 81.4291
R1079 VSS.t68 VSS.t19 80.7982
R1080 VSS.n48 VSS.t148 79.9891
R1081 VSS.t3254 VSS.n12 79.9891
R1082 VSS.n720 VSS.n257 3692.29
R1083 VSS.n107 VSS.t3269 10.1739
R1084 VSS.n760 VSS.t189 77.3644
R1085 VSS.n767 VSS.t190 77.3644
R1086 VSS.t748 VSS.t3237 77.1434
R1087 VSS.t188 VSS.n738 77.1434
R1088 VSS.t3292 VSS.t19 76.5012
R1089 VSS.t105 VSS.t3259 76.3274
R1090 VSS.n840 VSS.t69 74.234
R1091 VSS.t21 VSS.n172 2.33071
R1092 VSS.t183 VSS.n753 73.0664
R1093 VSS.t3230 VSS.n793 72.8576
R1094 VSS.n229 VSS.t49 88.5605
R1095 VSS.n940 VSS.t304 72.8576
R1096 VSS.t3251 VSS.t166 72.8576
R1097 VSS.t150 VSS.n875 72.8576
R1098 VSS.n850 VSS.t269 72.8451
R1099 VSS.t3227 VSS.n82 72.8441
R1100 VSS.n78 VSS.t3219 72.8441
R1101 VSS.n76 VSS.t44 72.8441
R1102 VSS.n74 VSS.t309 72.8441
R1103 VSS.n849 VSS.t271 72.6202
R1104 VSS.t212 VSS.n111 76.9095
R1105 VSS.t3272 VSS.n836 72.6202
R1106 VSS.t38 VSS.n837 72.6202
R1107 VSS.t19 VSS.t27 72.0417
R1108 VSS.n817 VSS.t184 71.4177
R1109 VSS.n882 VSS.t89 71.4177
R1110 VSS.t136 VSS.n929 70.8338
R1111 VSS.n883 VSS.t306 70.8338
R1112 VSS.n883 VSS.t22 70.8338
R1113 VSS.t238 VSS.n140 83.7485
R1114 VSS.t3270 VSS.n735 70.8338
R1115 VSS.t3264 VSS.n180 72.8451
R1116 VSS.t121 VSS.n184 72.8451
R1117 VSS.t124 VSS.n167 13.9422
R1118 VSS.n851 VSS.t3267 70.1995
R1119 VSS.n105 VSS.t258 13.9082
R1120 VSS.n171 VSS.t109 13.9422
R1121 VSS.t3242 VSS.n104 14.2643
R1122 VSS.t224 VSS.t100 68.7684
R1123 VSS.t3246 VSS.n796 68.5719
R1124 VSS.t261 VSS.n809 68.5719
R1125 VSS.n20 VSS.t224 67.2827
R1126 VSS.n17 VSS.t95 67.2827
R1127 VSS.t232 VSS.n857 67.2827
R1128 VSS.t242 VSS.n947 67.2827
R1129 VSS.t33 VSS.t765 66.6672
R1130 VSS.t126 VSS.t766 66.6672
R1131 VSS.t0 VSS.t3298 66.6672
R1132 VSS.t52 VSS.t3290 66.6672
R1133 VSS.t3257 VSS.n849 64.5513
R1134 VSS.t103 VSS.t277 64.4704
R1135 VSS.t171 VSS.n746 64.4704
R1136 VSS.n111 VSS.t21 10.0545
R1137 VSS.t96 VSS.t105 80.6121
R1138 VSS.n92 VSS.t250 63.9684
R1139 VSS.n79 VSS.t228 63.9684
R1140 VSS.t3263 VSS.n108 16.4142
R1141 VSS.t55 VSS.n162 16.4378
R1142 VSS.n839 VSS.t10 63.7444
R1143 VSS.n848 VSS.t3226 62.3556
R1144 VSS.n844 VSS.t75 62.3556
R1145 VSS.t168 VSS.n72 62.3556
R1146 VSS.n135 VSS.t272 16.9203
R1147 VSS.n755 VSS.t243 60.1724
R1148 VSS.t264 VSS.n745 60.1724
R1149 VSS.t220 VSS.n744 60.1724
R1150 VSS.n134 VSS.t203 75.2357
R1151 VSS.n926 VSS.t3295 60.0005
R1152 VSS.t169 VSS.n783 60.0005
R1153 VSS.t64 VSS.n768 60.0005
R1154 VSS.n775 VSS.t145 60.0005
R1155 VSS.t19 VSS.t260 51.2106
R1156 VSS.n91 VSS.t320 58.6622
R1157 VSS.n100 VSS.t21 0.22519
R1158 VSS.n89 VSS.t325 58.6622
R1159 VSS.t327 VSS.n99 26.1052
R1160 VSS.n96 VSS.t21 0.22519
R1161 VSS.n86 VSS.t336 58.6622
R1162 VSS.n93 VSS.t21 0.22519
R1163 VSS.n85 VSS.t341 58.6622
R1164 VSS.t343 VSS.n95 58.6622
R1165 VSS.t21 VSS.n113 0.121828
R1166 VSS.n77 VSS.t405 26.1053
R1167 VSS.t21 VSS.n116 0.12186
R1168 VSS.t21 VSS.n117 0.121828
R1169 VSS.n119 VSS.t21 0.12182
R1170 VSS.t21 VSS.n120 0.121828
R1171 VSS.n75 VSS.t425 26.1052
R1172 VSS.n47 VSS.t214 58.5605
R1173 VSS.n92 VSS.t317 58.3211
R1174 VSS.t331 VSS.n82 58.3211
R1175 VSS.n78 VSS.t397 58.3211
R1176 VSS.n76 VSS.t412 58.3211
R1177 VSS.n74 VSS.t428 58.3211
R1178 VSS.n846 VSS.t3256 57.8078
R1179 VSS.t21 VSS.n158 0.219073
R1180 VSS.n91 VSS.t319 57.0465
R1181 VSS.t321 VSS.n90 26.1544
R1182 VSS.n89 VSS.t324 57.0465
R1183 VSS.t326 VSS.n88 26.1544
R1184 VSS.t21 VSS.n99 0.12186
R1185 VSS.t332 VSS.n87 26.1544
R1186 VSS.n86 VSS.t335 57.0465
R1187 VSS.n94 VSS.t21 0.219018
R1188 VSS.n85 VSS.t340 57.0465
R1189 VSS.t342 VSS.n95 57.0465
R1190 VSS.n73 VSS.t398 26.1544
R1191 VSS.t21 VSS.n114 0.12182
R1192 VSS.t21 VSS.n115 0.12182
R1193 VSS.t21 VSS.n118 0.219018
R1194 VSS.t416 VSS.n117 26.2522
R1195 VSS.n119 VSS.t419 26.2515
R1196 VSS.t422 VSS.n120 26.2522
R1197 VSS.t21 VSS.n122 0.12182
R1198 VSS.t66 VSS.n752 55.8744
R1199 VSS.t3253 VSS.t3223 55.8744
R1200 VSS.t3281 VSS.n745 55.8744
R1201 VSS.t159 VSS.t3282 55.8744
R1202 VSS.t105 VSS.t7 72.0407
R1203 VSS.t3235 VSS.n798 55.7148
R1204 VSS.t298 VSS.n945 55.7148
R1205 VSS.n870 VSS.t155 55.7148
R1206 VSS.n108 VSS.t196 64.8343
R1207 VSS.n162 VSS.t3280 64.8293
R1208 VSS.n839 VSS.t3279 54.8687
R1209 VSS.n742 VSS.t164 54.1672
R1210 VSS.n845 VSS.t3241 54.0618
R1211 VSS.t3299 VSS.t19 53.8079
R1212 VSS.t19 VSS.t112 53.8079
R1213 VSS.n49 VSS.t60 53.1692
R1214 VSS.t194 VSS.n2 53.1692
R1215 VSS.t316 VSS.t21 26.5065
R1216 VSS.t330 VSS.t21 26.5067
R1217 VSS.t21 VSS.t427 26.5067
R1218 VSS.n163 VSS.t21 0.203701
R1219 VSS.t21 VSS.t345 26.5067
R1220 VSS.t411 VSS.t21 26.5067
R1221 VSS.n163 VSS.t396 26.334
R1222 VSS.t179 VSS.n146 66.3233
R1223 VSS.n763 VSS.t79 51.5764
R1224 VSS.t245 VSS.t80 51.5764
R1225 VSS.t42 VSS.n743 51.5764
R1226 VSS.t621 VSS.n147 23.2337
R1227 VSS.t743 VSS.t3287 51.4291
R1228 VSS.n739 VSS.t14 51.4291
R1229 VSS.n139 VSS.t311 47.2101
R1230 VSS.t319 VSS.n81 48.6385
R1231 VSS.t320 VSS.n90 47.2102
R1232 VSS.t324 VSS.n100 48.8187
R1233 VSS.t325 VSS.n88 47.2102
R1234 VSS.t329 VSS.n99 26.2591
R1235 VSS.t331 VSS.n87 47.2102
R1236 VSS.t335 VSS.n96 48.8187
R1237 VSS.n94 VSS.t337 26.1544
R1238 VSS.t340 VSS.n93 48.8187
R1239 VSS.n84 VSS.t342 48.6385
R1240 VSS.n83 VSS.t343 47.2101
R1241 VSS.n127 VSS.t348 26.1547
R1242 VSS.t353 VSS.n126 26.2524
R1243 VSS.n128 VSS.t358 26.2524
R1244 VSS.t360 VSS.n129 26.1049
R1245 VSS.n133 VSS.t368 48.8187
R1246 VSS.t374 VSS.n132 26.1049
R1247 VSS.n136 VSS.t382 26.2635
R1248 VSS.n138 VSS.t385 26.1547
R1249 VSS.t390 VSS.n69 26.2524
R1250 VSS.t395 VSS.n70 48.8187
R1251 VSS.n73 VSS.t397 47.2102
R1252 VSS.n113 VSS.t401 26.2522
R1253 VSS.t404 VSS.n114 26.2515
R1254 VSS.n77 VSS.t406 26.2522
R1255 VSS.t408 VSS.n115 26.2515
R1256 VSS.t409 VSS.n116 26.1052
R1257 VSS.t413 VSS.n118 26.1544
R1258 VSS.t415 VSS.n117 26.1053
R1259 VSS.t420 VSS.n120 26.1053
R1260 VSS.t424 VSS.n122 26.2515
R1261 VSS.n75 VSS.t426 26.2591
R1262 VSS.t429 VSS.n158 26.1611
R1263 VSS.n124 VSS.t83 37.8459
R1264 VSS.t288 VSS.n750 47.2784
R1265 VSS.n762 VSS.t161 47.2784
R1266 VSS.t236 VSS.t54 47.2784
R1267 VSS.n924 VSS.t3231 47.1434
R1268 VSS.t303 VSS.n938 47.1434
R1269 VSS.t151 VSS.n874 47.1434
R1270 VSS.t317 VSS.n81 47.0238
R1271 VSS.n100 VSS.t322 26.0021
R1272 VSS.n96 VSS.t333 26.0021
R1273 VSS.n93 VSS.t338 26.0021
R1274 VSS.t341 VSS.n84 47.0238
R1275 VSS.t365 VSS.n133 26.0017
R1276 VSS.t369 VSS.n131 26.1056
R1277 VSS.n114 VSS.t402 26.106
R1278 VSS.n115 VSS.t407 26.106
R1279 VSS.n119 VSS.t417 26.106
R1280 VSS.n122 VSS.t423 26.106
R1281 VSS.t226 VSS.t170 45.8338
R1282 VSS.t227 VSS.t182 45.8338
R1283 VSS.n858 VSS.t268 45.7789
R1284 VSS.t3274 VSS.n21 44.8359
R1285 VSS.t311 VSS.n257 56.194
R1286 VSS.n180 VSS.t346 58.3202
R1287 VSS.t21 VSS.n126 0.121827
R1288 VSS.t21 VSS.n128 0.121827
R1289 VSS.t21 VSS.n129 0.121827
R1290 VSS.t21 VSS.n133 0.225187
R1291 VSS.t21 VSS.n131 0.121819
R1292 VSS.t21 VSS.n132 0.121827
R1293 VSS.n136 VSS.t379 26.1048
R1294 VSS.n184 VSS.t383 58.3202
R1295 VSS.n69 VSS.t387 26.1049
R1296 VSS.n70 VSS.t392 26.0017
R1297 VSS.t246 VSS.n746 42.9804
R1298 VSS.n166 VSS.t275 50.7208
R1299 VSS.t255 VSS.n782 42.8576
R1300 VSS.n865 VSS.t3238 42.8576
R1301 VSS.t368 VSS.n318 56.7064
R1302 VSS.n136 VSS.t21 0.121878
R1303 VSS.n378 VSS.t395 56.7064
R1304 VSS.t19 VSS.t236 42.1172
R1305 VSS.t19 VSS.n146 1.60658
R1306 VSS.t292 VSS.n801 41.4177
R1307 VSS.t3226 VSS.n847 40.8632
R1308 VSS.t75 VSS.n843 40.8632
R1309 VSS.n835 VSS.t168 40.8632
R1310 VSS.t3224 VSS.n750 38.6824
R1311 VSS.n770 VSS.n766 38.6824
R1312 VSS.t147 VSS.t152 38.5719
R1313 VSS.t37 VSS.t105 53.8079
R1314 VSS.n884 VSS.t3289 37.5005
R1315 VSS.n7 VSS.t3228 37.1968
R1316 VSS.t3232 VSS.n923 37.1319
R1317 VSS.t196 VSS.n848 36.5343
R1318 VSS.t3280 VSS.n844 36.5343
R1319 VSS.t3279 VSS.n72 36.5343
R1320 VSS.n765 VSS.t3253 34.3845
R1321 VSS.n785 VSS.t3260 34.2862
R1322 VSS.n776 VSS.t144 34.2862
R1323 VSS.t3239 VSS.n872 34.2862
R1324 VSS.t112 VSS.t235 33.3338
R1325 VSS.n866 VSS.t137 32.8462
R1326 VSS.t3256 VSS.n845 31.469
R1327 VSS.t285 VSS.n752 30.0865
R1328 VSS.t244 VSS.n748 30.0865
R1329 VSS.n766 VSS.t159 30.0865
R1330 VSS.t3234 VSS.n797 30.0005
R1331 VSS.n786 VSS.t16 30.0005
R1332 VSS.t702 VSS.n156 228.291
R1333 VSS.n155 VSS.t616 15.0018
R1334 VSS.n772 VSS.t3265 30.0005
R1335 VSS.n944 VSS.t299 30.0005
R1336 VSS.n871 VSS.t154 30.0005
R1337 VSS.n741 VSS.t163 30.0005
R1338 VSS.t208 VSS.t19 29.2233
R1339 VSS.n885 VSS.t175 29.1672
R1340 VSS.t120 VSS.n11 28.6008
R1341 VSS.t21 VSS.n108 4.37826
R1342 VSS.t10 VSS.n71 27.6595
R1343 VSS.t250 VSS.n177 38.7811
R1344 VSS.n111 VSS.t62 16.225
R1345 VSS.t228 VSS.n836 27.4346
R1346 VSS.t3221 VSS.n837 27.4346
R1347 VSS.n856 VSS.t18 25.7885
R1348 VSS.t278 VSS.n808 25.7148
R1349 VSS.t166 VSS.n876 25.7148
R1350 VSS.t229 VSS.n737 25.7148
R1351 VSS.t142 VSS.t19 24.8989
R1352 VSS.t91 VSS.n28 24.2748
R1353 VSS.t84 VSS.n866 24.2748
R1354 VSS.t3241 VSS.n135 33.1136
R1355 VSS.t21 VSS.n104 3.49528
R1356 VSS.t3275 VSS.n172 14.8812
R1357 VSS.n178 VSS.t30 13.9422
R1358 VSS.t21 VSS.n167 3.37712
R1359 VSS.n171 VSS.t21 3.37712
R1360 VSS.t46 VSS.n185 13.9422
R1361 VSS.t117 VSS.n164 13.9374
R1362 VSS.n112 VSS.t128 13.9092
R1363 VSS.n105 VSS.t21 3.3689
R1364 VSS.t252 VSS.n749 21.4905
R1365 VSS.n939 VSS.t302 21.4291
R1366 VSS.t57 VSS.t3250 21.4291
R1367 VSS.t152 VSS.n873 21.4291
R1368 VSS.t12 VSS.t84 21.4291
R1369 VSS.t3267 VSS.n850 21.2035
R1370 VSS.t280 VSS.n7 20.0048
R1371 VSS.n923 VSS.t3233 19.9891
R1372 VSS.n177 VSS.t20 12.8073
R1373 VSS.n842 VSS.t212 18.7838
R1374 VSS.n80 VSS.t3272 18.7838
R1375 VSS.n79 VSS.t38 18.7838
R1376 VSS.t286 VSS.n172 20.3759
R1377 VSS.n178 VSS.t3227 29.5272
R1378 VSS.n167 VSS.t3264 29.5272
R1379 VSS.t262 VSS.n851 18.5589
R1380 VSS.t269 VSS.n105 29.5338
R1381 VSS.n112 VSS.t121 29.5336
R1382 VSS.t3219 VSS.n164 29.5281
R1383 VSS.t44 VSS.n171 29.5272
R1384 VSS.t309 VSS.n185 29.5272
R1385 VSS.n847 VSS.t3266 17.4635
R1386 VSS.n843 VSS.t211 17.4635
R1387 VSS.t119 VSS.n835 17.4635
R1388 VSS.t225 VSS.t278 17.1434
R1389 VSS.t32 VSS.t76 17.1434
R1390 VSS.t156 VSS.t3243 17.1434
R1391 VSS.t282 VSS.t53 17.1434
R1392 VSS.n257 VSS.t21 2.5939
R1393 VSS.n320 VSS.n123 5.64438
R1394 VSS.n123 VSS.n321 5.64438
R1395 VSS.t21 VSS.n177 2.99891
R1396 VSS.t21 VSS.n178 3.37712
R1397 VSS.n851 VSS.t21 17.0005
R1398 VSS.n849 VSS.t21 17.0005
R1399 VSS.n845 VSS.t21 17.0005
R1400 VSS.n112 VSS.t21 3.36914
R1401 VSS.n184 VSS.t21 0.405951
R1402 VSS.n228 VSS.t21 5.6463
R1403 VSS.t21 VSS.n840 17.0005
R1404 VSS.t21 VSS.n839 17.0005
R1405 VSS.t21 VSS.n836 17.0005
R1406 VSS.t21 VSS.n837 17.0005
R1407 VSS.t21 VSS.n164 3.37595
R1408 VSS.t21 VSS.n185 3.37712
R1409 VSS.t199 VSS.t2760 17.0005
R1410 VSS.n728 VSS.t199 17.0005
R1411 VSS.n169 VSS.t199 4.17712
R1412 VSS.n103 VSS.n299 5.64438
R1413 VSS.n300 VSS.n103 5.64438
R1414 VSS.n297 VSS.n102 5.64438
R1415 VSS.n102 VSS.n298 5.64438
R1416 VSS.n101 VSS.n295 5.64438
R1417 VSS.n296 VSS.n101 5.64438
R1418 VSS.n569 VSS.t1255 0.120486
R1419 VSS.n293 VSS.t248 4.17719
R1420 VSS.t1299 VSS.n280 0.179761
R1421 VSS.t1344 VSS.n591 0.120486
R1422 VSS.n106 VSS.n272 5.64438
R1423 VSS.n273 VSS.n106 5.64438
R1424 VSS.t105 VSS.n672 5.6463
R1425 VSS.t105 VSS.n270 0.666899
R1426 VSS.n927 VSS.t105 17.0005
R1427 VSS.t105 VSS.n928 17.0005
R1428 VSS.t105 VSS.n790 17.0005
R1429 VSS.n929 VSS.t105 17.0005
R1430 VSS.t105 VSS.n930 17.0005
R1431 VSS.n931 VSS.t105 17.0005
R1432 VSS.t105 VSS.n154 7.66905
R1433 VSS.t105 VSS.n156 15.2046
R1434 VSS.t105 VSS.n778 17.0005
R1435 VSS.t105 VSS.n789 17.0005
R1436 VSS.t105 VSS.n779 17.0005
R1437 VSS.n229 VSS.t105 0.649813
R1438 VSS.t105 VSS.n780 17.0005
R1439 VSS.t105 VSS.n788 17.0005
R1440 VSS.n787 VSS.t105 17.0005
R1441 VSS.t105 VSS.n781 17.0005
R1442 VSS.t105 VSS.n786 17.0005
R1443 VSS.t105 VSS.n782 17.0005
R1444 VSS.t105 VSS.n785 17.0005
R1445 VSS.t105 VSS.n783 17.0005
R1446 VSS.t105 VSS.n784 17.0005
R1447 VSS.t105 VSS.n150 13.0749
R1448 VSS.t105 VSS.n792 17.0005
R1449 VSS.n925 VSS.t105 17.0005
R1450 VSS.t105 VSS.n926 17.0005
R1451 VSS.t105 VSS.n791 17.0005
R1452 VSS.n153 VSS.t105 3.67123
R1453 VSS.n800 VSS.t105 17.0005
R1454 VSS.n799 VSS.t105 17.0005
R1455 VSS.n798 VSS.t105 17.0005
R1456 VSS.n797 VSS.t105 17.0005
R1457 VSS.t105 VSS.n924 17.0005
R1458 VSS.t105 VSS.n793 17.0005
R1459 VSS.t105 VSS.n795 17.0005
R1460 VSS.t105 VSS.n794 17.0005
R1461 VSS.t105 VSS.n142 10.6184
R1462 VSS.t105 VSS.n98 9.30147
R1463 VSS.t105 VSS.n268 0.649813
R1464 VSS.t105 VSS.n805 17.0005
R1465 VSS.t105 VSS.n806 17.0005
R1466 VSS.t105 VSS.n231 0.649813
R1467 VSS.t105 VSS.n804 17.0005
R1468 VSS.t105 VSS.n269 0.649813
R1469 VSS.t105 VSS.n803 17.0005
R1470 VSS.t105 VSS.n173 0.649813
R1471 VSS.t105 VSS.n796 17.0005
R1472 VSS.t105 VSS.n802 17.0005
R1473 VSS.n152 VSS.t105 7.66905
R1474 VSS.t105 VSS.n144 14.3867
R1475 VSS.n922 VSS.t105 17.0005
R1476 VSS.t105 VSS.n137 3.41984
R1477 VSS.t105 VSS.n807 17.0005
R1478 VSS.t105 VSS.n811 17.0005
R1479 VSS.t105 VSS.n808 17.0005
R1480 VSS.t105 VSS.n810 17.0005
R1481 VSS.t105 VSS.n809 17.0005
R1482 VSS.t105 VSS.n812 17.0005
R1483 VSS.t105 VSS.n920 17.0005
R1484 VSS.t105 VSS.n260 0.649813
R1485 VSS.t105 VSS.n919 17.0005
R1486 VSS.n174 VSS.t105 0.649813
R1487 VSS.t105 VSS.n918 17.0005
R1488 VSS.t105 VSS.n261 0.649813
R1489 VSS.t105 VSS.n917 17.0005
R1490 VSS.t105 VSS.n234 0.649813
R1491 VSS.t105 VSS.n916 17.0005
R1492 VSS.t105 VSS.n262 0.649813
R1493 VSS.t105 VSS.n915 17.0005
R1494 VSS.n181 VSS.t105 0.649813
R1495 VSS.t105 VSS.n827 17.0005
R1496 VSS.t105 VSS.n263 0.649813
R1497 VSS.t105 VSS.n826 17.0005
R1498 VSS.n233 VSS.t105 0.649813
R1499 VSS.t105 VSS.n825 17.0005
R1500 VSS.t105 VSS.n264 0.649813
R1501 VSS.t105 VSS.n824 17.0005
R1502 VSS.t105 VSS.n168 0.649813
R1503 VSS.t105 VSS.n823 17.0005
R1504 VSS.t105 VSS.n265 0.649813
R1505 VSS.t105 VSS.n822 17.0005
R1506 VSS.n232 VSS.t105 0.649813
R1507 VSS.t105 VSS.n821 17.0005
R1508 VSS.t105 VSS.n266 0.649813
R1509 VSS.t105 VSS.n820 17.0005
R1510 VSS.n182 VSS.t105 0.649813
R1511 VSS.t105 VSS.n815 17.0005
R1512 VSS.n267 VSS.t105 0.649813
R1513 VSS.n819 VSS.t105 17.0005
R1514 VSS.n818 VSS.t105 17.0005
R1515 VSS.n816 VSS.t105 17.0005
R1516 VSS.t105 VSS.n814 17.0005
R1517 VSS.t105 VSS.n813 17.0005
R1518 VSS.t19 VSS.n935 17.0005
R1519 VSS.t19 VSS.n942 17.0005
R1520 VSS.t19 VSS.n936 17.0005
R1521 VSS.t19 VSS.n941 17.0005
R1522 VSS.t19 VSS.n937 17.0005
R1523 VSS.t19 VSS.n940 17.0005
R1524 VSS.t19 VSS.n938 17.0005
R1525 VSS.t19 VSS.n939 17.0005
R1526 VSS.n943 VSS.t19 17.0005
R1527 VSS.t19 VSS.n944 17.0005
R1528 VSS.n945 VSS.t19 17.0005
R1529 VSS.t19 VSS.n946 17.0005
R1530 VSS.t19 VSS.n23 12.2522
R1531 VSS.n859 VSS.t19 17.0005
R1532 VSS.n860 VSS.t19 17.0005
R1533 VSS.n861 VSS.t19 17.0005
R1534 VSS.n862 VSS.t19 17.0005
R1535 VSS.n863 VSS.t19 17.0005
R1536 VSS.n865 VSS.t19 17.0005
R1537 VSS.n868 VSS.t19 17.0005
R1538 VSS.n869 VSS.t19 17.0005
R1539 VSS.n870 VSS.t19 17.0005
R1540 VSS.n871 VSS.t19 17.0005
R1541 VSS.n872 VSS.t19 17.0005
R1542 VSS.n873 VSS.t19 17.0005
R1543 VSS.n874 VSS.t19 17.0005
R1544 VSS.n875 VSS.t19 17.0005
R1545 VSS.n876 VSS.t19 17.0005
R1546 VSS.n877 VSS.t19 17.0005
R1547 VSS.n878 VSS.t19 17.0005
R1548 VSS.n879 VSS.t19 17.0005
R1549 VSS.n880 VSS.t19 17.0005
R1550 VSS.n881 VSS.t19 17.0005
R1551 VSS.t19 VSS.n208 0.649813
R1552 VSS.t19 VSS.n855 17.0005
R1553 VSS.t19 VSS.n774 17.0005
R1554 VSS.t19 VSS.n775 17.0005
R1555 VSS.t19 VSS.n776 17.0005
R1556 VSS.n856 VSS.t19 17.0005
R1557 VSS.t19 VSS.n885 17.0005
R1558 VSS.t19 VSS.n852 17.0005
R1559 VSS.t19 VSS.n884 17.0005
R1560 VSS.t19 VSS.n853 17.0005
R1561 VSS.t19 VSS.n883 17.0005
R1562 VSS.t19 VSS.n854 17.0005
R1563 VSS.t19 VSS.n886 17.0005
R1564 VSS.t19 VSS.n887 17.0005
R1565 VSS.t19 VSS.n888 17.0005
R1566 VSS.n889 VSS.t19 17.0005
R1567 VSS.t19 VSS.n124 2.49582
R1568 VSS.n141 VSS.t19 2.91846
R1569 VSS.n773 VSS.t19 17.0005
R1570 VSS.t19 VSS.n772 17.0005
R1571 VSS.t19 VSS.n768 17.0005
R1572 VSS.t19 VSS.n771 17.0005
R1573 VSS.n143 VSS.t19 12.2567
R1574 VSS.t19 VSS.n743 17.0005
R1575 VSS.t19 VSS.n767 17.0005
R1576 VSS.t19 VSS.n744 17.0005
R1577 VSS.t19 VSS.n766 17.0005
R1578 VSS.t19 VSS.n745 17.0005
R1579 VSS.t19 VSS.n765 17.0005
R1580 VSS.t19 VSS.n746 17.0005
R1581 VSS.t19 VSS.n764 17.0005
R1582 VSS.t19 VSS.n748 17.0005
R1583 VSS.t19 VSS.n763 17.0005
R1584 VSS.t19 VSS.n749 17.0005
R1585 VSS.t19 VSS.n762 17.0005
R1586 VSS.t19 VSS.n750 17.0005
R1587 VSS.t19 VSS.n761 17.0005
R1588 VSS.t19 VSS.n751 17.0005
R1589 VSS.t19 VSS.n760 17.0005
R1590 VSS.t19 VSS.n759 17.0005
R1591 VSS.t19 VSS.n757 17.0005
R1592 VSS.t19 VSS.n752 17.0005
R1593 VSS.t19 VSS.n756 17.0005
R1594 VSS.t19 VSS.n755 17.0005
R1595 VSS.t19 VSS.n753 17.0005
R1596 VSS.t19 VSS.n754 17.0005
R1597 VSS.t19 VSS.n948 17.0005
R1598 VSS.t19 VSS.n734 17.0005
R1599 VSS.t19 VSS.n258 0.666899
R1600 VSS.t19 VSS.n735 17.0005
R1601 VSS.t19 VSS.n742 17.0005
R1602 VSS.t19 VSS.n736 17.0005
R1603 VSS.t19 VSS.n741 17.0005
R1604 VSS.t19 VSS.n740 17.0005
R1605 VSS.t19 VSS.n737 17.0005
R1606 VSS.t19 VSS.n739 17.0005
R1607 VSS.t19 VSS.n738 17.0005
R1608 VSS.t76 VSS.n28 15.7034
R1609 VSS.n801 VSS.t259 15.7034
R1610 VSS.t69 VSS.n834 15.0429
R1611 VSS.n107 VSS.t21 2.23361
R1612 VSS.t318 VSS.n949 14.1658
R1613 VSS.t414 VSS.n828 14.1658
R1614 VSS.n890 VSS.t389 14.1658
R1615 VSS.n951 VSS.n731 14.1658
R1616 VSS.t3179 VSS.n950 14.1658
R1617 VSS.n953 VSS.n952 14.1658
R1618 VSS.n934 VSS.t352 14.1658
R1619 VSS.n949 VSS.t26 13.5005
R1620 VSS.t555 VSS.n733 13.5005
R1621 VSS.t829 VSS.n911 13.5005
R1622 VSS.n910 VSS.t1213 13.5005
R1623 VSS.t1509 VSS.n831 13.5005
R1624 VSS.t1901 VSS.n900 13.5005
R1625 VSS.n899 VSS.t2293 13.5005
R1626 VSS.t2676 VSS.n726 13.5005
R1627 VSS.n954 VSS.t2956 13.5005
R1628 VSS.n890 VSS.t266 13.5005
R1629 VSS.n891 VSS.t633 13.5005
R1630 VSS.n892 VSS.n830 13.5005
R1631 VSS.n895 VSS.n894 13.5005
R1632 VSS.n906 VSS.n905 13.5005
R1633 VSS.n904 VSS.n896 13.5005
R1634 VSS.n898 VSS.n730 13.5005
R1635 VSS.n729 VSS.n951 13.5005
R1636 VSS.t471 VSS.n828 13.5005
R1637 VSS.t661 VSS.n914 13.5005
R1638 VSS.n913 VSS.t1052 13.5005
R1639 VSS.n893 VSS.n829 13.5005
R1640 VSS.n902 VSS.t1732 13.5005
R1641 VSS.t2124 VSS.n903 13.5005
R1642 VSS.t2516 VSS.n732 13.5005
R1643 VSS.n950 VSS.t2801 13.5005
R1644 VSS.n952 VSS.t2859 13.5005
R1645 VSS.n897 VSS.n727 13.5005
R1646 VSS.n901 VSS.n832 13.5005
R1647 VSS.n908 VSS.n907 13.5005
R1648 VSS.t1408 VSS.n909 13.5005
R1649 VSS.n912 VSS.n777 13.5005
R1650 VSS.n933 VSS.n932 13.5005
R1651 VSS.t440 VSS.n934 13.5005
R1652 VSS.n834 VSS.t85 13.4291
R1653 VSS.n104 VSS.t3257 23.7593
R1654 VSS.t97 VSS.t48 12.8945
R1655 VSS.t284 VSS.n751 12.8945
R1656 VSS.n761 VSS.t279 12.8945
R1657 VSS.t141 VSS.n925 12.8576
R1658 VSS.n772 VSS.t176 12.8576
R1659 VSS.t154 VSS.t3255 12.8576
R1660 VSS.t768 VSS.t180 12.5005
R1661 VSS.n764 VSS.t245 8.59649
R1662 VSS.t253 VSS.n787 8.57193
R1663 VSS.n868 VSS.t3258 8.57193
R1664 VSS.n601 VSS.t248 4.19248
R1665 VSS.n123 VSS.t3216 8.50199
R1666 VSS.t2553 VSS.n103 8.50198
R1667 VSS.n102 VSS.t2161 8.50198
R1668 VSS.t1769 VSS.n101 8.50198
R1669 VSS.t1089 VSS.n106 8.50198
R1670 VSS.n377 VSS.t3213 0.130189
R1671 VSS.t3211 VSS.n123 8.501
R1672 VSS.n376 VSS.t3208 0.130189
R1673 VSS.t3206 VSS.n123 8.501
R1674 VSS.n375 VSS.t3203 0.130189
R1675 VSS.t3201 VSS.n123 8.501
R1676 VSS.n374 VSS.t3198 0.130189
R1677 VSS.t3196 VSS.n123 8.501
R1678 VSS.n373 VSS.t3193 0.130189
R1679 VSS.t3191 VSS.n123 8.501
R1680 VSS.n372 VSS.t3188 0.130189
R1681 VSS.t3186 VSS.n123 8.501
R1682 VSS.n371 VSS.t3183 0.130189
R1683 VSS.t3181 VSS.n320 0.0362711
R1684 VSS.n370 VSS.t3178 0.0793054
R1685 VSS.t3176 VSS.n123 8.501
R1686 VSS.n369 VSS.t3173 0.130189
R1687 VSS.t3171 VSS.n123 8.501
R1688 VSS.n368 VSS.t3168 0.130189
R1689 VSS.t3166 VSS.n123 8.501
R1690 VSS.n367 VSS.t3163 0.130189
R1691 VSS.t3161 VSS.n123 8.501
R1692 VSS.n366 VSS.t3158 0.130189
R1693 VSS.t3156 VSS.n123 8.501
R1694 VSS.n365 VSS.t3153 0.130189
R1695 VSS.t3151 VSS.n123 8.501
R1696 VSS.n364 VSS.t3148 0.130189
R1697 VSS.t3146 VSS.n123 8.501
R1698 VSS.n363 VSS.t3143 0.130189
R1699 VSS.t3141 VSS.n123 8.501
R1700 VSS.n362 VSS.t3138 0.130189
R1701 VSS.t3136 VSS.n123 8.501
R1702 VSS.n361 VSS.t3133 0.130189
R1703 VSS.t3131 VSS.n123 8.501
R1704 VSS.n360 VSS.t3128 0.130189
R1705 VSS.t3126 VSS.n123 8.501
R1706 VSS.n359 VSS.t3123 0.130189
R1707 VSS.t3121 VSS.n123 8.501
R1708 VSS.n358 VSS.t3118 0.130189
R1709 VSS.t3116 VSS.n123 8.501
R1710 VSS.n357 VSS.t3113 0.130189
R1711 VSS.t3111 VSS.n123 8.501
R1712 VSS.n356 VSS.t3108 0.130189
R1713 VSS.t3106 VSS.n321 0.0362711
R1714 VSS.n355 VSS.t3103 0.0793054
R1715 VSS.n123 VSS.t3101 8.501
R1716 VSS.t3098 VSS.n354 0.130189
R1717 VSS.t3096 VSS.n123 8.501
R1718 VSS.t3093 VSS.n353 0.130189
R1719 VSS.t3091 VSS.n123 8.501
R1720 VSS.t3088 VSS.n352 0.130189
R1721 VSS.t3086 VSS.n123 8.501
R1722 VSS.t3083 VSS.n351 0.130189
R1723 VSS.t3081 VSS.n123 8.501
R1724 VSS.t3078 VSS.n350 0.130189
R1725 VSS.t3076 VSS.n123 8.501
R1726 VSS.t3073 VSS.n349 0.130189
R1727 VSS.t3071 VSS.n123 8.501
R1728 VSS.t3068 VSS.n348 0.130189
R1729 VSS.t3066 VSS.n123 8.501
R1730 VSS.t3063 VSS.n347 0.130189
R1731 VSS.t3061 VSS.n123 8.501
R1732 VSS.t3058 VSS.n346 0.130189
R1733 VSS.t3056 VSS.n123 8.501
R1734 VSS.t3053 VSS.n345 0.130189
R1735 VSS.t3051 VSS.n123 8.501
R1736 VSS.t3048 VSS.n344 0.130189
R1737 VSS.t3046 VSS.n123 8.501
R1738 VSS.t3043 VSS.n343 0.130189
R1739 VSS.t3041 VSS.n123 8.501
R1740 VSS.t3038 VSS.n342 0.130189
R1741 VSS.t3036 VSS.n123 8.501
R1742 VSS.t3033 VSS.n341 0.130189
R1743 VSS.n123 VSS.t3031 8.501
R1744 VSS.t3028 VSS.n340 0.130189
R1745 VSS.t3026 VSS.n123 8.501
R1746 VSS.t3023 VSS.n339 0.130189
R1747 VSS.t3021 VSS.n123 8.501
R1748 VSS.t3018 VSS.n338 0.130189
R1749 VSS.t3016 VSS.n123 8.501
R1750 VSS.t3013 VSS.n337 0.130189
R1751 VSS.t3011 VSS.n123 8.501
R1752 VSS.t3008 VSS.n336 0.130189
R1753 VSS.t3006 VSS.n123 8.501
R1754 VSS.t3003 VSS.n335 0.130189
R1755 VSS.t3001 VSS.n123 8.501
R1756 VSS.t2998 VSS.n334 0.130189
R1757 VSS.t2996 VSS.n123 8.501
R1758 VSS.t2993 VSS.n333 0.130189
R1759 VSS.t2991 VSS.n123 8.501
R1760 VSS.t2988 VSS.n332 0.130189
R1761 VSS.t2986 VSS.n123 8.501
R1762 VSS.t2983 VSS.n331 0.130189
R1763 VSS.t2981 VSS.n123 8.501
R1764 VSS.t2978 VSS.n330 0.130189
R1765 VSS.t2976 VSS.n123 8.501
R1766 VSS.t2973 VSS.n329 0.130189
R1767 VSS.t2971 VSS.n123 8.501
R1768 VSS.t2968 VSS.n328 0.130189
R1769 VSS.t2966 VSS.n123 8.501
R1770 VSS.n327 VSS.t2963 0.130189
R1771 VSS.t2961 VSS.n123 8.501
R1772 VSS.n326 VSS.t2958 0.130189
R1773 VSS.t2953 VSS.n325 0.215686
R1774 VSS.t2951 VSS.n123 8.501
R1775 VSS.n324 VSS.t2948 0.130189
R1776 VSS.t2946 VSS.n123 8.501
R1777 VSS.n323 VSS.t2943 0.130189
R1778 VSS.t2941 VSS.n123 8.501
R1779 VSS.n123 VSS.n322 3.33079
R1780 VSS.t21 VSS.t312 8.501
R1781 VSS.n725 VSS.t21 3.32876
R1782 VSS.n319 VSS.t21 0.532065
R1783 VSS.t125 VSS.n379 0.964792
R1784 VSS.t21 VSS.n380 3.32876
R1785 VSS.n227 VSS.t21 5.6463
R1786 VSS.n381 VSS.t21 4.20253
R1787 VSS.t356 VSS.t21 8.501
R1788 VSS.n382 VSS.t21 3.32876
R1789 VSS.t361 VSS.t21 8.501
R1790 VSS.n383 VSS.t21 3.32876
R1791 VSS.t366 VSS.t21 8.501
R1792 VSS.n384 VSS.t21 3.32876
R1793 VSS.n385 VSS.t21 0.35896
R1794 VSS.n386 VSS.t21 3.32876
R1795 VSS.t375 VSS.t21 8.501
R1796 VSS.n387 VSS.t21 3.32876
R1797 VSS.t380 VSS.t21 8.501
R1798 VSS.n388 VSS.t21 3.32876
R1799 VSS.t122 VSS.n389 0.835741
R1800 VSS.t21 VSS.n390 3.32876
R1801 VSS.n228 VSS.t388 0.0333775
R1802 VSS.n391 VSS.t21 4.20253
R1803 VSS.t393 VSS.t21 8.501
R1804 VSS.n392 VSS.t21 3.32876
R1805 VSS.n396 VSS.t199 4.20253
R1806 VSS.n454 VSS.t2550 0.130189
R1807 VSS.t2548 VSS.n103 8.501
R1808 VSS.n453 VSS.t2545 0.130189
R1809 VSS.t2543 VSS.n103 8.501
R1810 VSS.n452 VSS.t2540 0.130189
R1811 VSS.t2538 VSS.n103 8.501
R1812 VSS.n451 VSS.t2535 0.130189
R1813 VSS.t2533 VSS.n103 8.501
R1814 VSS.n450 VSS.t2530 0.130189
R1815 VSS.t2528 VSS.n103 8.501
R1816 VSS.n449 VSS.t2525 0.130189
R1817 VSS.t2523 VSS.n103 8.501
R1818 VSS.n448 VSS.t2520 0.130189
R1819 VSS.t2518 VSS.n299 0.0362711
R1820 VSS.n447 VSS.t2515 0.0793054
R1821 VSS.t2513 VSS.n103 8.501
R1822 VSS.n446 VSS.t2510 0.130189
R1823 VSS.t2508 VSS.n103 8.501
R1824 VSS.n445 VSS.t2505 0.130189
R1825 VSS.t2503 VSS.n103 8.501
R1826 VSS.n444 VSS.t2500 0.130189
R1827 VSS.t2498 VSS.n103 8.501
R1828 VSS.n443 VSS.t2495 0.130189
R1829 VSS.t2493 VSS.n103 8.501
R1830 VSS.n442 VSS.t2490 0.130189
R1831 VSS.t2488 VSS.n103 8.501
R1832 VSS.n441 VSS.t2485 0.130189
R1833 VSS.t2483 VSS.n103 8.501
R1834 VSS.n440 VSS.t2480 0.130189
R1835 VSS.t2478 VSS.n103 8.501
R1836 VSS.n439 VSS.t2475 0.130189
R1837 VSS.t2473 VSS.n103 8.501
R1838 VSS.n438 VSS.t2470 0.130189
R1839 VSS.t2468 VSS.n103 8.501
R1840 VSS.n437 VSS.t2465 0.130189
R1841 VSS.t2463 VSS.n103 8.501
R1842 VSS.n436 VSS.t2460 0.130189
R1843 VSS.t2458 VSS.n103 8.501
R1844 VSS.n435 VSS.t2455 0.130189
R1845 VSS.t2453 VSS.n103 8.501
R1846 VSS.n434 VSS.t2450 0.130189
R1847 VSS.t2448 VSS.n103 8.501
R1848 VSS.n433 VSS.t2445 0.130189
R1849 VSS.t2443 VSS.n300 0.0362711
R1850 VSS.n432 VSS.t2440 0.0793054
R1851 VSS.t2438 VSS.n103 8.501
R1852 VSS.n431 VSS.t2435 0.130189
R1853 VSS.t2433 VSS.n103 8.501
R1854 VSS.n430 VSS.t2430 0.130189
R1855 VSS.t2428 VSS.n103 8.501
R1856 VSS.n429 VSS.t2425 0.130189
R1857 VSS.t2423 VSS.n103 8.501
R1858 VSS.n428 VSS.t2420 0.130189
R1859 VSS.t2418 VSS.n103 8.501
R1860 VSS.n427 VSS.t2415 0.130189
R1861 VSS.t2413 VSS.n103 8.501
R1862 VSS.n426 VSS.t2410 0.130189
R1863 VSS.t2408 VSS.n103 8.501
R1864 VSS.n425 VSS.t2405 0.130189
R1865 VSS.t2403 VSS.n103 8.501
R1866 VSS.n424 VSS.t2400 0.130189
R1867 VSS.t2398 VSS.n103 8.501
R1868 VSS.n423 VSS.t2395 0.130189
R1869 VSS.t2393 VSS.n103 8.501
R1870 VSS.n422 VSS.t2390 0.130189
R1871 VSS.t2388 VSS.n103 8.501
R1872 VSS.n421 VSS.t2385 0.130189
R1873 VSS.t2383 VSS.n103 8.501
R1874 VSS.n420 VSS.t2380 0.130189
R1875 VSS.t2378 VSS.n103 8.501
R1876 VSS.n419 VSS.t2375 0.130189
R1877 VSS.t2373 VSS.n103 8.501
R1878 VSS.n418 VSS.t2370 0.130189
R1879 VSS.n417 VSS.t2365 0.130189
R1880 VSS.t2363 VSS.n103 8.501
R1881 VSS.n416 VSS.t2360 0.130189
R1882 VSS.t2358 VSS.n103 8.501
R1883 VSS.n415 VSS.t2355 0.130189
R1884 VSS.t2353 VSS.n103 8.501
R1885 VSS.n414 VSS.t2350 0.130189
R1886 VSS.t2348 VSS.n103 8.501
R1887 VSS.n413 VSS.t2345 0.130189
R1888 VSS.t2343 VSS.n103 8.501
R1889 VSS.n412 VSS.t2340 0.130189
R1890 VSS.t2338 VSS.n103 8.501
R1891 VSS.n411 VSS.t2335 0.130189
R1892 VSS.t2333 VSS.n103 8.501
R1893 VSS.n410 VSS.t2330 0.130189
R1894 VSS.t2328 VSS.n103 8.501
R1895 VSS.n409 VSS.t2325 0.130189
R1896 VSS.t2323 VSS.n103 8.501
R1897 VSS.n408 VSS.t2320 0.130189
R1898 VSS.t2318 VSS.n103 8.501
R1899 VSS.n407 VSS.t2315 0.130189
R1900 VSS.t2313 VSS.n103 8.501
R1901 VSS.n406 VSS.t2310 0.130189
R1902 VSS.t2308 VSS.n103 8.501
R1903 VSS.n405 VSS.t2305 0.130189
R1904 VSS.t2303 VSS.n103 8.501
R1905 VSS.n404 VSS.t2300 0.130189
R1906 VSS.t2298 VSS.n103 8.501
R1907 VSS.n403 VSS.t2295 0.130189
R1908 VSS.t2293 VSS.n103 8.501
R1909 VSS.t2290 VSS.n402 0.130189
R1910 VSS.t2288 VSS.n103 8.501
R1911 VSS.t2285 VSS.n401 0.130189
R1912 VSS.t2283 VSS.n103 8.501
R1913 VSS.t2280 VSS.n400 0.130189
R1914 VSS.t2278 VSS.n103 8.501
R1915 VSS.n399 VSS.n103 3.33079
R1916 VSS.n511 VSS.t2158 0.130189
R1917 VSS.t2156 VSS.n102 8.501
R1918 VSS.n510 VSS.t2153 0.130189
R1919 VSS.t2151 VSS.n102 8.501
R1920 VSS.n509 VSS.t2148 0.130189
R1921 VSS.t2146 VSS.n102 8.501
R1922 VSS.n508 VSS.t2143 0.130189
R1923 VSS.t2141 VSS.n102 8.501
R1924 VSS.n507 VSS.t2138 0.130189
R1925 VSS.t2136 VSS.n102 8.501
R1926 VSS.n506 VSS.t2133 0.130189
R1927 VSS.t2131 VSS.n102 8.501
R1928 VSS.n505 VSS.t2128 0.130189
R1929 VSS.t2126 VSS.n297 0.0362711
R1930 VSS.n504 VSS.t2123 0.0793054
R1931 VSS.t2121 VSS.n102 8.501
R1932 VSS.n503 VSS.t2118 0.130189
R1933 VSS.t2116 VSS.n102 8.501
R1934 VSS.n502 VSS.t2113 0.130189
R1935 VSS.t2111 VSS.n102 8.501
R1936 VSS.n501 VSS.t2108 0.130189
R1937 VSS.t2106 VSS.n102 8.501
R1938 VSS.n500 VSS.t2103 0.130189
R1939 VSS.t2101 VSS.n102 8.501
R1940 VSS.n499 VSS.t2098 0.130189
R1941 VSS.t2096 VSS.n102 8.501
R1942 VSS.n498 VSS.t2093 0.130189
R1943 VSS.t2091 VSS.n102 8.501
R1944 VSS.n497 VSS.t2088 0.130189
R1945 VSS.t2086 VSS.n102 8.501
R1946 VSS.n496 VSS.t2083 0.130189
R1947 VSS.t2081 VSS.n102 8.501
R1948 VSS.n495 VSS.t2078 0.130189
R1949 VSS.t2076 VSS.n102 8.501
R1950 VSS.n494 VSS.t2073 0.130189
R1951 VSS.t2071 VSS.n102 8.501
R1952 VSS.n493 VSS.t2068 0.130189
R1953 VSS.t2066 VSS.n102 8.501
R1954 VSS.n492 VSS.t2063 0.130189
R1955 VSS.t2061 VSS.n102 8.501
R1956 VSS.n491 VSS.t2058 0.130189
R1957 VSS.t2056 VSS.n102 8.501
R1958 VSS.n490 VSS.t2053 0.130189
R1959 VSS.t2051 VSS.n298 0.0362711
R1960 VSS.n489 VSS.t2048 0.0793054
R1961 VSS.n102 VSS.t2046 8.501
R1962 VSS.t2043 VSS.n488 0.130189
R1963 VSS.t2041 VSS.n102 8.501
R1964 VSS.t2038 VSS.n487 0.130189
R1965 VSS.t2036 VSS.n102 8.501
R1966 VSS.t2033 VSS.n486 0.130189
R1967 VSS.t2031 VSS.n102 8.501
R1968 VSS.t2028 VSS.n485 0.130189
R1969 VSS.t2026 VSS.n102 8.501
R1970 VSS.t2023 VSS.n484 0.130189
R1971 VSS.t2021 VSS.n102 8.501
R1972 VSS.t2018 VSS.n483 0.130189
R1973 VSS.t2016 VSS.n102 8.501
R1974 VSS.t2013 VSS.n482 0.130189
R1975 VSS.t2011 VSS.n102 8.501
R1976 VSS.t2008 VSS.n481 0.130189
R1977 VSS.t2006 VSS.n102 8.501
R1978 VSS.t2003 VSS.n480 0.130189
R1979 VSS.t2001 VSS.n102 8.501
R1980 VSS.t1998 VSS.n479 0.130189
R1981 VSS.t1996 VSS.n102 8.501
R1982 VSS.t1993 VSS.n478 0.130189
R1983 VSS.t1991 VSS.n102 8.501
R1984 VSS.t1988 VSS.n477 0.130189
R1985 VSS.t1986 VSS.n102 8.501
R1986 VSS.t1983 VSS.n476 0.130189
R1987 VSS.t1981 VSS.n102 8.501
R1988 VSS.t1978 VSS.n475 0.130189
R1989 VSS.t1973 VSS.n474 0.130189
R1990 VSS.t1971 VSS.n102 8.501
R1991 VSS.t1968 VSS.n473 0.130189
R1992 VSS.t1966 VSS.n102 8.501
R1993 VSS.t1963 VSS.n472 0.130189
R1994 VSS.t1961 VSS.n102 8.501
R1995 VSS.t1958 VSS.n471 0.130189
R1996 VSS.t1956 VSS.n102 8.501
R1997 VSS.t1953 VSS.n470 0.130189
R1998 VSS.t1951 VSS.n102 8.501
R1999 VSS.t1948 VSS.n469 0.130189
R2000 VSS.t1946 VSS.n102 8.501
R2001 VSS.t1943 VSS.n468 0.130189
R2002 VSS.t1941 VSS.n102 8.501
R2003 VSS.t1938 VSS.n467 0.130189
R2004 VSS.t1936 VSS.n102 8.501
R2005 VSS.t1933 VSS.n466 0.130189
R2006 VSS.t1931 VSS.n102 8.501
R2007 VSS.t1928 VSS.n465 0.130189
R2008 VSS.t1926 VSS.n102 8.501
R2009 VSS.t1923 VSS.n464 0.130189
R2010 VSS.t1921 VSS.n102 8.501
R2011 VSS.t1918 VSS.n463 0.130189
R2012 VSS.t1916 VSS.n102 8.501
R2013 VSS.t1913 VSS.n462 0.130189
R2014 VSS.t1911 VSS.n102 8.501
R2015 VSS.t1908 VSS.n461 0.130189
R2016 VSS.t1906 VSS.n102 8.501
R2017 VSS.t1903 VSS.n460 0.130189
R2018 VSS.t1901 VSS.n102 8.501
R2019 VSS.t1898 VSS.n459 0.130189
R2020 VSS.t1896 VSS.n102 8.501
R2021 VSS.t1893 VSS.n458 0.130189
R2022 VSS.t1891 VSS.n102 8.501
R2023 VSS.t1888 VSS.n457 0.130189
R2024 VSS.t1886 VSS.n102 8.501
R2025 VSS.n456 VSS.n102 3.33079
R2026 VSS.n568 VSS.t1766 0.130189
R2027 VSS.t1764 VSS.n101 8.501
R2028 VSS.n567 VSS.t1761 0.130189
R2029 VSS.t1759 VSS.n101 8.501
R2030 VSS.n566 VSS.t1756 0.130189
R2031 VSS.t1754 VSS.n101 8.501
R2032 VSS.n565 VSS.t1751 0.130189
R2033 VSS.t1749 VSS.n101 8.501
R2034 VSS.n564 VSS.t1746 0.130189
R2035 VSS.t1744 VSS.n101 8.501
R2036 VSS.n563 VSS.t1741 0.130189
R2037 VSS.t1739 VSS.n101 8.501
R2038 VSS.n562 VSS.t1736 0.130189
R2039 VSS.t1734 VSS.n295 0.0362711
R2040 VSS.n561 VSS.t1731 0.0793054
R2041 VSS.n101 VSS.t1729 8.501
R2042 VSS.t1726 VSS.n560 0.130189
R2043 VSS.t1724 VSS.n101 8.501
R2044 VSS.t1721 VSS.n559 0.130189
R2045 VSS.t1719 VSS.n101 8.501
R2046 VSS.t1716 VSS.n558 0.130189
R2047 VSS.t1714 VSS.n101 8.501
R2048 VSS.t1711 VSS.n557 0.130189
R2049 VSS.t1709 VSS.n101 8.501
R2050 VSS.t1706 VSS.n556 0.130189
R2051 VSS.t1704 VSS.n101 8.501
R2052 VSS.t1701 VSS.n555 0.130189
R2053 VSS.t1699 VSS.n101 8.501
R2054 VSS.t1696 VSS.n554 0.130189
R2055 VSS.t1694 VSS.n101 8.501
R2056 VSS.t1691 VSS.n553 0.130189
R2057 VSS.t1689 VSS.n101 8.501
R2058 VSS.t1686 VSS.n552 0.130189
R2059 VSS.t1684 VSS.n101 8.501
R2060 VSS.t1681 VSS.n551 0.130189
R2061 VSS.t1679 VSS.n101 8.501
R2062 VSS.t1676 VSS.n550 0.130189
R2063 VSS.t1674 VSS.n101 8.501
R2064 VSS.t1671 VSS.n549 0.130189
R2065 VSS.t1669 VSS.n101 8.501
R2066 VSS.t1666 VSS.n548 0.130189
R2067 VSS.t1664 VSS.n101 8.501
R2068 VSS.t1661 VSS.n547 0.130189
R2069 VSS.t1659 VSS.n296 0.0362711
R2070 VSS.n546 VSS.t1656 0.0793054
R2071 VSS.t1654 VSS.n101 8.501
R2072 VSS.n545 VSS.t1651 0.130189
R2073 VSS.t1649 VSS.n101 8.501
R2074 VSS.n544 VSS.t1646 0.130189
R2075 VSS.t1644 VSS.n101 8.501
R2076 VSS.n543 VSS.t1641 0.130189
R2077 VSS.t1639 VSS.n101 8.501
R2078 VSS.n542 VSS.t1636 0.130189
R2079 VSS.t1634 VSS.n101 8.501
R2080 VSS.n541 VSS.t1631 0.130189
R2081 VSS.t1629 VSS.n101 8.501
R2082 VSS.n540 VSS.t1626 0.130189
R2083 VSS.t1624 VSS.n101 8.501
R2084 VSS.n539 VSS.t1621 0.130189
R2085 VSS.t1619 VSS.n101 8.501
R2086 VSS.n538 VSS.t1616 0.130189
R2087 VSS.t1614 VSS.n101 8.501
R2088 VSS.n537 VSS.t1611 0.130189
R2089 VSS.t1609 VSS.n101 8.501
R2090 VSS.n536 VSS.t1606 0.130189
R2091 VSS.t1604 VSS.n101 8.501
R2092 VSS.n535 VSS.t1601 0.130189
R2093 VSS.t1599 VSS.n101 8.501
R2094 VSS.n534 VSS.t1596 0.130189
R2095 VSS.t1594 VSS.n101 8.501
R2096 VSS.n533 VSS.t1591 0.130189
R2097 VSS.t1589 VSS.n101 8.501
R2098 VSS.n532 VSS.t1586 0.130189
R2099 VSS.n531 VSS.t1581 0.130189
R2100 VSS.t1579 VSS.n101 8.501
R2101 VSS.t1576 VSS.n530 0.130189
R2102 VSS.t1574 VSS.n101 8.501
R2103 VSS.t1571 VSS.n529 0.130189
R2104 VSS.t1569 VSS.n101 8.501
R2105 VSS.t1566 VSS.n528 0.130189
R2106 VSS.t1564 VSS.n101 8.501
R2107 VSS.t1561 VSS.n527 0.130189
R2108 VSS.t1559 VSS.n101 8.501
R2109 VSS.t1556 VSS.n526 0.130189
R2110 VSS.t1554 VSS.n101 8.501
R2111 VSS.t1551 VSS.n525 0.130189
R2112 VSS.t1549 VSS.n101 8.501
R2113 VSS.t1546 VSS.n524 0.130189
R2114 VSS.t1544 VSS.n101 8.501
R2115 VSS.t1541 VSS.n523 0.130189
R2116 VSS.t1539 VSS.n101 8.501
R2117 VSS.t1536 VSS.n522 0.130189
R2118 VSS.t1534 VSS.n101 8.501
R2119 VSS.t1531 VSS.n521 0.130189
R2120 VSS.t1529 VSS.n101 8.501
R2121 VSS.t1526 VSS.n520 0.130189
R2122 VSS.t1524 VSS.n101 8.501
R2123 VSS.t1521 VSS.n519 0.130189
R2124 VSS.t1519 VSS.n101 8.501
R2125 VSS.t1516 VSS.n518 0.130189
R2126 VSS.t1514 VSS.n101 8.501
R2127 VSS.t1511 VSS.n517 0.130189
R2128 VSS.t1509 VSS.n101 8.501
R2129 VSS.t1506 VSS.n516 0.130189
R2130 VSS.t1504 VSS.n101 8.501
R2131 VSS.t1501 VSS.n515 0.130189
R2132 VSS.t1499 VSS.n101 8.501
R2133 VSS.t1496 VSS.n514 0.130189
R2134 VSS.t1494 VSS.n101 8.501
R2135 VSS.n513 VSS.n101 3.33079
R2136 VSS.n658 VSS.t1086 0.130189
R2137 VSS.t1084 VSS.n106 8.501
R2138 VSS.n657 VSS.t1081 0.130189
R2139 VSS.t1079 VSS.n106 8.501
R2140 VSS.n656 VSS.t1076 0.130189
R2141 VSS.t1074 VSS.n106 8.501
R2142 VSS.n655 VSS.t1071 0.130189
R2143 VSS.t1069 VSS.n106 8.501
R2144 VSS.n654 VSS.t1066 0.130189
R2145 VSS.t1064 VSS.n106 8.501
R2146 VSS.n653 VSS.t1061 0.130189
R2147 VSS.t1059 VSS.n106 8.501
R2148 VSS.n652 VSS.t1056 0.130189
R2149 VSS.t1054 VSS.n272 0.0362711
R2150 VSS.n651 VSS.t1051 0.0793054
R2151 VSS.n106 VSS.t1049 8.501
R2152 VSS.t1046 VSS.n650 0.130189
R2153 VSS.t1044 VSS.n106 8.501
R2154 VSS.t1041 VSS.n649 0.130189
R2155 VSS.t1039 VSS.n106 8.501
R2156 VSS.t1036 VSS.n648 0.130189
R2157 VSS.t1034 VSS.n106 8.501
R2158 VSS.t1031 VSS.n647 0.130189
R2159 VSS.t1029 VSS.n106 8.501
R2160 VSS.t1026 VSS.n646 0.130189
R2161 VSS.t1024 VSS.n106 8.501
R2162 VSS.t1021 VSS.n645 0.130189
R2163 VSS.t1019 VSS.n106 8.501
R2164 VSS.t1016 VSS.n644 0.130189
R2165 VSS.t1014 VSS.n106 8.501
R2166 VSS.t1011 VSS.n643 0.130189
R2167 VSS.t1009 VSS.n106 8.501
R2168 VSS.t1006 VSS.n642 0.130189
R2169 VSS.t1004 VSS.n106 8.501
R2170 VSS.t1001 VSS.n641 0.130189
R2171 VSS.t999 VSS.n106 8.501
R2172 VSS.t996 VSS.n640 0.130189
R2173 VSS.t994 VSS.n106 8.501
R2174 VSS.t991 VSS.n639 0.130189
R2175 VSS.t989 VSS.n106 8.501
R2176 VSS.t986 VSS.n638 0.130189
R2177 VSS.t984 VSS.n106 8.501
R2178 VSS.t981 VSS.n637 0.130189
R2179 VSS.t979 VSS.n273 0.0362711
R2180 VSS.t976 VSS.n636 0.0793054
R2181 VSS.t974 VSS.n106 8.501
R2182 VSS.t971 VSS.n635 0.130189
R2183 VSS.t969 VSS.n106 8.501
R2184 VSS.t966 VSS.n634 0.130189
R2185 VSS.t964 VSS.n106 8.501
R2186 VSS.t961 VSS.n633 0.130189
R2187 VSS.t959 VSS.n106 8.501
R2188 VSS.t956 VSS.n632 0.130189
R2189 VSS.t954 VSS.n106 8.501
R2190 VSS.t951 VSS.n631 0.130189
R2191 VSS.t949 VSS.n106 8.501
R2192 VSS.t946 VSS.n630 0.130189
R2193 VSS.t944 VSS.n106 8.501
R2194 VSS.t941 VSS.n629 0.130189
R2195 VSS.t939 VSS.n106 8.501
R2196 VSS.t936 VSS.n628 0.130189
R2197 VSS.t934 VSS.n106 8.501
R2198 VSS.t931 VSS.n627 0.130189
R2199 VSS.t929 VSS.n106 8.501
R2200 VSS.t926 VSS.n626 0.130189
R2201 VSS.t924 VSS.n106 8.501
R2202 VSS.t921 VSS.n625 0.130189
R2203 VSS.t919 VSS.n106 8.501
R2204 VSS.t916 VSS.n624 0.130189
R2205 VSS.t914 VSS.n106 8.501
R2206 VSS.t911 VSS.n623 0.130189
R2207 VSS.t909 VSS.n106 8.501
R2208 VSS.t906 VSS.n622 0.130189
R2209 VSS.t901 VSS.n621 0.130189
R2210 VSS.t899 VSS.n106 8.501
R2211 VSS.t896 VSS.n620 0.130189
R2212 VSS.t894 VSS.n106 8.501
R2213 VSS.t891 VSS.n619 0.130189
R2214 VSS.t889 VSS.n106 8.501
R2215 VSS.t886 VSS.n618 0.130189
R2216 VSS.t884 VSS.n106 8.501
R2217 VSS.t881 VSS.n617 0.130189
R2218 VSS.t879 VSS.n106 8.501
R2219 VSS.t876 VSS.n616 0.130189
R2220 VSS.t874 VSS.n106 8.501
R2221 VSS.t871 VSS.n615 0.130189
R2222 VSS.t869 VSS.n106 8.501
R2223 VSS.t866 VSS.n614 0.130189
R2224 VSS.t864 VSS.n106 8.501
R2225 VSS.t861 VSS.n613 0.130189
R2226 VSS.t859 VSS.n106 8.501
R2227 VSS.t856 VSS.n612 0.130189
R2228 VSS.t854 VSS.n106 8.501
R2229 VSS.t851 VSS.n611 0.130189
R2230 VSS.t849 VSS.n106 8.501
R2231 VSS.t846 VSS.n610 0.130189
R2232 VSS.t844 VSS.n106 8.501
R2233 VSS.t841 VSS.n609 0.130189
R2234 VSS.t839 VSS.n106 8.501
R2235 VSS.t836 VSS.n608 0.130189
R2236 VSS.t834 VSS.n106 8.501
R2237 VSS.t831 VSS.n607 0.130189
R2238 VSS.t829 VSS.n106 8.501
R2239 VSS.t826 VSS.n606 0.130189
R2240 VSS.t824 VSS.n106 8.501
R2241 VSS.t821 VSS.n605 0.130189
R2242 VSS.t819 VSS.n106 8.501
R2243 VSS.t816 VSS.n604 0.130189
R2244 VSS.t814 VSS.n106 8.501
R2245 VSS.n603 VSS.n106 3.33079
R2246 VSS.t731 VSS.n672 0.0333775
R2247 VSS.t729 VSS.t105 8.501
R2248 VSS.t59 VSS.n671 0.129991
R2249 VSS.t725 VSS.t105 8.501
R2250 VSS.t618 VSS.n670 0.123414
R2251 VSS.t615 VSS.t105 8.501
R2252 VSS.t612 VSS.n669 0.130189
R2253 VSS.t610 VSS.t105 8.501
R2254 VSS.n668 VSS.t607 0.130189
R2255 VSS.n667 VSS.t602 0.130189
R2256 VSS.t600 VSS.t105 8.501
R2257 VSS.t597 VSS.n666 0.130189
R2258 VSS.t595 VSS.t105 8.501
R2259 VSS.t592 VSS.n665 0.130189
R2260 VSS.t590 VSS.t105 8.501
R2261 VSS.t587 VSS.n664 0.130189
R2262 VSS.t585 VSS.t105 8.501
R2263 VSS.t582 VSS.n663 0.130189
R2264 VSS.t580 VSS.t105 8.501
R2265 VSS.t577 VSS.n662 0.130189
R2266 VSS.t575 VSS.t105 8.501
R2267 VSS.t572 VSS.n661 0.130189
R2268 VSS.t570 VSS.t105 8.501
R2269 VSS.t567 VSS.n660 0.130189
R2270 VSS.n271 VSS.t105 1.74963
R2271 VSS.t254 VSS.n659 0.235729
R2272 VSS.n674 VSS.t105 0.983384
R2273 VSS.t735 VSS.n673 0.130189
R2274 VSS.t105 VSS.n252 4.20253
R2275 VSS.t744 VSS.n183 0.331253
R2276 VSS.t635 VSS.n679 0.235729
R2277 VSS.n678 VSS.t105 2.74175
R2278 VSS.t627 VSS.n677 0.235729
R2279 VSS.t625 VSS.n676 0.235729
R2280 VSS.t215 VSS.n675 0.129991
R2281 VSS.t623 VSS.n230 0.575462
R2282 VSS.t637 VSS.t105 8.501
R2283 VSS.t771 VSS.n682 0.130189
R2284 VSS.t769 VSS.t105 8.501
R2285 VSS.n681 VSS.t34 0.130189
R2286 VSS.t77 VSS.n680 0.652244
R2287 VSS.t682 VSS.n699 0.096752
R2288 VSS.t679 VSS.n698 0.235729
R2289 VSS.t676 VSS.n697 0.235729
R2290 VSS.t673 VSS.n696 0.235729
R2291 VSS.t670 VSS.n695 0.235729
R2292 VSS.t667 VSS.n694 0.235729
R2293 VSS.t664 VSS.n693 0.235729
R2294 VSS.t661 VSS.n692 0.235729
R2295 VSS.t658 VSS.n691 0.235729
R2296 VSS.t655 VSS.n690 0.235729
R2297 VSS.t652 VSS.n689 0.235729
R2298 VSS.t649 VSS.n688 0.235729
R2299 VSS.t646 VSS.n687 0.235729
R2300 VSS.t643 VSS.n686 0.235729
R2301 VSS.t640 VSS.n685 0.235729
R2302 VSS.t102 VSS.n684 0.235729
R2303 VSS.t105 VSS.n683 2.31576
R2304 VSS.t774 VSS.t105 8.501
R2305 VSS.n700 VSS.t19 0.983739
R2306 VSS.t297 VSS.t19 8.501
R2307 VSS.n701 VSS.t19 0.482662
R2308 VSS.n235 VSS.t19 0.99289
R2309 VSS.n255 VSS.t19 2.74273
R2310 VSS.t446 VSS.n256 0.0737702
R2311 VSS.t492 VSS.n716 0.096752
R2312 VSS.t19 VSS.t491 8.501
R2313 VSS.t489 VSS.n715 0.130189
R2314 VSS.t19 VSS.t488 8.501
R2315 VSS.t486 VSS.n714 0.130189
R2316 VSS.t19 VSS.t485 8.501
R2317 VSS.t483 VSS.n713 0.130189
R2318 VSS.t19 VSS.t482 8.501
R2319 VSS.t480 VSS.n712 0.130189
R2320 VSS.t19 VSS.t479 8.501
R2321 VSS.t477 VSS.n711 0.130189
R2322 VSS.t19 VSS.t476 8.501
R2323 VSS.t474 VSS.n710 0.130189
R2324 VSS.t19 VSS.t473 8.501
R2325 VSS.t471 VSS.n709 0.130189
R2326 VSS.t19 VSS.t470 8.501
R2327 VSS.t468 VSS.n708 0.130189
R2328 VSS.t19 VSS.t467 8.501
R2329 VSS.t465 VSS.n707 0.130189
R2330 VSS.t19 VSS.t464 8.501
R2331 VSS.t462 VSS.n706 0.130189
R2332 VSS.t19 VSS.t461 8.501
R2333 VSS.t459 VSS.n705 0.130189
R2334 VSS.t19 VSS.t458 8.501
R2335 VSS.t456 VSS.n704 0.130189
R2336 VSS.t19 VSS.t455 8.501
R2337 VSS.t453 VSS.n703 0.130189
R2338 VSS.t19 VSS.t452 8.501
R2339 VSS.n702 VSS.t450 0.130189
R2340 VSS.t449 VSS.t19 8.501
R2341 VSS.n719 VSS.t506 0.130189
R2342 VSS.t29 VSS.t19 8.501
R2343 VSS.n718 VSS.t6 0.130189
R2344 VSS.n717 VSS.t19 0.574293
R2345 VSS.n724 VSS.t19 0.60983
R2346 VSS.n723 VSS.t19 3.33079
R2347 VSS.n722 VSS.t19 0.991912
R2348 VSS.t435 VSS.t19 8.501
R2349 VSS.n721 VSS.t19 3.33079
R2350 VSS.n103 VSS.t2368 8.5005
R2351 VSS.t1976 VSS.n102 8.5005
R2352 VSS.n101 VSS.t1584 8.5005
R2353 VSS.t904 VSS.n106 8.5005
R2354 VSS.t105 VSS.t605 8.5005
R2355 VSS.n370 VSS.n123 4.20468
R2356 VSS.n355 VSS.n123 4.20468
R2357 VSS.t352 VSS.n381 0.173604
R2358 VSS.n391 VSS.t389 0.153604
R2359 VSS.n393 VSS.t2920 0.17801
R2360 VSS.t2802 VSS.t199 8.47111
R2361 VSS.n188 VSS.t199 4.177
R2362 VSS.n188 VSS.t2804 0.119605
R2363 VSS.n204 VSS.t199 4.177
R2364 VSS.t2806 VSS.n204 0.119605
R2365 VSS.t199 VSS.n394 3.30696
R2366 VSS.t2928 VSS.n302 0.17801
R2367 VSS.t2931 VSS.n209 0.119605
R2368 VSS.t199 VSS.t2812 8.47111
R2369 VSS.n209 VSS.t199 4.177
R2370 VSS.t2814 VSS.n395 0.119605
R2371 VSS.t199 VSS.n395 4.177
R2372 VSS.n301 VSS.t199 4.177
R2373 VSS.n301 VSS.t2818 0.119605
R2374 VSS.t2820 VSS.n396 0.083315
R2375 VSS.n250 VSS.t199 3.30696
R2376 VSS.n303 VSS.t2796 0.119605
R2377 VSS.n303 VSS.t199 4.177
R2378 VSS.t199 VSS.n249 3.30688
R2379 VSS.t2788 VSS.n304 0.17801
R2380 VSS.t2782 VSS.n248 0.17801
R2381 VSS.n305 VSS.t2778 0.177814
R2382 VSS.n306 VSS.t2773 0.177814
R2383 VSS.n247 VSS.t2768 0.177814
R2384 VSS.n307 VSS.t2764 0.17801
R2385 VSS.t199 VSS.t2759 8.47111
R2386 VSS.n308 VSS.t2758 0.17801
R2387 VSS.n246 VSS.t2753 0.17801
R2388 VSS.t2749 VSS.n309 0.17801
R2389 VSS.t2744 VSS.n245 0.17801
R2390 VSS.t2740 VSS.n310 0.177814
R2391 VSS.t2735 VSS.n311 0.177814
R2392 VSS.n244 VSS.t199 3.30696
R2393 VSS.n312 VSS.t2726 0.177814
R2394 VSS.t199 VSS.t2721 8.47111
R2395 VSS.n313 VSS.t2720 0.177814
R2396 VSS.n243 VSS.t2714 0.177814
R2397 VSS.n314 VSS.t2709 0.17801
R2398 VSS.n242 VSS.t2703 0.17801
R2399 VSS.t2698 VSS.n315 0.17801
R2400 VSS.t2692 VSS.n316 0.17801
R2401 VSS.t2686 VSS.n241 0.17801
R2402 VSS.t2684 VSS.n240 0.17801
R2403 VSS.n239 VSS.t2682 0.17801
R2404 VSS.t2677 VSS.n317 0.119605
R2405 VSS.t199 VSS.n317 4.177
R2406 VSS.t199 VSS.n238 3.30688
R2407 VSS.t2670 VSS.n237 0.17801
R2408 VSS.n397 VSS.t2667 0.10425
R2409 VSS.n103 VSS.n447 4.20468
R2410 VSS.n432 VSS.n103 4.20468
R2411 VSS.n504 VSS.n102 4.20468
R2412 VSS.n489 VSS.n102 4.20468
R2413 VSS.n561 VSS.n101 4.20468
R2414 VSS.n546 VSS.n101 4.20468
R2415 VSS.n569 VSS.t248 5.61485
R2416 VSS.t1256 VSS.n570 0.418588
R2417 VSS.t1259 VSS.n186 0.119605
R2418 VSS.n186 VSS.t248 4.177
R2419 VSS.n571 VSS.t248 3.30696
R2420 VSS.t1265 VSS.n572 0.177814
R2421 VSS.n157 VSS.t248 3.30688
R2422 VSS.t1269 VSS.n573 0.119605
R2423 VSS.n573 VSS.t248 4.177
R2424 VSS.n203 VSS.t248 4.177
R2425 VSS.t1272 VSS.n203 0.119605
R2426 VSS.n574 VSS.t248 3.30688
R2427 VSS.t1275 VSS.t248 8.47111
R2428 VSS.t1276 VSS.n575 0.17801
R2429 VSS.t1279 VSS.n576 0.119605
R2430 VSS.n576 VSS.t248 4.177
R2431 VSS.t1282 VSS.n577 0.119605
R2432 VSS.n577 VSS.t248 4.177
R2433 VSS.t1285 VSS.n578 0.119605
R2434 VSS.n578 VSS.t248 4.177
R2435 VSS.t1287 VSS.t248 8.47111
R2436 VSS.n283 VSS.t248 3.30696
R2437 VSS.t1290 VSS.n196 0.119605
R2438 VSS.t1292 VSS.n579 0.119605
R2439 VSS.n196 VSS.t248 4.177
R2440 VSS.n579 VSS.t248 4.177
R2441 VSS.n282 VSS.t248 4.177
R2442 VSS.t1294 VSS.n282 0.119605
R2443 VSS.t1296 VSS.n281 0.17801
R2444 VSS.t1297 VSS.t248 8.47111
R2445 VSS.t248 VSS.n580 5.61485
R2446 VSS.t1302 VSS.n207 0.17801
R2447 VSS.t248 VSS.n581 4.177
R2448 VSS.n581 VSS.t1304 0.119605
R2449 VSS.n582 VSS.t1305 0.119605
R2450 VSS.t1443 VSS.t248 8.47111
R2451 VSS.t248 VSS.n582 4.177
R2452 VSS.n583 VSS.t248 3.30688
R2453 VSS.t1446 VSS.t248 8.47111
R2454 VSS.t1310 VSS.n210 0.119605
R2455 VSS.n210 VSS.t248 4.177
R2456 VSS.n584 VSS.t1312 0.119605
R2457 VSS.t248 VSS.n584 4.177
R2458 VSS.n585 VSS.t1314 0.119605
R2459 VSS.t1451 VSS.t248 8.47111
R2460 VSS.t248 VSS.n585 4.177
R2461 VSS.t1316 VSS.n586 0.17801
R2462 VSS.t1454 VSS.t248 8.47111
R2463 VSS.n587 VSS.t248 3.30688
R2464 VSS.t248 VSS.n175 3.30688
R2465 VSS.n588 VSS.t1325 0.119605
R2466 VSS.t248 VSS.n588 4.177
R2467 VSS.t248 VSS.n279 4.177
R2468 VSS.n279 VSS.t1329 0.119605
R2469 VSS.n278 VSS.t1331 0.17801
R2470 VSS.t248 VSS.t1332 8.47111
R2471 VSS.t1467 VSS.n151 0.177814
R2472 VSS.n589 VSS.t248 3.30688
R2473 VSS.t1470 VSS.t248 8.47111
R2474 VSS.n590 VSS.t248 3.30688
R2475 VSS.t1473 VSS.t248 8.47111
R2476 VSS.n591 VSS.t248 5.61485
R2477 VSS.t1345 VSS.n205 0.119605
R2478 VSS.t248 VSS.n205 4.177
R2479 VSS.n592 VSS.t248 3.30688
R2480 VSS.t1478 VSS.n277 0.119605
R2481 VSS.n277 VSS.t248 4.177
R2482 VSS.t248 VSS.n176 3.30688
R2483 VSS.n593 VSS.t1355 0.119605
R2484 VSS.t248 VSS.n593 4.177
R2485 VSS.t248 VSS.n276 4.177
R2486 VSS.n276 VSS.t1359 0.119605
R2487 VSS.n275 VSS.t1361 0.17801
R2488 VSS.t248 VSS.t1362 8.47111
R2489 VSS.n274 VSS.t1364 0.17801
R2490 VSS.n206 VSS.t1365 0.149177
R2491 VSS.n594 VSS.t248 4.177
R2492 VSS.n594 VSS.t1253 0.119605
R2493 VSS.t248 VSS.n211 4.177
R2494 VSS.n211 VSS.t1251 0.119605
R2495 VSS.t248 VSS.n595 4.177
R2496 VSS.n595 VSS.t1248 0.119605
R2497 VSS.t248 VSS.n212 4.177
R2498 VSS.t1246 VSS.n212 0.119605
R2499 VSS.n191 VSS.t248 4.177
R2500 VSS.t1244 VSS.n191 0.119605
R2501 VSS.n596 VSS.t248 4.177
R2502 VSS.t1397 VSS.n596 0.119605
R2503 VSS.t248 VSS.n213 4.177
R2504 VSS.n213 VSS.t1240 0.119605
R2505 VSS.t248 VSS.n192 4.177
R2506 VSS.n192 VSS.t1238 0.119605
R2507 VSS.n187 VSS.t248 4.177
R2508 VSS.t1236 VSS.n187 0.119605
R2509 VSS.t1392 VSS.n145 0.119605
R2510 VSS.t248 VSS.n145 4.177
R2511 VSS.t248 VSS.n597 4.177
R2512 VSS.n597 VSS.t1233 0.119605
R2513 VSS.n284 VSS.t1231 0.177814
R2514 VSS.n285 VSS.t1229 0.177814
R2515 VSS.t1385 VSS.n286 0.119605
R2516 VSS.t248 VSS.n286 4.177
R2517 VSS.t248 VSS.n598 4.177
R2518 VSS.n598 VSS.t1225 0.119605
R2519 VSS.n287 VSS.t1223 0.177814
R2520 VSS.n288 VSS.t1221 0.177814
R2521 VSS.t1378 VSS.n289 0.119605
R2522 VSS.t248 VSS.n289 4.177
R2523 VSS.t248 VSS.n599 4.177
R2524 VSS.n599 VSS.t1217 0.119605
R2525 VSS.n290 VSS.t1215 0.177814
R2526 VSS.t1373 VSS.n291 0.177814
R2527 VSS.t1211 VSS.n292 0.119605
R2528 VSS.n292 VSS.t248 4.177
R2529 VSS.n600 VSS.t248 4.177
R2530 VSS.t1208 VSS.n600 0.119605
R2531 VSS.t1206 VSS.n294 0.177814
R2532 VSS.t1204 VSS.t248 8.47111
R2533 VSS.t1203 VSS.n601 0.10425
R2534 VSS.n651 VSS.n106 4.20468
R2535 VSS.n106 VSS.n636 4.20468
R2536 VSS.t732 VSS.n252 0.083315
R2537 VSS.n121 VSS.t254 0.32297
R2538 VSS.t270 VSS.n255 0.179489
R2539 VSS.n194 VSS.t19 4.177
R2540 VSS.t73 VSS.n194 0.119605
R2541 VSS.t23 VSS.n259 0.762797
R2542 VSS.t19 VSS.n256 4.20744
R2543 VSS.t135 VSS.n190 0.177814
R2544 VSS.n160 VSS.t266 0.40553
R2545 VSS.n179 VSS.t19 1.97622
R2546 VSS.n160 VSS.t19 2.72093
R2547 VSS.n840 VSS.t138 8.06935
R2548 VSS.t219 VSS.t730 7.1604
R2549 VSS.t239 VSS.t63 7.1604
R2550 VSS.t52 VSS.t19 0.737454
R2551 VSS.t0 VSS.t19 0.439585
R2552 VSS.t199 VSS.n397 4.19381
R2553 VSS.t105 VSS.n699 3.35999
R2554 VSS.n123 VSS.n377 3.33079
R2555 VSS.n376 VSS.n123 3.33079
R2556 VSS.n123 VSS.n375 3.33079
R2557 VSS.n374 VSS.n123 3.33079
R2558 VSS.n123 VSS.n373 3.33079
R2559 VSS.n372 VSS.n123 3.33079
R2560 VSS.n123 VSS.n371 3.33079
R2561 VSS.n123 VSS.n369 3.33079
R2562 VSS.n368 VSS.n123 3.33079
R2563 VSS.n123 VSS.n367 3.33079
R2564 VSS.n366 VSS.n123 3.33079
R2565 VSS.n123 VSS.n365 3.33079
R2566 VSS.n364 VSS.n123 3.33079
R2567 VSS.n123 VSS.n363 3.33079
R2568 VSS.n362 VSS.n123 3.33079
R2569 VSS.n123 VSS.n361 3.33079
R2570 VSS.n360 VSS.n123 3.33079
R2571 VSS.n123 VSS.n359 3.33079
R2572 VSS.n358 VSS.n123 3.33079
R2573 VSS.n123 VSS.n357 3.33079
R2574 VSS.n356 VSS.n123 3.33079
R2575 VSS.n123 VSS.n354 3.33079
R2576 VSS.n353 VSS.n123 3.33079
R2577 VSS.n352 VSS.n123 3.33079
R2578 VSS.n351 VSS.n123 3.33079
R2579 VSS.n350 VSS.n123 3.33079
R2580 VSS.n349 VSS.n123 3.33079
R2581 VSS.n348 VSS.n123 3.33079
R2582 VSS.n347 VSS.n123 3.33079
R2583 VSS.n346 VSS.n123 3.33079
R2584 VSS.n345 VSS.n123 3.33079
R2585 VSS.n344 VSS.n123 3.33079
R2586 VSS.n343 VSS.n123 3.33079
R2587 VSS.n342 VSS.n123 3.33079
R2588 VSS.n341 VSS.n123 3.33079
R2589 VSS.n340 VSS.n123 3.33079
R2590 VSS.n339 VSS.n123 3.33079
R2591 VSS.n338 VSS.n123 3.33079
R2592 VSS.n337 VSS.n123 3.33079
R2593 VSS.n336 VSS.n123 3.33079
R2594 VSS.n335 VSS.n123 3.33079
R2595 VSS.n334 VSS.n123 3.33079
R2596 VSS.n333 VSS.n123 3.33079
R2597 VSS.n332 VSS.n123 3.33079
R2598 VSS.n331 VSS.n123 3.33079
R2599 VSS.n330 VSS.n123 3.33079
R2600 VSS.n329 VSS.n123 3.33079
R2601 VSS.n328 VSS.n123 3.33079
R2602 VSS.n327 VSS.n123 3.33079
R2603 VSS.n123 VSS.n326 3.33079
R2604 VSS.n324 VSS.n123 3.33079
R2605 VSS.n123 VSS.n323 3.33079
R2606 VSS.t2939 VSS.n322 0.0863258
R2607 VSS.t313 VSS.n725 0.0896992
R2608 VSS.t347 VSS.n380 0.0896992
R2609 VSS.t357 VSS.n382 0.0896992
R2610 VSS.t362 VSS.n383 0.0896992
R2611 VSS.t367 VSS.n384 0.0896992
R2612 VSS.t371 VSS.n386 0.0896992
R2613 VSS.t376 VSS.n387 0.0896992
R2614 VSS.t381 VSS.n388 0.0896992
R2615 VSS.t384 VSS.n390 0.0896992
R2616 VSS.n392 VSS.t394 0.0896992
R2617 VSS.t2800 VSS.t199 5.61485
R2618 VSS.t199 VSS.n393 3.30688
R2619 VSS.t2808 VSS.n394 0.118193
R2620 VSS.t199 VSS.t2809 5.61485
R2621 VSS.t199 VSS.n302 3.30688
R2622 VSS.t2816 VSS.t199 5.61485
R2623 VSS.t2819 VSS.t199 5.61485
R2624 VSS.t2798 VSS.n250 0.118193
R2625 VSS.t199 VSS.t2797 5.61485
R2626 VSS.t199 VSS.t2794 5.61485
R2627 VSS.n249 VSS.t2792 0.118323
R2628 VSS.n165 VSS.t199 2.7209
R2629 VSS.t2789 VSS.n165 0.175554
R2630 VSS.t199 VSS.n304 3.30688
R2631 VSS.n226 VSS.t2786 0.175395
R2632 VSS.n226 VSS.t199 2.72098
R2633 VSS.t2783 VSS.t199 5.61485
R2634 VSS.t199 VSS.n248 3.30688
R2635 VSS.n197 VSS.t2780 0.175395
R2636 VSS.n197 VSS.t199 2.72098
R2637 VSS.n305 VSS.t199 3.30696
R2638 VSS.n225 VSS.t2776 0.175554
R2639 VSS.t199 VSS.n225 2.7209
R2640 VSS.t2774 VSS.t199 5.61485
R2641 VSS.n306 VSS.t199 3.30696
R2642 VSS.n224 VSS.t2771 0.175554
R2643 VSS.t199 VSS.n224 2.7209
R2644 VSS.t2769 VSS.t199 5.61485
R2645 VSS.n247 VSS.t199 3.30696
R2646 VSS.n198 VSS.t2766 0.175554
R2647 VSS.t199 VSS.n198 2.7209
R2648 VSS.t199 VSS.n307 3.30688
R2649 VSS.n223 VSS.t2762 0.175714
R2650 VSS.n223 VSS.t199 2.72082
R2651 VSS.t199 VSS.n308 3.30688
R2652 VSS.t2756 VSS.n222 0.175714
R2653 VSS.t199 VSS.t2754 5.61485
R2654 VSS.t199 VSS.n246 3.30688
R2655 VSS.t2751 VSS.n199 0.175714
R2656 VSS.t199 VSS.n199 2.72082
R2657 VSS.t199 VSS.n309 3.30688
R2658 VSS.n221 VSS.t2747 0.175395
R2659 VSS.n221 VSS.t199 2.72098
R2660 VSS.t199 VSS.t2745 5.61485
R2661 VSS.t199 VSS.n245 3.30688
R2662 VSS.t199 VSS.n189 2.72098
R2663 VSS.t2741 VSS.n189 0.175395
R2664 VSS.n310 VSS.t199 3.30696
R2665 VSS.n220 VSS.t2738 0.175554
R2666 VSS.t199 VSS.n220 2.7209
R2667 VSS.t2736 VSS.t199 5.61485
R2668 VSS.n311 VSS.t199 3.30696
R2669 VSS.n219 VSS.t2733 0.175554
R2670 VSS.t199 VSS.n219 2.7209
R2671 VSS.t2731 VSS.t199 5.61485
R2672 VSS.t2729 VSS.n244 0.118193
R2673 VSS.t199 VSS.n170 2.7209
R2674 VSS.n170 VSS.t2727 0.175554
R2675 VSS.n312 VSS.t199 3.30696
R2676 VSS.t2723 VSS.n218 0.175714
R2677 VSS.t199 VSS.n218 2.72082
R2678 VSS.n313 VSS.t199 3.30696
R2679 VSS.t2717 VSS.n217 0.175714
R2680 VSS.t199 VSS.n217 2.72082
R2681 VSS.t199 VSS.t2715 5.61485
R2682 VSS.n243 VSS.t199 3.30696
R2683 VSS.t2711 VSS.n200 0.175714
R2684 VSS.t199 VSS.n200 2.72082
R2685 VSS.t199 VSS.n314 3.30688
R2686 VSS.t2706 VSS.n216 0.175554
R2687 VSS.n216 VSS.t199 2.7209
R2688 VSS.t199 VSS.t2704 5.61485
R2689 VSS.t199 VSS.n242 3.30688
R2690 VSS.t2700 VSS.n201 0.175554
R2691 VSS.n201 VSS.t199 2.7209
R2692 VSS.t199 VSS.n315 3.30688
R2693 VSS.n215 VSS.t2696 0.175395
R2694 VSS.n215 VSS.t199 2.72098
R2695 VSS.t2693 VSS.t199 5.61485
R2696 VSS.t199 VSS.n316 3.30688
R2697 VSS.n214 VSS.t2690 0.175395
R2698 VSS.n214 VSS.t199 2.72098
R2699 VSS.t2687 VSS.t199 5.61485
R2700 VSS.t199 VSS.n241 3.30688
R2701 VSS.t199 VSS.n240 3.30688
R2702 VSS.t199 VSS.n239 3.30688
R2703 VSS.t2679 VSS.n202 0.175554
R2704 VSS.n202 VSS.t199 2.7209
R2705 VSS.n169 VSS.t2675 0.0600369
R2706 VSS.n238 VSS.t2673 0.118323
R2707 VSS.t2672 VSS.n195 0.175714
R2708 VSS.t199 VSS.n195 2.72082
R2709 VSS.t199 VSS.n237 3.30688
R2710 VSS.t199 VSS.t2668 5.61485
R2711 VSS.n103 VSS.n417 3.33079
R2712 VSS.n454 VSS.n103 3.33079
R2713 VSS.n103 VSS.n453 3.33079
R2714 VSS.n452 VSS.n103 3.33079
R2715 VSS.n103 VSS.n451 3.33079
R2716 VSS.n450 VSS.n103 3.33079
R2717 VSS.n103 VSS.n449 3.33079
R2718 VSS.n448 VSS.n103 3.33079
R2719 VSS.n446 VSS.n103 3.33079
R2720 VSS.n103 VSS.n445 3.33079
R2721 VSS.n444 VSS.n103 3.33079
R2722 VSS.n103 VSS.n443 3.33079
R2723 VSS.n442 VSS.n103 3.33079
R2724 VSS.n103 VSS.n441 3.33079
R2725 VSS.n440 VSS.n103 3.33079
R2726 VSS.n103 VSS.n439 3.33079
R2727 VSS.n438 VSS.n103 3.33079
R2728 VSS.n103 VSS.n437 3.33079
R2729 VSS.n436 VSS.n103 3.33079
R2730 VSS.n103 VSS.n435 3.33079
R2731 VSS.n434 VSS.n103 3.33079
R2732 VSS.n103 VSS.n433 3.33079
R2733 VSS.n103 VSS.n431 3.33079
R2734 VSS.n430 VSS.n103 3.33079
R2735 VSS.n103 VSS.n429 3.33079
R2736 VSS.n428 VSS.n103 3.33079
R2737 VSS.n103 VSS.n427 3.33079
R2738 VSS.n426 VSS.n103 3.33079
R2739 VSS.n103 VSS.n425 3.33079
R2740 VSS.n424 VSS.n103 3.33079
R2741 VSS.n103 VSS.n423 3.33079
R2742 VSS.n422 VSS.n103 3.33079
R2743 VSS.n103 VSS.n421 3.33079
R2744 VSS.n420 VSS.n103 3.33079
R2745 VSS.n103 VSS.n419 3.33079
R2746 VSS.n418 VSS.n103 3.33079
R2747 VSS.n416 VSS.n103 3.33079
R2748 VSS.n103 VSS.n415 3.33079
R2749 VSS.n414 VSS.n103 3.33079
R2750 VSS.n103 VSS.n413 3.33079
R2751 VSS.n412 VSS.n103 3.33079
R2752 VSS.n103 VSS.n411 3.33079
R2753 VSS.n410 VSS.n103 3.33079
R2754 VSS.n103 VSS.n409 3.33079
R2755 VSS.n408 VSS.n103 3.33079
R2756 VSS.n103 VSS.n407 3.33079
R2757 VSS.n406 VSS.n103 3.33079
R2758 VSS.n103 VSS.n405 3.33079
R2759 VSS.n404 VSS.n103 3.33079
R2760 VSS.n103 VSS.n403 3.33079
R2761 VSS.n401 VSS.n103 3.33079
R2762 VSS.n400 VSS.n103 3.33079
R2763 VSS.t2276 VSS.n399 0.0863258
R2764 VSS.n474 VSS.n102 3.33079
R2765 VSS.n102 VSS.n511 3.33079
R2766 VSS.n510 VSS.n102 3.33079
R2767 VSS.n102 VSS.n509 3.33079
R2768 VSS.n508 VSS.n102 3.33079
R2769 VSS.n102 VSS.n507 3.33079
R2770 VSS.n506 VSS.n102 3.33079
R2771 VSS.n102 VSS.n505 3.33079
R2772 VSS.n102 VSS.n503 3.33079
R2773 VSS.n502 VSS.n102 3.33079
R2774 VSS.n102 VSS.n501 3.33079
R2775 VSS.n500 VSS.n102 3.33079
R2776 VSS.n102 VSS.n499 3.33079
R2777 VSS.n498 VSS.n102 3.33079
R2778 VSS.n102 VSS.n497 3.33079
R2779 VSS.n496 VSS.n102 3.33079
R2780 VSS.n102 VSS.n495 3.33079
R2781 VSS.n494 VSS.n102 3.33079
R2782 VSS.n102 VSS.n493 3.33079
R2783 VSS.n492 VSS.n102 3.33079
R2784 VSS.n102 VSS.n491 3.33079
R2785 VSS.n490 VSS.n102 3.33079
R2786 VSS.n102 VSS.n488 3.33079
R2787 VSS.n487 VSS.n102 3.33079
R2788 VSS.n486 VSS.n102 3.33079
R2789 VSS.n485 VSS.n102 3.33079
R2790 VSS.n484 VSS.n102 3.33079
R2791 VSS.n483 VSS.n102 3.33079
R2792 VSS.n482 VSS.n102 3.33079
R2793 VSS.n481 VSS.n102 3.33079
R2794 VSS.n480 VSS.n102 3.33079
R2795 VSS.n479 VSS.n102 3.33079
R2796 VSS.n478 VSS.n102 3.33079
R2797 VSS.n477 VSS.n102 3.33079
R2798 VSS.n476 VSS.n102 3.33079
R2799 VSS.n475 VSS.n102 3.33079
R2800 VSS.n473 VSS.n102 3.33079
R2801 VSS.n472 VSS.n102 3.33079
R2802 VSS.n471 VSS.n102 3.33079
R2803 VSS.n470 VSS.n102 3.33079
R2804 VSS.n469 VSS.n102 3.33079
R2805 VSS.n468 VSS.n102 3.33079
R2806 VSS.n467 VSS.n102 3.33079
R2807 VSS.n466 VSS.n102 3.33079
R2808 VSS.n465 VSS.n102 3.33079
R2809 VSS.n464 VSS.n102 3.33079
R2810 VSS.n463 VSS.n102 3.33079
R2811 VSS.n462 VSS.n102 3.33079
R2812 VSS.n461 VSS.n102 3.33079
R2813 VSS.n460 VSS.n102 3.33079
R2814 VSS.n458 VSS.n102 3.33079
R2815 VSS.n457 VSS.n102 3.33079
R2816 VSS.t1884 VSS.n456 0.0863258
R2817 VSS.n531 VSS.n101 3.33079
R2818 VSS.n568 VSS.n101 3.33079
R2819 VSS.n101 VSS.n567 3.33079
R2820 VSS.n566 VSS.n101 3.33079
R2821 VSS.n101 VSS.n565 3.33079
R2822 VSS.n564 VSS.n101 3.33079
R2823 VSS.n101 VSS.n563 3.33079
R2824 VSS.n562 VSS.n101 3.33079
R2825 VSS.n101 VSS.n560 3.33079
R2826 VSS.n559 VSS.n101 3.33079
R2827 VSS.n558 VSS.n101 3.33079
R2828 VSS.n557 VSS.n101 3.33079
R2829 VSS.n556 VSS.n101 3.33079
R2830 VSS.n555 VSS.n101 3.33079
R2831 VSS.n554 VSS.n101 3.33079
R2832 VSS.n553 VSS.n101 3.33079
R2833 VSS.n552 VSS.n101 3.33079
R2834 VSS.n551 VSS.n101 3.33079
R2835 VSS.n550 VSS.n101 3.33079
R2836 VSS.n549 VSS.n101 3.33079
R2837 VSS.n548 VSS.n101 3.33079
R2838 VSS.n547 VSS.n101 3.33079
R2839 VSS.n101 VSS.n545 3.33079
R2840 VSS.n544 VSS.n101 3.33079
R2841 VSS.n101 VSS.n543 3.33079
R2842 VSS.n542 VSS.n101 3.33079
R2843 VSS.n101 VSS.n541 3.33079
R2844 VSS.n540 VSS.n101 3.33079
R2845 VSS.n101 VSS.n539 3.33079
R2846 VSS.n538 VSS.n101 3.33079
R2847 VSS.n101 VSS.n537 3.33079
R2848 VSS.n536 VSS.n101 3.33079
R2849 VSS.n101 VSS.n535 3.33079
R2850 VSS.n534 VSS.n101 3.33079
R2851 VSS.n101 VSS.n533 3.33079
R2852 VSS.n532 VSS.n101 3.33079
R2853 VSS.n530 VSS.n101 3.33079
R2854 VSS.n529 VSS.n101 3.33079
R2855 VSS.n528 VSS.n101 3.33079
R2856 VSS.n527 VSS.n101 3.33079
R2857 VSS.n526 VSS.n101 3.33079
R2858 VSS.n525 VSS.n101 3.33079
R2859 VSS.n524 VSS.n101 3.33079
R2860 VSS.n523 VSS.n101 3.33079
R2861 VSS.n522 VSS.n101 3.33079
R2862 VSS.n521 VSS.n101 3.33079
R2863 VSS.n520 VSS.n101 3.33079
R2864 VSS.n519 VSS.n101 3.33079
R2865 VSS.n518 VSS.n101 3.33079
R2866 VSS.n517 VSS.n101 3.33079
R2867 VSS.n515 VSS.n101 3.33079
R2868 VSS.n514 VSS.n101 3.33079
R2869 VSS.t1492 VSS.n513 0.0863258
R2870 VSS.n570 VSS.t248 3.30688
R2871 VSS.t1262 VSS.n571 0.118193
R2872 VSS.t1264 VSS.n193 0.175554
R2873 VSS.n572 VSS.t248 3.30696
R2874 VSS.t1268 VSS.n157 0.118323
R2875 VSS.t1274 VSS.n574 0.118323
R2876 VSS.n575 VSS.t248 3.30688
R2877 VSS.t1278 VSS.t248 5.61485
R2878 VSS.t1281 VSS.t248 5.61485
R2879 VSS.t1284 VSS.t248 5.61485
R2880 VSS.t1288 VSS.n283 0.118193
R2881 VSS.n281 VSS.t248 3.30688
R2882 VSS.n280 VSS.t248 4.17712
R2883 VSS.n207 VSS.t248 3.30688
R2884 VSS.n583 VSS.t1308 0.118323
R2885 VSS.t248 VSS.n586 3.30688
R2886 VSS.n587 VSS.t1320 0.118323
R2887 VSS.t248 VSS.t1322 5.61485
R2888 VSS.t1323 VSS.n175 0.118323
R2889 VSS.t248 VSS.t1327 5.61485
R2890 VSS.t248 VSS.n278 3.30688
R2891 VSS.t248 VSS.n251 2.7209
R2892 VSS.t1334 VSS.n251 0.175554
R2893 VSS.t248 VSS.n151 3.30696
R2894 VSS.n589 VSS.t1338 0.118323
R2895 VSS.n590 VSS.t1341 0.118323
R2896 VSS.n592 VSS.t1347 0.118323
R2897 VSS.n236 VSS.t1350 0.175554
R2898 VSS.t248 VSS.n236 2.7209
R2899 VSS.t1353 VSS.n176 0.118323
R2900 VSS.t248 VSS.t1357 5.61485
R2901 VSS.t248 VSS.n275 3.30688
R2902 VSS.t248 VSS.n274 3.30688
R2903 VSS.t1254 VSS.n293 0.0599544
R2904 VSS.t248 VSS.t1250 5.61485
R2905 VSS.t1243 VSS.t248 5.61485
R2906 VSS.t248 VSS.t1232 5.61485
R2907 VSS.n284 VSS.t248 3.30696
R2908 VSS.n285 VSS.t248 3.30696
R2909 VSS.t248 VSS.t1224 5.61485
R2910 VSS.n287 VSS.t248 3.30696
R2911 VSS.n288 VSS.t248 3.30696
R2912 VSS.t248 VSS.t1216 5.61485
R2913 VSS.n290 VSS.t248 3.30696
R2914 VSS.n291 VSS.t248 3.30696
R2915 VSS.t1207 VSS.t248 5.61485
R2916 VSS.n294 VSS.t248 3.30696
R2917 VSS.n621 VSS.n106 3.33079
R2918 VSS.n658 VSS.n106 3.33079
R2919 VSS.n106 VSS.n657 3.33079
R2920 VSS.n656 VSS.n106 3.33079
R2921 VSS.n106 VSS.n655 3.33079
R2922 VSS.n654 VSS.n106 3.33079
R2923 VSS.n106 VSS.n653 3.33079
R2924 VSS.n652 VSS.n106 3.33079
R2925 VSS.n106 VSS.n650 3.33079
R2926 VSS.n649 VSS.n106 3.33079
R2927 VSS.n648 VSS.n106 3.33079
R2928 VSS.n647 VSS.n106 3.33079
R2929 VSS.n646 VSS.n106 3.33079
R2930 VSS.n645 VSS.n106 3.33079
R2931 VSS.n644 VSS.n106 3.33079
R2932 VSS.n643 VSS.n106 3.33079
R2933 VSS.n642 VSS.n106 3.33079
R2934 VSS.n641 VSS.n106 3.33079
R2935 VSS.n640 VSS.n106 3.33079
R2936 VSS.n639 VSS.n106 3.33079
R2937 VSS.n638 VSS.n106 3.33079
R2938 VSS.n637 VSS.n106 3.33079
R2939 VSS.n635 VSS.n106 3.33079
R2940 VSS.n634 VSS.n106 3.33079
R2941 VSS.n633 VSS.n106 3.33079
R2942 VSS.n632 VSS.n106 3.33079
R2943 VSS.n631 VSS.n106 3.33079
R2944 VSS.n630 VSS.n106 3.33079
R2945 VSS.n629 VSS.n106 3.33079
R2946 VSS.n628 VSS.n106 3.33079
R2947 VSS.n627 VSS.n106 3.33079
R2948 VSS.n626 VSS.n106 3.33079
R2949 VSS.n625 VSS.n106 3.33079
R2950 VSS.n624 VSS.n106 3.33079
R2951 VSS.n623 VSS.n106 3.33079
R2952 VSS.n622 VSS.n106 3.33079
R2953 VSS.n620 VSS.n106 3.33079
R2954 VSS.n619 VSS.n106 3.33079
R2955 VSS.n618 VSS.n106 3.33079
R2956 VSS.n617 VSS.n106 3.33079
R2957 VSS.n616 VSS.n106 3.33079
R2958 VSS.n615 VSS.n106 3.33079
R2959 VSS.n614 VSS.n106 3.33079
R2960 VSS.n613 VSS.n106 3.33079
R2961 VSS.n612 VSS.n106 3.33079
R2962 VSS.n611 VSS.n106 3.33079
R2963 VSS.n610 VSS.n106 3.33079
R2964 VSS.n609 VSS.n106 3.33079
R2965 VSS.n608 VSS.n106 3.33079
R2966 VSS.n607 VSS.n106 3.33079
R2967 VSS.n605 VSS.n106 3.33079
R2968 VSS.n604 VSS.n106 3.33079
R2969 VSS.t812 VSS.n603 0.0863258
R2970 VSS.n667 VSS.t105 3.33079
R2971 VSS.t105 VSS.n671 3.33087
R2972 VSS.t105 VSS.n670 3.33348
R2973 VSS.n669 VSS.t105 3.33079
R2974 VSS.n668 VSS.t105 3.33079
R2975 VSS.n666 VSS.t105 3.33079
R2976 VSS.n665 VSS.t105 3.33079
R2977 VSS.n664 VSS.t105 3.33079
R2978 VSS.n663 VSS.t105 3.33079
R2979 VSS.n662 VSS.t105 3.33079
R2980 VSS.n661 VSS.t105 3.33079
R2981 VSS.n660 VSS.t105 3.33079
R2982 VSS.t105 VSS.n673 3.33079
R2983 VSS.t105 VSS.n675 3.33087
R2984 VSS.n681 VSS.t105 3.33079
R2985 VSS.t105 VSS.n682 3.33079
R2986 VSS.t19 VSS.n719 3.33079
R2987 VSS.t19 VSS.n159 2.7209
R2988 VSS.t515 VSS.n159 0.175554
R2989 VSS.n190 VSS.t19 3.30696
R2990 VSS.n110 VSS.t19 0.865364
R2991 VSS.t1 VSS.n254 0.175714
R2992 VSS.n254 VSS.t19 2.72082
R2993 VSS.t276 VSS.n179 0.286777
R2994 VSS.t19 VSS.n715 3.33079
R2995 VSS.t19 VSS.n714 3.33079
R2996 VSS.t19 VSS.n713 3.33079
R2997 VSS.t19 VSS.n712 3.33079
R2998 VSS.t19 VSS.n711 3.33079
R2999 VSS.t19 VSS.n710 3.33079
R3000 VSS.t19 VSS.n709 3.33079
R3001 VSS.t19 VSS.n708 3.33079
R3002 VSS.t19 VSS.n707 3.33079
R3003 VSS.t19 VSS.n706 3.33079
R3004 VSS.t19 VSS.n705 3.33079
R3005 VSS.t19 VSS.n704 3.33079
R3006 VSS.t19 VSS.n703 3.33079
R3007 VSS.t19 VSS.n702 3.33079
R3008 VSS.n109 VSS.t19 0.865538
R3009 VSS.n718 VSS.t19 3.33079
R3010 VSS.t497 VSS.n723 0.0863258
R3011 VSS.t433 VSS.n721 0.0863258
R3012 VSS.t271 VSS.n107 16.952
R3013 VSS.n763 VSS.t281 4.29849
R3014 VSS.t301 VSS.n943 4.28621
R3015 VSS.n776 VSS.t191 4.28621
R3016 VSS.n880 VSS.t149 4.28621
R3017 VSS.n872 VSS.t153 4.28621
R3018 VSS.t248 VSS.n206 3.32935
R3019 VSS.t105 VSS.t219 4.251
R3020 VSS.n716 VSS.t19 3.36082
R3021 VSS.t19 VSS.t63 4.2505
R3022 VSS.n678 VSS.t633 0.379757
R3023 VSS.t239 VSS.n769 3.50108
R3024 VSS.n769 VSS.t2 3.50108
R3025 VSS.t105 VSS.n183 1.74964
R3026 VSS.t105 VSS.n659 2.31585
R3027 VSS.t105 VSS.n679 2.31585
R3028 VSS.t105 VSS.n677 2.31585
R3029 VSS.t105 VSS.n676 2.31585
R3030 VSS.t105 VSS.n698 2.31585
R3031 VSS.t105 VSS.n697 2.31585
R3032 VSS.t105 VSS.n696 2.31585
R3033 VSS.t105 VSS.n695 2.31585
R3034 VSS.t105 VSS.n694 2.31585
R3035 VSS.t105 VSS.n693 2.31585
R3036 VSS.t105 VSS.n692 2.31585
R3037 VSS.t105 VSS.n691 2.31585
R3038 VSS.t105 VSS.n690 2.31585
R3039 VSS.t105 VSS.n689 2.31585
R3040 VSS.t105 VSS.n688 2.31585
R3041 VSS.t105 VSS.n687 2.31585
R3042 VSS.t105 VSS.n686 2.31585
R3043 VSS.t105 VSS.n685 2.31585
R3044 VSS.t105 VSS.n684 2.31585
R3045 VSS.t776 VSS.n683 0.0923917
R3046 VSS.n841 VSS.t21 2.72109
R3047 VSS.t21 VSS.n180 0.405951
R3048 VSS.n318 VSS.t21 0.405951
R3049 VSS.n847 VSS.t21 2.59384
R3050 VSS.n846 VSS.t21 2.59384
R3051 VSS.n843 VSS.t21 2.59384
R3052 VSS.t21 VSS.n378 0.405951
R3053 VSS.t21 VSS.n834 2.59384
R3054 VSS.t21 VSS.n835 2.59384
R3055 VSS.n833 VSS.t21 2.29778
R3056 VSS.t19 VSS.n769 1.88939
R3057 VSS.n230 VSS.t105 0.991884
R3058 VSS.t52 VSS.t87 1.37665
R3059 VSS.n110 VSS.t108 0.0565685
R3060 VSS.n235 VSS.t443 0.0815508
R3061 VSS.t131 VSS.n722 0.0822487
R3062 VSS.t39 VSS.n109 0.034667
R3063 VSS.n700 VSS.t305 0.082792
R3064 VSS.n674 VSS.t620 0.083181
R3065 VSS.t399 VSS.t118 1.17344
R3066 VSS.t41 VSS.t114 1.16654
R3067 VSS.n379 VSS.t339 0.0329209
R3068 VSS.n385 VSS.t370 0.94915
R3069 VSS.t328 VSS.t31 1.1131
R3070 VSS.n838 VSS.t11 1.10319
R3071 VSS.t45 VSS.t403 1.08659
R3072 VSS.t47 VSS.t421 1.08583
R3073 VSS.t162 VSS.n747 1.05782
R3074 VSS.t105 VSS.n121 0.893546
R3075 VSS.t318 VSS.t323 1.01774
R3076 VSS.t339 VSS.t334 1.01465
R3077 VSS.n389 VSS.t56 1.06044
R3078 VSS.t174 VSS.t98 0.983807
R3079 VSS.t45 VSS.t414 0.975846
R3080 VSS.n680 VSS.t105 0.808749
R3081 VSS.n701 VSS.t90 0.819475
R3082 VSS.n319 VSS.t287 0.801469
R3083 VSS.n717 VSS.t6 1.00103
R3084 VSS.t174 VSS.n259 0.080317
R3085 VSS.t26 VSS.n724 0.774744
R3086 VSS.t3 VSS.n717 0.752541
R3087 VSS.n259 VSS.t19 0.72794
R3088 VSS.t3 VSS.t160 0.876684
R3089 VSS.t162 VSS.t160 0.852391
R3090 VSS.t323 VSS.t328 0.841646
R3091 VSS.t0 VSS.t48 0.829229
R3092 VSS.t21 VSS.t418 0.815996
R3093 VSS.t399 VSS.t403 0.807755
R3094 VSS.t92 VSS.t34 0.806182
R3095 VSS.t19 VSS.t160 0.800406
R3096 VSS.t105 VSS.t555 0.355149
R3097 VSS.n680 VSS.t92 0.0757059
R3098 VSS.n724 VSS.t41 0.067182
R3099 VSS.n747 VSS.t114 0.726758
R3100 VSS.t620 VSS.t742 0.716723
R3101 VSS.t440 VSS.t305 0.714038
R3102 VSS.t9 VSS.n674 0.581374
R3103 VSS.t548 VSS.t550 0.708889
R3104 VSS.n700 VSS.t300 0.578618
R3105 VSS.n838 VSS.t118 0.698053
R3106 VSS.n722 VSS.t15 0.570079
R3107 VSS.t143 VSS.n235 0.56497
R3108 VSS.t105 VSS.n49 0.666899
R3109 VSS.n921 VSS.t105 0.666899
R3110 VSS.t19 VSS.n18 0.666899
R3111 VSS.t19 VSS.n22 0.666899
R3112 VSS.t19 VSS.n21 0.666899
R3113 VSS.t19 VSS.n0 0.666899
R3114 VSS.t19 VSS.n2 0.666899
R3115 VSS.n954 VSS.n726 0.66578
R3116 VSS.n899 VSS.n726 0.66578
R3117 VSS.n900 VSS.n899 0.66578
R3118 VSS.n900 VSS.n831 0.66578
R3119 VSS.n910 VSS.n831 0.66578
R3120 VSS.n911 VSS.n910 0.66578
R3121 VSS.n911 VSS.n733 0.66578
R3122 VSS.n949 VSS.n733 0.66578
R3123 VSS.n951 VSS.n730 0.66578
R3124 VSS.n904 VSS.n730 0.66578
R3125 VSS.n905 VSS.n904 0.66578
R3126 VSS.n905 VSS.n895 0.66578
R3127 VSS.n895 VSS.n892 0.66578
R3128 VSS.n892 VSS.n891 0.66578
R3129 VSS.n891 VSS.n890 0.66578
R3130 VSS.n950 VSS.n732 0.66578
R3131 VSS.n903 VSS.n732 0.66578
R3132 VSS.n903 VSS.n902 0.66578
R3133 VSS.n902 VSS.n829 0.66578
R3134 VSS.n913 VSS.n829 0.66578
R3135 VSS.n914 VSS.n913 0.66578
R3136 VSS.n914 VSS.n828 0.66578
R3137 VSS.n952 VSS.n727 0.66578
R3138 VSS.n832 VSS.n727 0.66578
R3139 VSS.n908 VSS.n832 0.66578
R3140 VSS.n909 VSS.n908 0.66578
R3141 VSS.n909 VSS.n777 0.66578
R3142 VSS.n933 VSS.n777 0.66578
R3143 VSS.n934 VSS.n933 0.66578
R3144 VSS.n858 VSS.t19 0.655024
R3145 VSS.t19 VSS.n19 0.655024
R3146 VSS.t105 VSS.n26 0.649813
R3147 VSS.t105 VSS.n25 0.649813
R3148 VSS.t105 VSS.n24 0.649813
R3149 VSS.t105 VSS.n48 0.649813
R3150 VSS.n923 VSS.t105 0.649813
R3151 VSS.t105 VSS.n30 0.649813
R3152 VSS.t105 VSS.n31 0.649813
R3153 VSS.t105 VSS.n32 0.649813
R3154 VSS.t105 VSS.n35 0.649813
R3155 VSS.t105 VSS.n36 0.649813
R3156 VSS.t105 VSS.n34 0.649813
R3157 VSS.t105 VSS.n33 0.649813
R3158 VSS.t105 VSS.n47 0.649813
R3159 VSS.n801 VSS.t105 0.649813
R3160 VSS.t105 VSS.n27 0.649813
R3161 VSS.t105 VSS.n29 0.649813
R3162 VSS.t105 VSS.n28 0.649813
R3163 VSS.t105 VSS.n50 0.649813
R3164 VSS.t105 VSS.n51 0.649813
R3165 VSS.t105 VSS.n52 0.649813
R3166 VSS.t105 VSS.n62 0.649813
R3167 VSS.t105 VSS.n61 0.649813
R3168 VSS.t105 VSS.n63 0.649813
R3169 VSS.t105 VSS.n64 0.649813
R3170 VSS.t105 VSS.n67 0.649813
R3171 VSS.t105 VSS.n68 0.649813
R3172 VSS.t105 VSS.n66 0.649813
R3173 VSS.t105 VSS.n65 0.649813
R3174 VSS.t105 VSS.n59 0.649813
R3175 VSS.t105 VSS.n60 0.649813
R3176 VSS.t105 VSS.n58 0.649813
R3177 VSS.t105 VSS.n57 0.649813
R3178 VSS.t105 VSS.n54 0.649813
R3179 VSS.t105 VSS.n53 0.649813
R3180 VSS.t105 VSS.n55 0.649813
R3181 VSS.t105 VSS.n56 0.649813
R3182 VSS.t105 VSS.n40 0.649813
R3183 VSS.t105 VSS.n39 0.649813
R3184 VSS.t105 VSS.n41 0.649813
R3185 VSS.t105 VSS.n42 0.649813
R3186 VSS.t105 VSS.n45 0.649813
R3187 VSS.t105 VSS.n46 0.649813
R3188 VSS.t105 VSS.n44 0.649813
R3189 VSS.t105 VSS.n43 0.649813
R3190 VSS.t105 VSS.n37 0.649813
R3191 VSS.t105 VSS.n38 0.649813
R3192 VSS.n817 VSS.t105 0.649813
R3193 VSS.t105 VSS.n125 427.5
R3194 VSS.t19 VSS.n16 0.649813
R3195 VSS.t19 VSS.n13 0.649813
R3196 VSS.t19 VSS.n15 0.649813
R3197 VSS.t19 VSS.n14 0.649813
R3198 VSS.n864 VSS.t19 0.649813
R3199 VSS.n866 VSS.t19 0.649813
R3200 VSS.n867 VSS.t19 0.649813
R3201 VSS.n882 VSS.t19 0.649813
R3202 VSS.t19 VSS.n12 0.649813
R3203 VSS.t19 VSS.n1 0.649813
R3204 VSS.n857 VSS.t19 0.648101
R3205 VSS.t19 VSS.n17 0.648101
R3206 VSS.t19 VSS.n20 0.648101
R3207 VSS.t19 VSS.n3 0.648101
R3208 VSS.t19 VSS.n4 0.648101
R3209 VSS.t19 VSS.n11 0.648101
R3210 VSS.t19 VSS.n5 0.648101
R3211 VSS.t19 VSS.n6 0.648101
R3212 VSS.t19 VSS.n7 0.648101
R3213 VSS.t19 VSS.n10 0.648101
R3214 VSS.t19 VSS.n9 0.648101
R3215 VSS.t19 VSS.n8 0.648101
R3216 VSS.n947 VSS.t19 0.648101
R3217 VSS.t318 VSS.n319 0.845789
R3218 VSS.t414 VSS.t418 0.626987
R3219 VSS.t747 VSS.n230 0.571832
R3220 VSS.t31 VSS.t334 0.611475
R3221 VSS.t131 VSS.t165 0.600657
R3222 VSS.t21 VSS.n838 0.594402
R3223 VSS.t13 VSS.n701 1.01616
R3224 VSS.n389 VSS.t21 0.480953
R3225 VSS.t13 VSS.n253 1.06989
R3226 VSS.t21 VSS.t31 0.508724
R3227 VSS.t440 VSS.t443 0.489392
R3228 VSS.t418 VSS.t421 0.453971
R3229 VSS.t86 VSS.n833 0.452661
R3230 VSS.t197 VSS.n385 1.13923
R3231 VSS.n139 VSS.t21 0.219075
R3232 VSS.t21 VSS.n92 0.405951
R3233 VSS.t21 VSS.n81 0.405951
R3234 VSS.t21 VSS.n90 0.219018
R3235 VSS.t21 VSS.n88 0.219018
R3236 VSS.t21 VSS.n82 0.405951
R3237 VSS.t21 VSS.n87 0.219018
R3238 VSS.n94 VSS.t336 47.2102
R3239 VSS.t21 VSS.n84 0.405951
R3240 VSS.t21 VSS.n83 0.219075
R3241 VSS.n127 VSS.t346 47.2102
R3242 VSS.n126 VSS.t350 26.1049
R3243 VSS.t355 VSS.n128 26.1049
R3244 VSS.n850 VSS.t21 0.405951
R3245 VSS.n848 VSS.t21 0.405951
R3246 VSS.n844 VSS.t21 0.405951
R3247 VSS.n842 VSS.t21 0.405951
R3248 VSS.t383 VSS.n138 47.2102
R3249 VSS.t21 VSS.n70 0.225187
R3250 VSS.t21 VSS.n71 0.405951
R3251 VSS.t21 VSS.n72 0.405951
R3252 VSS.t21 VSS.n80 0.405951
R3253 VSS.t21 VSS.n79 0.405951
R3254 VSS.n163 VSS.t3221 64.1701
R3255 VSS.t21 VSS.n78 0.405951
R3256 VSS.t21 VSS.n73 0.219018
R3257 VSS.n113 VSS.t400 26.1053
R3258 VSS.t21 VSS.n77 0.121828
R3259 VSS.t21 VSS.n76 0.405951
R3260 VSS.n118 VSS.t412 47.2102
R3261 VSS.t21 VSS.n75 0.12186
R3262 VSS.t21 VSS.n74 0.405951
R3263 VSS.n158 VSS.t428 47.2101
R3264 VSS.n841 VSS.t263 0.396535
R3265 VSS.t2671 VSS.n195 0.175714
R3266 VSS.n223 VSS.t2761 0.175714
R3267 VSS.t2776 VSS.t2777 0.36115
R3268 VSS.t2771 VSS.t2772 0.36115
R3269 VSS.t2766 VSS.t2767 0.36115
R3270 VSS.t2755 VSS.n222 0.175714
R3271 VSS.t2750 VSS.n199 0.175714
R3272 VSS.t2745 VSS.t2746 0.36115
R3273 VSS.t1263 VSS.t1262 0.36115
R3274 VSS.t2722 VSS.n218 0.175714
R3275 VSS.t2728 VSS.t2729 0.36115
R3276 VSS.t2733 VSS.t2734 0.36115
R3277 VSS.t2738 VSS.t2739 0.36115
R3278 VSS.t2704 VSS.t2705 0.36115
R3279 VSS.t2710 VSS.n200 0.175714
R3280 VSS.t2716 VSS.n217 0.175714
R3281 VSS.t1334 VSS.t1335 0.36115
R3282 VSS.n254 VSS.t3278 0.175714
R3283 VSS.t2797 VSS.t2798 0.36115
R3284 VSS.t2808 VSS.t2809 0.36115
R3285 VSS.t2723 VSS.t2724 0.360811
R3286 VSS.t2678 VSS.n202 0.175554
R3287 VSS.t2687 VSS.t2688 0.360811
R3288 VSS.t2693 VSS.t2694 0.360811
R3289 VSS.t2699 VSS.n201 0.175554
R3290 VSS.t2705 VSS.n216 0.175554
R3291 VSS.t2711 VSS.t2712 0.360811
R3292 VSS.t2717 VSS.t2718 0.360811
R3293 VSS.t2715 VSS.t2716 0.360811
R3294 VSS.t2697 VSS.t2696 0.360811
R3295 VSS.t2691 VSS.t2690 0.360811
R3296 VSS.t2668 VSS.t2669 0.360811
R3297 VSS.n193 VSS.t1263 0.175554
R3298 VSS.t1268 VSS.t1266 0.360811
R3299 VSS.n236 VSS.t1352 0.175554
R3300 VSS.n251 VSS.t1333 0.175554
R3301 VSS.t1320 VSS.t1322 0.360811
R3302 VSS.t3278 VSS.t276 0.360811
R3303 VSS.n110 VSS.t1 0.648324
R3304 VSS.n159 VSS.t88 0.175554
R3305 VSS.t2783 VSS.t2784 0.360811
R3306 VSS.n165 VSS.t2790 0.175554
R3307 VSS.t2787 VSS.t2786 0.360811
R3308 VSS.t2781 VSS.t2780 0.360811
R3309 VSS.n225 VSS.t2775 0.175554
R3310 VSS.n224 VSS.t2770 0.175554
R3311 VSS.n198 VSS.t2765 0.175554
R3312 VSS.t2755 VSS.t2754 0.360811
R3313 VSS.t2747 VSS.t2748 0.360811
R3314 VSS.t2742 VSS.t2743 0.360811
R3315 VSS.t2737 VSS.n220 0.175554
R3316 VSS.t2732 VSS.n219 0.175554
R3317 VSS.n170 VSS.t2728 0.175554
R3318 VSS.t2706 VSS.t2708 0.360471
R3319 VSS.t2700 VSS.t2702 0.360471
R3320 VSS.t2694 VSS.n215 0.175395
R3321 VSS.t2688 VSS.n214 0.175395
R3322 VSS.t2679 VSS.t2681 0.360471
R3323 VSS.t2672 VSS.t2673 0.360471
R3324 VSS.t1278 VSS.t1277 0.360471
R3325 VSS.t1353 VSS.t1352 0.360471
R3326 VSS.t1323 VSS.t1322 0.360471
R3327 VSS.t2790 VSS.t2792 0.360471
R3328 VSS.t2784 VSS.n226 0.175395
R3329 VSS.t2779 VSS.n197 0.175395
R3330 VSS.t2774 VSS.t2775 0.360471
R3331 VSS.t2769 VSS.t2770 0.360471
R3332 VSS.t2762 VSS.t2763 0.360471
R3333 VSS.t2756 VSS.t2757 0.360471
R3334 VSS.t2751 VSS.t2752 0.360471
R3335 VSS.t2746 VSS.n221 0.175395
R3336 VSS.n189 VSS.t2742 0.175395
R3337 VSS.t2736 VSS.t2737 0.360471
R3338 VSS.t2731 VSS.t2732 0.360471
R3339 VSS.t761 VSS.t637 0.344562
R3340 VSS.n659 VSS.t50 0.436369
R3341 VSS.t210 VSS.n271 0.330919
R3342 VSS.t679 VSS.n697 0.433869
R3343 VSS.t676 VSS.n696 0.433869
R3344 VSS.t673 VSS.n695 0.433869
R3345 VSS.t670 VSS.n694 0.433869
R3346 VSS.t667 VSS.n693 0.433869
R3347 VSS.t664 VSS.n692 0.433869
R3348 VSS.t661 VSS.n691 0.433869
R3349 VSS.t658 VSS.n690 0.433869
R3350 VSS.t655 VSS.n689 0.433869
R3351 VSS.t652 VSS.n688 0.433869
R3352 VSS.t649 VSS.n687 0.433869
R3353 VSS.t646 VSS.n686 0.433869
R3354 VSS.t643 VSS.n685 0.433869
R3355 VSS.t630 VSS.n677 0.433869
R3356 VSS.t627 VSS.n676 0.433869
R3357 VSS.t776 VSS.t102 0.341746
R3358 VSS.t50 VSS.n271 0.328762
R3359 VSS.t742 VSS.n183 0.328435
R3360 VSS.t197 VSS.n841 0.338658
R3361 VSS.t36 VSS.n683 0.23595
R3362 VSS.n684 VSS.t640 0.433869
R3363 VSS.n679 VSS.t761 0.0923073
R3364 VSS.t682 VSS.n698 0.422619
R3365 VSS.n325 VSS.t2954 0.0850573
R3366 VSS.t2730 VSS.t2731 0.301114
R3367 VSS.t2735 VSS.t2736 0.301114
R3368 VSS.t2740 VSS.t2741 0.301114
R3369 VSS.t2697 VSS.n315 0.118323
R3370 VSS.t2691 VSS.n316 0.118323
R3371 VSS.t2685 VSS.n241 0.118323
R3372 VSS.t1378 VSS.t1220 0.301114
R3373 VSS.t1385 VSS.t1228 0.301114
R3374 VSS.t1406 VSS.t1254 0.301114
R3375 VSS.n281 VSS.t1295 0.118323
R3376 VSS.t1257 VSS.n570 0.118323
R3377 VSS.t2787 VSS.n304 0.118323
R3378 VSS.t2781 VSS.n248 0.118323
R3379 VSS.n302 VSS.t2811 0.118323
R3380 VSS.n393 VSS.t2803 0.118323
R3381 VSS.t2800 VSS.t2799 0.301114
R3382 VSS.t2677 VSS.t2678 0.301114
R3383 VSS.t2686 VSS.t2687 0.301114
R3384 VSS.t2692 VSS.t2693 0.301114
R3385 VSS.t2698 VSS.t2699 0.301114
R3386 VSS.t2743 VSS.n245 0.118323
R3387 VSS.t2748 VSS.n309 0.118323
R3388 VSS.t2669 VSS.n237 0.118323
R3389 VSS.t2683 VSS.n240 0.118323
R3390 VSS.n314 VSS.t2708 0.118323
R3391 VSS.n242 VSS.t2702 0.118323
R3392 VSS.n239 VSS.t2681 0.118323
R3393 VSS.n238 VSS.t2674 0.17801
R3394 VSS.t1205 VSS.t1204 0.301114
R3395 VSS.t1207 VSS.t1206 0.301114
R3396 VSS.t1212 VSS.t1211 0.301114
R3397 VSS.t1242 VSS.t1243 0.301114
R3398 VSS.n574 VSS.t1273 0.17801
R3399 VSS.t1277 VSS.n575 0.118323
R3400 VSS.t1279 VSS.t1278 0.301114
R3401 VSS.t1282 VSS.t1281 0.301114
R3402 VSS.t1285 VSS.t1284 0.301114
R3403 VSS.t1288 VSS.t1287 0.301114
R3404 VSS.t1363 VSS.n274 0.118323
R3405 VSS.t1360 VSS.n275 0.118323
R3406 VSS.t1357 VSS.t1358 0.301114
R3407 VSS.t1301 VSS.n207 0.118323
R3408 VSS.n176 VSS.t1354 0.17801
R3409 VSS.t1349 VSS.t1350 0.301114
R3410 VSS.t1346 VSS.n592 0.17801
R3411 VSS.t1340 VSS.n590 0.17801
R3412 VSS.t1337 VSS.n589 0.17801
R3413 VSS.t1330 VSS.n278 0.118323
R3414 VSS.t1327 VSS.t1328 0.301114
R3415 VSS.n175 VSS.t1324 0.17801
R3416 VSS.t1319 VSS.n587 0.17801
R3417 VSS.n586 VSS.t1317 0.118323
R3418 VSS.t1307 VSS.n583 0.17801
R3419 VSS.t88 VSS.t23 0.301114
R3420 VSS.t1250 VSS.t1251 0.301114
R3421 VSS.t1232 VSS.t1233 0.301114
R3422 VSS.t1229 VSS.t1230 0.301114
R3423 VSS.t1224 VSS.t1225 0.301114
R3424 VSS.t1221 VSS.t1222 0.301114
R3425 VSS.t1216 VSS.t1217 0.301114
R3426 VSS.t2782 VSS.t2783 0.301114
R3427 VSS.t2788 VSS.t2789 0.301114
R3428 VSS.t2794 VSS.t2795 0.301114
R3429 VSS.t2793 VSS.n249 0.17801
R3430 VSS.t2778 VSS.t2779 0.301114
R3431 VSS.t2773 VSS.t2774 0.301114
R3432 VSS.t2768 VSS.t2769 0.301114
R3433 VSS.t2763 VSS.n307 0.118323
R3434 VSS.t2816 VSS.t2817 0.301114
R3435 VSS.t2819 VSS.t2820 0.301114
R3436 VSS.t2757 VSS.n308 0.118323
R3437 VSS.t2752 VSS.n246 0.118323
R3438 VSS.n244 VSS.t2730 0.177814
R3439 VSS.t2734 VSS.n311 0.118193
R3440 VSS.t2739 VSS.n310 0.118193
R3441 VSS.t2724 VSS.n312 0.118193
R3442 VSS.t2712 VSS.n243 0.118193
R3443 VSS.t2718 VSS.n313 0.118193
R3444 VSS.t2714 VSS.t2715 0.300775
R3445 VSS.t2709 VSS.t2710 0.300775
R3446 VSS.t2703 VSS.t2704 0.300775
R3447 VSS.t2684 VSS.t2685 0.300775
R3448 VSS.t2682 VSS.t2683 0.300775
R3449 VSS.t2674 VSS.t2675 0.300775
R3450 VSS.t2670 VSS.t2671 0.300775
R3451 VSS.t2667 VSS.t2668 0.300775
R3452 VSS.n294 VSS.t1205 0.118193
R3453 VSS.t1208 VSS.t1207 0.300775
R3454 VSS.n291 VSS.t1212 0.118193
R3455 VSS.t1243 VSS.t1244 0.300775
R3456 VSS.n571 VSS.t1260 0.177814
R3457 VSS.t1259 VSS.t1257 0.300775
R3458 VSS.t1265 VSS.t1264 0.300775
R3459 VSS.t1266 VSS.n572 0.118193
R3460 VSS.t1214 VSS.n290 0.118193
R3461 VSS.t1220 VSS.n288 0.118193
R3462 VSS.t1222 VSS.n287 0.118193
R3463 VSS.t1228 VSS.n285 0.118193
R3464 VSS.t1230 VSS.n284 0.118193
R3465 VSS.t1275 VSS.t1274 0.300775
R3466 VSS.t1281 VSS.t1280 0.300775
R3467 VSS.t1284 VSS.t1283 0.300775
R3468 VSS.t1289 VSS.n283 0.177814
R3469 VSS.t1295 VSS.t1294 0.300775
R3470 VSS.t1298 VSS.t1297 0.300775
R3471 VSS.t1362 VSS.t1363 0.300775
R3472 VSS.t1359 VSS.t1360 0.300775
R3473 VSS.t1356 VSS.t1357 0.300775
R3474 VSS.t1347 VSS.t1478 0.300775
R3475 VSS.t1341 VSS.t1473 0.300775
R3476 VSS.t1338 VSS.t1470 0.300775
R3477 VSS.t1335 VSS.n151 0.118193
R3478 VSS.t1332 VSS.t1333 0.300775
R3479 VSS.t1329 VSS.t1330 0.300775
R3480 VSS.t1326 VSS.t1327 0.300775
R3481 VSS.t1317 VSS.t1454 0.300775
R3482 VSS.t1308 VSS.t1446 0.300775
R3483 VSS.t1301 VSS.t1300 0.300775
R3484 VSS.n190 VSS.t98 0.118193
R3485 VSS.t1249 VSS.t1250 0.300775
R3486 VSS.t1231 VSS.t1232 0.300775
R3487 VSS.t1223 VSS.t1224 0.300775
R3488 VSS.t1215 VSS.t1216 0.300775
R3489 VSS.n250 VSS.t2799 0.177814
R3490 VSS.t2796 VSS.t2797 0.300775
R3491 VSS.t2793 VSS.t2794 0.300775
R3492 VSS.t2767 VSS.n247 0.118193
R3493 VSS.t2772 VSS.n306 0.118193
R3494 VSS.t2777 VSS.n305 0.118193
R3495 VSS.t2764 VSS.t2765 0.300775
R3496 VSS.t2819 VSS.t2818 0.300775
R3497 VSS.t2816 VSS.t2815 0.300775
R3498 VSS.t2811 VSS.t2812 0.300775
R3499 VSS.t2809 VSS.t2928 0.300775
R3500 VSS.n394 VSS.t2807 0.177814
R3501 VSS.t2803 VSS.t2804 0.300775
R3502 VSS.t2753 VSS.t2754 0.300775
R3503 VSS.t2749 VSS.t2750 0.300775
R3504 VSS.t2744 VSS.t2745 0.300775
R3505 VSS.t2726 VSS.t2727 0.300775
R3506 VSS.t2721 VSS.t2722 0.300775
R3507 VSS.t21 VSS.n379 0.242614
R3508 VSS.n678 VSS.t630 0.182614
R3509 VSS.n206 VSS.t1366 0.0997544
R3510 VSS.t2829 VSS.n317 0.119605
R3511 VSS.t1392 VSS.t1236 0.241078
R3512 VSS.n596 VSS.t1242 0.119605
R3513 VSS.n191 VSS.t1245 0.119605
R3514 VSS.t1293 VSS.n579 0.360183
R3515 VSS.t1269 VSS.n157 0.418588
R3516 VSS.t1260 VSS.n186 0.360183
R3517 VSS.t1443 VSS.t1307 0.241078
R3518 VSS.t1446 VSS.t1310 0.241078
R3519 VSS.t1451 VSS.t1316 0.241078
R3520 VSS.t1454 VSS.t1319 0.241078
R3521 VSS.t1467 VSS.t1337 0.241078
R3522 VSS.t1470 VSS.t1340 0.241078
R3523 VSS.t1473 VSS.t1343 0.241078
R3524 VSS.t1475 VSS.n205 0.119605
R3525 VSS.t1345 VSS.t1346 0.241078
R3526 VSS.n277 VSS.t1349 0.119605
R3527 VSS.t2923 VSS.t2805 0.241078
R3528 VSS.n209 VSS.t2813 0.119605
R3529 VSS.t1204 VSS.t1203 0.241078
R3530 VSS.t1209 VSS.n600 0.119605
R3531 VSS.t1210 VSS.t1209 0.241078
R3532 VSS.n292 VSS.t1210 0.119605
R3533 VSS.n187 VSS.t1237 0.119605
R3534 VSS.t1245 VSS.t1246 0.241078
R3535 VSS.t1270 VSS.n573 0.119605
R3536 VSS.t1271 VSS.t1270 0.241078
R3537 VSS.n203 VSS.t1271 0.119605
R3538 VSS.t1273 VSS.t1272 0.241078
R3539 VSS.t1276 VSS.t1275 0.241078
R3540 VSS.t1280 VSS.n576 0.119605
R3541 VSS.t1283 VSS.n577 0.119605
R3542 VSS.t1286 VSS.n578 0.119605
R3543 VSS.t1287 VSS.t1286 0.241078
R3544 VSS.t1290 VSS.t1289 0.241078
R3545 VSS.t1291 VSS.n196 0.119605
R3546 VSS.t1292 VSS.t1291 0.241078
R3547 VSS.n282 VSS.t1293 0.119605
R3548 VSS.t1297 VSS.t1296 0.241078
R3549 VSS.n210 VSS.t1311 0.119605
R3550 VSS.t1364 VSS.t1365 0.241078
R3551 VSS.t1361 VSS.t1362 0.241078
R3552 VSS.t1358 VSS.n276 0.119605
R3553 VSS.n593 VSS.t1356 0.119605
R3554 VSS.t1354 VSS.t1355 0.241078
R3555 VSS.t1331 VSS.t1332 0.241078
R3556 VSS.t1328 VSS.n279 0.119605
R3557 VSS.n588 VSS.t1326 0.119605
R3558 VSS.t1324 VSS.t1325 0.241078
R3559 VSS.t1315 VSS.t1451 0.241078
R3560 VSS.n585 VSS.t1315 0.119605
R3561 VSS.t1313 VSS.t1314 0.241078
R3562 VSS.t1311 VSS.t1312 0.241078
R3563 VSS.n584 VSS.t1313 0.119605
R3564 VSS.t1306 VSS.t1443 0.241078
R3565 VSS.n582 VSS.t1306 0.119605
R3566 VSS.t1304 VSS.t1305 0.241078
R3567 VSS.t1302 VSS.t1303 0.241078
R3568 VSS.t1303 VSS.n581 0.119605
R3569 VSS.t73 VSS.n253 1.13212
R3570 VSS.t123 VSS.n194 0.360183
R3571 VSS.n255 VSS.t123 0.207801
R3572 VSS.t65 VSS.t267 0.241078
R3573 VSS.t267 VSS.n160 0.235599
R3574 VSS.n594 VSS.t1406 0.119605
R3575 VSS.t1252 VSS.t1253 0.241078
R3576 VSS.n211 VSS.t1252 0.119605
R3577 VSS.n595 VSS.t1249 0.119605
R3578 VSS.n212 VSS.t1247 0.119605
R3579 VSS.t1247 VSS.t1248 0.241078
R3580 VSS.t1241 VSS.t1397 0.241078
R3581 VSS.n213 VSS.t1241 0.119605
R3582 VSS.t1239 VSS.t1240 0.241078
R3583 VSS.t1237 VSS.t1238 0.241078
R3584 VSS.n192 VSS.t1239 0.119605
R3585 VSS.t1235 VSS.n145 0.119605
R3586 VSS.t1234 VSS.t1235 0.241078
R3587 VSS.n597 VSS.t1234 0.119605
R3588 VSS.t1227 VSS.n286 0.119605
R3589 VSS.t1226 VSS.t1227 0.241078
R3590 VSS.n598 VSS.t1226 0.119605
R3591 VSS.t1219 VSS.n289 0.119605
R3592 VSS.t1218 VSS.t1219 0.241078
R3593 VSS.n599 VSS.t1218 0.119605
R3594 VSS.t2795 VSS.n303 0.119605
R3595 VSS.t2920 VSS.t2802 0.241078
R3596 VSS.t2805 VSS.n204 0.119605
R3597 VSS.t2813 VSS.t2814 0.241078
R3598 VSS.t2817 VSS.n301 0.119605
R3599 VSS.n395 VSS.t2815 0.119605
R3600 VSS.t2812 VSS.t2931 0.241078
R3601 VSS.t2806 VSS.t2807 0.241078
R3602 VSS.n188 VSS.t2923 0.119605
R3603 VSS.t2758 VSS.t2759 0.241078
R3604 VSS.t2828 VSS.n169 0.179761
R3605 VSS.n280 VSS.t1298 0.0600369
R3606 VSS.t2761 VSS.t2760 0.240486
R3607 VSS.n833 VSS.t11 0.232128
R3608 VSS.t21 VSS.t399 0.228622
R3609 VSS.n725 VSS.t315 0.135296
R3610 VSS.t386 VSS.n390 0.135296
R3611 VSS.t56 VSS.n388 0.135296
R3612 VSS.t378 VSS.n387 0.135296
R3613 VSS.t373 VSS.n386 0.135296
R3614 VSS.t263 VSS.n384 0.135296
R3615 VSS.t364 VSS.n383 0.135296
R3616 VSS.t359 VSS.n382 0.135296
R3617 VSS.t349 VSS.n380 0.135296
R3618 VSS.n392 VSS.t86 0.135296
R3619 VSS.t727 VSS.t729 0.227075
R3620 VSS.t725 VSS.t617 0.227075
R3621 VSS.t2939 VSS.t2941 0.226736
R3622 VSS.t2946 VSS.t2944 0.226736
R3623 VSS.t2949 VSS.t2951 0.226736
R3624 VSS.t3109 VSS.t3111 0.226736
R3625 VSS.t3116 VSS.t3114 0.226736
R3626 VSS.t3119 VSS.t3121 0.226736
R3627 VSS.t3126 VSS.t3124 0.226736
R3628 VSS.t3129 VSS.t3131 0.226736
R3629 VSS.t3136 VSS.t3134 0.226736
R3630 VSS.t3139 VSS.t3141 0.226736
R3631 VSS.t3146 VSS.t3144 0.226736
R3632 VSS.t3149 VSS.t3151 0.226736
R3633 VSS.t3156 VSS.t3154 0.226736
R3634 VSS.t3159 VSS.t3161 0.226736
R3635 VSS.t3166 VSS.t3164 0.226736
R3636 VSS.t3169 VSS.t3171 0.226736
R3637 VSS.t3176 VSS.t3174 0.226736
R3638 VSS.t3186 VSS.t3184 0.226736
R3639 VSS.t3189 VSS.t3191 0.226736
R3640 VSS.t3196 VSS.t3194 0.226736
R3641 VSS.t3199 VSS.t3201 0.226736
R3642 VSS.t3206 VSS.t3204 0.226736
R3643 VSS.t3209 VSS.t3211 0.226736
R3644 VSS.t3216 VSS.t3214 0.226736
R3645 VSS.t3036 VSS.t3034 0.226736
R3646 VSS.t3041 VSS.t3039 0.226736
R3647 VSS.t3046 VSS.t3044 0.226736
R3648 VSS.t3051 VSS.t3049 0.226736
R3649 VSS.t3056 VSS.t3054 0.226736
R3650 VSS.t3061 VSS.t3059 0.226736
R3651 VSS.t3066 VSS.t3064 0.226736
R3652 VSS.t3071 VSS.t3069 0.226736
R3653 VSS.t3076 VSS.t3074 0.226736
R3654 VSS.t3081 VSS.t3079 0.226736
R3655 VSS.t3086 VSS.t3084 0.226736
R3656 VSS.t3091 VSS.t3089 0.226736
R3657 VSS.t3096 VSS.t3094 0.226736
R3658 VSS.t3101 VSS.t3099 0.226736
R3659 VSS.t3024 VSS.t3026 0.226736
R3660 VSS.t3019 VSS.t3021 0.226736
R3661 VSS.t3014 VSS.t3016 0.226736
R3662 VSS.t3009 VSS.t3011 0.226736
R3663 VSS.t3004 VSS.t3006 0.226736
R3664 VSS.t2999 VSS.t3001 0.226736
R3665 VSS.t2994 VSS.t2996 0.226736
R3666 VSS.t2989 VSS.t2991 0.226736
R3667 VSS.t2984 VSS.t2986 0.226736
R3668 VSS.t2979 VSS.t2981 0.226736
R3669 VSS.t2974 VSS.t2976 0.226736
R3670 VSS.t2969 VSS.t2971 0.226736
R3671 VSS.t2964 VSS.t2966 0.226736
R3672 VSS.t2961 VSS.t2959 0.226736
R3673 VSS.t2278 VSS.t2276 0.226736
R3674 VSS.t2283 VSS.t2281 0.226736
R3675 VSS.t2288 VSS.t2286 0.226736
R3676 VSS.t2293 VSS.t2291 0.226736
R3677 VSS.t2298 VSS.t2296 0.226736
R3678 VSS.t2301 VSS.t2303 0.226736
R3679 VSS.t2308 VSS.t2306 0.226736
R3680 VSS.t2311 VSS.t2313 0.226736
R3681 VSS.t2318 VSS.t2316 0.226736
R3682 VSS.t2321 VSS.t2323 0.226736
R3683 VSS.t2328 VSS.t2326 0.226736
R3684 VSS.t2331 VSS.t2333 0.226736
R3685 VSS.t2338 VSS.t2336 0.226736
R3686 VSS.t2341 VSS.t2343 0.226736
R3687 VSS.t2348 VSS.t2346 0.226736
R3688 VSS.t2351 VSS.t2353 0.226736
R3689 VSS.t2358 VSS.t2356 0.226736
R3690 VSS.t2361 VSS.t2363 0.226736
R3691 VSS.t2371 VSS.t2373 0.226736
R3692 VSS.t2378 VSS.t2376 0.226736
R3693 VSS.t2381 VSS.t2383 0.226736
R3694 VSS.t2388 VSS.t2386 0.226736
R3695 VSS.t2391 VSS.t2393 0.226736
R3696 VSS.t2398 VSS.t2396 0.226736
R3697 VSS.t2401 VSS.t2403 0.226736
R3698 VSS.t2408 VSS.t2406 0.226736
R3699 VSS.t2411 VSS.t2413 0.226736
R3700 VSS.t2418 VSS.t2416 0.226736
R3701 VSS.t2421 VSS.t2423 0.226736
R3702 VSS.t2428 VSS.t2426 0.226736
R3703 VSS.t2431 VSS.t2433 0.226736
R3704 VSS.t2438 VSS.t2436 0.226736
R3705 VSS.t2448 VSS.t2446 0.226736
R3706 VSS.t2451 VSS.t2453 0.226736
R3707 VSS.t2458 VSS.t2456 0.226736
R3708 VSS.t2461 VSS.t2463 0.226736
R3709 VSS.t2468 VSS.t2466 0.226736
R3710 VSS.t2471 VSS.t2473 0.226736
R3711 VSS.t2478 VSS.t2476 0.226736
R3712 VSS.t2481 VSS.t2483 0.226736
R3713 VSS.t2488 VSS.t2486 0.226736
R3714 VSS.t2491 VSS.t2493 0.226736
R3715 VSS.t2498 VSS.t2496 0.226736
R3716 VSS.t2501 VSS.t2503 0.226736
R3717 VSS.t2508 VSS.t2506 0.226736
R3718 VSS.t2511 VSS.t2513 0.226736
R3719 VSS.t2521 VSS.t2523 0.226736
R3720 VSS.t2528 VSS.t2526 0.226736
R3721 VSS.t2531 VSS.t2533 0.226736
R3722 VSS.t2538 VSS.t2536 0.226736
R3723 VSS.t2541 VSS.t2543 0.226736
R3724 VSS.t2548 VSS.t2546 0.226736
R3725 VSS.t2551 VSS.t2553 0.226736
R3726 VSS.t1886 VSS.t1884 0.226736
R3727 VSS.t1891 VSS.t1889 0.226736
R3728 VSS.t1896 VSS.t1894 0.226736
R3729 VSS.t1901 VSS.t1899 0.226736
R3730 VSS.t1906 VSS.t1904 0.226736
R3731 VSS.t1911 VSS.t1909 0.226736
R3732 VSS.t1916 VSS.t1914 0.226736
R3733 VSS.t1921 VSS.t1919 0.226736
R3734 VSS.t1926 VSS.t1924 0.226736
R3735 VSS.t1931 VSS.t1929 0.226736
R3736 VSS.t1936 VSS.t1934 0.226736
R3737 VSS.t1941 VSS.t1939 0.226736
R3738 VSS.t1946 VSS.t1944 0.226736
R3739 VSS.t1951 VSS.t1949 0.226736
R3740 VSS.t1956 VSS.t1954 0.226736
R3741 VSS.t1961 VSS.t1959 0.226736
R3742 VSS.t1966 VSS.t1964 0.226736
R3743 VSS.t1971 VSS.t1969 0.226736
R3744 VSS.t1981 VSS.t1979 0.226736
R3745 VSS.t1986 VSS.t1984 0.226736
R3746 VSS.t1991 VSS.t1989 0.226736
R3747 VSS.t1996 VSS.t1994 0.226736
R3748 VSS.t2001 VSS.t1999 0.226736
R3749 VSS.t2006 VSS.t2004 0.226736
R3750 VSS.t2011 VSS.t2009 0.226736
R3751 VSS.t2016 VSS.t2014 0.226736
R3752 VSS.t2021 VSS.t2019 0.226736
R3753 VSS.t2026 VSS.t2024 0.226736
R3754 VSS.t2031 VSS.t2029 0.226736
R3755 VSS.t2036 VSS.t2034 0.226736
R3756 VSS.t2041 VSS.t2039 0.226736
R3757 VSS.t2046 VSS.t2044 0.226736
R3758 VSS.t2054 VSS.t2056 0.226736
R3759 VSS.t2061 VSS.t2059 0.226736
R3760 VSS.t2064 VSS.t2066 0.226736
R3761 VSS.t2071 VSS.t2069 0.226736
R3762 VSS.t2074 VSS.t2076 0.226736
R3763 VSS.t2081 VSS.t2079 0.226736
R3764 VSS.t2084 VSS.t2086 0.226736
R3765 VSS.t2091 VSS.t2089 0.226736
R3766 VSS.t2094 VSS.t2096 0.226736
R3767 VSS.t2101 VSS.t2099 0.226736
R3768 VSS.t2104 VSS.t2106 0.226736
R3769 VSS.t2111 VSS.t2109 0.226736
R3770 VSS.t2114 VSS.t2116 0.226736
R3771 VSS.t2121 VSS.t2119 0.226736
R3772 VSS.t2131 VSS.t2129 0.226736
R3773 VSS.t2134 VSS.t2136 0.226736
R3774 VSS.t2141 VSS.t2139 0.226736
R3775 VSS.t2144 VSS.t2146 0.226736
R3776 VSS.t2151 VSS.t2149 0.226736
R3777 VSS.t2154 VSS.t2156 0.226736
R3778 VSS.t2161 VSS.t2159 0.226736
R3779 VSS.t1494 VSS.t1492 0.226736
R3780 VSS.t1499 VSS.t1497 0.226736
R3781 VSS.t1504 VSS.t1502 0.226736
R3782 VSS.t1509 VSS.t1507 0.226736
R3783 VSS.t1514 VSS.t1512 0.226736
R3784 VSS.t1519 VSS.t1517 0.226736
R3785 VSS.t1524 VSS.t1522 0.226736
R3786 VSS.t1529 VSS.t1527 0.226736
R3787 VSS.t1534 VSS.t1532 0.226736
R3788 VSS.t1539 VSS.t1537 0.226736
R3789 VSS.t1544 VSS.t1542 0.226736
R3790 VSS.t1549 VSS.t1547 0.226736
R3791 VSS.t1554 VSS.t1552 0.226736
R3792 VSS.t1559 VSS.t1557 0.226736
R3793 VSS.t1564 VSS.t1562 0.226736
R3794 VSS.t1569 VSS.t1567 0.226736
R3795 VSS.t1574 VSS.t1572 0.226736
R3796 VSS.t1579 VSS.t1577 0.226736
R3797 VSS.t1587 VSS.t1589 0.226736
R3798 VSS.t1594 VSS.t1592 0.226736
R3799 VSS.t1597 VSS.t1599 0.226736
R3800 VSS.t1604 VSS.t1602 0.226736
R3801 VSS.t1607 VSS.t1609 0.226736
R3802 VSS.t1614 VSS.t1612 0.226736
R3803 VSS.t1617 VSS.t1619 0.226736
R3804 VSS.t1624 VSS.t1622 0.226736
R3805 VSS.t1627 VSS.t1629 0.226736
R3806 VSS.t1634 VSS.t1632 0.226736
R3807 VSS.t1637 VSS.t1639 0.226736
R3808 VSS.t1644 VSS.t1642 0.226736
R3809 VSS.t1647 VSS.t1649 0.226736
R3810 VSS.t1654 VSS.t1652 0.226736
R3811 VSS.t1664 VSS.t1662 0.226736
R3812 VSS.t1669 VSS.t1667 0.226736
R3813 VSS.t1674 VSS.t1672 0.226736
R3814 VSS.t1679 VSS.t1677 0.226736
R3815 VSS.t1684 VSS.t1682 0.226736
R3816 VSS.t1689 VSS.t1687 0.226736
R3817 VSS.t1694 VSS.t1692 0.226736
R3818 VSS.t1699 VSS.t1697 0.226736
R3819 VSS.t1704 VSS.t1702 0.226736
R3820 VSS.t1709 VSS.t1707 0.226736
R3821 VSS.t1714 VSS.t1712 0.226736
R3822 VSS.t1719 VSS.t1717 0.226736
R3823 VSS.t1724 VSS.t1722 0.226736
R3824 VSS.t1729 VSS.t1727 0.226736
R3825 VSS.t1737 VSS.t1739 0.226736
R3826 VSS.t1744 VSS.t1742 0.226736
R3827 VSS.t1747 VSS.t1749 0.226736
R3828 VSS.t1754 VSS.t1752 0.226736
R3829 VSS.t1757 VSS.t1759 0.226736
R3830 VSS.t1764 VSS.t1762 0.226736
R3831 VSS.t1767 VSS.t1769 0.226736
R3832 VSS.t814 VSS.t812 0.226736
R3833 VSS.t819 VSS.t817 0.226736
R3834 VSS.t824 VSS.t822 0.226736
R3835 VSS.t829 VSS.t827 0.226736
R3836 VSS.t834 VSS.t832 0.226736
R3837 VSS.t839 VSS.t837 0.226736
R3838 VSS.t844 VSS.t842 0.226736
R3839 VSS.t849 VSS.t847 0.226736
R3840 VSS.t854 VSS.t852 0.226736
R3841 VSS.t859 VSS.t857 0.226736
R3842 VSS.t864 VSS.t862 0.226736
R3843 VSS.t869 VSS.t867 0.226736
R3844 VSS.t874 VSS.t872 0.226736
R3845 VSS.t879 VSS.t877 0.226736
R3846 VSS.t884 VSS.t882 0.226736
R3847 VSS.t889 VSS.t887 0.226736
R3848 VSS.t894 VSS.t892 0.226736
R3849 VSS.t899 VSS.t897 0.226736
R3850 VSS.t909 VSS.t907 0.226736
R3851 VSS.t914 VSS.t912 0.226736
R3852 VSS.t919 VSS.t917 0.226736
R3853 VSS.t924 VSS.t922 0.226736
R3854 VSS.t929 VSS.t927 0.226736
R3855 VSS.t934 VSS.t932 0.226736
R3856 VSS.t939 VSS.t937 0.226736
R3857 VSS.t944 VSS.t942 0.226736
R3858 VSS.t949 VSS.t947 0.226736
R3859 VSS.t954 VSS.t952 0.226736
R3860 VSS.t959 VSS.t957 0.226736
R3861 VSS.t964 VSS.t962 0.226736
R3862 VSS.t969 VSS.t967 0.226736
R3863 VSS.t974 VSS.t972 0.226736
R3864 VSS.t984 VSS.t982 0.226736
R3865 VSS.t989 VSS.t987 0.226736
R3866 VSS.t994 VSS.t992 0.226736
R3867 VSS.t999 VSS.t997 0.226736
R3868 VSS.t1004 VSS.t1002 0.226736
R3869 VSS.t1009 VSS.t1007 0.226736
R3870 VSS.t1014 VSS.t1012 0.226736
R3871 VSS.t1019 VSS.t1017 0.226736
R3872 VSS.t1024 VSS.t1022 0.226736
R3873 VSS.t1029 VSS.t1027 0.226736
R3874 VSS.t1034 VSS.t1032 0.226736
R3875 VSS.t1039 VSS.t1037 0.226736
R3876 VSS.t1044 VSS.t1042 0.226736
R3877 VSS.t1049 VSS.t1047 0.226736
R3878 VSS.t1057 VSS.t1059 0.226736
R3879 VSS.t1064 VSS.t1062 0.226736
R3880 VSS.t1067 VSS.t1069 0.226736
R3881 VSS.t1074 VSS.t1072 0.226736
R3882 VSS.t1077 VSS.t1079 0.226736
R3883 VSS.t1084 VSS.t1082 0.226736
R3884 VSS.t1087 VSS.t1089 0.226736
R3885 VSS.t774 VSS.t772 0.226736
R3886 VSS.t767 VSS.t769 0.226736
R3887 VSS.t613 VSS.t615 0.226736
R3888 VSS.t608 VSS.t610 0.226736
R3889 VSS.t570 VSS.t568 0.226736
R3890 VSS.t575 VSS.t573 0.226736
R3891 VSS.t580 VSS.t578 0.226736
R3892 VSS.t585 VSS.t583 0.226736
R3893 VSS.t590 VSS.t588 0.226736
R3894 VSS.t595 VSS.t593 0.226736
R3895 VSS.t600 VSS.t598 0.226736
R3896 VSS.t448 VSS.t449 0.226736
R3897 VSS.t452 VSS.t451 0.226736
R3898 VSS.t455 VSS.t454 0.226736
R3899 VSS.t458 VSS.t457 0.226736
R3900 VSS.t461 VSS.t460 0.226736
R3901 VSS.t464 VSS.t463 0.226736
R3902 VSS.t467 VSS.t466 0.226736
R3903 VSS.t470 VSS.t469 0.226736
R3904 VSS.t473 VSS.t472 0.226736
R3905 VSS.t476 VSS.t475 0.226736
R3906 VSS.t479 VSS.t478 0.226736
R3907 VSS.t482 VSS.t481 0.226736
R3908 VSS.t485 VSS.t484 0.226736
R3909 VSS.t488 VSS.t487 0.226736
R3910 VSS.t491 VSS.t490 0.226736
R3911 VSS.t435 VSS.t433 0.226736
R3912 VSS.t26 VSS.t497 0.226736
R3913 VSS.t503 VSS.t29 0.226736
R3914 VSS.t297 VSS.t295 0.226736
R3915 VSS.t9 VSS.t736 0.226736
R3916 VSS.t625 VSS.t752 0.224575
R3917 VSS.n327 VSS.t2964 0.0863258
R3918 VSS.n328 VSS.t2969 0.0863258
R3919 VSS.n329 VSS.t2974 0.0863258
R3920 VSS.n330 VSS.t2979 0.0863258
R3921 VSS.n331 VSS.t2984 0.0863258
R3922 VSS.n332 VSS.t2989 0.0863258
R3923 VSS.n333 VSS.t2994 0.0863258
R3924 VSS.n334 VSS.t2999 0.0863258
R3925 VSS.n335 VSS.t3004 0.0863258
R3926 VSS.n336 VSS.t3009 0.0863258
R3927 VSS.n337 VSS.t3014 0.0863258
R3928 VSS.n338 VSS.t3019 0.0863258
R3929 VSS.n339 VSS.t3024 0.0863258
R3930 VSS.n340 VSS.t3029 0.0863258
R3931 VSS.n356 VSS.t3109 0.0863258
R3932 VSS.n358 VSS.t3119 0.0863258
R3933 VSS.n360 VSS.t3129 0.0863258
R3934 VSS.n362 VSS.t3139 0.0863258
R3935 VSS.n364 VSS.t3149 0.0863258
R3936 VSS.n366 VSS.t3159 0.0863258
R3937 VSS.n368 VSS.t3169 0.0863258
R3938 VSS.n718 VSS.t503 0.0863258
R3939 VSS.n668 VSS.t608 0.0863258
R3940 VSS.n669 VSS.t613 0.0863258
R3941 VSS.n681 VSS.t767 0.0863258
R3942 VSS.n652 VSS.t1057 0.0863258
R3943 VSS.n654 VSS.t1067 0.0863258
R3944 VSS.n656 VSS.t1077 0.0863258
R3945 VSS.n658 VSS.t1087 0.0863258
R3946 VSS.t1082 VSS.n657 0.0863258
R3947 VSS.t1072 VSS.n655 0.0863258
R3948 VSS.t1062 VSS.n653 0.0863258
R3949 VSS.t1047 VSS.n650 0.0863258
R3950 VSS.t902 VSS.n621 0.0863258
R3951 VSS.n603 VSS.t811 0.130189
R3952 VSS.t817 VSS.n604 0.0863258
R3953 VSS.t822 VSS.n605 0.0863258
R3954 VSS.t827 VSS.n606 0.0863258
R3955 VSS.n532 VSS.t1587 0.0863258
R3956 VSS.n534 VSS.t1597 0.0863258
R3957 VSS.n536 VSS.t1607 0.0863258
R3958 VSS.n538 VSS.t1617 0.0863258
R3959 VSS.n540 VSS.t1627 0.0863258
R3960 VSS.n542 VSS.t1637 0.0863258
R3961 VSS.n544 VSS.t1647 0.0863258
R3962 VSS.n490 VSS.t2054 0.0863258
R3963 VSS.n492 VSS.t2064 0.0863258
R3964 VSS.n494 VSS.t2074 0.0863258
R3965 VSS.n496 VSS.t2084 0.0863258
R3966 VSS.n498 VSS.t2094 0.0863258
R3967 VSS.n500 VSS.t2104 0.0863258
R3968 VSS.n502 VSS.t2114 0.0863258
R3969 VSS.n562 VSS.t1737 0.0863258
R3970 VSS.n564 VSS.t1747 0.0863258
R3971 VSS.n566 VSS.t1757 0.0863258
R3972 VSS.n568 VSS.t1767 0.0863258
R3973 VSS.t1762 VSS.n567 0.0863258
R3974 VSS.t1752 VSS.n565 0.0863258
R3975 VSS.t1742 VSS.n563 0.0863258
R3976 VSS.t1727 VSS.n560 0.0863258
R3977 VSS.t1662 VSS.n547 0.0863258
R3978 VSS.t1667 VSS.n548 0.0863258
R3979 VSS.t1672 VSS.n549 0.0863258
R3980 VSS.t1677 VSS.n550 0.0863258
R3981 VSS.t1682 VSS.n551 0.0863258
R3982 VSS.t1687 VSS.n552 0.0863258
R3983 VSS.t1692 VSS.n553 0.0863258
R3984 VSS.t1697 VSS.n554 0.0863258
R3985 VSS.t1702 VSS.n555 0.0863258
R3986 VSS.t1707 VSS.n556 0.0863258
R3987 VSS.t1712 VSS.n557 0.0863258
R3988 VSS.t1717 VSS.n558 0.0863258
R3989 VSS.t1722 VSS.n559 0.0863258
R3990 VSS.n506 VSS.t2134 0.0863258
R3991 VSS.n508 VSS.t2144 0.0863258
R3992 VSS.n510 VSS.t2154 0.0863258
R3993 VSS.t2159 VSS.n511 0.0863258
R3994 VSS.t2149 VSS.n509 0.0863258
R3995 VSS.t2139 VSS.n507 0.0863258
R3996 VSS.t2129 VSS.n505 0.0863258
R3997 VSS.t2119 VSS.n503 0.0863258
R3998 VSS.t2109 VSS.n501 0.0863258
R3999 VSS.t2099 VSS.n499 0.0863258
R4000 VSS.t2089 VSS.n497 0.0863258
R4001 VSS.t2079 VSS.n495 0.0863258
R4002 VSS.t2069 VSS.n493 0.0863258
R4003 VSS.t2059 VSS.n491 0.0863258
R4004 VSS.t2044 VSS.n488 0.0863258
R4005 VSS.t1974 VSS.n474 0.0863258
R4006 VSS.n456 VSS.t1883 0.130189
R4007 VSS.t1889 VSS.n457 0.0863258
R4008 VSS.t1894 VSS.n458 0.0863258
R4009 VSS.t1899 VSS.n459 0.0863258
R4010 VSS.n404 VSS.t2301 0.0863258
R4011 VSS.n406 VSS.t2311 0.0863258
R4012 VSS.n408 VSS.t2321 0.0863258
R4013 VSS.n410 VSS.t2331 0.0863258
R4014 VSS.n412 VSS.t2341 0.0863258
R4015 VSS.n414 VSS.t2351 0.0863258
R4016 VSS.n416 VSS.t2361 0.0863258
R4017 VSS.n418 VSS.t2371 0.0863258
R4018 VSS.n420 VSS.t2381 0.0863258
R4019 VSS.n422 VSS.t2391 0.0863258
R4020 VSS.n424 VSS.t2401 0.0863258
R4021 VSS.n426 VSS.t2411 0.0863258
R4022 VSS.n428 VSS.t2421 0.0863258
R4023 VSS.n430 VSS.t2431 0.0863258
R4024 VSS.n434 VSS.t2451 0.0863258
R4025 VSS.n436 VSS.t2461 0.0863258
R4026 VSS.n438 VSS.t2471 0.0863258
R4027 VSS.n440 VSS.t2481 0.0863258
R4028 VSS.n442 VSS.t2491 0.0863258
R4029 VSS.n444 VSS.t2501 0.0863258
R4030 VSS.n446 VSS.t2511 0.0863258
R4031 VSS.n448 VSS.t2521 0.0863258
R4032 VSS.n450 VSS.t2531 0.0863258
R4033 VSS.n452 VSS.t2541 0.0863258
R4034 VSS.n454 VSS.t2551 0.0863258
R4035 VSS.t2546 VSS.n453 0.0863258
R4036 VSS.t2536 VSS.n451 0.0863258
R4037 VSS.t2526 VSS.n449 0.0863258
R4038 VSS.t2506 VSS.n445 0.0863258
R4039 VSS.t2496 VSS.n443 0.0863258
R4040 VSS.t2486 VSS.n441 0.0863258
R4041 VSS.t2476 VSS.n439 0.0863258
R4042 VSS.t2466 VSS.n437 0.0863258
R4043 VSS.t2456 VSS.n435 0.0863258
R4044 VSS.t2446 VSS.n433 0.0863258
R4045 VSS.t2436 VSS.n431 0.0863258
R4046 VSS.t2426 VSS.n429 0.0863258
R4047 VSS.t2416 VSS.n427 0.0863258
R4048 VSS.t2406 VSS.n425 0.0863258
R4049 VSS.t2396 VSS.n423 0.0863258
R4050 VSS.t2386 VSS.n421 0.0863258
R4051 VSS.t2376 VSS.n419 0.0863258
R4052 VSS.t2366 VSS.n417 0.0863258
R4053 VSS.t2356 VSS.n415 0.0863258
R4054 VSS.t2346 VSS.n413 0.0863258
R4055 VSS.t2336 VSS.n411 0.0863258
R4056 VSS.t2326 VSS.n409 0.0863258
R4057 VSS.t2316 VSS.n407 0.0863258
R4058 VSS.t2306 VSS.n405 0.0863258
R4059 VSS.t2296 VSS.n403 0.0863258
R4060 VSS.n399 VSS.t2275 0.130189
R4061 VSS.t2281 VSS.n400 0.0863258
R4062 VSS.t2286 VSS.n401 0.0863258
R4063 VSS.t2291 VSS.n402 0.0863258
R4064 VSS.t1904 VSS.n460 0.0863258
R4065 VSS.t1909 VSS.n461 0.0863258
R4066 VSS.t1914 VSS.n462 0.0863258
R4067 VSS.t1919 VSS.n463 0.0863258
R4068 VSS.t1924 VSS.n464 0.0863258
R4069 VSS.t1929 VSS.n465 0.0863258
R4070 VSS.t1934 VSS.n466 0.0863258
R4071 VSS.t1939 VSS.n467 0.0863258
R4072 VSS.t1944 VSS.n468 0.0863258
R4073 VSS.t1949 VSS.n469 0.0863258
R4074 VSS.t1954 VSS.n470 0.0863258
R4075 VSS.t1959 VSS.n471 0.0863258
R4076 VSS.t1964 VSS.n472 0.0863258
R4077 VSS.t1969 VSS.n473 0.0863258
R4078 VSS.t1979 VSS.n475 0.0863258
R4079 VSS.t1984 VSS.n476 0.0863258
R4080 VSS.t1989 VSS.n477 0.0863258
R4081 VSS.t1994 VSS.n478 0.0863258
R4082 VSS.t1999 VSS.n479 0.0863258
R4083 VSS.t2004 VSS.n480 0.0863258
R4084 VSS.t2009 VSS.n481 0.0863258
R4085 VSS.t2014 VSS.n482 0.0863258
R4086 VSS.t2019 VSS.n483 0.0863258
R4087 VSS.t2024 VSS.n484 0.0863258
R4088 VSS.t2029 VSS.n485 0.0863258
R4089 VSS.t2034 VSS.n486 0.0863258
R4090 VSS.t2039 VSS.n487 0.0863258
R4091 VSS.n109 VSS.t448 0.179249
R4092 VSS.n715 VSS.t490 0.0863258
R4093 VSS.n714 VSS.t487 0.0863258
R4094 VSS.n713 VSS.t484 0.0863258
R4095 VSS.n712 VSS.t481 0.0863258
R4096 VSS.n711 VSS.t478 0.0863258
R4097 VSS.n710 VSS.t475 0.0863258
R4098 VSS.n709 VSS.t472 0.0863258
R4099 VSS.n708 VSS.t469 0.0863258
R4100 VSS.n707 VSS.t466 0.0863258
R4101 VSS.n706 VSS.t463 0.0863258
R4102 VSS.n705 VSS.t460 0.0863258
R4103 VSS.n704 VSS.t457 0.0863258
R4104 VSS.n703 VSS.t454 0.0863258
R4105 VSS.t451 VSS.n702 0.0863258
R4106 VSS.t1652 VSS.n545 0.0863258
R4107 VSS.t1642 VSS.n543 0.0863258
R4108 VSS.t1632 VSS.n541 0.0863258
R4109 VSS.t1622 VSS.n539 0.0863258
R4110 VSS.t1612 VSS.n537 0.0863258
R4111 VSS.t1602 VSS.n535 0.0863258
R4112 VSS.t1592 VSS.n533 0.0863258
R4113 VSS.n513 VSS.t1491 0.130189
R4114 VSS.t1497 VSS.n514 0.0863258
R4115 VSS.t1502 VSS.n515 0.0863258
R4116 VSS.t1507 VSS.n516 0.0863258
R4117 VSS.t1512 VSS.n517 0.0863258
R4118 VSS.t1517 VSS.n518 0.0863258
R4119 VSS.t1522 VSS.n519 0.0863258
R4120 VSS.t1527 VSS.n520 0.0863258
R4121 VSS.t1532 VSS.n521 0.0863258
R4122 VSS.t1537 VSS.n522 0.0863258
R4123 VSS.t1542 VSS.n523 0.0863258
R4124 VSS.t1547 VSS.n524 0.0863258
R4125 VSS.t1552 VSS.n525 0.0863258
R4126 VSS.t1557 VSS.n526 0.0863258
R4127 VSS.t1562 VSS.n527 0.0863258
R4128 VSS.t1567 VSS.n528 0.0863258
R4129 VSS.t1572 VSS.n529 0.0863258
R4130 VSS.t1577 VSS.n530 0.0863258
R4131 VSS.n531 VSS.t1582 0.0863258
R4132 VSS.t832 VSS.n607 0.0863258
R4133 VSS.t837 VSS.n608 0.0863258
R4134 VSS.t842 VSS.n609 0.0863258
R4135 VSS.t847 VSS.n610 0.0863258
R4136 VSS.t852 VSS.n611 0.0863258
R4137 VSS.t857 VSS.n612 0.0863258
R4138 VSS.t862 VSS.n613 0.0863258
R4139 VSS.t867 VSS.n614 0.0863258
R4140 VSS.t872 VSS.n615 0.0863258
R4141 VSS.t877 VSS.n616 0.0863258
R4142 VSS.t882 VSS.n617 0.0863258
R4143 VSS.t887 VSS.n618 0.0863258
R4144 VSS.t892 VSS.n619 0.0863258
R4145 VSS.t897 VSS.n620 0.0863258
R4146 VSS.t907 VSS.n622 0.0863258
R4147 VSS.t912 VSS.n623 0.0863258
R4148 VSS.t917 VSS.n624 0.0863258
R4149 VSS.t922 VSS.n625 0.0863258
R4150 VSS.t927 VSS.n626 0.0863258
R4151 VSS.t932 VSS.n627 0.0863258
R4152 VSS.t937 VSS.n628 0.0863258
R4153 VSS.t942 VSS.n629 0.0863258
R4154 VSS.t947 VSS.n630 0.0863258
R4155 VSS.t952 VSS.n631 0.0863258
R4156 VSS.t957 VSS.n632 0.0863258
R4157 VSS.t962 VSS.n633 0.0863258
R4158 VSS.t967 VSS.n634 0.0863258
R4159 VSS.t972 VSS.n635 0.0863258
R4160 VSS.t982 VSS.n637 0.0863258
R4161 VSS.t987 VSS.n638 0.0863258
R4162 VSS.t992 VSS.n639 0.0863258
R4163 VSS.t997 VSS.n640 0.0863258
R4164 VSS.t1002 VSS.n641 0.0863258
R4165 VSS.t1007 VSS.n642 0.0863258
R4166 VSS.t1012 VSS.n643 0.0863258
R4167 VSS.t1017 VSS.n644 0.0863258
R4168 VSS.t1022 VSS.n645 0.0863258
R4169 VSS.t1027 VSS.n646 0.0863258
R4170 VSS.t1032 VSS.n647 0.0863258
R4171 VSS.t1037 VSS.n648 0.0863258
R4172 VSS.t1042 VSS.n649 0.0863258
R4173 VSS.n682 VSS.t772 0.0863258
R4174 VSS.t736 VSS.n673 0.0863258
R4175 VSS.t568 VSS.n660 0.0863258
R4176 VSS.t573 VSS.n661 0.0863258
R4177 VSS.t578 VSS.n662 0.0863258
R4178 VSS.t583 VSS.n663 0.0863258
R4179 VSS.t588 VSS.n664 0.0863258
R4180 VSS.t593 VSS.n665 0.0863258
R4181 VSS.t598 VSS.n666 0.0863258
R4182 VSS.n667 VSS.t603 0.0863258
R4183 VSS.t295 VSS.n719 0.0863258
R4184 VSS.n721 VSS.t432 0.130189
R4185 VSS.n723 VSS.t165 0.130189
R4186 VSS.t2938 VSS.n322 0.130189
R4187 VSS.n324 VSS.t2949 0.0863258
R4188 VSS.t2944 VSS.n323 0.0863258
R4189 VSS.n372 VSS.t3189 0.0863258
R4190 VSS.n374 VSS.t3199 0.0863258
R4191 VSS.n376 VSS.t3209 0.0863258
R4192 VSS.t3214 VSS.n377 0.0863258
R4193 VSS.t3204 VSS.n375 0.0863258
R4194 VSS.t3194 VSS.n373 0.0863258
R4195 VSS.t3184 VSS.n371 0.0863258
R4196 VSS.t3174 VSS.n369 0.0863258
R4197 VSS.t3164 VSS.n367 0.0863258
R4198 VSS.t3154 VSS.n365 0.0863258
R4199 VSS.t3144 VSS.n363 0.0863258
R4200 VSS.t3134 VSS.n361 0.0863258
R4201 VSS.t3124 VSS.n359 0.0863258
R4202 VSS.t3114 VSS.n357 0.0863258
R4203 VSS.t3099 VSS.n354 0.0863258
R4204 VSS.t3034 VSS.n341 0.0863258
R4205 VSS.t3039 VSS.n342 0.0863258
R4206 VSS.t3044 VSS.n343 0.0863258
R4207 VSS.t3049 VSS.n344 0.0863258
R4208 VSS.t3054 VSS.n345 0.0863258
R4209 VSS.t3059 VSS.n346 0.0863258
R4210 VSS.t3064 VSS.n347 0.0863258
R4211 VSS.t3069 VSS.n348 0.0863258
R4212 VSS.t3074 VSS.n349 0.0863258
R4213 VSS.t3079 VSS.n350 0.0863258
R4214 VSS.t3084 VSS.n351 0.0863258
R4215 VSS.t3089 VSS.n352 0.0863258
R4216 VSS.t3094 VSS.n353 0.0863258
R4217 VSS.t2959 VSS.n326 0.0863258
R4218 VSS.t312 VSS.t313 0.217986
R4219 VSS.t384 VSS.t122 0.217986
R4220 VSS.t381 VSS.t380 0.217986
R4221 VSS.t376 VSS.t375 0.217986
R4222 VSS.t371 VSS.t370 0.217986
R4223 VSS.t367 VSS.t366 0.217986
R4224 VSS.t362 VSS.t361 0.217986
R4225 VSS.t357 VSS.t356 0.217986
R4226 VSS.t347 VSS.t125 0.217986
R4227 VSS.t394 VSS.t393 0.217986
R4228 VSS.n675 VSS.t752 0.0861948
R4229 VSS.n671 VSS.t727 0.0861948
R4230 VSS.t3029 VSS.n953 0.210486
R4231 VSS.t2366 VSS.n897 0.210486
R4232 VSS.n901 VSS.t1974 0.210486
R4233 VSS.n907 VSS.t1582 0.210486
R4234 VSS.n912 VSS.t902 0.210486
R4235 VSS.n932 VSS.t603 0.210486
R4236 VSS.n397 VSS.t200 0.104635
R4237 VSS.n601 VSS.t249 0.104635
R4238 VSS.n670 VSS.t617 0.0818513
R4239 VSS.t515 VSS.t270 0.206736
R4240 VSS.t21 VSS.t47 0.204291
R4241 VSS.t21 VSS.t45 0.203557
R4242 VSS.n672 VSS.t732 0.24604
R4243 VSS.t1343 VSS.n591 0.0605362
R4244 VSS.n580 VSS.t1300 0.0605362
R4245 VSS.t1256 VSS.n569 0.0605362
R4246 VSS.t17 VSS.n121 0.019997
R4247 VSS.n728 VSS.t2720 0.180789
R4248 VSS.t1213 VSS.t1214 0.170825
R4249 VSS.t2801 VSS.t2802 0.170789
R4250 VSS.t1475 VSS.n893 0.170789
R4251 VSS.n731 VSS.t3104 0.170789
R4252 VSS.t977 VSS.n830 0.170789
R4253 VSS.t1657 VSS.n906 0.170789
R4254 VSS.n896 VSS.t2049 0.170789
R4255 VSS.t2441 VSS.n898 0.170789
R4256 VSS.n729 VSS.t2759 0.170789
R4257 VSS.n391 VSS.t391 0.0836055
R4258 VSS.n396 VSS.t2821 0.0836055
R4259 VSS.n252 VSS.t733 0.0836055
R4260 VSS.t354 VSS.n381 0.0836055
R4261 VSS.t809 VSS.n699 0.0647427
R4262 VSS.n716 VSS.t493 0.0647427
R4263 VSS.t3104 VSS.n355 0.07903
R4264 VSS.n432 VSS.t2441 0.07903
R4265 VSS.t2049 VSS.n489 0.07903
R4266 VSS.n546 VSS.t1657 0.07903
R4267 VSS.t977 VSS.n636 0.07903
R4268 VSS.t21 VSS.t323 0.157212
R4269 VSS.t446 VSS.t135 0.153289
R4270 VSS.t65 VSS.n256 0.0735143
R4271 VSS.t2956 VSS.t2954 0.135506
R4272 VSS.t1213 VSS.t1373 0.130789
R4273 VSS.t2801 VSS.t2800 0.130486
R4274 VSS.t2829 VSS.t2676 0.110789
R4275 VSS.t389 VSS.n228 0.175751
R4276 VSS.n894 VSS.t1299 0.1105
R4277 VSS.n321 VSS.n731 0.081538
R4278 VSS.t3179 VSS.n320 0.181538
R4279 VSS.n898 VSS.n300 0.081538
R4280 VSS.n299 VSS.t2516 0.181538
R4281 VSS.n298 VSS.n896 0.081538
R4282 VSS.t2124 VSS.n297 0.181538
R4283 VSS.n296 VSS.n906 0.081538
R4284 VSS.n295 VSS.t1732 0.181538
R4285 VSS.n273 VSS.n830 0.081538
R4286 VSS.n272 VSS.t1052 0.181538
R4287 VSS.t635 VSS.n805 0.10425
R4288 VSS.t351 VSS.n227 0.0333775
R4289 VSS.t2859 VSS.t2721 0.090789
R4290 VSS.n227 VSS.t352 0.155751
R4291 VSS.t2859 VSS.n728 0.0905
R4292 VSS.t1408 VSS.n293 0.269511
R4293 VSS.t2941 VSS.t2943 0.0855
R4294 VSS.t2948 VSS.t2946 0.0855
R4295 VSS.t2951 VSS.t2953 0.0855
R4296 VSS.t386 VSS.t388 0.0855
R4297 VSS.t391 VSS.t393 0.0855
R4298 VSS.t3108 VSS.t3106 0.0855
R4299 VSS.t3111 VSS.t3113 0.0855
R4300 VSS.t3118 VSS.t3116 0.0855
R4301 VSS.t3121 VSS.t3123 0.0855
R4302 VSS.t3128 VSS.t3126 0.0855
R4303 VSS.t3131 VSS.t3133 0.0855
R4304 VSS.t3138 VSS.t3136 0.0855
R4305 VSS.t3141 VSS.t3143 0.0855
R4306 VSS.t3148 VSS.t3146 0.0855
R4307 VSS.t3151 VSS.t3153 0.0855
R4308 VSS.t3158 VSS.t3156 0.0855
R4309 VSS.t3161 VSS.t3163 0.0855
R4310 VSS.t3168 VSS.t3166 0.0855
R4311 VSS.t3171 VSS.t3173 0.0855
R4312 VSS.t3178 VSS.t3176 0.0855
R4313 VSS.t3181 VSS.t3183 0.0855
R4314 VSS.t3188 VSS.t3186 0.0855
R4315 VSS.t3191 VSS.t3193 0.0855
R4316 VSS.t3198 VSS.t3196 0.0855
R4317 VSS.t3201 VSS.t3203 0.0855
R4318 VSS.t3208 VSS.t3206 0.0855
R4319 VSS.t3211 VSS.t3213 0.0855
R4320 VSS.t3033 VSS.t3031 0.0855
R4321 VSS.t3038 VSS.t3036 0.0855
R4322 VSS.t3043 VSS.t3041 0.0855
R4323 VSS.t3048 VSS.t3046 0.0855
R4324 VSS.t3053 VSS.t3051 0.0855
R4325 VSS.t3058 VSS.t3056 0.0855
R4326 VSS.t3063 VSS.t3061 0.0855
R4327 VSS.t3068 VSS.t3066 0.0855
R4328 VSS.t3073 VSS.t3071 0.0855
R4329 VSS.t3078 VSS.t3076 0.0855
R4330 VSS.t3083 VSS.t3081 0.0855
R4331 VSS.t3088 VSS.t3086 0.0855
R4332 VSS.t3093 VSS.t3091 0.0855
R4333 VSS.t3098 VSS.t3096 0.0855
R4334 VSS.t3101 VSS.t3103 0.0855
R4335 VSS.t3026 VSS.t3028 0.0855
R4336 VSS.t3021 VSS.t3023 0.0855
R4337 VSS.t3016 VSS.t3018 0.0855
R4338 VSS.t3011 VSS.t3013 0.0855
R4339 VSS.t3006 VSS.t3008 0.0855
R4340 VSS.t3001 VSS.t3003 0.0855
R4341 VSS.t2996 VSS.t2998 0.0855
R4342 VSS.t2991 VSS.t2993 0.0855
R4343 VSS.t2986 VSS.t2988 0.0855
R4344 VSS.t2981 VSS.t2983 0.0855
R4345 VSS.t2976 VSS.t2978 0.0855
R4346 VSS.t2971 VSS.t2973 0.0855
R4347 VSS.t2966 VSS.t2968 0.0855
R4348 VSS.t2963 VSS.t2961 0.0855
R4349 VSS.t2956 VSS.t2958 0.0855
R4350 VSS.t2280 VSS.t2278 0.0855
R4351 VSS.t2285 VSS.t2283 0.0855
R4352 VSS.t2290 VSS.t2288 0.0855
R4353 VSS.t2293 VSS.t2295 0.0855
R4354 VSS.t2300 VSS.t2298 0.0855
R4355 VSS.t2303 VSS.t2305 0.0855
R4356 VSS.t2310 VSS.t2308 0.0855
R4357 VSS.t2313 VSS.t2315 0.0855
R4358 VSS.t2320 VSS.t2318 0.0855
R4359 VSS.t2323 VSS.t2325 0.0855
R4360 VSS.t2330 VSS.t2328 0.0855
R4361 VSS.t2333 VSS.t2335 0.0855
R4362 VSS.t2340 VSS.t2338 0.0855
R4363 VSS.t2343 VSS.t2345 0.0855
R4364 VSS.t2350 VSS.t2348 0.0855
R4365 VSS.t2353 VSS.t2355 0.0855
R4366 VSS.t2360 VSS.t2358 0.0855
R4367 VSS.t2363 VSS.t2365 0.0855
R4368 VSS.t2370 VSS.t2368 0.0855
R4369 VSS.t2373 VSS.t2375 0.0855
R4370 VSS.t2380 VSS.t2378 0.0855
R4371 VSS.t2383 VSS.t2385 0.0855
R4372 VSS.t2390 VSS.t2388 0.0855
R4373 VSS.t2393 VSS.t2395 0.0855
R4374 VSS.t2400 VSS.t2398 0.0855
R4375 VSS.t2403 VSS.t2405 0.0855
R4376 VSS.t2410 VSS.t2408 0.0855
R4377 VSS.t2413 VSS.t2415 0.0855
R4378 VSS.t2420 VSS.t2418 0.0855
R4379 VSS.t2423 VSS.t2425 0.0855
R4380 VSS.t2430 VSS.t2428 0.0855
R4381 VSS.t2433 VSS.t2435 0.0855
R4382 VSS.t2440 VSS.t2438 0.0855
R4383 VSS.t2443 VSS.t2445 0.0855
R4384 VSS.t2450 VSS.t2448 0.0855
R4385 VSS.t2453 VSS.t2455 0.0855
R4386 VSS.t2460 VSS.t2458 0.0855
R4387 VSS.t2463 VSS.t2465 0.0855
R4388 VSS.t2470 VSS.t2468 0.0855
R4389 VSS.t2473 VSS.t2475 0.0855
R4390 VSS.t2480 VSS.t2478 0.0855
R4391 VSS.t2483 VSS.t2485 0.0855
R4392 VSS.t2490 VSS.t2488 0.0855
R4393 VSS.t2493 VSS.t2495 0.0855
R4394 VSS.t2500 VSS.t2498 0.0855
R4395 VSS.t2503 VSS.t2505 0.0855
R4396 VSS.t2510 VSS.t2508 0.0855
R4397 VSS.t2513 VSS.t2515 0.0855
R4398 VSS.t2520 VSS.t2518 0.0855
R4399 VSS.t2523 VSS.t2525 0.0855
R4400 VSS.t2530 VSS.t2528 0.0855
R4401 VSS.t2533 VSS.t2535 0.0855
R4402 VSS.t2540 VSS.t2538 0.0855
R4403 VSS.t2543 VSS.t2545 0.0855
R4404 VSS.t2550 VSS.t2548 0.0855
R4405 VSS.t1888 VSS.t1886 0.0855
R4406 VSS.t1893 VSS.t1891 0.0855
R4407 VSS.t1898 VSS.t1896 0.0855
R4408 VSS.t1903 VSS.t1901 0.0855
R4409 VSS.t1908 VSS.t1906 0.0855
R4410 VSS.t1913 VSS.t1911 0.0855
R4411 VSS.t1918 VSS.t1916 0.0855
R4412 VSS.t1923 VSS.t1921 0.0855
R4413 VSS.t1928 VSS.t1926 0.0855
R4414 VSS.t1933 VSS.t1931 0.0855
R4415 VSS.t1938 VSS.t1936 0.0855
R4416 VSS.t1943 VSS.t1941 0.0855
R4417 VSS.t1948 VSS.t1946 0.0855
R4418 VSS.t1953 VSS.t1951 0.0855
R4419 VSS.t1958 VSS.t1956 0.0855
R4420 VSS.t1963 VSS.t1961 0.0855
R4421 VSS.t1968 VSS.t1966 0.0855
R4422 VSS.t1973 VSS.t1971 0.0855
R4423 VSS.t1978 VSS.t1976 0.0855
R4424 VSS.t1983 VSS.t1981 0.0855
R4425 VSS.t1988 VSS.t1986 0.0855
R4426 VSS.t1993 VSS.t1991 0.0855
R4427 VSS.t1998 VSS.t1996 0.0855
R4428 VSS.t2003 VSS.t2001 0.0855
R4429 VSS.t2008 VSS.t2006 0.0855
R4430 VSS.t2013 VSS.t2011 0.0855
R4431 VSS.t2018 VSS.t2016 0.0855
R4432 VSS.t2023 VSS.t2021 0.0855
R4433 VSS.t2028 VSS.t2026 0.0855
R4434 VSS.t2033 VSS.t2031 0.0855
R4435 VSS.t2038 VSS.t2036 0.0855
R4436 VSS.t2043 VSS.t2041 0.0855
R4437 VSS.t2046 VSS.t2048 0.0855
R4438 VSS.t2053 VSS.t2051 0.0855
R4439 VSS.t2056 VSS.t2058 0.0855
R4440 VSS.t2063 VSS.t2061 0.0855
R4441 VSS.t2066 VSS.t2068 0.0855
R4442 VSS.t2073 VSS.t2071 0.0855
R4443 VSS.t2076 VSS.t2078 0.0855
R4444 VSS.t2083 VSS.t2081 0.0855
R4445 VSS.t2086 VSS.t2088 0.0855
R4446 VSS.t2093 VSS.t2091 0.0855
R4447 VSS.t2096 VSS.t2098 0.0855
R4448 VSS.t2103 VSS.t2101 0.0855
R4449 VSS.t2106 VSS.t2108 0.0855
R4450 VSS.t2113 VSS.t2111 0.0855
R4451 VSS.t2116 VSS.t2118 0.0855
R4452 VSS.t2123 VSS.t2121 0.0855
R4453 VSS.t2126 VSS.t2128 0.0855
R4454 VSS.t2133 VSS.t2131 0.0855
R4455 VSS.t2136 VSS.t2138 0.0855
R4456 VSS.t2143 VSS.t2141 0.0855
R4457 VSS.t2146 VSS.t2148 0.0855
R4458 VSS.t2153 VSS.t2151 0.0855
R4459 VSS.t2156 VSS.t2158 0.0855
R4460 VSS.t1496 VSS.t1494 0.0855
R4461 VSS.t1501 VSS.t1499 0.0855
R4462 VSS.t1506 VSS.t1504 0.0855
R4463 VSS.t1511 VSS.t1509 0.0855
R4464 VSS.t1516 VSS.t1514 0.0855
R4465 VSS.t1521 VSS.t1519 0.0855
R4466 VSS.t1526 VSS.t1524 0.0855
R4467 VSS.t1531 VSS.t1529 0.0855
R4468 VSS.t1536 VSS.t1534 0.0855
R4469 VSS.t1541 VSS.t1539 0.0855
R4470 VSS.t1546 VSS.t1544 0.0855
R4471 VSS.t1551 VSS.t1549 0.0855
R4472 VSS.t1556 VSS.t1554 0.0855
R4473 VSS.t1561 VSS.t1559 0.0855
R4474 VSS.t1566 VSS.t1564 0.0855
R4475 VSS.t1571 VSS.t1569 0.0855
R4476 VSS.t1576 VSS.t1574 0.0855
R4477 VSS.t1581 VSS.t1579 0.0855
R4478 VSS.t1586 VSS.t1584 0.0855
R4479 VSS.t1589 VSS.t1591 0.0855
R4480 VSS.t1596 VSS.t1594 0.0855
R4481 VSS.t1599 VSS.t1601 0.0855
R4482 VSS.t1606 VSS.t1604 0.0855
R4483 VSS.t1609 VSS.t1611 0.0855
R4484 VSS.t1616 VSS.t1614 0.0855
R4485 VSS.t1619 VSS.t1621 0.0855
R4486 VSS.t1626 VSS.t1624 0.0855
R4487 VSS.t1629 VSS.t1631 0.0855
R4488 VSS.t1636 VSS.t1634 0.0855
R4489 VSS.t1639 VSS.t1641 0.0855
R4490 VSS.t1646 VSS.t1644 0.0855
R4491 VSS.t1649 VSS.t1651 0.0855
R4492 VSS.t1656 VSS.t1654 0.0855
R4493 VSS.t1661 VSS.t1659 0.0855
R4494 VSS.t1666 VSS.t1664 0.0855
R4495 VSS.t1671 VSS.t1669 0.0855
R4496 VSS.t1676 VSS.t1674 0.0855
R4497 VSS.t1681 VSS.t1679 0.0855
R4498 VSS.t1686 VSS.t1684 0.0855
R4499 VSS.t1691 VSS.t1689 0.0855
R4500 VSS.t1696 VSS.t1694 0.0855
R4501 VSS.t1701 VSS.t1699 0.0855
R4502 VSS.t1706 VSS.t1704 0.0855
R4503 VSS.t1711 VSS.t1709 0.0855
R4504 VSS.t1716 VSS.t1714 0.0855
R4505 VSS.t1721 VSS.t1719 0.0855
R4506 VSS.t1726 VSS.t1724 0.0855
R4507 VSS.t1729 VSS.t1731 0.0855
R4508 VSS.t1736 VSS.t1734 0.0855
R4509 VSS.t1739 VSS.t1741 0.0855
R4510 VSS.t1746 VSS.t1744 0.0855
R4511 VSS.t1749 VSS.t1751 0.0855
R4512 VSS.t1756 VSS.t1754 0.0855
R4513 VSS.t1759 VSS.t1761 0.0855
R4514 VSS.t1766 VSS.t1764 0.0855
R4515 VSS.t816 VSS.t814 0.0855
R4516 VSS.t821 VSS.t819 0.0855
R4517 VSS.t826 VSS.t824 0.0855
R4518 VSS.t831 VSS.t829 0.0855
R4519 VSS.t836 VSS.t834 0.0855
R4520 VSS.t841 VSS.t839 0.0855
R4521 VSS.t846 VSS.t844 0.0855
R4522 VSS.t851 VSS.t849 0.0855
R4523 VSS.t856 VSS.t854 0.0855
R4524 VSS.t861 VSS.t859 0.0855
R4525 VSS.t866 VSS.t864 0.0855
R4526 VSS.t871 VSS.t869 0.0855
R4527 VSS.t876 VSS.t874 0.0855
R4528 VSS.t881 VSS.t879 0.0855
R4529 VSS.t886 VSS.t884 0.0855
R4530 VSS.t891 VSS.t889 0.0855
R4531 VSS.t896 VSS.t894 0.0855
R4532 VSS.t901 VSS.t899 0.0855
R4533 VSS.t906 VSS.t904 0.0855
R4534 VSS.t911 VSS.t909 0.0855
R4535 VSS.t916 VSS.t914 0.0855
R4536 VSS.t921 VSS.t919 0.0855
R4537 VSS.t926 VSS.t924 0.0855
R4538 VSS.t931 VSS.t929 0.0855
R4539 VSS.t936 VSS.t934 0.0855
R4540 VSS.t941 VSS.t939 0.0855
R4541 VSS.t946 VSS.t944 0.0855
R4542 VSS.t951 VSS.t949 0.0855
R4543 VSS.t956 VSS.t954 0.0855
R4544 VSS.t961 VSS.t959 0.0855
R4545 VSS.t966 VSS.t964 0.0855
R4546 VSS.t971 VSS.t969 0.0855
R4547 VSS.t976 VSS.t974 0.0855
R4548 VSS.t981 VSS.t979 0.0855
R4549 VSS.t986 VSS.t984 0.0855
R4550 VSS.t991 VSS.t989 0.0855
R4551 VSS.t996 VSS.t994 0.0855
R4552 VSS.t1001 VSS.t999 0.0855
R4553 VSS.t1006 VSS.t1004 0.0855
R4554 VSS.t1011 VSS.t1009 0.0855
R4555 VSS.t1016 VSS.t1014 0.0855
R4556 VSS.t1021 VSS.t1019 0.0855
R4557 VSS.t1026 VSS.t1024 0.0855
R4558 VSS.t1031 VSS.t1029 0.0855
R4559 VSS.t1036 VSS.t1034 0.0855
R4560 VSS.t1041 VSS.t1039 0.0855
R4561 VSS.t1046 VSS.t1044 0.0855
R4562 VSS.t1049 VSS.t1051 0.0855
R4563 VSS.t1056 VSS.t1054 0.0855
R4564 VSS.t1059 VSS.t1061 0.0855
R4565 VSS.t1066 VSS.t1064 0.0855
R4566 VSS.t1069 VSS.t1071 0.0855
R4567 VSS.t1076 VSS.t1074 0.0855
R4568 VSS.t1079 VSS.t1081 0.0855
R4569 VSS.t1086 VSS.t1084 0.0855
R4570 VSS.t36 VSS.t774 0.0855
R4571 VSS.t769 VSS.t771 0.0855
R4572 VSS.t747 VSS.t744 0.0855
R4573 VSS.t735 VSS.t733 0.0855
R4574 VSS.t731 VSS.t729 0.0855
R4575 VSS.t59 VSS.t725 0.0855
R4576 VSS.t610 VSS.t612 0.0855
R4577 VSS.t607 VSS.t605 0.0855
R4578 VSS.t567 VSS.t210 0.0855
R4579 VSS.t572 VSS.t570 0.0855
R4580 VSS.t577 VSS.t575 0.0855
R4581 VSS.t582 VSS.t580 0.0855
R4582 VSS.t587 VSS.t585 0.0855
R4583 VSS.t592 VSS.t590 0.0855
R4584 VSS.t597 VSS.t595 0.0855
R4585 VSS.t602 VSS.t600 0.0855
R4586 VSS.t449 VSS.t450 0.0855
R4587 VSS.t452 VSS.t453 0.0855
R4588 VSS.t455 VSS.t456 0.0855
R4589 VSS.t458 VSS.t459 0.0855
R4590 VSS.t461 VSS.t462 0.0855
R4591 VSS.t464 VSS.t465 0.0855
R4592 VSS.t467 VSS.t468 0.0855
R4593 VSS.t470 VSS.t471 0.0855
R4594 VSS.t473 VSS.t474 0.0855
R4595 VSS.t476 VSS.t477 0.0855
R4596 VSS.t479 VSS.t480 0.0855
R4597 VSS.t482 VSS.t483 0.0855
R4598 VSS.t485 VSS.t486 0.0855
R4599 VSS.t488 VSS.t489 0.0855
R4600 VSS.t15 VSS.t435 0.0855
R4601 VSS.t29 VSS.t506 0.0855
R4602 VSS.t300 VSS.t297 0.0855
R4603 VSS.t356 VSS.t354 0.0855
R4604 VSS.t361 VSS.t359 0.0855
R4605 VSS.t366 VSS.t364 0.0855
R4606 VSS.t375 VSS.t373 0.0855
R4607 VSS.t380 VSS.t378 0.0855
R4608 VSS.t349 VSS.t351 0.0855
R4609 VSS.t623 VSS.t215 0.0855
R4610 VSS.t637 VSS.t77 0.07425
R4611 VSS.t615 VSS.t618 0.07425
R4612 VSS.t491 VSS.t492 0.07425
R4613 VSS.t315 VSS.t287 0.07425
R4614 VSS.n370 VSS.t3179 0.149319
R4615 VSS.t1052 VSS.n651 0.149319
R4616 VSS.n504 VSS.t2124 0.149319
R4617 VSS.t1732 VSS.n561 0.149319
R4618 VSS.n447 VSS.t2516 0.149319
R4619 VSS.t266 VSS.n179 0.416535
R4620 VSS.t2676 VSS.t2828 0.0705
R4621 VSS.t21 VSS.n91 0.0643474
R4622 VSS.t21 VSS.n89 0.0643474
R4623 VSS.t21 VSS.n86 0.0643474
R4624 VSS.n83 VSS.t344 26.1613
R4625 VSS.n116 VSS.t410 26.2591
R4626 VSS.t90 VSS.t143 0.05925
R4627 VSS.t1255 VSS.t1408 0.0305
R4628 VSS.n103 VSS.t2547 109.992
R4629 VSS.t2522 VSS.n103 109.992
R4630 VSS.t2492 VSS.n103 109.992
R4631 VSS.t2472 VSS.n103 109.992
R4632 VSS.n103 VSS.t2447 109.992
R4633 VSS.n103 VSS.t2427 109.992
R4634 VSS.n103 VSS.t2377 109.992
R4635 VSS.n103 VSS.t2337 109.992
R4636 VSS.n103 VSS.t2327 109.992
R4637 VSS.n103 VSS.t2307 109.992
R4638 VSS.t2145 VSS.n102 109.992
R4639 VSS.t2135 VSS.n102 109.992
R4640 VSS.t2125 VSS.n102 109.992
R4641 VSS.n102 VSS.t2070 109.992
R4642 VSS.t2055 VSS.n102 109.992
R4643 VSS.n102 VSS.t2050 109.992
R4644 VSS.n102 VSS.t2030 109.992
R4645 VSS.n102 VSS.t2000 109.992
R4646 VSS.n102 VSS.t1980 109.992
R4647 VSS.n102 VSS.t1960 109.992
R4648 VSS.n102 VSS.t1930 109.992
R4649 VSS.n102 VSS.t1915 109.992
R4650 VSS.n102 VSS.t1905 109.992
R4651 VSS.n101 VSS.t1753 109.992
R4652 VSS.n101 VSS.t1733 109.992
R4653 VSS.n101 VSS.t1678 109.992
R4654 VSS.n101 VSS.t1663 109.992
R4655 VSS.t1638 VSS.n101 109.992
R4656 VSS.t1608 VSS.n101 109.992
R4657 VSS.t1588 VSS.n101 109.992
R4658 VSS.n101 VSS.t1568 109.992
R4659 VSS.n101 VSS.t1538 109.992
R4660 VSS.n101 VSS.t1513 109.992
R4661 VSS.n106 VSS.t1033 109.992
R4662 VSS.n106 VSS.t1028 109.992
R4663 VSS.n106 VSS.t1008 109.992
R4664 VSS.n106 VSS.t963 109.992
R4665 VSS.n106 VSS.t933 109.992
R4666 VSS.n106 VSS.t883 109.992
R4667 VSS.n106 VSS.t863 109.992
R4668 VSS.n106 VSS.t843 109.992
R4669 VSS.t105 VSS.t604 109.992
R4670 VSS.t105 VSS.t599 109.992
R4671 VSS VSS.n954 0.01986
R4672 VSS.n953 VSS.t3031 0.01675
R4673 VSS.n897 VSS.t2368 0.01675
R4674 VSS.t1976 VSS.n901 0.01675
R4675 VSS.n907 VSS.t1584 0.01675
R4676 VSS.t904 VSS.n912 0.01675
R4677 VSS.n932 VSS.t605 0.01675
R4678 VSS.t2760 VSS.n729 0.0105
R4679 VSS.n894 VSS.n580 0.130486
R4680 VSS.t1344 VSS.n893 0.0105
R4681 VSS.t633 VSS.n805 0.0105
R4682 VSS.n123 VSS.t3195 183.805
R4683 VSS.n123 VSS.t3155 183.805
R4684 VSS.t3130 VSS.n123 183.805
R4685 VSS.n123 VSS.t3125 183.805
R4686 VSS.n123 VSS.t3100 183.805
R4687 VSS.n123 VSS.t3075 183.805
R4688 VSS.n123 VSS.t3050 183.805
R4689 VSS.t3030 VSS.n123 183.805
R4690 VSS.t3005 VSS.n123 183.805
R4691 VSS.n123 VSS.t2960 183.805
R4692 VSS.n516 VSS.n101 4.2022
R4693 VSS.n459 VSS.n102 4.20218
R4694 VSS.n402 VSS.n103 4.20216
R4695 VSS.n606 VSS.n106 4.15539
R4696 VSS.t199 VSS.n222 2.94492
R4697 VSS.n193 VSS.t248 2.91272
R4698 VSS.n325 VSS.n123 2.86035
R4699 VSS.n253 VSS.t19 1.41706
R4700 VSS.t105 VSS.n97 1.29766
R4701 VSS.t19 VSS.n747 1.2435
R4702 VSS.t105 VSS.t550 1.10297
R4703 VSS.t21 VSS.n85 1.02865
R4704 VSS.t21 VSS.n95 1.01269
C0 sg13cmos5l_buf_8_2.A a_18123_14495# 0.02096f
C1 sg13cmos5l_or3_1_1.A a_27034_15202# 0.05929f
C2 a_20000_15366# sg13cmos5l_dfrbpq_1_2.Q 0.02435f
C3 a_21166_16263# a_20960_16082# 0.01604f
C4 a_6789_14495# a_6891_14495# 0.3643f
C5 a_22319_14845# a_22986_14484# 0.09257f
C6 a_4175_15311# a_3435_15356# 0.17382f
C7 sg13cmos5l_o21ai_1_3.Y a_24310_15230# 0.06016f
C8 sg13cmos5l_buf_8_2.X sg13cmos5l_a21oi_1_3.A1 0.02668f
C9 sg13cmos5l_dfrbpq_1_6.RESET_B a_21070_15423# 0.05075f
C10 a_21060_14488# sg13cmos5l_o21ai_1_1.Y 0.0268f
C11 a_17318_14922# sg13cmos5l_a21oi_1_3.B1 0.01499f
C12 a_16042_13945# a_16485_13701# 0.02241f
C13 a_38536_10034# a_38720_10034# 0.05762f
C14 sg13cmos5l_a21oi_1_3.B1 sg13cmos5l_o21ai_1_1.Y 0.03114f
C15 a_25206_14508# sg13cmos5l_or3_1_1.A 0.0186f
C16 sg13cmos5l_inv_1_0.A sg13cmos5l_dfrbpq_1_3.D 0.1171f
C17 sg13cmos5l_or3_1_1.C VDD 0.82343f
C18 a_16140_15424# sg13cmos5l_or3_1_1.B 0.03017f
C19 sg13cmos5l_or3_1_1.A sg13cmos5l_o21ai_1_3.Y 0.21954f
C20 a_10337_14750# a_10222_14751# 0.3854f
C21 sg13cmos5l_dfrbpq_1_2.D sg13cmos5l_nor2_1_0.B 0.11174f
C22 sg13cmos5l_dlygate4sd3_1_0.X sg13cmos5l_xnor2_1_2.B 0.10767f
C23 sg13cmos5l_nand4_1_0.Y VDD 1.02388f
C24 a_21466_15202# sg13cmos5l_or3_1_2.A 0.03705f
C25 a_16068_14040# a_17327_13799# 0.01412f
C26 sg13cmos5l_dfrbpq_1_6.D sg13cmos5l_buf_8_2.X 0.02715f
C27 sg13cmos5l_dfrbpq_1_2.CLK VDD 1.58512f
C28 sg13cmos5l_dfrbpq_1_7.Q sg13cmos5l_or3_1_1.A 0.08495f
C29 a_8685_14832# VDD 0.28623f
C30 a_6682_13690# sg13cmos5l_xnor2_1_2.B 0.01246f
C31 a_1856_14570# VDD 0.08533f
C32 a_24824_14525# sg13cmos5l_buf_8_2.X 0.01711f
C33 a_6372_14488# sg13cmos5l_xnor2_1_2.B 0.03099f
C34 sg13cmos5l_dfrbpq_1_0.RESET_B VDD 1.2525f
C35 a_17327_13799# a_17994_14020# 0.09257f
C36 a_32492_15960# sg13cmos5l_dfrbpq_1_7.Q 0.1927f
C37 a_10222_14751# VDD 0.16191f
C38 sg13cmos5l_xnor2_1_2.B a_6202_15238# 0.01843f
C39 a_15671_15549# VDD 0.08776f
C40 a_9444_15552# a_9963_15356# 0.20773f
C41 a_27296_16082# a_27500_15960# 0.01689f
C42 a_3872_14570# VDD 0.08604f
C43 counter_value_o[2] a_12232_16082# 0.02116f
C44 sg13cmos5l_dfrbpq_1_2.D sg13cmos5l_a21oi_1_3.B1 0.08258f
C45 sg13cmos5l_dfrbpq_1_5.RESET_B a_25956_14488# 0.01473f
C46 a_15579_14854# sg13cmos5l_inv_1_0.Y 0.02441f
C47 a_26633_16334# a_26757_16033# 0.08186f
C48 a_22508_15960# counter_value_o[4] 0.15504f
C49 sg13cmos5l_dlygate4sd3_1_4.X a_18789_15277# 0.03893f
C50 a_6080_13854# VDD 0.07075f
C51 sg13cmos5l_dlygate4sd3_1_1.A sg13cmos5l_dlygate4sd3_1_8.X 0.16183f
C52 sg13cmos5l_nand4_1_0.Y a_8312_15238# 0.0158f
C53 a_9963_15356# a_10960_15454# 0.03412f
C54 sg13cmos5l_dfrbpq_1_2.CLK a_8312_15238# 0.01101f
C55 sg13cmos5l_dlygate4sd3_1_3.A a_3435_15356# 0.0271f
C56 a_9737_14822# sg13cmos5l_dlygate4sd3_1_8.X 0.02198f
C57 a_15870_15486# sg13cmos5l_dfrbpq_1_2.RESET_B 0.06273f
C58 sg13cmos5l_dfrbpq_1_1.RESET_B a_6346_14452# 0.18209f
C59 sg13cmos5l_inv_1_0.A a_16140_15424# 0.01251f
C60 a_21562_15960# sg13cmos5l_dfrbpq_1_6.RESET_B 0.04463f
C61 a_21824_15366# a_22030_15423# 0.01604f
C62 sg13cmos5l_dfrbpq_1_5.RESET_B a_26475_14495# 0.02481f
C63 sg13cmos5l_nand3_1_0.Y VDD 0.70369f
C64 a_17892_14909# sg13cmos5l_dfrbpq_1_2.Q 0.02394f
C65 a_27472_14726# a_27215_14845# 0.23043f
C66 sg13cmos5l_dfrbpq_1_6.Q sg13cmos5l_o21ai_1_2.B1 1.63709f
C67 sg13cmos5l_buf_8_2.A sg13cmos5l_dfrbpq_1_2.Q 0.04399f
C68 a_7888_14726# VDD 0.13652f
C69 sg13cmos5l_buf_8_2.X sg13cmos5l_dfrbpq_1_3.RESET_B 0.01196f
C70 sg13cmos5l_dfrbpq_1_2.D a_15338_14484# 0.01367f
C71 sg13cmos5l_and2_1_2.X a_8694_15302# 0.02064f
C72 a_19054_15423# a_18789_15277# 0.0144f
C73 counter_value_o[7] VDD 0.1164f
C74 a_27296_16082# VDD 0.10061f
C75 a_9444_15552# VDD 0.0722f
C76 a_19169_15424# sg13cmos5l_dfrbpq_1_2.Q 0.0208f
C77 a_10618_14448# a_10337_14750# 0.18796f
C78 sg13cmos5l_dlygate4sd3_1_1.A clock_i 0.01208f
C79 a_18586_15455# sg13cmos5l_dfrbpq_1_2.Q 0.04669f
C80 a_26554_16237# VDD 0.09431f
C81 a_6372_14488# sg13cmos5l_dlygate4sd3_1_8.X 0.02859f
C82 a_26249_16334# VDD 0.07375f
C83 a_4432_15454# a_4842_15532# 0.07015f
C84 a_20278_14862# sg13cmos5l_or3_1_2.B 0.08485f
C85 a_22508_15960# sg13cmos5l_dfrbpq_1_3.Q 0.19275f
C86 a_10960_15454# VDD 0.13649f
C87 a_15579_14854# sg13cmos5l_dfrbpq_1_2.D 0.09154f
C88 a_9732_15247# a_9861_15213# 0.01562f
C89 sg13cmos5l_xnor2_1_2.B VDD 0.63659f
C90 sg13cmos5l_dfrbpq_1_5.D sg13cmos5l_a21oi_1_3.B1 0.19488f
C91 a_10618_14448# VDD 0.28771f
C92 sg13cmos5l_dlygate4sd3_1_1.A sg13cmos5l_xnor2_1_2.A 0.06433f
C93 a_22426_15202# VDD 0.29669f
C94 a_18552_15976# sg13cmos5l_dlygate4sd3_1_5.A 0.01087f
C95 sg13cmos5l_or3_1_1.C sg13cmos5l_buf_8_2.X 0.01896f
C96 a_25930_14452# sg13cmos5l_a21oi_1_3.Y 0.0453f
C97 a_10609_15311# a_10703_15311# 0.16704f
C98 sg13cmos5l_dfrbpq_1_7.RESET_B a_25930_14452# 0.17295f
C99 a_25670_14922# a_25956_14488# 0.26205f
C100 VDD sg13cmos5l_or3_1_1.B 1.88587f
C101 sg13cmos5l_a21oi_1_3.B1 sg13cmos5l_o21ai_1_2.Y 0.01177f
C102 counter_value_o[6] VDD 0.12121f
C103 sg13cmos5l_o21ai_1_3.Y sg13cmos5l_or3_1_2.B 0.05035f
C104 counter_value_o[5] a_27500_15960# 0.15495f
C105 a_26244_14909# sg13cmos5l_a21oi_1_3.Y 0.01169f
C106 sg13cmos5l_or3_1_2.A a_20278_14862# 0.02431f
C107 a_5687_15549# VDD 0.09536f
C108 a_25670_14922# a_26475_14495# 0.07916f
C109 sg13cmos5l_dfrbpq_1_2.RESET_B a_17327_13799# 0.10868f
C110 sg13cmos5l_dlygate4sd3_1_4.X sg13cmos5l_dlygate4sd3_1_5.A 0.24548f
C111 a_17604_14488# a_18769_14845# 0.25046f
C112 sg13cmos5l_or3_1_1.X a_24841_13726# 0.12621f
C113 a_6682_13690# sg13cmos5l_xnor2_1_2.A 0.03858f
C114 a_10337_14750# sg13cmos5l_dlygate4sd3_1_8.X 0.01066f
C115 a_9418_15457# sg13cmos5l_tiehi_1.L_HI 0.17464f
C116 sg13cmos5l_buf_8_2.A sg13cmos5l_dfrbpq_1_2.RESET_B 0.08449f
C117 a_6372_14488# sg13cmos5l_xnor2_1_2.A 0.01799f
C118 sg13cmos5l_nand4_1_0.Y a_7680_15549# 0.03194f
C119 sg13cmos5l_or3_1_2.C sg13cmos5l_or3_1_1.B 0.09208f
C120 sg13cmos5l_or3_1_2.B sg13cmos5l_dfrbpq_1_2.Q 0.38942f
C121 a_24520_13854# VDD 0.14054f
C122 a_21251_13690# a_20968_13854# 0.01625f
C123 a_19816_15366# VDD 0.12937f
C124 sg13cmos5l_inv_1_0.A VDD 0.2568f
C125 sg13cmos5l_dlygate4sd3_1_8.X VDD 0.35396f
C126 sg13cmos5l_or3_1_1.X a_25094_15238# 0.04107f
C127 sg13cmos5l_dfrbpq_1_1.RESET_B sg13cmos5l_buf_1_0.X 0.16585f
C128 sg13cmos5l_dlygate4sd3_1_1.A sg13cmos5l_xor2_1_0.B 0.01964f
C129 counter_value_o[5] VDD 0.13222f
C130 sg13cmos5l_dfrbpq_1_6.Q sg13cmos5l_or3_1_1.A 1.7649f
C131 VDD sg13cmos5l_a21oi_1_3.Y 0.39493f
C132 sg13cmos5l_dfrbpq_1_7.RESET_B VDD 1.10388f
C133 sg13cmos5l_dfrbpq_1_3.D sg13cmos5l_a21oi_1_0.A2 0.13532f
C134 sg13cmos5l_or3_1_1.B sg13cmos5l_a21oi_1_3.A1 0.01717f
C135 a_16140_15424# sg13cmos5l_a21oi_1_0.Y 0.03336f
C136 VDD a_38720_3986# 0.0582f
C137 a_21060_14488# sg13cmos5l_dfrbpq_1_6.RESET_B 0.27212f
C138 VDD a_25206_15302# 0.16099f
C139 a_17578_14452# sg13cmos5l_buf_8_2.A 0.01404f
C140 a_26565_13701# VDD 0.28166f
C141 a_24841_13726# a_25037_14020# 0.01485f
C142 a_2630_15234# a_2916_15552# 0.26205f
C143 a_17710_16263# sg13cmos5l_a21oi_1_0.A1 0.10824f
C144 sg13cmos5l_dfrbpq_1_6.RESET_B sg13cmos5l_a21oi_1_3.B1 0.0175f
C145 sg13cmos5l_or3_1_2.A sg13cmos5l_dfrbpq_1_2.Q 0.09838f
C146 sg13cmos5l_dfrbpq_1_5.RESET_B sg13cmos5l_dfrbpq_1_7.Q 0.02776f
C147 sg13cmos5l_nand3_1_0.Y a_7680_15549# 0.23616f
C148 a_25889_15424# a_26170_15202# 0.18796f
C149 a_22319_14845# sg13cmos5l_dfrbpq_1_6.RESET_B 0.10879f
C150 sg13cmos5l_nand4_1_0.Y sg13cmos5l_dfrbpq_1_2.CLK 1.61147f
C151 sg13cmos5l_o21ai_1_1.Y sg13cmos5l_or3_1_2.X 0.05673f
C152 sg13cmos5l_o21ai_1_2.B1 sg13cmos5l_or3_1_1.A 0.03039f
C153 clock_i VDD 1.62643f
C154 a_24169_14508# sg13cmos5l_o21ai_1_2.B1 0.24209f
C155 sg13cmos5l_dfrbpq_1_7.Q a_27882_14484# 0.09875f
C156 a_15782_13722# sg13cmos5l_or3_1_1.B 0.04779f
C157 a_6372_14488# sg13cmos5l_xor2_1_0.B 0.02396f
C158 a_21281_16262# VDD 0.2072f
C159 VDD a_38720_15366# 0.09056f
C160 a_7532_15960# a_7240_16082# 0.01635f
C161 a_2824_16082# a_3008_16082# 0.05762f
C162 a_3130_16237# a_3333_16033# 0.02453f
C163 counter_value_o[4] VDD 0.09581f
C164 a_25670_14922# sg13cmos5l_dfrbpq_1_7.D 0.16976f
C165 sg13cmos5l_dfrbpq_1_1.RESET_B sg13cmos5l_buf_1_10.X 0.02402f
C166 VDD a_16042_13945# 0.09565f
C167 a_23552_14570# VDD 0.06435f
C168 a_17318_14922# sg13cmos5l_dfrbpq_1_3.D 0.17256f
C169 a_17584_13942# sg13cmos5l_or3_1_1.B 0.01425f
C170 sg13cmos5l_a21oi_1_1.Y VDD 0.38748f
C171 sg13cmos5l_xnor2_1_2.A VDD 0.73342f
C172 a_32200_16082# counter_value_o[6] 0.02116f
C173 sg13cmos5l_buf_8_2.X sg13cmos5l_or3_1_1.B 0.1628f
C174 sg13cmos5l_a21oi_1_3.A1 sg13cmos5l_a21oi_1_3.Y 0.35f
C175 a_7937_13912# sg13cmos5l_dlygate4sd3_1_1.A 0.02056f
C176 a_26122_13945# a_25862_13722# 0.45119f
C177 a_19120_14726# a_18863_14845# 0.23043f
C178 a_16969_16020# sg13cmos5l_or3_1_2.B 0.17174f
C179 a_22145_15424# sg13cmos5l_dfrbpq_1_2.Q 0.01328f
C180 a_12010_15202# VDD 1.01037f
C181 a_20774_14922# sg13cmos5l_or3_1_2.B 0.04313f
C182 a_6789_14495# a_7537_14845# 0.01058f
C183 sg13cmos5l_nand3_1_0.Y sg13cmos5l_nand4_1_0.Y 0.14351f
C184 VDD a_1192_3900# 0.18614f
C185 a_25206_15302# sg13cmos5l_a21oi_1_3.A1 0.11555f
C186 a_16552_15996# sg13cmos5l_dfrbpq_1_2.Q 0.19543f
C187 sg13cmos5l_buf_1_0.X sg13cmos5l_buf_1_10.X 0.13688f
C188 a_25109_12972# sg13cmos5l_a21oi_1_3.Y 0.10082f
C189 a_21348_14909# sg13cmos5l_or3_1_2.B 0.01476f
C190 a_18106_15960# sg13cmos5l_dlygate4sd3_1_5.A 0.28314f
C191 a_16140_15424# sg13cmos5l_inv_1_0.Y 0.08646f
C192 a_6286_13911# sg13cmos5l_dlygate4sd3_1_0.X 0.10725f
C193 counter_value_o[3] VDD 0.07686f
C194 a_18665_15180# VDD 0.0736f
C195 sg13cmos5l_dfrbpq_1_3.Q VDD 1.10993f
C196 a_27407_13799# a_27664_13942# 0.23043f
C197 a_26148_14040# a_27313_13799# 0.25046f
C198 a_24824_15238# sg13cmos5l_o21ai_1_2.Y 0.27487f
C199 a_26667_13844# a_26436_13735# 0.07823f
C200 a_18202_15202# VDD 0.26193f
C201 a_21034_14452# a_21060_14488# 0.24169f
C202 sg13cmos5l_dfrbpq_1_7.RESET_B a_25786_15960# 0.03625f
C203 a_9444_15552# sg13cmos5l_nand4_1_0.Y 0.02334f
C204 a_9444_15552# sg13cmos5l_dfrbpq_1_2.CLK 0.08307f
C205 sg13cmos5l_or3_1_1.A a_25774_15423# 0.01031f
C206 a_6086_14922# a_6789_14495# 0.02431f
C207 a_23638_14862# sg13cmos5l_o21ai_1_2.Y 0.06016f
C208 a_21477_14495# a_21579_14495# 0.3643f
C209 sg13cmos5l_buf_8_2.X sg13cmos5l_a21oi_1_3.Y 0.07372f
C210 sg13cmos5l_dfrbpq_1_7.RESET_B sg13cmos5l_buf_8_2.X 0.0607f
C211 a_12524_15960# a_12232_16082# 0.01635f
C212 a_20774_14922# sg13cmos5l_or3_1_2.A 0.03212f
C213 a_10960_15454# sg13cmos5l_nand4_1_0.Y 0.0126f
C214 a_27502_15423# a_27617_15424# 0.3854f
C215 sg13cmos5l_dfrbpq_1_6.Q sg13cmos5l_or3_1_2.B 0.20181f
C216 sg13cmos5l_xor2_1_0.B VDD 0.49614f
C217 sg13cmos5l_or3_1_1.A a_24310_15230# 0.02324f
C218 a_22025_16334# a_21946_16237# 0.08889f
C219 sg13cmos5l_o21ai_1_2.A2 sg13cmos5l_dfrbpq_1_3.Q 0.12945f
C220 sg13cmos5l_a21oi_1_0.Y VDD 0.26526f
C221 a_6372_14488# a_6660_14909# 0.24435f
C222 sg13cmos5l_a21oi_1_0.A1 VDD 0.33029f
C223 sg13cmos5l_a21oi_1_3.A2 sg13cmos5l_o21ai_1_2.Y 0.04308f
C224 a_22576_14726# a_22319_14845# 0.23043f
C225 a_4175_15311# a_2916_15552# 0.01412f
C226 sg13cmos5l_xnor2_1_2.B sg13cmos5l_dfrbpq_1_2.CLK 0.02511f
C227 a_21070_15423# sg13cmos5l_dlygate4sd3_1_9.X 0.10667f
C228 a_22149_16033# counter_value_o[4] 0.0172f
C229 sg13cmos5l_dfrbpq_1_3.Q sg13cmos5l_or3_1_2.C 0.20063f
C230 a_21348_14909# sg13cmos5l_or3_1_2.A 0.01104f
C231 a_26565_13701# sg13cmos5l_buf_8_2.X 0.21461f
C232 sg13cmos5l_inv_1_0.A sg13cmos5l_dfrbpq_1_3.RESET_B 0.03151f
C233 sg13cmos5l_or3_1_1.C sg13cmos5l_or3_1_1.B 0.12764f
C234 a_16042_13945# a_15782_13722# 0.45119f
C235 sg13cmos5l_dlygate4sd3_1_8.X a_7680_15549# 0.10198f
C236 sg13cmos5l_nand3_1_0.Y a_7923_15532# 0.01019f
C237 sg13cmos5l_a21oi_1_1.Y sg13cmos5l_dfrbpq_1_6.D 0.02843f
C238 counter_value_o[2] VDD 0.12104f
C239 sg13cmos5l_nand4_1_0.Y sg13cmos5l_or3_1_1.B 0.01086f
C240 a_4081_15311# a_3333_15213# 0.01058f
C241 sg13cmos5l_inv_1_0.A a_17238_15302# 0.01275f
C242 sg13cmos5l_dfrbpq_1_2.CLK sg13cmos5l_or3_1_1.B 0.21155f
C243 a_10016_14570# a_9861_14521# 0.03131f
C244 a_18021_14495# sg13cmos5l_a21oi_1_3.B1 0.01249f
C245 sg13cmos5l_o21ai_1_2.B1 sg13cmos5l_or3_1_2.B 0.35664f
C246 a_16485_13701# a_16587_13844# 0.36168f
C247 a_3333_15213# VDD 0.28955f
C248 sg13cmos5l_a21oi_1_3.B1 a_24923_15996# 0.01453f
C249 a_25390_16263# a_25505_16262# 0.3854f
C250 sg13cmos5l_buf_8_2.A sg13cmos5l_buf_1_10.X 0.38553f
C251 a_17318_14922# a_17604_14488# 0.26205f
C252 a_1965_14832# VDD 0.305f
C253 a_3333_16033# VDD 0.07215f
C254 a_16485_13701# a_16356_13735# 0.01562f
C255 a_8694_15302# sg13cmos5l_and2_1_2.B 0.12545f
C256 sg13cmos5l_tiehi_1.L_HI a_9737_14822# 0.01916f
C257 a_9536_14570# VDD 0.10026f
C258 sg13cmos5l_a21oi_1_0.A2 VDD 0.3392f
C259 a_25956_14488# a_26373_14495# 0.28418f
C260 a_9158_15234# a_9861_15213# 0.02453f
C261 sg13cmos5l_or3_1_1.C a_24520_13854# 0.0191f
C262 a_2516_14484# VDD 0.14128f
C263 sg13cmos5l_dfrbpq_1_6.D sg13cmos5l_dfrbpq_1_3.Q 0.01666f
C264 sg13cmos5l_a21oi_1_3.B1 sg13cmos5l_or3_1_1.X 0.09969f
C265 a_26249_16334# a_26554_16237# 0.01055f
C266 a_7937_13912# VDD 0.21568f
C267 a_6286_13911# VDD 0.15952f
C268 sg13cmos5l_dfrbpq_1_5.RESET_B sg13cmos5l_dfrbpq_1_6.Q 0.03307f
C269 sg13cmos5l_dlygate4sd3_1_8.X sg13cmos5l_nand4_1_0.Y 0.20079f
C270 a_26373_14495# a_26475_14495# 0.3643f
C271 counter_value_o[1] VDD 0.11682f
C272 sg13cmos5l_inv_1_0.A sg13cmos5l_dfrbpq_1_2.CLK 0.34455f
C273 a_5613_14832# sg13cmos5l_and2_1_1.X 0.08726f
C274 sg13cmos5l_dlygate4sd3_1_8.X sg13cmos5l_dfrbpq_1_2.CLK 0.39427f
C275 a_5504_14570# VDD 0.08633f
C276 sg13cmos5l_dlygate4sd3_1_3.A a_2916_15552# 0.0212f
C277 sg13cmos5l_buf_1_0.X a_3435_15356# 0.01828f
C278 a_21477_14495# VDD 0.24916f
C279 a_15870_15486# a_15671_15315# 0.02453f
C280 sg13cmos5l_dfrbpq_1_5.RESET_B a_26633_16334# 0.01098f
C281 a_2490_14447# sg13cmos5l_buf_1_0.X 0.09015f
C282 a_26475_14495# a_27472_14726# 0.03546f
C283 sg13cmos5l_inv_1_0.Y VDD 0.76193f
C284 sg13cmos5l_or3_1_1.X a_25505_16262# 0.01201f
C285 sg13cmos5l_dfrbpq_1_3.Q sg13cmos5l_buf_8_2.X 0.02606f
C286 a_10222_14751# sg13cmos5l_dlygate4sd3_1_8.X 0.1126f
C287 a_22986_14484# VDD 0.30036f
C288 sg13cmos5l_dfrbpq_1_1.RESET_B a_6891_14495# 0.28013f
C289 sg13cmos5l_inv_1_0.A a_15671_15549# 0.01207f
C290 sg13cmos5l_xor2_1_0.X VDD 0.14666f
C291 a_4474_14448# sg13cmos5l_dlygate4sd3_1_3.A 0.28823f
C292 a_17318_14922# VDD 0.52408f
C293 sg13cmos5l_dfrbpq_1_5.RESET_B sg13cmos5l_o21ai_1_2.B1 0.12304f
C294 clock_i sg13cmos5l_nand4_1_0.Y 0.14857f
C295 sg13cmos5l_o21ai_1_1.Y VDD 0.29617f
C296 a_17921_15424# sg13cmos5l_dfrbpq_1_2.Q 0.03888f
C297 a_26170_16237# VDD 0.09144f
C298 a_23736_14464# VDD 0.01784f
C299 clock_i sg13cmos5l_dfrbpq_1_2.CLK 0.03525f
C300 sg13cmos5l_dfrbpq_1_6.RESET_B sg13cmos5l_or3_1_2.X 0.36966f
C301 sg13cmos5l_dfrbpq_1_3.Q a_19450_15202# 0.28632f
C302 sg13cmos5l_dfrbpq_1_3.RESET_B a_18665_15180# 0.01111f
C303 a_4175_15311# a_4432_15454# 0.23043f
C304 a_18202_15202# sg13cmos5l_dfrbpq_1_3.RESET_B 0.06264f
C305 sg13cmos5l_dlygate4sd3_1_8.X sg13cmos5l_nand3_1_0.Y 0.28523f
C306 counter_value_o[0] VDD 0.11896f
C307 sg13cmos5l_tiehi_1.L_HI a_9963_15356# 0.28158f
C308 sg13cmos5l_or3_1_2.B a_24310_15230# 0.07683f
C309 a_7888_14726# sg13cmos5l_dlygate4sd3_1_8.X 0.01017f
C310 a_9732_15247# a_9158_15234# 0.18486f
C311 a_27215_14845# VDD 0.17631f
C312 a_17806_15423# a_17921_15424# 0.3854f
C313 sg13cmos5l_a21oi_1_3.B1 sg13cmos5l_dfrbpq_1_7.D 0.26997f
C314 a_15671_15549# clock_i 0.03769f
C315 sg13cmos5l_dlygate4sd3_1_8.X a_7262_15242# 0.01812f
C316 a_2490_14447# sg13cmos5l_buf_1_10.X 0.01712f
C317 sg13cmos5l_xnor2_1_2.A sg13cmos5l_nand4_1_0.Y 0.05029f
C318 sg13cmos5l_buf_1_0.X a_7160_15242# 0.01376f
C319 sg13cmos5l_a21oi_1_3.B1 a_18123_14495# 0.01374f
C320 sg13cmos5l_xnor2_1_2.A sg13cmos5l_dfrbpq_1_2.CLK 0.07807f
C321 a_21824_15366# VDD 0.07818f
C322 enable_i sg13cmos5l_buf_1_0.X 0.0337f
C323 a_4842_15532# VDD 0.28434f
C324 sg13cmos5l_or3_1_2.C sg13cmos5l_o21ai_1_1.Y 0.03402f
C325 a_5886_15486# a_5687_15315# 0.02453f
C326 a_24169_14508# sg13cmos5l_or3_1_2.B 0.16618f
C327 a_27296_16082# counter_value_o[5] 0.01377f
C328 VDD a_16168_15996# 0.22709f
C329 sg13cmos5l_dfrbpq_1_2.D VDD 0.43023f
C330 a_12010_15202# sg13cmos5l_nand4_1_0.Y 0.04366f
C331 sg13cmos5l_a21oi_1_3.B1 a_20278_14862# 0.01435f
C332 sg13cmos5l_dlygate4sd3_1_0.A a_6280_13058# 0.01639f
C333 a_12010_15202# sg13cmos5l_dfrbpq_1_2.CLK 0.67763f
C334 sg13cmos5l_dfrbpq_1_7.RESET_B a_26249_16334# 0.01098f
C335 clock_i sg13cmos5l_nand3_1_0.Y 0.04233f
C336 a_9963_15356# sg13cmos5l_dlygate4sd3_1_8.A 0.0308f
C337 sg13cmos5l_dlygate4sd3_1_4.X a_17710_16263# 0.01296f
C338 a_17604_14488# a_18863_14845# 0.01412f
C339 sg13cmos5l_or3_1_1.C sg13cmos5l_dfrbpq_1_3.Q 0.09624f
C340 sg13cmos5l_tiehi_1.L_HI VDD 1.09488f
C341 a_19323_13726# VDD 0.94636f
C342 sg13cmos5l_nor2_1_0.B a_16175_15238# 0.0301f
C343 sg13cmos5l_dfrbpq_1_6.Q a_23960_15242# 0.01412f
C344 a_4432_15454# sg13cmos5l_dlygate4sd3_1_3.A 0.05808f
C345 sg13cmos5l_o21ai_1_2.B1 a_26638_15423# 0.10722f
C346 sg13cmos5l_dfrbpq_1_5.RESET_B a_26667_13844# 0.28617f
C347 sg13cmos5l_inv_1_0.A sg13cmos5l_or3_1_1.B 0.44688f
C348 sg13cmos5l_a21oi_1_3.B1 sg13cmos5l_o21ai_1_3.Y 0.37884f
C349 a_21477_14495# sg13cmos5l_buf_8_2.X 0.21497f
C350 sg13cmos5l_dlygate4sd3_1_17.A sg13cmos5l_o21ai_1_2.Y 0.21213f
C351 a_20376_14464# sg13cmos5l_o21ai_1_1.Y 0.01087f
C352 a_11752_15366# VDD 0.15245f
C353 sg13cmos5l_dfrbpq_1_6.Q a_27898_15202# 0.012f
C354 sg13cmos5l_dfrbpq_1_6.D sg13cmos5l_o21ai_1_1.Y 0.09542f
C355 sg13cmos5l_a21oi_1_0.A2 sg13cmos5l_dfrbpq_1_3.RESET_B 0.01456f
C356 a_25094_14484# sg13cmos5l_or3_1_1.X 0.03354f
C357 a_21034_14452# sg13cmos5l_or3_1_2.X 0.02296f
C358 sg13cmos5l_dfrbpq_1_6.Q a_23368_14570# 0.0251f
C359 VDD a_26170_15202# 0.25937f
C360 sg13cmos5l_xor2_1_0.B sg13cmos5l_dfrbpq_1_2.CLK 0.10767f
C361 a_22986_14484# sg13cmos5l_buf_8_2.X 0.01572f
C362 sg13cmos5l_a21oi_1_0.Y sg13cmos5l_dfrbpq_1_2.CLK 0.1806f
C363 sg13cmos5l_a21oi_1_0.A1 sg13cmos5l_dfrbpq_1_2.CLK 0.27031f
C364 a_24169_14508# a_24263_14508# 0.02103f
C365 a_17238_15302# sg13cmos5l_a21oi_1_0.A2 0.03082f
C366 sg13cmos5l_o21ai_1_3.Y a_25505_16262# 0.02436f
C367 a_25786_15960# a_26170_16237# 0.01303f
C368 VDD sg13cmos5l_dlygate4sd3_1_8.A 0.84676f
C369 a_6714_12972# sg13cmos5l_xnor2_1_2.B 0.01001f
C370 sg13cmos5l_dfrbpq_1_5.Q VDD 2.16343f
C371 sg13cmos5l_dfrbpq_1_5.RESET_B sg13cmos5l_or3_1_1.A 0.02336f
C372 sg13cmos5l_dfrbpq_1_5.D VDD 0.42253f
C373 a_25862_13722# VDD 0.53201f
C374 sg13cmos5l_a21oi_1_3.B1 sg13cmos5l_dfrbpq_1_2.Q 0.27687f
C375 a_18863_14845# VDD 0.17376f
C376 sg13cmos5l_dfrbpq_1_7.Q a_26373_14495# 0.01321f
C377 sg13cmos5l_o21ai_1_1.Y sg13cmos5l_buf_8_2.X 0.26217f
C378 clock_i sg13cmos5l_or3_1_1.B 0.07955f
C379 a_7631_14845# a_8298_14484# 0.09257f
C380 sg13cmos5l_a21oi_1_3.B1 sg13cmos5l_dlygate4sd3_1_9.X 0.10511f
C381 a_3872_14570# sg13cmos5l_xor2_1_0.B 0.01249f
C382 a_21579_14495# sg13cmos5l_dfrbpq_1_6.RESET_B 0.27969f
C383 sg13cmos5l_xnor2_1_2.A sg13cmos5l_xnor2_1_2.B 0.34537f
C384 a_27664_13942# VDD 0.14131f
C385 VDD sg13cmos5l_o21ai_1_2.Y 0.33363f
C386 sg13cmos5l_dlygate4sd3_1_1.A a_8298_14484# 0.09568f
C387 sg13cmos5l_dfrbpq_1_7.Q a_27472_14726# 0.01873f
C388 a_3333_15213# sg13cmos5l_dfrbpq_1_2.CLK 0.20287f
C389 a_16042_13945# sg13cmos5l_or3_1_1.B 0.0385f
C390 sg13cmos5l_dfrbpq_1_2.D a_15782_13722# 0.16401f
C391 a_17318_14922# sg13cmos5l_dfrbpq_1_3.RESET_B 0.10741f
C392 a_18552_15976# VDD 0.01784f
C393 reset_n_i sg13cmos5l_buf_1_10.X 0.01015f
C394 sg13cmos5l_inv_1_0.Y a_18454_16374# 0.05732f
C395 sg13cmos5l_and2_1_2.X sg13cmos5l_buf_1_10.X 0.01634f
C396 a_22030_15423# sg13cmos5l_dfrbpq_1_2.Q 0.01335f
C397 sg13cmos5l_dfrbpq_1_7.RESET_B sg13cmos5l_a21oi_1_3.Y 0.10426f
C398 VDD a_27617_15424# 0.20604f
C399 sg13cmos5l_dfrbpq_1_0.RESET_B a_3333_15213# 0.03853f
C400 sg13cmos5l_dfrbpq_1_6.RESET_B a_21185_15424# 0.04526f
C401 a_9737_14822# a_9658_14725# 0.08889f
C402 a_38536_10034# VDD 0.1399f
C403 a_21166_16263# VDD 0.15938f
C404 a_37484_15960# a_37192_16082# 0.01635f
C405 VDD a_16587_13844# 0.21312f
C406 sg13cmos5l_dlygate4sd3_1_4.X VDD 0.58517f
C407 sg13cmos5l_o21ai_1_2.A2 sg13cmos5l_o21ai_1_2.Y 0.08237f
C408 a_17233_13799# a_16068_14040# 0.25046f
C409 sg13cmos5l_inv_1_0.A clock_i 0.04697f
C410 a_2890_15457# a_2916_15552# 0.24169f
C411 a_18123_14495# a_19120_14726# 0.03546f
C412 sg13cmos5l_dfrbpq_1_2.RESET_B sg13cmos5l_nor2_1_0.B 0.07964f
C413 VDD a_12524_15960# 0.22898f
C414 a_20705_15260# sg13cmos5l_dlygate4sd3_1_9.X 0.01276f
C415 a_22426_15202# sg13cmos5l_dfrbpq_1_3.Q 0.03081f
C416 sg13cmos5l_dfrbpq_1_5.D sg13cmos5l_a21oi_1_3.A1 0.10222f
C417 a_26148_14040# a_26667_13844# 0.20773f
C418 sg13cmos5l_or3_1_1.A a_24841_13726# 0.20349f
C419 a_4474_14448# a_4193_14750# 0.18796f
C420 sg13cmos5l_dlygate4sd3_1_1.A a_6789_14495# 0.01319f
C421 a_19323_13726# sg13cmos5l_buf_8_2.X 0.66336f
C422 sg13cmos5l_inv_1_0.Y sg13cmos5l_dfrbpq_1_2.CLK 0.01047f
C423 sg13cmos5l_xnor2_1_2.A sg13cmos5l_dlygate4sd3_1_8.X 0.06752f
C424 sg13cmos5l_xor2_1_0.B sg13cmos5l_xnor2_1_2.B 0.02186f
C425 sg13cmos5l_or3_1_1.A a_26638_15423# 0.01026f
C426 a_19054_15423# VDD 0.15932f
C427 a_26148_14040# a_26436_13735# 0.24435f
C428 a_20774_14922# a_21060_14488# 0.26205f
C429 a_6286_13911# a_6080_13854# 0.01604f
C430 sg13cmos5l_dfrbpq_1_2.RESET_B sg13cmos5l_a21oi_1_3.B1 0.03328f
C431 a_2248_16082# VDD 0.16554f
C432 a_15671_15549# sg13cmos5l_inv_1_0.Y 0.01387f
C433 sg13cmos5l_or3_1_2.A sg13cmos5l_or3_1_2.B 0.76615f
C434 a_6540_13238# a_6280_13058# 0.01728f
C435 a_20968_13854# sg13cmos5l_or3_1_2.X 0.02112f
C436 sg13cmos5l_dfrbpq_1_6.RESET_B VDD 1.15314f
C437 a_27407_13799# a_27313_13799# 0.16704f
C438 sg13cmos5l_or3_1_1.A a_25094_15238# 0.04844f
C439 a_6086_14922# a_6346_14452# 0.45119f
C440 a_25206_14508# a_25094_14484# 0.3854f
C441 a_21060_14488# a_21348_14909# 0.24435f
C442 a_6682_13690# sg13cmos5l_dlygate4sd3_1_0.A 0.31148f
C443 sg13cmos5l_a21oi_1_0.Y sg13cmos5l_or3_1_1.B 0.21476f
C444 a_2528_15366# sg13cmos5l_and2_1_0.X 0.03662f
C445 a_6372_14488# a_6789_14495# 0.28418f
C446 a_24824_14525# sg13cmos5l_o21ai_1_2.Y 0.01349f
C447 a_21579_14495# a_22576_14726# 0.03546f
C448 sg13cmos5l_dfrbpq_1_3.Q a_19816_15366# 0.05363f
C449 sg13cmos5l_dfrbpq_1_5.D sg13cmos5l_buf_8_2.X 0.07404f
C450 sg13cmos5l_o21ai_1_3.Y a_24824_15238# 0.03926f
C451 sg13cmos5l_buf_8_2.X a_18863_14845# 0.02216f
C452 sg13cmos5l_a21oi_1_1.Y a_21281_16262# 0.02116f
C453 a_21562_15960# a_21946_16237# 0.01303f
C454 a_21166_16263# sg13cmos5l_dfrbpq_1_6.D 0.10665f
C455 a_3204_15247# a_3333_15213# 0.01562f
C456 sg13cmos5l_a21oi_1_3.B1 a_20603_15532# 0.03672f
C457 sg13cmos5l_dlygate4sd3_1_0.X a_5613_14832# 0.20961f
C458 sg13cmos5l_dfrbpq_1_6.RESET_B sg13cmos5l_or3_1_2.C 0.02463f
C459 sg13cmos5l_buf_8_2.X sg13cmos5l_o21ai_1_2.Y 0.51052f
C460 a_17578_14452# sg13cmos5l_a21oi_1_3.B1 0.01016f
C461 sg13cmos5l_dfrbpq_1_7.Q a_27502_15423# 0.01894f
C462 a_15782_13722# a_16587_13844# 0.07916f
C463 a_16068_14040# a_16485_13701# 0.28324f
C464 sg13cmos5l_dfrbpq_1_6.Q sg13cmos5l_a21oi_1_3.B1 0.03563f
C465 a_2630_15234# VDD 0.54684f
C466 a_8298_14484# VDD 0.27815f
C467 a_6286_13911# sg13cmos5l_xnor2_1_2.B 0.05827f
C468 a_18863_14845# sg13cmos5l_dfrbpq_1_3.RESET_B 0.10879f
C469 a_16552_15996# sg13cmos5l_or3_1_2.B 0.09282f
C470 sg13cmos5l_inv_1_0.A sg13cmos5l_a21oi_1_0.Y 0.03371f
C471 sg13cmos5l_inv_1_0.A sg13cmos5l_a21oi_1_0.A1 0.01808f
C472 a_15579_14854# sg13cmos5l_dfrbpq_1_2.RESET_B 0.11274f
C473 sg13cmos5l_tiehi_1.L_HI sg13cmos5l_nand4_1_0.Y 0.03669f
C474 a_21185_15424# a_21466_15202# 0.18796f
C475 a_2824_16082# VDD 0.12267f
C476 a_16587_13844# a_17584_13942# 0.03412f
C477 a_15782_13722# a_16356_13735# 0.18486f
C478 a_8582_15238# a_8694_15302# 0.3854f
C479 sg13cmos5l_tiehi_1.L_HI sg13cmos5l_dfrbpq_1_2.CLK 0.04608f
C480 a_9658_14725# VDD 0.10119f
C481 a_16856_15238# VDD 0.28158f
C482 a_25930_14452# a_25956_14488# 0.24169f
C483 a_17604_14488# a_18021_14495# 0.28418f
C484 a_4078_14751# VDD 0.15946f
C485 a_7829_15238# sg13cmos5l_xnor2_1_0.Y 0.02386f
C486 sg13cmos5l_dfrbpq_1_3.Q counter_value_o[4] 0.01007f
C487 a_26249_16334# a_26170_16237# 0.08889f
C488 a_21251_13690# sg13cmos5l_or3_1_2.B 0.15851f
C489 sg13cmos5l_o21ai_1_2.B1 sg13cmos5l_a21oi_1_3.B1 0.01704f
C490 a_25956_14488# a_26244_14909# 0.24435f
C491 a_18106_15960# VDD 0.28888f
C492 sg13cmos5l_buf_1_0.X a_2916_15552# 0.0434f
C493 a_15870_15486# sg13cmos5l_nor2_1_0.B 0.0389f
C494 a_21034_14452# VDD 0.09647f
C495 sg13cmos5l_a21oi_1_1.Y sg13cmos5l_dfrbpq_1_3.Q 0.01499f
C496 sg13cmos5l_dfrbpq_1_6.D sg13cmos5l_dfrbpq_1_6.RESET_B 0.64332f
C497 sg13cmos5l_dfrbpq_1_1.RESET_B a_6086_14922# 0.07767f
C498 sg13cmos5l_inv_1_0.Y sg13cmos5l_or3_1_1.B 0.86348f
C499 sg13cmos5l_dlygate4sd3_1_17.A a_24923_15996# 0.11419f
C500 sg13cmos5l_dlygate4sd3_1_0.A VDD 0.32455f
C501 sg13cmos5l_dlygate4sd3_1_4.X sg13cmos5l_dfrbpq_1_3.RESET_B 0.01938f
C502 sg13cmos5l_and2_1_0.X VDD 0.30117f
C503 a_26244_14909# a_26475_14495# 0.07823f
C504 sg13cmos5l_dlygate4sd3_1_3.A sg13cmos5l_dlygate4sd3_1_1.A 0.1901f
C505 sg13cmos5l_nand4_1_0.Y sg13cmos5l_dlygate4sd3_1_8.A 0.30072f
C506 a_6789_14495# VDD 0.24623f
C507 a_22576_14726# VDD 0.13981f
C508 sg13cmos5l_dfrbpq_1_2.CLK sg13cmos5l_dlygate4sd3_1_8.A 0.11676f
C509 sg13cmos5l_inv_1_0.A sg13cmos5l_a21oi_1_0.A2 0.0306f
C510 sg13cmos5l_a21oi_1_2.A1 a_25390_16263# 0.10831f
C511 sg13cmos5l_dlygate4sd3_1_4.X a_18454_16374# 0.02479f
C512 counter_value_o[2] clock_i 0.0407f
C513 a_27215_14845# a_27121_14845# 0.16704f
C514 a_25390_16263# VDD 0.16049f
C515 sg13cmos5l_xor2_1_0.B sg13cmos5l_xnor2_1_2.A 0.34223f
C516 sg13cmos5l_or3_1_1.C sg13cmos5l_o21ai_1_2.Y 0.14946f
C517 sg13cmos5l_dfrbpq_1_6.RESET_B sg13cmos5l_buf_8_2.X 0.0379f
C518 sg13cmos5l_or3_1_1.X sg13cmos5l_dlygate4sd3_1_17.A 0.05473f
C519 sg13cmos5l_a21oi_1_2.A1 a_25025_16344# 0.01276f
C520 sg13cmos5l_and2_1_2.X a_9158_15234# 0.16719f
C521 sg13cmos5l_or3_1_2.X sg13cmos5l_dfrbpq_1_2.Q 0.33145f
C522 a_21466_15202# VDD 0.265f
C523 a_21034_14452# sg13cmos5l_or3_1_2.C 0.01367f
C524 sg13cmos5l_or3_1_2.A a_21251_13690# 0.20657f
C525 VDD a_8694_15302# 0.15959f
C526 sg13cmos5l_dlygate4sd3_1_9.X sg13cmos5l_or3_1_2.X 0.17041f
C527 a_25956_14488# VDD 0.07273f
C528 a_18021_14495# VDD 0.24448f
C529 a_18586_15455# a_18789_15277# 0.02453f
C530 sg13cmos5l_a21oi_1_2.A1 a_24923_15996# 0.0686f
C531 sg13cmos5l_tiehi_1.L_HI a_9444_15552# 0.29159f
C532 a_9418_15457# a_9861_15213# 0.02241f
C533 a_5613_14832# VDD 0.30068f
C534 sg13cmos5l_dfrbpq_1_1.RESET_B sg13cmos5l_and2_1_1.X 0.07099f
C535 sg13cmos5l_inv_1_0.A sg13cmos5l_inv_1_0.Y 0.12555f
C536 a_24923_15996# VDD 0.16154f
C537 a_26475_14495# VDD 0.20647f
C538 a_4175_15311# a_4081_15311# 0.16704f
C539 sg13cmos5l_tiehi_1.L_HI a_10960_15454# 0.09962f
C540 a_16168_15996# sg13cmos5l_or3_1_1.B 0.18678f
C541 sg13cmos5l_dfrbpq_1_3.D sg13cmos5l_dfrbpq_1_2.Q 0.01008f
C542 a_17165_16020# a_16969_16020# 0.01485f
C543 sg13cmos5l_dfrbpq_1_2.CLK a_16587_13844# 0.04306f
C544 a_4175_15311# VDD 0.17883f
C545 sg13cmos5l_a21oi_1_2.A1 sg13cmos5l_or3_1_1.X 0.23534f
C546 sg13cmos5l_a21oi_1_3.B1 a_25774_15423# 0.01368f
C547 counter_value_o[1] clock_i 0.0407f
C548 a_14344_14570# VDD 0.15065f
C549 sg13cmos5l_or3_1_1.X VDD 0.43882f
C550 sg13cmos5l_dfrbpq_1_7.RESET_B a_26170_16237# 0.0434f
C551 a_5886_15486# VDD 0.09482f
C552 sg13cmos5l_dfrbpq_1_5.Q counter_value_o[7] 0.01279f
C553 a_9444_15552# sg13cmos5l_dlygate4sd3_1_8.A 0.02593f
C554 sg13cmos5l_dfrbpq_1_2.RESET_B a_16485_13701# 0.0353f
C555 a_19323_13726# sg13cmos5l_or3_1_1.B 0.05142f
C556 a_17604_14488# a_18123_14495# 0.20754f
C557 sg13cmos5l_dfrbpq_1_5.RESET_B a_26638_15423# 0.01351f
C558 sg13cmos5l_inv_1_0.Y clock_i 0.06063f
C559 sg13cmos5l_dfrbpq_1_5.RESET_B a_25670_14922# 0.04146f
C560 a_7937_13912# sg13cmos5l_xnor2_1_2.A 0.01378f
C561 sg13cmos5l_buf_8_2.A sg13cmos5l_nor2_1_0.B 0.19122f
C562 sg13cmos5l_dfrbpq_1_7.RESET_B a_27215_14845# 0.10879f
C563 sg13cmos5l_a21oi_1_3.B1 sg13cmos5l_buf_1_10.X 0.10047f
C564 sg13cmos5l_a21oi_1_0.Y sg13cmos5l_a21oi_1_0.A1 0.0944f
C565 a_10960_15454# sg13cmos5l_dlygate4sd3_1_8.A 0.01793f
C566 a_16140_15424# a_16175_15238# 0.19075f
C567 sg13cmos5l_or3_1_1.A sg13cmos5l_a21oi_1_3.B1 0.13946f
C568 sg13cmos5l_dfrbpq_1_5.RESET_B a_26148_14040# 0.28728f
C569 a_20968_13854# VDD 0.1724f
C570 a_10618_14448# sg13cmos5l_dlygate4sd3_1_8.A 0.28818f
C571 a_16140_15424# sg13cmos5l_dfrbpq_1_2.Q 0.03116f
C572 sg13cmos5l_dfrbpq_1_6.Q a_27502_15423# 0.0569f
C573 counter_value_o[0] clock_i 0.04197f
C574 a_20774_14922# sg13cmos5l_or3_1_2.X 0.02499f
C575 sg13cmos5l_and2_1_2.B sg13cmos5l_buf_1_10.X 0.19757f
C576 a_22576_14726# sg13cmos5l_buf_8_2.X 0.0155f
C577 sg13cmos5l_buf_8_2.A sg13cmos5l_a21oi_1_3.B1 0.56082f
C578 sg13cmos5l_tiehi_1.L_HI sg13cmos5l_dlygate4sd3_1_8.X 0.04348f
C579 sg13cmos5l_dlygate4sd3_1_3.A VDD 1.34734f
C580 sg13cmos5l_or3_1_1.X sg13cmos5l_a21oi_1_3.A1 0.59456f
C581 sg13cmos5l_and2_1_1.X sg13cmos5l_buf_1_10.X 0.04042f
C582 a_6575_13342# sg13cmos5l_xnor2_1_2.B 0.01242f
C583 a_37484_15960# VDD 0.22428f
C584 VDD sg13cmos5l_dfrbpq_1_7.D 0.19689f
C585 a_18123_14495# VDD 0.20905f
C586 sg13cmos5l_or3_1_1.B sg13cmos5l_o21ai_1_2.Y 0.01359f
C587 a_2516_14484# sg13cmos5l_xor2_1_0.B 0.01121f
C588 a_18106_15960# a_18454_16374# 0.02803f
C589 sg13cmos5l_a21oi_1_0.A2 sg13cmos5l_a21oi_1_0.A1 0.83799f
C590 sg13cmos5l_dfrbpq_1_2.D clock_i 0.02532f
C591 sg13cmos5l_o21ai_1_3.Y sg13cmos5l_dlygate4sd3_1_17.A 0.0459f
C592 sg13cmos5l_inv_1_0.Y counter_value_o[3] 0.15994f
C593 a_25956_14488# sg13cmos5l_buf_8_2.X 0.09542f
C594 a_18021_14495# sg13cmos5l_buf_8_2.X 0.20547f
C595 a_20603_15532# sg13cmos5l_or3_1_2.X 0.06091f
C596 a_23638_14862# sg13cmos5l_o21ai_1_2.B1 0.02318f
C597 a_20278_14862# VDD 0.01267f
C598 a_2916_15552# a_3435_15356# 0.20773f
C599 a_11370_15532# a_10703_15311# 0.09257f
C600 a_6540_13238# VDD 0.19533f
C601 a_26475_14495# sg13cmos5l_buf_8_2.X 0.0491f
C602 a_26170_15202# sg13cmos5l_a21oi_1_3.Y 0.28819f
C603 sg13cmos5l_dfrbpq_1_7.RESET_B a_26170_15202# 0.03678f
C604 VDD a_27034_15202# 0.25715f
C605 a_3209_16334# a_3130_16237# 0.08889f
C606 a_17604_14488# sg13cmos5l_dfrbpq_1_2.Q 0.02704f
C607 sg13cmos5l_dfrbpq_1_0.RESET_B a_2630_15234# 0.10309f
C608 a_16587_13844# sg13cmos5l_or3_1_1.B 0.03034f
C609 a_16856_15238# sg13cmos5l_dfrbpq_1_2.CLK 0.01408f
C610 a_6660_14909# sg13cmos5l_xor2_1_0.B 0.023f
C611 a_18021_14495# sg13cmos5l_dfrbpq_1_3.RESET_B 0.04294f
C612 a_38720_13058# VDD 0.09066f
C613 sg13cmos5l_a21oi_1_0.Y sg13cmos5l_inv_1_0.Y 0.02996f
C614 sg13cmos5l_xor2_1_0.X sg13cmos5l_xor2_1_0.B 0.07025f
C615 sg13cmos5l_inv_1_0.Y sg13cmos5l_a21oi_1_0.A1 0.05298f
C616 a_4078_14751# sg13cmos5l_dfrbpq_1_2.CLK 0.01392f
C617 sg13cmos5l_dfrbpq_1_5.D sg13cmos5l_a21oi_1_3.Y 0.30057f
C618 a_25774_15423# a_25889_15424# 0.3854f
C619 VDD a_16068_14040# 0.08143f
C620 sg13cmos5l_or3_1_1.X sg13cmos5l_buf_8_2.X 0.02628f
C621 sg13cmos5l_a21oi_1_2.A1 sg13cmos5l_o21ai_1_3.Y 0.03141f
C622 a_25206_14508# VDD 0.16141f
C623 a_15579_14854# sg13cmos5l_buf_8_2.A 0.68123f
C624 sg13cmos5l_nor2_1_0.B sg13cmos5l_or3_1_2.B 0.03734f
C625 a_16356_13735# sg13cmos5l_or3_1_1.B 0.01005f
C626 sg13cmos5l_or3_1_2.C a_20278_14862# 0.06102f
C627 sg13cmos5l_o21ai_1_3.Y VDD 0.48036f
C628 VDD a_17994_14020# 0.28402f
C629 sg13cmos5l_a21oi_1_3.A1 sg13cmos5l_dfrbpq_1_7.D 0.09285f
C630 sg13cmos5l_dfrbpq_1_7.Q VDD 1.33022f
C631 a_17233_13799# a_17327_13799# 0.16704f
C632 a_25862_13722# a_26565_13701# 0.02453f
C633 a_4078_14751# a_3872_14570# 0.01604f
C634 a_18863_14845# a_18769_14845# 0.16704f
C635 sg13cmos5l_dlygate4sd3_1_5.A sg13cmos5l_or3_1_2.B 0.19226f
C636 clock_i sg13cmos5l_dlygate4sd3_1_8.A 0.08616f
C637 a_6789_14495# sg13cmos5l_dfrbpq_1_2.CLK 0.2273f
C638 a_21060_14488# sg13cmos5l_or3_1_2.B 0.01273f
C639 a_7888_14726# a_8298_14484# 0.07015f
C640 a_16969_16020# a_17710_16263# 0.01693f
C641 sg13cmos5l_or3_1_1.A a_25889_15424# 0.01269f
C642 a_26667_13844# a_27407_13799# 0.17382f
C643 sg13cmos5l_dfrbpq_1_0.RESET_B sg13cmos5l_and2_1_0.X 0.07063f
C644 sg13cmos5l_a21oi_1_3.B1 sg13cmos5l_or3_1_2.B 1.50917f
C645 sg13cmos5l_xor2_1_0.X a_1965_14832# 0.19131f
C646 VDD sg13cmos5l_dfrbpq_1_2.Q 1.33086f
C647 sg13cmos5l_inv_1_0.Y sg13cmos5l_a21oi_1_0.A2 0.01864f
C648 sg13cmos5l_nand4_1_0.Y a_8694_15302# 0.0137f
C649 sg13cmos5l_dlygate4sd3_1_9.X VDD 0.18623f
C650 a_12010_15202# a_11752_15366# 0.01836f
C651 a_25094_14484# sg13cmos5l_or3_1_1.A 0.0598f
C652 a_20774_14922# a_21579_14495# 0.07916f
C653 a_6401_13912# a_6682_13690# 0.18796f
C654 sg13cmos5l_xor2_1_0.X a_2516_14484# 0.06124f
C655 a_26753_15424# a_27034_15202# 0.18796f
C656 a_5613_14832# sg13cmos5l_dfrbpq_1_2.CLK 0.01227f
C657 a_17806_15423# VDD 0.1592f
C658 a_25206_14508# sg13cmos5l_a21oi_1_3.A1 0.03685f
C659 a_6346_14452# a_6372_14488# 0.24169f
C660 a_6086_14922# a_6891_14495# 0.07916f
C661 sg13cmos5l_or3_1_1.A a_24824_15238# 0.02528f
C662 a_21060_14488# a_22225_14845# 0.25046f
C663 a_21348_14909# a_21579_14495# 0.07823f
C664 a_12010_15202# sg13cmos5l_dlygate4sd3_1_8.A 0.02872f
C665 sg13cmos5l_buf_8_2.X sg13cmos5l_dfrbpq_1_7.D 0.01301f
C666 a_21060_14488# sg13cmos5l_or3_1_2.A 0.03179f
C667 sg13cmos5l_buf_8_2.X a_18123_14495# 0.02452f
C668 sg13cmos5l_o21ai_1_2.A2 sg13cmos5l_dfrbpq_1_2.Q 0.02634f
C669 sg13cmos5l_or3_1_1.A a_27502_15423# 0.12348f
C670 sg13cmos5l_or3_1_2.C sg13cmos5l_dfrbpq_1_2.Q 0.11689f
C671 a_21166_16263# a_21281_16262# 0.3854f
C672 a_6575_13342# sg13cmos5l_xnor2_1_2.A 0.01681f
C673 a_22319_14845# a_22225_14845# 0.16704f
C674 a_4432_15454# a_3435_15356# 0.03412f
C675 a_3204_15247# a_2630_15234# 0.18486f
C676 sg13cmos5l_a21oi_1_3.B1 sg13cmos5l_or3_1_2.A 0.01884f
C677 a_1192_9948# sg13cmos5l_buf_1_10.X 0.15509f
C678 a_15782_13722# a_16068_14040# 0.26205f
C679 a_4175_15311# sg13cmos5l_dfrbpq_1_0.RESET_B 0.10904f
C680 a_21166_16263# sg13cmos5l_a21oi_1_1.Y 0.01491f
C681 sg13cmos5l_dfrbpq_1_1.RESET_B a_7631_14845# 0.10879f
C682 sg13cmos5l_a21oi_1_3.A2 sg13cmos5l_or3_1_1.A 0.11755f
C683 a_18123_14495# sg13cmos5l_dfrbpq_1_3.RESET_B 0.28174f
C684 a_24169_14508# sg13cmos5l_a21oi_1_3.A2 0.12591f
C685 a_22030_15423# sg13cmos5l_or3_1_2.A 0.10722f
C686 a_7240_16082# VDD 0.1655f
C687 a_3209_16334# VDD 0.10631f
C688 sg13cmos5l_dfrbpq_1_1.RESET_B sg13cmos5l_dlygate4sd3_1_1.A 0.02096f
C689 a_25786_15960# sg13cmos5l_o21ai_1_3.Y 0.29053f
C690 sg13cmos5l_dlygate4sd3_1_0.A sg13cmos5l_xnor2_1_2.B 0.34813f
C691 a_17578_14452# a_17604_14488# 0.24169f
C692 a_25206_14508# sg13cmos5l_buf_8_2.X 0.01098f
C693 a_9158_15234# sg13cmos5l_and2_1_2.B 0.02349f
C694 a_17584_13942# a_17994_14020# 0.07015f
C695 sg13cmos5l_tiehi_1.L_HI a_9536_14570# 0.01076f
C696 sg13cmos5l_dfrbpq_1_6.D sg13cmos5l_dfrbpq_1_2.Q 0.01319f
C697 sg13cmos5l_dfrbpq_1_2.RESET_B VDD 1.18089f
C698 a_16969_16020# VDD 0.24435f
C699 a_9861_15213# a_9963_15356# 0.36168f
C700 a_10609_15311# sg13cmos5l_dfrbpq_1_2.CLK 0.0137f
C701 sg13cmos5l_dfrbpq_1_7.Q sg13cmos5l_buf_8_2.X 0.1448f
C702 sg13cmos5l_dfrbpq_1_6.Q a_27500_15960# 0.19565f
C703 a_4193_14750# VDD 0.20555f
C704 sg13cmos5l_dfrbpq_1_6.Q sg13cmos5l_dlygate4sd3_1_17.A 0.01411f
C705 a_20774_14922# VDD 0.52379f
C706 a_21281_16262# sg13cmos5l_dfrbpq_1_6.RESET_B 0.02115f
C707 sg13cmos5l_dfrbpq_1_6.D sg13cmos5l_dlygate4sd3_1_9.X 0.09017f
C708 sg13cmos5l_dfrbpq_1_5.RESET_B a_26373_14495# 0.01805f
C709 counter_value_o[2] sg13cmos5l_dlygate4sd3_1_8.A 0.01367f
C710 sg13cmos5l_inv_1_0.Y a_16168_15996# 0.03785f
C711 sg13cmos5l_dlygate4sd3_1_4.X a_18665_15180# 0.04007f
C712 a_6401_13912# VDD 0.20914f
C713 sg13cmos5l_dfrbpq_1_1.RESET_B a_6682_13690# 0.01306f
C714 a_2890_15457# VDD 0.10858f
C715 a_25956_14488# a_27121_14845# 0.25046f
C716 sg13cmos5l_dlygate4sd3_1_1.A sg13cmos5l_buf_1_0.X 0.27666f
C717 a_6346_14452# VDD 0.09662f
C718 sg13cmos5l_dlygate4sd3_1_3.A sg13cmos5l_dfrbpq_1_2.CLK 0.05316f
C719 sg13cmos5l_dfrbpq_1_1.RESET_B a_6372_14488# 0.29766f
C720 sg13cmos5l_a21oi_1_1.Y sg13cmos5l_dfrbpq_1_6.RESET_B 0.15755f
C721 a_21824_15366# sg13cmos5l_o21ai_1_1.Y 0.03907f
C722 a_22145_15424# a_22030_15423# 0.3854f
C723 sg13cmos5l_buf_8_2.X sg13cmos5l_dfrbpq_1_2.Q 0.04395f
C724 a_27472_14726# a_27882_14484# 0.07015f
C725 sg13cmos5l_dlygate4sd3_1_3.A sg13cmos5l_dfrbpq_1_0.RESET_B 0.11811f
C726 a_24408_15552# VDD 0.01784f
C727 sg13cmos5l_o21ai_1_2.B1 sg13cmos5l_dlygate4sd3_1_17.A 0.02204f
C728 sg13cmos5l_and2_1_2.X sg13cmos5l_and2_1_2.B 0.13511f
C729 a_20774_14922# sg13cmos5l_or3_1_2.C 0.03077f
C730 a_20603_15532# VDD 0.16158f
C731 VDD sg13cmos5l_xnor2_1_0.Y 0.31635f
C732 sg13cmos5l_dlygate4sd3_1_4.X sg13cmos5l_a21oi_1_0.A1 0.09426f
C733 a_17578_14452# VDD 0.09602f
C734 sg13cmos5l_dfrbpq_1_6.Q VDD 0.92075f
C735 a_9418_15457# a_9158_15234# 0.45119f
C736 a_9861_15213# VDD 0.24352f
C737 a_19450_15202# sg13cmos5l_dfrbpq_1_2.Q 0.02358f
C738 sg13cmos5l_dfrbpq_1_3.RESET_B sg13cmos5l_dfrbpq_1_2.Q 0.24996f
C739 a_26757_16033# VDD 0.07049f
C740 a_6789_14495# sg13cmos5l_dlygate4sd3_1_8.X 0.01594f
C741 a_7631_14845# sg13cmos5l_buf_1_10.X 0.02226f
C742 a_26633_16334# VDD 0.10189f
C743 sg13cmos5l_dfrbpq_1_6.RESET_B sg13cmos5l_dfrbpq_1_3.Q 0.02561f
C744 a_25670_14922# sg13cmos5l_a21oi_1_3.B1 0.0136f
C745 sg13cmos5l_dlygate4sd3_1_3.A sg13cmos5l_nand3_1_0.Y 0.01196f
C746 sg13cmos5l_dlygate4sd3_1_1.A sg13cmos5l_buf_1_10.X 0.16121f
C747 a_17238_15302# sg13cmos5l_dfrbpq_1_2.Q 0.01082f
C748 sg13cmos5l_or3_1_1.C sg13cmos5l_o21ai_1_3.Y 0.05321f
C749 counter_value_o[2] a_12524_15960# 0.15504f
C750 a_9732_15247# a_9963_15356# 0.07823f
C751 a_10609_15311# a_9444_15552# 0.25046f
C752 sg13cmos5l_dfrbpq_1_2.CLK a_16068_14040# 0.04723f
C753 a_17806_15423# sg13cmos5l_dfrbpq_1_3.RESET_B 0.05914f
C754 a_23638_14862# sg13cmos5l_or3_1_2.B 0.06579f
C755 a_10016_14570# VDD 0.07441f
C756 a_8312_15238# sg13cmos5l_xnor2_1_0.Y 0.30653f
C757 sg13cmos5l_dfrbpq_1_6.Q sg13cmos5l_o21ai_1_2.A2 0.19177f
C758 sg13cmos5l_o21ai_1_2.B1 VDD 0.449f
C759 a_25956_14488# sg13cmos5l_a21oi_1_3.Y 0.02684f
C760 a_17238_15302# a_17806_15423# 0.01641f
C761 sg13cmos5l_dfrbpq_1_7.RESET_B a_25956_14488# 0.28972f
C762 a_17126_15238# sg13cmos5l_dfrbpq_1_3.D 0.02016f
C763 a_25670_14922# a_26373_14495# 0.02431f
C764 a_5687_15315# a_5600_15366# 0.03131f
C765 a_5886_15486# a_5687_15549# 0.08889f
C766 sg13cmos5l_dfrbpq_1_6.D a_20774_14922# 0.17726f
C767 a_37484_15960# counter_value_o[7] 0.15504f
C768 sg13cmos5l_dfrbpq_1_2.RESET_B a_15782_13722# 0.11354f
C769 sg13cmos5l_dlygate4sd3_1_4.X sg13cmos5l_a21oi_1_0.A2 0.04461f
C770 sg13cmos5l_dlygate4sd3_1_0.X sg13cmos5l_buf_1_10.X 0.06585f
C771 sg13cmos5l_dfrbpq_1_1.RESET_B VDD 1.16726f
C772 sg13cmos5l_dfrbpq_1_7.RESET_B a_26475_14495# 0.27969f
C773 sg13cmos5l_dfrbpq_1_2.RESET_B a_17584_13942# 0.09962f
C774 a_6372_14488# sg13cmos5l_buf_1_10.X 0.01881f
C775 a_18021_14495# a_18769_14845# 0.01058f
C776 sg13cmos5l_dlygate4sd3_1_3.A sg13cmos5l_xnor2_1_2.B 0.11793f
C777 sg13cmos5l_dfrbpq_1_5.RESET_B a_26122_13945# 0.20792f
C778 sg13cmos5l_dlygate4sd3_1_0.A sg13cmos5l_xnor2_1_2.A 0.09582f
C779 sg13cmos5l_o21ai_1_2.B1 sg13cmos5l_o21ai_1_2.A2 0.18866f
C780 sg13cmos5l_dfrbpq_1_2.CLK sg13cmos5l_dfrbpq_1_2.Q 0.01544f
C781 a_19048_13854# VDD 0.14253f
C782 sg13cmos5l_or3_1_2.X sg13cmos5l_or3_1_2.B 0.03269f
C783 a_20774_14922# sg13cmos5l_buf_8_2.X 0.01038f
C784 a_6789_14495# sg13cmos5l_xnor2_1_2.A 0.02956f
C785 a_23736_14464# sg13cmos5l_o21ai_1_2.Y 0.01095f
C786 a_15870_15486# VDD 0.09411f
C787 sg13cmos5l_or3_1_1.X sg13cmos5l_a21oi_1_3.Y 0.01332f
C788 sg13cmos5l_dfrbpq_1_6.Q a_26753_15424# 0.01045f
C789 sg13cmos5l_dfrbpq_1_7.RESET_B sg13cmos5l_or3_1_1.X 0.01339f
C790 sg13cmos5l_inv_1_0.Y sg13cmos5l_dlygate4sd3_1_4.X 0.90342f
C791 a_4081_15311# sg13cmos5l_buf_1_0.X 0.0102f
C792 VDD a_2540_15960# 0.19767f
C793 sg13cmos5l_dfrbpq_1_5.RESET_B a_27407_13799# 0.10868f
C794 a_23168_15366# VDD 0.10558f
C795 a_24704_13854# VDD 0.06781f
C796 a_21251_13690# a_21460_14020# 0.01485f
C797 a_19048_13854# a_19232_13854# 0.05762f
C798 a_20000_15366# VDD 0.07202f
C799 sg13cmos5l_buf_1_0.X VDD 3.99477f
C800 sg13cmos5l_or3_1_1.X a_25206_15302# 0.05682f
C801 a_5687_15549# sg13cmos5l_dlygate4sd3_1_3.A 0.01959f
C802 a_6540_13238# sg13cmos5l_xnor2_1_2.B 0.25625f
C803 sg13cmos5l_o21ai_1_2.B1 sg13cmos5l_a21oi_1_3.A1 0.02427f
C804 sg13cmos5l_or3_1_1.A sg13cmos5l_dlygate4sd3_1_17.A 0.15251f
C805 a_24169_14508# sg13cmos5l_dlygate4sd3_1_17.A 0.01646f
C806 a_16856_15238# sg13cmos5l_a21oi_1_0.Y 0.27231f
C807 a_16856_15238# sg13cmos5l_a21oi_1_0.A1 0.067f
C808 a_17710_16263# a_17825_16262# 0.3854f
C809 a_4078_14751# sg13cmos5l_xor2_1_0.B 0.11637f
C810 sg13cmos5l_o21ai_1_3.Y a_26249_16334# 0.01284f
C811 sg13cmos5l_tiehi_1.L_HI sg13cmos5l_dlygate4sd3_1_8.A 0.02474f
C812 a_17604_14488# a_17892_14909# 0.24435f
C813 a_21477_14495# sg13cmos5l_dfrbpq_1_6.RESET_B 0.03611f
C814 sg13cmos5l_or3_1_2.A sg13cmos5l_or3_1_2.X 0.55116f
C815 a_17604_14488# sg13cmos5l_buf_8_2.A 0.01462f
C816 VDD a_25774_15423# 0.15949f
C817 sg13cmos5l_dfrbpq_1_6.Q sg13cmos5l_buf_8_2.X 0.11448f
C818 a_26667_13844# VDD 0.20664f
C819 a_2630_15234# a_3333_15213# 0.02453f
C820 a_10337_14750# sg13cmos5l_buf_1_10.X 0.01927f
C821 a_38536_13854# VDD 0.13998f
C822 a_11752_15366# sg13cmos5l_dlygate4sd3_1_8.A 0.03099f
C823 sg13cmos5l_xor2_1_0.B sg13cmos5l_and2_1_0.X 0.16893f
C824 sg13cmos5l_dfrbpq_1_7.Q a_27121_14845# 0.02056f
C825 a_1192_9948# reset_n_i 0.19796f
C826 a_16068_14040# sg13cmos5l_or3_1_1.B 0.03267f
C827 a_17578_14452# sg13cmos5l_dfrbpq_1_3.RESET_B 0.19309f
C828 a_18021_14495# a_18202_15202# 0.0121f
C829 a_21946_16237# VDD 0.09557f
C830 a_22025_16334# VDD 0.07626f
C831 a_7680_15549# sg13cmos5l_xnor2_1_0.Y 0.14663f
C832 a_7532_15960# sg13cmos5l_dlygate4sd3_1_1.A 0.19272f
C833 VDD sg13cmos5l_buf_1_10.X 2.54445f
C834 sg13cmos5l_dfrbpq_1_7.RESET_B sg13cmos5l_dfrbpq_1_7.D 0.11217f
C835 a_3209_16334# sg13cmos5l_dfrbpq_1_0.RESET_B 0.01409f
C836 VDD a_15680_13854# 0.10463f
C837 sg13cmos5l_dfrbpq_1_6.RESET_B sg13cmos5l_o21ai_1_1.Y 0.02262f
C838 sg13cmos5l_or3_1_1.A VDD 0.48327f
C839 a_24169_14508# VDD 0.25699f
C840 sg13cmos5l_o21ai_1_2.B1 sg13cmos5l_buf_8_2.X 0.22463f
C841 a_17994_14020# sg13cmos5l_or3_1_1.B 0.01534f
C842 a_16140_15424# sg13cmos5l_or3_1_2.B 0.23811f
C843 a_2248_16082# counter_value_o[0] 0.02116f
C844 a_9658_14725# a_9536_14570# 0.01854f
C845 a_9737_14822# a_9861_14521# 0.08186f
C846 sg13cmos5l_dfrbpq_1_2.RESET_B sg13cmos5l_dfrbpq_1_2.CLK 0.04617f
C847 a_4193_14750# sg13cmos5l_dfrbpq_1_2.CLK 0.01906f
C848 VDD a_17327_13799# 0.18096f
C849 a_8218_13690# sg13cmos5l_dlygate4sd3_1_1.A 0.30158f
C850 a_32492_15960# VDD 0.22858f
C851 sg13cmos5l_dfrbpq_1_5.D a_25862_13722# 0.17436f
C852 a_26122_13945# a_26148_14040# 0.24169f
C853 a_19120_14726# a_19530_14484# 0.07015f
C854 a_16175_15238# sg13cmos5l_or3_1_1.B 0.02065f
C855 sg13cmos5l_dlygate4sd3_1_3.A clock_i 0.14753f
C856 a_22426_15202# sg13cmos5l_dfrbpq_1_2.Q 0.01343f
C857 a_6346_14452# sg13cmos5l_dfrbpq_1_2.CLK 0.01513f
C858 a_15671_15549# sg13cmos5l_dfrbpq_1_2.RESET_B 0.01966f
C859 sg13cmos5l_buf_8_2.A VDD 1.75883f
C860 a_6891_14495# a_7631_14845# 0.17382f
C861 a_1965_14832# sg13cmos5l_and2_1_0.X 0.07702f
C862 a_24824_15238# a_25094_15238# 0.18796f
C863 sg13cmos5l_or3_1_1.C a_24408_15552# 0.01124f
C864 a_24169_14508# sg13cmos5l_o21ai_1_2.A2 0.15962f
C865 a_26148_14040# a_27407_13799# 0.01412f
C866 sg13cmos5l_or3_1_1.B sg13cmos5l_dfrbpq_1_2.Q 0.01742f
C867 sg13cmos5l_a21oi_1_3.A2 a_24841_13726# 0.06354f
C868 sg13cmos5l_dfrbpq_1_0.RESET_B a_2890_15457# 0.20779f
C869 sg13cmos5l_dlygate4sd3_1_1.A a_6891_14495# 0.03657f
C870 sg13cmos5l_nor2_1_0.B sg13cmos5l_a21oi_1_3.B1 0.08511f
C871 a_21579_14495# sg13cmos5l_or3_1_2.B 0.01018f
C872 sg13cmos5l_buf_8_2.A a_19232_13854# 0.0236f
C873 a_5896_13854# sg13cmos5l_dlygate4sd3_1_0.X 0.01652f
C874 a_2516_14484# sg13cmos5l_and2_1_0.X 0.03166f
C875 sg13cmos5l_nand4_1_0.Y sg13cmos5l_xnor2_1_0.Y 0.04658f
C876 a_38536_13854# a_38720_13854# 0.05762f
C877 a_19169_15424# VDD 0.21183f
C878 sg13cmos5l_dfrbpq_1_6.Q sg13cmos5l_or3_1_1.C 0.13093f
C879 a_21251_13690# sg13cmos5l_or3_1_2.X 0.13427f
C880 a_26565_13701# a_27313_13799# 0.01058f
C881 a_27407_13799# a_28074_14020# 0.09257f
C882 a_18586_15455# VDD 0.09516f
C883 a_21034_14452# a_21477_14495# 0.02241f
C884 a_6286_13911# sg13cmos5l_dlygate4sd3_1_0.A 0.02097f
C885 a_25203_13320# sg13cmos5l_a21oi_1_3.A1 0.01172f
C886 a_9861_15213# sg13cmos5l_nand4_1_0.Y 0.0176f
C887 a_9861_15213# sg13cmos5l_dfrbpq_1_2.CLK 0.21068f
C888 sg13cmos5l_inv_1_0.Y a_18106_15960# 0.01212f
C889 sg13cmos5l_dfrbpq_1_7.RESET_B sg13cmos5l_dfrbpq_1_7.Q 0.0164f
C890 a_21185_15424# sg13cmos5l_or3_1_2.B 0.03542f
C891 a_17126_15238# VDD 0.20971f
C892 a_17825_16262# VDD 0.20672f
C893 sg13cmos5l_or3_1_1.A sg13cmos5l_a21oi_1_3.A1 0.08765f
C894 a_21070_15423# sg13cmos5l_or3_1_2.X 0.04119f
C895 a_21060_14488# a_22319_14845# 0.01412f
C896 a_12524_15960# sg13cmos5l_dlygate4sd3_1_8.A 0.1978f
C897 sg13cmos5l_or3_1_1.A a_26753_15424# 0.01592f
C898 a_21946_16237# a_22149_16033# 0.02453f
C899 a_22025_16334# a_22149_16033# 0.08186f
C900 sg13cmos5l_xor2_1_0.X sg13cmos5l_and2_1_0.X 0.28573f
C901 a_6540_13238# sg13cmos5l_xnor2_1_2.A 0.12802f
C902 a_6372_14488# a_6891_14495# 0.20754f
C903 a_6789_14495# a_6660_14909# 0.01562f
C904 sg13cmos5l_inv_1_0.A sg13cmos5l_dfrbpq_1_2.Q 0.70863f
C905 a_22576_14726# a_22986_14484# 0.07015f
C906 sg13cmos5l_o21ai_1_2.B1 sg13cmos5l_or3_1_1.C 0.46973f
C907 a_26667_13844# sg13cmos5l_buf_8_2.X 0.04348f
C908 a_21477_14495# a_21466_15202# 0.01088f
C909 a_16042_13945# a_16068_14040# 0.24169f
C910 sg13cmos5l_nand3_1_0.Y sg13cmos5l_xnor2_1_0.Y 0.05205f
C911 sg13cmos5l_and2_1_1.X a_6086_14922# 0.18067f
C912 a_24824_14525# sg13cmos5l_or3_1_1.A 0.0282f
C913 sg13cmos5l_inv_1_0.A a_17806_15423# 0.12443f
C914 a_10016_14570# a_10222_14751# 0.01604f
C915 a_21185_15424# sg13cmos5l_or3_1_2.A 0.01897f
C916 a_3435_15356# VDD 0.20564f
C917 sg13cmos5l_dfrbpq_1_1.RESET_B sg13cmos5l_dfrbpq_1_2.CLK 0.03866f
C918 sg13cmos5l_dlygate4sd3_1_3.A sg13cmos5l_xor2_1_0.B 0.05133f
C919 a_6401_13912# sg13cmos5l_xnor2_1_2.B 0.03894f
C920 a_17318_14922# a_18021_14495# 0.02431f
C921 sg13cmos5l_or3_1_1.A sg13cmos5l_buf_8_2.X 0.02847f
C922 a_2490_14447# VDD 0.19284f
C923 sg13cmos5l_dfrbpq_1_2.RESET_B sg13cmos5l_or3_1_1.B 0.15658f
C924 a_6346_14452# sg13cmos5l_xnor2_1_2.B 0.01548f
C925 a_21466_15202# sg13cmos5l_o21ai_1_1.Y 0.28384f
C926 a_7532_15960# VDD 0.22643f
C927 a_17327_13799# a_17584_13942# 0.23043f
C928 a_16587_13844# a_16356_13735# 0.07823f
C929 VDD sg13cmos5l_or3_1_2.B 2.19079f
C930 a_32492_15960# a_32200_16082# 0.01635f
C931 sg13cmos5l_tiehi_1.L_HI a_9658_14725# 0.06039f
C932 a_9861_14521# VDD 0.06515f
C933 a_15671_15315# VDD 0.06777f
C934 a_9444_15552# a_9861_15213# 0.28324f
C935 a_9158_15234# a_9963_15356# 0.07916f
C936 a_9732_15247# sg13cmos5l_dfrbpq_1_2.CLK 0.01421f
C937 sg13cmos5l_or3_1_1.C a_24704_13854# 0.02884f
C938 a_2942_14484# VDD 0.01096f
C939 sg13cmos5l_dfrbpq_1_5.RESET_B a_25930_14452# 0.0148f
C940 a_15579_14854# sg13cmos5l_a21oi_1_3.B1 0.06371f
C941 sg13cmos5l_or3_1_2.C a_20218_15238# 0.01849f
C942 a_26554_16237# a_26757_16033# 0.02453f
C943 a_26633_16334# a_26554_16237# 0.08889f
C944 sg13cmos5l_dlygate4sd3_1_4.X a_19054_15423# 0.10798f
C945 a_8218_13690# VDD 0.29954f
C946 sg13cmos5l_buf_8_2.A sg13cmos5l_buf_8_2.X 0.17028f
C947 a_5896_13854# VDD 0.14015f
C948 sg13cmos5l_buf_1_0.X sg13cmos5l_nand4_1_0.Y 0.0546f
C949 a_25956_14488# a_27215_14845# 0.01412f
C950 a_9963_15356# a_10703_15311# 0.17382f
C951 sg13cmos5l_buf_1_0.X sg13cmos5l_dfrbpq_1_2.CLK 0.05368f
C952 sg13cmos5l_dfrbpq_1_0.RESET_B a_2540_15960# 0.0105f
C953 sg13cmos5l_dlygate4sd3_1_3.A a_3333_15213# 0.01794f
C954 a_15870_15486# a_15671_15549# 0.08889f
C955 sg13cmos5l_a21oi_1_1.Y sg13cmos5l_dlygate4sd3_1_9.X 0.07532f
C956 a_21166_16263# sg13cmos5l_dfrbpq_1_6.RESET_B 0.02119f
C957 sg13cmos5l_dfrbpq_1_5.RESET_B a_26244_14909# 0.01674f
C958 sg13cmos5l_o21ai_1_2.A2 sg13cmos5l_or3_1_2.B 0.55335f
C959 sg13cmos5l_dfrbpq_1_3.RESET_B a_17327_13799# 0.01722f
C960 sg13cmos5l_dfrbpq_1_1.RESET_B sg13cmos5l_nand3_1_0.Y 0.01467f
C961 a_26475_14495# a_27215_14845# 0.17382f
C962 sg13cmos5l_or3_1_2.C sg13cmos5l_or3_1_2.B 0.64121f
C963 sg13cmos5l_dfrbpq_1_0.RESET_B sg13cmos5l_buf_1_0.X 0.05907f
C964 sg13cmos5l_dfrbpq_1_6.Q a_22426_15202# 0.27955f
C965 a_6891_14495# VDD 0.20627f
C966 a_17892_14909# sg13cmos5l_dfrbpq_1_3.RESET_B 0.0197f
C967 sg13cmos5l_dfrbpq_1_1.RESET_B a_7888_14726# 0.09622f
C968 sg13cmos5l_inv_1_0.A sg13cmos5l_dfrbpq_1_2.RESET_B 0.01762f
C969 sg13cmos5l_or3_1_2.A VDD 0.38339f
C970 sg13cmos5l_buf_8_2.A sg13cmos5l_dfrbpq_1_3.RESET_B 0.03701f
C971 sg13cmos5l_or3_1_1.C a_24310_15230# 0.11145f
C972 enable_i VDD 0.25464f
C973 a_9158_15234# VDD 0.52421f
C974 counter_value_o[3] sg13cmos5l_dfrbpq_1_2.Q 0.01238f
C975 sg13cmos5l_dfrbpq_1_3.Q sg13cmos5l_dfrbpq_1_2.Q 2.85025f
C976 a_18665_15180# sg13cmos5l_dfrbpq_1_2.Q 0.02237f
C977 a_26373_16033# VDD 0.0659f
C978 a_18202_15202# sg13cmos5l_dfrbpq_1_2.Q 0.34354f
C979 sg13cmos5l_dfrbpq_1_3.Q sg13cmos5l_dlygate4sd3_1_9.X 0.01028f
C980 a_19169_15424# a_19450_15202# 0.18796f
C981 a_22508_15960# a_22304_16082# 0.01689f
C982 a_4175_15311# a_4842_15532# 0.09257f
C983 a_18586_15455# sg13cmos5l_dfrbpq_1_3.RESET_B 0.04249f
C984 sg13cmos5l_buf_1_0.X sg13cmos5l_nand3_1_0.Y 0.18201f
C985 sg13cmos5l_or3_1_1.C sg13cmos5l_or3_1_1.A 0.19409f
C986 sg13cmos5l_dfrbpq_1_5.RESET_B VDD 1.27461f
C987 a_24169_14508# sg13cmos5l_or3_1_1.C 0.03594f
C988 a_10703_15311# VDD 0.19385f
C989 sg13cmos5l_dfrbpq_1_2.CLK sg13cmos5l_buf_1_10.X 2.24876f
C990 a_8685_14832# sg13cmos5l_buf_1_10.X 0.108f
C991 a_9732_15247# a_9444_15552# 0.24435f
C992 a_27882_14484# VDD 0.28095f
C993 sg13cmos5l_or3_1_2.C sg13cmos5l_or3_1_2.A 0.72302f
C994 sg13cmos5l_o21ai_1_2.B1 sg13cmos5l_or3_1_1.B 0.03172f
C995 a_21070_15423# a_21185_15424# 0.3854f
C996 sg13cmos5l_dfrbpq_1_1.RESET_B sg13cmos5l_xnor2_1_2.B 0.15083f
C997 sg13cmos5l_dfrbpq_1_2.RESET_B clock_i 0.18083f
C998 a_1856_14570# sg13cmos5l_buf_1_10.X 0.02603f
C999 sg13cmos5l_dlygate4sd3_1_8.X sg13cmos5l_xnor2_1_0.Y 0.01362f
C1000 sg13cmos5l_dfrbpq_1_6.D sg13cmos5l_or3_1_2.B 0.02411f
C1001 a_22145_15424# VDD 0.21275f
C1002 sg13cmos5l_a21oi_1_0.Y sg13cmos5l_dfrbpq_1_2.Q 0.01608f
C1003 sg13cmos5l_a21oi_1_0.A1 sg13cmos5l_dfrbpq_1_2.Q 0.1004f
C1004 a_10222_14751# sg13cmos5l_buf_1_10.X 0.01427f
C1005 a_25670_14922# a_25930_14452# 0.45119f
C1006 a_17126_15238# a_17238_15302# 0.3854f
C1007 sg13cmos5l_dfrbpq_1_6.Q counter_value_o[5] 0.01034f
C1008 sg13cmos5l_dfrbpq_1_2.RESET_B a_16042_13945# 0.19612f
C1009 VDD a_16552_15996# 0.18144f
C1010 sg13cmos5l_dfrbpq_1_6.Q sg13cmos5l_a21oi_1_3.Y 0.01464f
C1011 a_17318_14922# a_18123_14495# 0.07916f
C1012 sg13cmos5l_dfrbpq_1_7.RESET_B sg13cmos5l_dfrbpq_1_6.Q 0.01935f
C1013 sg13cmos5l_buf_8_2.A sg13cmos5l_nand4_1_0.Y 0.03656f
C1014 sg13cmos5l_dlygate4sd3_1_0.A a_6575_13342# 0.03821f
C1015 reset_n_i VDD 0.14588f
C1016 sg13cmos5l_buf_8_2.A sg13cmos5l_dfrbpq_1_2.CLK 0.3488f
C1017 sg13cmos5l_and2_1_2.X VDD 0.32197f
C1018 a_25670_14922# a_26244_14909# 0.18486f
C1019 a_5600_15366# VDD 0.09581f
C1020 a_5687_15549# sg13cmos5l_dfrbpq_1_1.RESET_B 0.01133f
C1021 sg13cmos5l_dlygate4sd3_1_4.X a_18106_15960# 0.01488f
C1022 sg13cmos5l_buf_8_2.X sg13cmos5l_or3_1_2.B 0.10287f
C1023 sg13cmos5l_buf_1_0.X sg13cmos5l_xnor2_1_2.B 0.22918f
C1024 a_10016_14570# sg13cmos5l_dlygate4sd3_1_8.X 0.01314f
C1025 sg13cmos5l_dlygate4sd3_1_17.A a_25094_15238# 0.01415f
C1026 a_21251_13690# VDD 0.28201f
C1027 sg13cmos5l_o21ai_1_1.Y a_20278_14862# 0.06702f
C1028 a_7888_14726# sg13cmos5l_buf_1_10.X 0.01264f
C1029 sg13cmos5l_dfrbpq_1_6.D sg13cmos5l_or3_1_2.A 0.02907f
C1030 a_4842_15532# sg13cmos5l_dlygate4sd3_1_3.A 0.12425f
C1031 a_3204_15247# sg13cmos5l_buf_1_0.X 0.01531f
C1032 sg13cmos5l_o21ai_1_2.B1 sg13cmos5l_a21oi_1_3.Y 0.05014f
C1033 sg13cmos5l_dfrbpq_1_7.RESET_B sg13cmos5l_o21ai_1_2.B1 0.02543f
C1034 a_24841_13726# VDD 0.26704f
C1035 sg13cmos5l_a21oi_1_0.A2 sg13cmos5l_dfrbpq_1_2.Q 0.02237f
C1036 a_21070_15423# VDD 0.15921f
C1037 a_14261_15238# VDD 0.49384f
C1038 a_16969_16020# counter_value_o[3] 0.08229f
C1039 sg13cmos5l_dfrbpq_1_5.RESET_B a_26753_15424# 0.01144f
C1040 sg13cmos5l_a21oi_1_1.Y a_20603_15532# 0.09955f
C1041 a_21060_14488# sg13cmos5l_or3_1_2.X 0.04034f
C1042 VDD a_26638_15423# 0.15952f
C1043 a_25670_14922# VDD 0.52312f
C1044 a_18454_16374# sg13cmos5l_or3_1_2.B 0.0782f
C1045 sg13cmos5l_or3_1_2.A sg13cmos5l_buf_8_2.X 0.58091f
C1046 a_24169_14508# a_24365_14508# 0.01485f
C1047 sg13cmos5l_or3_1_2.C a_21251_13690# 0.16807f
C1048 sg13cmos5l_a21oi_1_3.B1 sg13cmos5l_or3_1_2.X 0.02158f
C1049 sg13cmos5l_o21ai_1_3.Y a_26170_16237# 0.03498f
C1050 sg13cmos5l_inv_1_0.Y a_16175_15238# 0.01129f
C1051 sg13cmos5l_o21ai_1_2.B1 a_24062_15242# 0.01812f
C1052 VDD a_38536_3986# 0.1399f
C1053 a_21034_14452# sg13cmos5l_dfrbpq_1_6.RESET_B 0.17208f
C1054 VDD a_25094_15238# 0.20673f
C1055 sg13cmos5l_xnor2_1_2.B sg13cmos5l_buf_1_10.X 0.01762f
C1056 a_26148_14040# VDD 0.08291f
C1057 a_24841_13726# a_24935_14020# 0.02103f
C1058 a_24520_13854# a_24704_13854# 0.05762f
C1059 a_19530_14484# VDD 0.28068f
C1060 a_10618_14448# sg13cmos5l_buf_1_10.X 0.01712f
C1061 sg13cmos5l_inv_1_0.Y sg13cmos5l_dfrbpq_1_2.Q 0.06528f
C1062 a_7631_14845# a_7537_14845# 0.16704f
C1063 a_4193_14750# sg13cmos5l_xor2_1_0.B 0.01654f
C1064 a_19816_15366# a_20000_15366# 0.05762f
C1065 a_16969_16020# sg13cmos5l_a21oi_1_0.A1 0.01278f
C1066 a_22576_14726# sg13cmos5l_dfrbpq_1_6.RESET_B 0.09622f
C1067 sg13cmos5l_buf_1_0.X sg13cmos5l_dlygate4sd3_1_8.X 0.15391f
C1068 a_10609_15311# sg13cmos5l_dlygate4sd3_1_8.A 0.0173f
C1069 a_28074_14020# VDD 0.28333f
C1070 a_17318_14922# sg13cmos5l_dfrbpq_1_2.Q 0.02985f
C1071 sg13cmos5l_dfrbpq_1_5.RESET_B sg13cmos5l_buf_8_2.X 0.10136f
C1072 sg13cmos5l_dlygate4sd3_1_1.A a_7537_14845# 0.01546f
C1073 sg13cmos5l_dfrbpq_1_7.Q a_27215_14845# 0.0476f
C1074 a_3435_15356# sg13cmos5l_dfrbpq_1_2.CLK 0.01756f
C1075 a_20960_16082# VDD 0.08507f
C1076 sg13cmos5l_dfrbpq_1_3.D sg13cmos5l_a21oi_1_3.B1 0.03309f
C1077 sg13cmos5l_or3_1_1.C sg13cmos5l_or3_1_2.B 0.39924f
C1078 sg13cmos5l_or3_1_1.A sg13cmos5l_or3_1_1.B 0.12822f
C1079 sg13cmos5l_dfrbpq_1_6.Q sg13cmos5l_dfrbpq_1_3.Q 0.18548f
C1080 sg13cmos5l_o21ai_1_1.Y sg13cmos5l_dfrbpq_1_2.Q 0.02544f
C1081 VDD a_27898_15202# 0.2847f
C1082 a_3209_16334# a_3333_16033# 0.08186f
C1083 a_3130_16237# a_3008_16082# 0.01854f
C1084 a_24841_13726# sg13cmos5l_a21oi_1_3.A1 0.05315f
C1085 sg13cmos5l_dfrbpq_1_0.RESET_B a_3435_15356# 0.28294f
C1086 a_23368_14570# VDD 0.13204f
C1087 a_17327_13799# sg13cmos5l_or3_1_1.B 0.01909f
C1088 a_38720_10034# VDD 0.0583f
C1089 a_16140_15424# sg13cmos5l_nor2_1_0.B 0.1273f
C1090 a_21562_15960# VDD 0.26426f
C1091 a_32492_15960# counter_value_o[6] 0.15504f
C1092 a_37484_15960# sg13cmos5l_dfrbpq_1_5.Q 0.19611f
C1093 sg13cmos5l_dfrbpq_1_1.RESET_B sg13cmos5l_xnor2_1_2.A 0.04487f
C1094 sg13cmos5l_dfrbpq_1_7.RESET_B a_25774_15423# 0.02935f
C1095 sg13cmos5l_dfrbpq_1_5.D sg13cmos5l_dfrbpq_1_7.D 0.03838f
C1096 a_7822_13911# sg13cmos5l_dlygate4sd3_1_1.A 0.01022f
C1097 a_17233_13799# a_16485_13701# 0.01058f
C1098 sg13cmos5l_buf_8_2.A sg13cmos5l_or3_1_1.B 0.33039f
C1099 a_7240_16082# counter_value_o[1] 0.02116f
C1100 a_2890_15457# a_3333_15213# 0.02241f
C1101 sg13cmos5l_and2_1_0.X a_2630_15234# 0.18471f
C1102 a_16955_14484# VDD 0.20174f
C1103 a_18123_14495# a_18863_14845# 0.17382f
C1104 a_15671_15315# a_15671_15549# 0.08186f
C1105 a_11370_15532# VDD 0.27891f
C1106 a_16969_16020# sg13cmos5l_a21oi_1_0.A2 0.13879f
C1107 a_26638_15423# a_26753_15424# 0.3854f
C1108 a_6372_14488# a_7537_14845# 0.25046f
C1109 sg13cmos5l_dfrbpq_1_6.D a_21070_15423# 0.03572f
C1110 a_25206_15302# a_25774_15423# 0.01641f
C1111 a_16168_15996# sg13cmos5l_dfrbpq_1_2.Q 0.01748f
C1112 a_26565_13701# a_26667_13844# 0.36168f
C1113 sg13cmos5l_dlygate4sd3_1_8.X sg13cmos5l_buf_1_10.X 1.2223f
C1114 a_6891_14495# sg13cmos5l_dfrbpq_1_2.CLK 0.02479f
C1115 sg13cmos5l_or3_1_1.A sg13cmos5l_a21oi_1_3.Y 0.01853f
C1116 sg13cmos5l_dfrbpq_1_7.RESET_B sg13cmos5l_or3_1_1.A 0.02533f
C1117 sg13cmos5l_buf_1_0.X sg13cmos5l_xnor2_1_2.A 0.16524f
C1118 a_18789_15277# VDD 0.06795f
C1119 a_22304_16082# VDD 0.07521f
C1120 a_26565_13701# a_26436_13735# 0.01562f
C1121 a_17921_15424# VDD 0.20695f
C1122 a_20774_14922# a_21477_14495# 0.02431f
C1123 a_6286_13911# a_6401_13912# 0.3854f
C1124 a_5896_13854# a_6080_13854# 0.05762f
C1125 a_9158_15234# sg13cmos5l_nand4_1_0.Y 0.02144f
C1126 sg13cmos5l_dfrbpq_1_2.RESET_B sg13cmos5l_inv_1_0.Y 0.01813f
C1127 a_9158_15234# sg13cmos5l_dfrbpq_1_2.CLK 0.01121f
C1128 sg13cmos5l_inv_1_0.Y a_16969_16020# 0.16895f
C1129 a_6540_13238# a_6575_13342# 0.19075f
C1130 sg13cmos5l_or3_1_1.A a_25206_15302# 0.01524f
C1131 a_6086_14922# a_6372_14488# 0.26205f
C1132 a_25206_14508# sg13cmos5l_dfrbpq_1_5.D 0.10738f
C1133 a_21060_14488# a_21579_14495# 0.20754f
C1134 a_21477_14495# a_21348_14909# 0.01562f
C1135 sg13cmos5l_buf_1_0.X a_1192_3900# 0.15903f
C1136 a_25670_14922# sg13cmos5l_buf_8_2.X 0.01876f
C1137 a_10703_15311# sg13cmos5l_nand4_1_0.Y 0.01618f
C1138 clock_i sg13cmos5l_buf_1_10.X 0.01285f
C1139 a_10703_15311# sg13cmos5l_dfrbpq_1_2.CLK 0.01174f
C1140 sg13cmos5l_dfrbpq_1_7.Q sg13cmos5l_dfrbpq_1_5.Q 0.45875f
C1141 sg13cmos5l_dfrbpq_1_1.RESET_B sg13cmos5l_xor2_1_0.B 0.04436f
C1142 sg13cmos5l_dfrbpq_1_6.D a_20960_16082# 0.01243f
C1143 a_21579_14495# a_22319_14845# 0.17382f
C1144 a_22025_16334# counter_value_o[4] 0.0192f
C1145 a_26148_14040# sg13cmos5l_buf_8_2.X 0.04861f
C1146 sg13cmos5l_o21ai_1_3.Y sg13cmos5l_o21ai_1_2.Y 0.07365f
C1147 a_20774_14922# sg13cmos5l_o21ai_1_1.Y 0.03526f
C1148 sg13cmos5l_buf_8_2.X a_19530_14484# 0.02075f
C1149 sg13cmos5l_a21oi_1_1.Y a_21946_16237# 0.03498f
C1150 a_6891_14495# a_7888_14726# 0.03546f
C1151 sg13cmos5l_a21oi_1_1.Y a_22025_16334# 0.01284f
C1152 a_4081_15311# a_2916_15552# 0.25046f
C1153 a_3204_15247# a_3435_15356# 0.07823f
C1154 sg13cmos5l_dlygate4sd3_1_0.X sg13cmos5l_and2_1_1.X 0.05101f
C1155 sg13cmos5l_inv_1_0.A a_17126_15238# 0.01214f
C1156 sg13cmos5l_xnor2_1_2.A sg13cmos5l_buf_1_10.X 0.03534f
C1157 a_21348_14909# sg13cmos5l_o21ai_1_1.Y 0.02008f
C1158 a_17604_14488# sg13cmos5l_a21oi_1_3.B1 0.03688f
C1159 sg13cmos5l_buf_8_2.A clock_i 0.02615f
C1160 sg13cmos5l_and2_1_2.X sg13cmos5l_nand4_1_0.Y 0.01576f
C1161 a_16068_14040# a_16587_13844# 0.20773f
C1162 sg13cmos5l_and2_1_2.X sg13cmos5l_dfrbpq_1_2.CLK 0.02931f
C1163 sg13cmos5l_and2_1_2.X a_8685_14832# 0.07413f
C1164 a_2916_15552# VDD 0.09493f
C1165 sg13cmos5l_dfrbpq_1_6.Q a_22986_14484# 0.08106f
C1166 sg13cmos5l_buf_1_0.X sg13cmos5l_xor2_1_0.B 0.67613f
C1167 sg13cmos5l_a21oi_1_3.B1 sg13cmos5l_dlygate4sd3_1_17.A 0.24924f
C1168 sg13cmos5l_or3_1_1.B sg13cmos5l_or3_1_2.B 0.04606f
C1169 a_17318_14922# a_17578_14452# 0.45119f
C1170 sg13cmos5l_dfrbpq_1_2.D sg13cmos5l_dfrbpq_1_2.RESET_B 0.3532f
C1171 a_3008_16082# VDD 0.06559f
C1172 a_16068_14040# a_16356_13735# 0.24435f
C1173 a_8582_15238# sg13cmos5l_and2_1_2.B 0.01938f
C1174 sg13cmos5l_nor2_1_0.B VDD 0.25674f
C1175 a_25930_14452# a_26373_14495# 0.02241f
C1176 a_9158_15234# a_9444_15552# 0.26205f
C1177 sg13cmos5l_or3_1_1.C a_24841_13726# 0.14829f
C1178 sg13cmos5l_dfrbpq_1_6.Q sg13cmos5l_o21ai_1_1.Y 0.01042f
C1179 a_22149_16033# a_22304_16082# 0.03131f
C1180 a_4474_14448# VDD 0.29254f
C1181 a_26373_16033# a_26554_16237# 0.04141f
C1182 a_26249_16334# a_26373_16033# 0.08186f
C1183 a_7822_13911# VDD 0.16525f
C1184 a_38720_14570# VDD 0.08963f
C1185 a_14261_15238# sg13cmos5l_nand4_1_0.Y 0.23765f
C1186 a_26373_14495# a_26244_14909# 0.01562f
C1187 a_25956_14488# a_26475_14495# 0.20754f
C1188 sg13cmos5l_dlygate4sd3_1_5.A VDD 0.30993f
C1189 a_9444_15552# a_10703_15311# 0.01412f
C1190 a_12010_15202# sg13cmos5l_buf_8_2.A 0.34017f
C1191 a_14261_15238# sg13cmos5l_dfrbpq_1_2.CLK 0.01831f
C1192 a_6086_14922# VDD 0.52224f
C1193 sg13cmos5l_dfrbpq_1_5.RESET_B a_26554_16237# 0.0434f
C1194 sg13cmos5l_dlygate4sd3_1_3.A a_2630_15234# 0.03756f
C1195 sg13cmos5l_buf_1_0.X a_3333_15213# 0.01557f
C1196 a_21060_14488# VDD 0.07667f
C1197 sg13cmos5l_dfrbpq_1_5.RESET_B a_26249_16334# 0.01855f
C1198 sg13cmos5l_dlygate4sd3_1_4.X sg13cmos5l_dfrbpq_1_2.Q 0.07532f
C1199 sg13cmos5l_or3_1_1.X a_25390_16263# 0.03003f
C1200 sg13cmos5l_a21oi_1_3.B1 sg13cmos5l_a21oi_1_2.A1 0.05556f
C1201 sg13cmos5l_or3_1_2.A sg13cmos5l_or3_1_1.B 0.02451f
C1202 sg13cmos5l_a21oi_1_3.B1 VDD 1.64688f
C1203 a_10703_15311# a_10960_15454# 0.23043f
C1204 sg13cmos5l_dlygate4sd3_1_3.A a_2824_16082# 0.03948f
C1205 sg13cmos5l_inv_1_0.A sg13cmos5l_or3_1_2.B 0.02593f
C1206 a_9861_14521# sg13cmos5l_dlygate4sd3_1_8.X 0.02311f
C1207 sg13cmos5l_xor2_1_0.B sg13cmos5l_buf_1_10.X 2.58844f
C1208 a_22319_14845# VDD 0.19988f
C1209 sg13cmos5l_inv_1_0.A a_15671_15315# 0.03242f
C1210 a_2516_14484# sg13cmos5l_buf_1_0.X 0.01414f
C1211 sg13cmos5l_or3_1_1.X a_24923_15996# 0.06735f
C1212 a_19054_15423# sg13cmos5l_dfrbpq_1_2.Q 0.01821f
C1213 a_22030_15423# VDD 0.16094f
C1214 VDD sg13cmos5l_and2_1_2.B 0.23394f
C1215 a_25505_16262# VDD 0.20709f
C1216 a_26373_14495# VDD 0.24869f
C1217 a_18586_15455# a_18665_15180# 0.08889f
C1218 a_17921_15424# sg13cmos5l_dfrbpq_1_3.RESET_B 0.07437f
C1219 a_18202_15202# a_18586_15455# 0.01303f
C1220 sg13cmos5l_tiehi_1.L_HI a_9861_15213# 0.03738f
C1221 sg13cmos5l_a21oi_1_3.B1 sg13cmos5l_or3_1_2.C 0.03201f
C1222 a_22145_15424# a_22426_15202# 0.18796f
C1223 sg13cmos5l_and2_1_1.X VDD 0.27664f
C1224 sg13cmos5l_dlygate4sd3_1_3.A sg13cmos5l_and2_1_0.X 0.01628f
C1225 sg13cmos5l_buf_8_2.A sg13cmos5l_a21oi_1_0.Y 0.21299f
C1226 a_6891_14495# sg13cmos5l_dlygate4sd3_1_8.X 0.01277f
C1227 sg13cmos5l_dfrbpq_1_6.RESET_B sg13cmos5l_dfrbpq_1_2.Q 0.01328f
C1228 a_27472_14726# VDD 0.13629f
C1229 a_15671_15315# clock_i 0.02493f
C1230 a_1965_14832# sg13cmos5l_buf_1_10.X 0.10177f
C1231 a_4432_15454# VDD 0.13966f
C1232 counter_value_o[0] a_2540_15960# 0.15504f
C1233 a_23552_14570# sg13cmos5l_or3_1_2.B 0.0358f
C1234 sg13cmos5l_a21oi_1_3.B1 sg13cmos5l_a21oi_1_3.A1 0.26386f
C1235 a_15579_14854# VDD 0.86798f
C1236 a_16955_14484# sg13cmos5l_dfrbpq_1_2.CLK 0.02772f
C1237 a_11370_15532# sg13cmos5l_nand4_1_0.Y 0.01256f
C1238 sg13cmos5l_a21oi_1_1.Y sg13cmos5l_or3_1_2.B 0.39227f
C1239 sg13cmos5l_dlygate4sd3_1_0.A a_6540_13238# 0.12959f
C1240 a_5687_15315# VDD 0.07168f
C1241 a_17126_15238# sg13cmos5l_a21oi_1_0.A1 0.02337f
C1242 sg13cmos5l_dfrbpq_1_6.D a_21060_14488# 0.03479f
C1243 sg13cmos5l_a21oi_1_0.A1 a_17825_16262# 0.01004f
C1244 sg13cmos5l_dfrbpq_1_2.RESET_B a_16587_13844# 0.27963f
C1245 a_9861_15213# sg13cmos5l_dlygate4sd3_1_8.A 0.01043f
C1246 a_5504_14570# sg13cmos5l_buf_1_10.X 0.02387f
C1247 sg13cmos5l_dlygate4sd3_1_4.X a_16969_16020# 0.2162f
C1248 sg13cmos5l_dfrbpq_1_6.Q sg13cmos5l_dfrbpq_1_5.Q 0.01209f
C1249 a_21251_13690# sg13cmos5l_or3_1_1.B 0.02075f
C1250 a_18021_14495# a_18123_14495# 0.3643f
C1251 sg13cmos5l_dfrbpq_1_5.RESET_B sg13cmos5l_a21oi_1_3.Y 0.50817f
C1252 sg13cmos5l_dfrbpq_1_7.RESET_B sg13cmos5l_dfrbpq_1_5.RESET_B 0.12636f
C1253 a_9418_15457# VDD 0.1001f
C1254 sg13cmos5l_dfrbpq_1_6.D sg13cmos5l_a21oi_1_3.B1 0.04716f
C1255 a_24841_13726# sg13cmos5l_or3_1_1.B 0.16221f
C1256 a_4842_15532# sg13cmos5l_buf_1_0.X 0.01204f
C1257 a_4175_15311# sg13cmos5l_dlygate4sd3_1_3.A 0.04571f
C1258 sg13cmos5l_xor2_1_0.X sg13cmos5l_buf_1_10.X 0.14017f
C1259 sg13cmos5l_dfrbpq_1_6.Q sg13cmos5l_o21ai_1_2.Y 0.02669f
C1260 sg13cmos5l_o21ai_1_2.B1 a_26170_15202# 0.05397f
C1261 sg13cmos5l_dfrbpq_1_5.RESET_B a_26565_13701# 0.03932f
C1262 a_14261_15238# sg13cmos5l_or3_1_1.B 0.25178f
C1263 a_16856_15238# sg13cmos5l_dfrbpq_1_2.Q 0.01361f
C1264 counter_value_o[3] sg13cmos5l_or3_1_2.B 0.48267f
C1265 a_21060_14488# sg13cmos5l_buf_8_2.X 0.06778f
C1266 sg13cmos5l_dlygate4sd3_1_17.A a_24824_15238# 0.06549f
C1267 sg13cmos5l_dfrbpq_1_3.Q sg13cmos5l_or3_1_2.B 0.36223f
C1268 a_6891_14495# sg13cmos5l_xnor2_1_2.A 0.06395f
C1269 sg13cmos5l_and2_1_2.X sg13cmos5l_dlygate4sd3_1_8.X 0.03283f
C1270 sg13cmos5l_dfrbpq_1_6.Q a_27617_15424# 0.04727f
C1271 a_5886_15486# sg13cmos5l_dlygate4sd3_1_3.A 0.03759f
C1272 sg13cmos5l_a21oi_1_3.B1 sg13cmos5l_buf_8_2.X 0.47568f
C1273 VDD a_25889_15424# 0.20712f
C1274 a_25390_16263# sg13cmos5l_o21ai_1_3.Y 0.01565f
C1275 a_22319_14845# sg13cmos5l_buf_8_2.X 0.02057f
C1276 a_17126_15238# sg13cmos5l_a21oi_1_0.A2 0.0707f
C1277 a_2490_14447# sg13cmos5l_xor2_1_0.B 0.22356f
C1278 a_25786_15960# a_25505_16262# 0.18796f
C1279 VDD a_12232_16082# 0.16754f
C1280 a_17318_14922# a_17892_14909# 0.18486f
C1281 a_20774_14922# sg13cmos5l_dfrbpq_1_6.RESET_B 0.07398f
C1282 a_37192_16082# VDD 0.16744f
C1283 sg13cmos5l_o21ai_1_2.B1 sg13cmos5l_o21ai_1_2.Y 0.55898f
C1284 a_25094_14484# VDD 0.20607f
C1285 a_17318_14922# sg13cmos5l_buf_8_2.A 0.02999f
C1286 a_26122_13945# VDD 0.09474f
C1287 sg13cmos5l_a21oi_1_0.Y sg13cmos5l_or3_1_2.B 0.01754f
C1288 sg13cmos5l_a21oi_1_3.A2 sg13cmos5l_dlygate4sd3_1_17.A 0.05288f
C1289 a_19120_14726# VDD 0.13647f
C1290 sg13cmos5l_dfrbpq_1_7.Q a_25956_14488# 0.03198f
C1291 sg13cmos5l_dlygate4sd3_1_5.A a_18454_16374# 0.07345f
C1292 enable_i a_1192_3900# 0.1951f
C1293 sg13cmos5l_a21oi_1_3.B1 sg13cmos5l_dfrbpq_1_3.RESET_B 0.04636f
C1294 a_26373_14495# sg13cmos5l_buf_8_2.X 0.23747f
C1295 a_21185_15424# sg13cmos5l_or3_1_2.X 0.02913f
C1296 a_27407_13799# VDD 0.18933f
C1297 VDD a_24824_15238# 0.26964f
C1298 sg13cmos5l_dlygate4sd3_1_1.A a_7631_14845# 0.04295f
C1299 sg13cmos5l_dfrbpq_1_7.Q a_26475_14495# 0.03274f
C1300 a_2916_15552# sg13cmos5l_dfrbpq_1_2.CLK 0.07118f
C1301 a_3333_15213# a_3435_15356# 0.36168f
C1302 a_11370_15532# a_10960_15454# 0.07015f
C1303 sg13cmos5l_dfrbpq_1_2.D a_15680_13854# 0.03989f
C1304 a_6280_13058# VDD 0.16648f
C1305 sg13cmos5l_inv_1_0.Y a_17825_16262# 0.01405f
C1306 a_26638_15423# sg13cmos5l_a21oi_1_3.Y 0.01596f
C1307 a_25206_14508# sg13cmos5l_or3_1_1.X 0.04711f
C1308 VDD a_27502_15423# 0.16013f
C1309 a_25670_14922# sg13cmos5l_a21oi_1_3.Y 0.04949f
C1310 sg13cmos5l_dfrbpq_1_7.RESET_B a_25670_14922# 0.07823f
C1311 a_18021_14495# sg13cmos5l_dfrbpq_1_2.Q 0.02098f
C1312 sg13cmos5l_dfrbpq_1_0.RESET_B a_2916_15552# 0.28678f
C1313 sg13cmos5l_or3_1_1.X sg13cmos5l_o21ai_1_3.Y 0.04258f
C1314 a_1965_14832# a_2490_14447# 0.01705f
C1315 sg13cmos5l_nor2_1_0.B sg13cmos5l_dfrbpq_1_2.CLK 0.18311f
C1316 a_1192_9948# VDD 0.18614f
C1317 sg13cmos5l_tiehi_1.L_HI sg13cmos5l_buf_1_10.X 0.03277f
C1318 sg13cmos5l_o21ai_1_2.A2 a_23480_15242# 0.01468f
C1319 a_4474_14448# sg13cmos5l_dfrbpq_1_2.CLK 0.01341f
C1320 VDD a_16485_13701# 0.27675f
C1321 sg13cmos5l_a21oi_1_3.A2 VDD 0.40843f
C1322 a_2490_14447# a_2516_14484# 0.21976f
C1323 a_38536_3986# a_38720_3986# 0.05762f
C1324 a_7829_15238# a_7680_15549# 0.19075f
C1325 a_17057_14832# sg13cmos5l_a21oi_1_0.A1 0.01159f
C1326 a_2890_15457# a_2630_15234# 0.45119f
C1327 a_6086_14922# sg13cmos5l_dfrbpq_1_2.CLK 0.01616f
C1328 a_6372_14488# a_7631_14845# 0.01412f
C1329 sg13cmos5l_or3_1_1.C sg13cmos5l_a21oi_1_3.B1 0.10968f
C1330 a_22145_15424# sg13cmos5l_dfrbpq_1_3.Q 0.01469f
C1331 a_25094_15238# a_25206_15302# 0.3854f
C1332 a_23638_14862# sg13cmos5l_o21ai_1_2.A2 0.10051f
C1333 a_26148_14040# a_26565_13701# 0.28324f
C1334 a_25862_13722# a_26667_13844# 0.07916f
C1335 a_7532_15960# counter_value_o[1] 0.15504f
C1336 a_4078_14751# a_4193_14750# 0.3854f
C1337 counter_value_o[3] a_16552_15996# 0.1598f
C1338 sg13cmos5l_dlygate4sd3_1_1.A a_6372_14488# 0.03332f
C1339 sg13cmos5l_a21oi_1_3.B1 sg13cmos5l_dfrbpq_1_2.CLK 0.1602f
C1340 a_21477_14495# sg13cmos5l_or3_1_2.B 0.01108f
C1341 sg13cmos5l_buf_8_2.A a_19323_13726# 0.35369f
C1342 sg13cmos5l_or3_1_2.X VDD 0.34653f
C1343 sg13cmos5l_or3_1_1.A a_26170_15202# 0.01215f
C1344 a_25862_13722# a_26436_13735# 0.18486f
C1345 a_26667_13844# a_27664_13942# 0.03412f
C1346 a_7937_13912# a_8218_13690# 0.18796f
C1347 a_20774_14922# a_21034_14452# 0.45119f
C1348 sg13cmos5l_dlygate4sd3_1_8.A sg13cmos5l_buf_1_10.X 0.03261f
C1349 sg13cmos5l_xor2_1_0.X a_2490_14447# 0.14671f
C1350 sg13cmos5l_inv_1_0.Y sg13cmos5l_or3_1_2.B 0.96765f
C1351 sg13cmos5l_nand4_1_0.Y sg13cmos5l_and2_1_2.B 0.01346f
C1352 a_25206_14508# sg13cmos5l_dfrbpq_1_7.D 0.01672f
C1353 a_22508_15960# VDD 0.22831f
C1354 sg13cmos5l_dfrbpq_1_2.CLK sg13cmos5l_and2_1_2.B 0.03578f
C1355 a_24824_14525# a_25094_14484# 0.18796f
C1356 a_8685_14832# sg13cmos5l_and2_1_2.B 0.17752f
C1357 a_6401_13912# sg13cmos5l_dlygate4sd3_1_0.A 0.04884f
C1358 sg13cmos5l_and2_1_1.X sg13cmos5l_dfrbpq_1_2.CLK 0.02079f
C1359 sg13cmos5l_o21ai_1_1.Y sg13cmos5l_or3_1_2.B 0.1545f
C1360 sg13cmos5l_dfrbpq_1_3.D VDD 0.20543f
C1361 sg13cmos5l_a21oi_1_3.A2 sg13cmos5l_a21oi_1_3.A1 0.17776f
C1362 a_6346_14452# a_6789_14495# 0.02241f
C1363 sg13cmos5l_or3_1_1.A sg13cmos5l_o21ai_1_2.Y 0.04759f
C1364 a_24169_14508# sg13cmos5l_o21ai_1_2.Y 0.05936f
C1365 a_24824_14525# a_24824_15238# 0.01163f
C1366 a_21477_14495# a_22225_14845# 0.01058f
C1367 sg13cmos5l_or3_1_2.C sg13cmos5l_or3_1_2.X 0.02676f
C1368 a_25094_14484# sg13cmos5l_buf_8_2.X 0.01175f
C1369 a_2248_16082# a_2540_15960# 0.01635f
C1370 sg13cmos5l_inv_1_0.A a_17921_15424# 0.01143f
C1371 sg13cmos5l_buf_8_2.X a_19120_14726# 0.01548f
C1372 sg13cmos5l_buf_8_2.A a_18863_14845# 0.01736f
C1373 sg13cmos5l_nand3_1_0.Y a_6680_15242# 0.01437f
C1374 a_21562_15960# a_21281_16262# 0.18796f
C1375 a_6660_14909# a_6891_14495# 0.07823f
C1376 a_3204_15247# a_2916_15552# 0.24435f
C1377 a_23368_14570# a_23552_14570# 0.05762f
C1378 sg13cmos5l_a21oi_1_3.A2 a_25109_12972# 0.05791f
C1379 sg13cmos5l_dfrbpq_1_7.Q a_27034_15202# 0.28887f
C1380 a_15782_13722# a_16485_13701# 0.02453f
C1381 a_18123_14495# sg13cmos5l_dfrbpq_1_2.Q 0.04207f
C1382 a_4432_15454# sg13cmos5l_dfrbpq_1_0.RESET_B 0.09976f
C1383 a_21562_15960# sg13cmos5l_a21oi_1_1.Y 0.28648f
C1384 a_7631_14845# VDD 0.17872f
C1385 sg13cmos5l_dfrbpq_1_3.Q a_19530_14484# 0.08004f
C1386 a_19120_14726# sg13cmos5l_dfrbpq_1_3.RESET_B 0.09622f
C1387 a_24824_14525# sg13cmos5l_a21oi_1_3.A2 0.06269f
C1388 a_16168_15996# sg13cmos5l_or3_1_2.B 0.15767f
C1389 sg13cmos5l_nor2_1_0.B sg13cmos5l_or3_1_1.B 0.1517f
C1390 a_6086_14922# sg13cmos5l_xnor2_1_2.B 0.05954f
C1391 a_9418_15457# sg13cmos5l_nand4_1_0.Y 0.01592f
C1392 sg13cmos5l_o21ai_1_1.Y sg13cmos5l_or3_1_2.A 0.23707f
C1393 sg13cmos5l_dlygate4sd3_1_1.A VDD 0.97447f
C1394 a_3130_16237# VDD 0.10639f
C1395 a_16587_13844# a_17327_13799# 0.17382f
C1396 a_9737_14822# VDD 0.0769f
C1397 a_16140_15424# VDD 0.18406f
C1398 a_17578_14452# a_18021_14495# 0.02241f
C1399 sg13cmos5l_dfrbpq_1_6.D sg13cmos5l_or3_1_2.X 0.04306f
C1400 sg13cmos5l_a21oi_1_3.A2 sg13cmos5l_buf_8_2.X 0.01098f
C1401 a_26170_16237# a_26373_16033# 0.02453f
C1402 a_22304_16082# counter_value_o[4] 0.01136f
C1403 a_17710_16263# VDD 0.16005f
C1404 sg13cmos5l_dlygate4sd3_1_0.X VDD 0.44473f
C1405 a_21946_16237# sg13cmos5l_dfrbpq_1_6.RESET_B 0.04633f
C1406 a_2824_16082# a_2540_15960# 0.01225f
C1407 a_7537_14845# sg13cmos5l_dlygate4sd3_1_8.X 0.02247f
C1408 a_22025_16334# sg13cmos5l_dfrbpq_1_6.RESET_B 0.01142f
C1409 a_21824_15366# sg13cmos5l_or3_1_2.A 0.01319f
C1410 sg13cmos5l_a21oi_1_3.B1 sg13cmos5l_or3_1_1.B 0.03473f
C1411 sg13cmos5l_inv_1_0.Y a_16552_15996# 0.01509f
C1412 a_6682_13690# VDD 0.28405f
C1413 a_2528_15366# VDD 0.08632f
C1414 a_26373_14495# a_27121_14845# 0.01058f
C1415 sg13cmos5l_buf_8_2.X sg13cmos5l_or3_1_2.X 0.02259f
C1416 a_6372_14488# VDD 0.07271f
C1417 a_21579_14495# VDD 0.21266f
C1418 sg13cmos5l_dfrbpq_1_1.RESET_B a_6789_14495# 0.03692f
C1419 a_17994_14020# sg13cmos5l_dfrbpq_1_2.Q 0.0782f
C1420 sg13cmos5l_and2_1_1.X sg13cmos5l_xnor2_1_2.B 0.04672f
C1421 sg13cmos5l_dlygate4sd3_1_4.X a_17825_16262# 0.01299f
C1422 sg13cmos5l_dfrbpq_1_6.Q sg13cmos5l_or3_1_1.X 0.01503f
C1423 a_27215_14845# a_27882_14484# 0.09257f
C1424 a_21185_15424# VDD 0.20696f
C1425 VDD a_8582_15238# 0.21098f
C1426 a_18789_15277# a_18665_15180# 0.08186f
C1427 a_25930_14452# VDD 0.0966f
C1428 a_19054_15423# a_19169_15424# 0.3854f
C1429 a_17604_14488# VDD 0.07286f
C1430 a_17921_15424# a_18202_15202# 0.18796f
C1431 sg13cmos5l_a21oi_1_0.Y a_16955_14484# 0.0998f
C1432 sg13cmos5l_a21oi_1_0.A1 a_16955_14484# 0.02731f
C1433 sg13cmos5l_tiehi_1.L_HI a_9158_15234# 0.08086f
C1434 sg13cmos5l_a21oi_1_2.A1 sg13cmos5l_dlygate4sd3_1_17.A 0.07757f
C1435 a_9418_15457# a_9444_15552# 0.24169f
C1436 a_9963_15356# VDD 0.20809f
C1437 sg13cmos5l_buf_1_0.X sg13cmos5l_and2_1_0.X 0.11175f
C1438 sg13cmos5l_dlygate4sd3_1_3.A a_2890_15457# 0.01478f
C1439 sg13cmos5l_inv_1_0.A sg13cmos5l_a21oi_1_3.B1 0.05318f
C1440 sg13cmos5l_dlygate4sd3_1_9.X sg13cmos5l_dfrbpq_1_2.Q 0.01954f
C1441 a_21579_14495# sg13cmos5l_or3_1_2.C 0.01468f
C1442 a_27500_15960# VDD 0.22496f
C1443 sg13cmos5l_dlygate4sd3_1_17.A VDD 0.29477f
C1444 a_8298_14484# sg13cmos5l_buf_1_10.X 0.03737f
C1445 sg13cmos5l_a21oi_1_3.B1 sg13cmos5l_a21oi_1_3.Y 0.63581f
C1446 sg13cmos5l_dfrbpq_1_7.RESET_B sg13cmos5l_a21oi_1_3.B1 0.04148f
C1447 sg13cmos5l_nor2_1_0.B clock_i 0.09977f
C1448 sg13cmos5l_o21ai_1_2.B1 sg13cmos5l_or3_1_1.X 0.01824f
C1449 sg13cmos5l_tiehi_1.L_HI a_10703_15311# 0.1087f
C1450 sg13cmos5l_a21oi_1_3.A2 sg13cmos5l_or3_1_1.C 0.14595f
C1451 a_15579_14854# sg13cmos5l_or3_1_1.B 0.05153f
C1452 a_17806_15423# sg13cmos5l_dfrbpq_1_2.Q 0.01441f
C1453 a_17063_16020# a_16969_16020# 0.02103f
C1454 sg13cmos5l_dfrbpq_1_2.CLK a_16485_13701# 0.22095f
C1455 a_10609_15311# a_9861_15213# 0.01058f
C1456 sg13cmos5l_dfrbpq_1_3.D sg13cmos5l_dfrbpq_1_3.RESET_B 0.09733f
C1457 sg13cmos5l_dlygate4sd3_1_8.X sg13cmos5l_and2_1_2.B 0.03311f
C1458 sg13cmos5l_a21oi_1_3.B1 a_25206_15302# 0.01649f
C1459 a_8312_15238# a_8582_15238# 0.18796f
C1460 a_10337_14750# VDD 0.20387f
C1461 sg13cmos5l_a21oi_1_3.B1 a_18769_14845# 0.01028f
C1462 a_17238_15302# sg13cmos5l_dfrbpq_1_3.D 0.12541f
C1463 sg13cmos5l_dfrbpq_1_7.RESET_B a_26373_14495# 0.03634f
C1464 sg13cmos5l_dlygate4sd3_1_4.X sg13cmos5l_or3_1_2.B 0.18148f
C1465 a_7829_15238# sg13cmos5l_dlygate4sd3_1_8.X 0.02577f
C1466 a_5687_15315# a_5687_15549# 0.08186f
C1467 a_37192_16082# counter_value_o[7] 0.02116f
C1468 a_5886_15486# sg13cmos5l_dfrbpq_1_1.RESET_B 0.04267f
C1469 sg13cmos5l_dfrbpq_1_2.RESET_B a_16068_14040# 0.30414f
C1470 sg13cmos5l_a21oi_1_3.B1 clock_i 0.02814f
C1471 sg13cmos5l_dfrbpq_1_5.RESET_B a_26170_15202# 0.02237f
C1472 sg13cmos5l_a21oi_1_2.A1 VDD 0.17436f
C1473 a_7822_13911# sg13cmos5l_xnor2_1_2.A 0.11116f
C1474 sg13cmos5l_a21oi_1_0.A2 a_16955_14484# 0.05566f
C1475 sg13cmos5l_tiehi_1.L_HI sg13cmos5l_and2_1_2.X 0.10137f
C1476 sg13cmos5l_dfrbpq_1_7.RESET_B a_27472_14726# 0.09622f
C1477 sg13cmos5l_and2_1_0.X sg13cmos5l_buf_1_10.X 0.04444f
C1478 a_6086_14922# sg13cmos5l_xnor2_1_2.A 0.01661f
C1479 a_10703_15311# sg13cmos5l_dlygate4sd3_1_8.A 0.05509f
C1480 a_6789_14495# sg13cmos5l_buf_1_10.X 0.01284f
C1481 a_4175_15311# sg13cmos5l_buf_1_0.X 0.0138f
C1482 sg13cmos5l_dfrbpq_1_5.RESET_B sg13cmos5l_dfrbpq_1_5.D 0.09565f
C1483 sg13cmos5l_dfrbpq_1_5.RESET_B a_25862_13722# 0.11402f
C1484 a_23368_14570# a_22986_14484# 0.01648f
C1485 sg13cmos5l_dfrbpq_1_5.Q a_27882_14484# 0.01003f
C1486 sg13cmos5l_a21oi_1_1.Y sg13cmos5l_a21oi_1_3.B1 0.23211f
C1487 a_19232_13854# VDD 0.06399f
C1488 sg13cmos5l_dfrbpq_1_6.Q a_27034_15202# 0.01446f
C1489 sg13cmos5l_dlygate4sd3_1_1.A a_7680_15549# 0.05742f
C1490 sg13cmos5l_dfrbpq_1_5.RESET_B a_27664_13942# 0.09962f
C1491 sg13cmos5l_o21ai_1_2.B1 sg13cmos5l_dfrbpq_1_7.D 0.02262f
C1492 sg13cmos5l_o21ai_1_2.A2 VDD 0.55223f
C1493 sg13cmos5l_xor2_1_0.B a_2916_15552# 0.01285f
C1494 a_21579_14495# sg13cmos5l_buf_8_2.X 0.03908f
C1495 a_24408_15552# sg13cmos5l_o21ai_1_3.Y 0.01291f
C1496 a_21251_13690# a_21549_14020# 0.02103f
C1497 sg13cmos5l_dfrbpq_1_6.RESET_B sg13cmos5l_or3_1_2.B 0.24505f
C1498 sg13cmos5l_or3_1_2.C VDD 0.6831f
C1499 a_16856_15238# a_17126_15238# 0.18796f
C1500 VDD a_8312_15238# 0.27567f
C1501 sg13cmos5l_dfrbpq_1_1.RESET_B sg13cmos5l_dlygate4sd3_1_3.A 0.14117f
C1502 a_5613_14832# sg13cmos5l_buf_1_10.X 0.09367f
C1503 a_24824_14525# sg13cmos5l_dlygate4sd3_1_17.A 0.29888f
C1504 a_15579_14854# clock_i 0.3255f
C1505 sg13cmos5l_dfrbpq_1_3.Q sg13cmos5l_a21oi_1_3.B1 0.86219f
C1506 a_18106_15960# a_17825_16262# 0.18796f
C1507 a_25930_14452# sg13cmos5l_buf_8_2.X 0.01411f
C1508 sg13cmos5l_dfrbpq_1_6.Q sg13cmos5l_dfrbpq_1_7.Q 0.04426f
C1509 a_18021_14495# a_17892_14909# 0.01562f
C1510 a_17604_14488# sg13cmos5l_buf_8_2.X 0.05299f
C1511 VDD sg13cmos5l_a21oi_1_3.A1 0.28007f
C1512 a_18021_14495# sg13cmos5l_buf_8_2.A 0.01317f
C1513 sg13cmos5l_dlygate4sd3_1_3.A a_2540_15960# 0.19598f
C1514 a_2630_15234# a_3435_15356# 0.07916f
C1515 a_2916_15552# a_3333_15213# 0.28324f
C1516 a_14344_14570# sg13cmos5l_buf_1_10.X 0.03427f
C1517 a_38720_13854# VDD 0.05657f
C1518 sg13cmos5l_dlygate4sd3_1_17.A sg13cmos5l_buf_8_2.X 0.02847f
C1519 sg13cmos5l_or3_1_1.A sg13cmos5l_or3_1_1.X 0.269f
C1520 sg13cmos5l_dlygate4sd3_1_1.A sg13cmos5l_nand4_1_0.Y 0.27454f
C1521 sg13cmos5l_dfrbpq_1_7.RESET_B a_25889_15424# 0.08041f
C1522 VDD a_26753_15424# 0.20784f
C1523 sg13cmos5l_dlygate4sd3_1_3.A sg13cmos5l_buf_1_0.X 0.67869f
C1524 sg13cmos5l_dlygate4sd3_1_1.A sg13cmos5l_dfrbpq_1_2.CLK 0.27858f
C1525 a_20603_15532# sg13cmos5l_dlygate4sd3_1_9.X 0.06946f
C1526 sg13cmos5l_dfrbpq_1_6.RESET_B sg13cmos5l_or3_1_2.A 0.02401f
C1527 sg13cmos5l_dlygate4sd3_1_1.A a_8685_14832# 0.06006f
C1528 a_17578_14452# sg13cmos5l_dfrbpq_1_2.Q 0.01204f
C1529 a_20376_14464# VDD 0.01867f
C1530 a_16485_13701# sg13cmos5l_or3_1_1.B 0.02104f
C1531 sg13cmos5l_dfrbpq_1_6.Q sg13cmos5l_dfrbpq_1_2.Q 0.44792f
C1532 a_17604_14488# sg13cmos5l_dfrbpq_1_3.RESET_B 0.30415f
C1533 a_25109_12972# VDD 0.21318f
C1534 a_22149_16033# VDD 0.06428f
C1535 sg13cmos5l_dfrbpq_1_6.D VDD 0.33298f
C1536 sg13cmos5l_a21oi_1_0.Y sg13cmos5l_a21oi_1_3.B1 0.43231f
C1537 sg13cmos5l_a21oi_1_3.B1 sg13cmos5l_a21oi_1_0.A1 0.06245f
C1538 sg13cmos5l_a21oi_1_3.A2 sg13cmos5l_or3_1_1.B 0.10458f
C1539 a_3130_16237# sg13cmos5l_dfrbpq_1_0.RESET_B 0.05105f
C1540 VDD a_15782_13722# 0.52997f
C1541 sg13cmos5l_dfrbpq_1_5.D a_25670_14922# 0.04812f
C1542 a_24824_14525# VDD 0.2598f
C1543 a_9658_14725# a_9861_14521# 0.02453f
C1544 a_25786_15960# VDD 0.26183f
C1545 sg13cmos5l_dlygate4sd3_1_0.X sg13cmos5l_dfrbpq_1_2.CLK 0.03779f
C1546 a_25774_15423# sg13cmos5l_dfrbpq_1_7.D 0.10701f
C1547 VDD a_17584_13942# 0.13897f
C1548 a_32200_16082# VDD 0.1695f
C1549 a_25862_13722# a_26148_14040# 0.26205f
C1550 a_26122_13945# a_26565_13701# 0.02241f
C1551 a_18863_14845# a_19530_14484# 0.09257f
C1552 sg13cmos5l_or3_1_2.X sg13cmos5l_or3_1_1.B 0.01428f
C1553 a_18106_15960# sg13cmos5l_or3_1_2.B 0.01302f
C1554 sg13cmos5l_buf_8_2.X VDD 1.73258f
C1555 a_20376_14464# sg13cmos5l_or3_1_2.C 0.01238f
C1556 sg13cmos5l_and2_1_1.X sg13cmos5l_xor2_1_0.B 0.01253f
C1557 a_6372_14488# sg13cmos5l_dfrbpq_1_2.CLK 0.08815f
C1558 a_21034_14452# sg13cmos5l_or3_1_2.B 0.03049f
C1559 a_7888_14726# a_7631_14845# 0.23043f
C1560 sg13cmos5l_dlygate4sd3_1_1.A sg13cmos5l_nand3_1_0.Y 0.37433f
C1561 sg13cmos5l_dfrbpq_1_5.Q a_28074_14020# 0.07823f
C1562 a_2490_14447# sg13cmos5l_and2_1_0.X 0.05334f
C1563 a_7822_13911# a_7937_13912# 0.3854f
C1564 sg13cmos5l_dlygate4sd3_1_3.A sg13cmos5l_buf_1_10.X 0.02697f
C1565 sg13cmos5l_dlygate4sd3_1_1.A a_7888_14726# 0.01306f
C1566 sg13cmos5l_dfrbpq_1_5.Q a_27898_15202# 0.2865f
C1567 sg13cmos5l_a21oi_1_3.B1 sg13cmos5l_a21oi_1_0.A2 0.02675f
C1568 sg13cmos5l_nor2_1_0.B sg13cmos5l_inv_1_0.Y 0.02795f
C1569 a_6080_13854# sg13cmos5l_dlygate4sd3_1_0.X 0.01464f
C1570 sg13cmos5l_nand4_1_0.Y a_8582_15238# 0.0177f
C1571 a_19450_15202# VDD 0.27372f
C1572 a_11370_15532# a_11752_15366# 0.01648f
C1573 sg13cmos5l_dfrbpq_1_3.RESET_B VDD 1.16418f
C1574 a_27664_13942# a_28074_14020# 0.07015f
C1575 a_21060_14488# a_21477_14495# 0.28418f
C1576 a_20774_14922# a_21348_14909# 0.18486f
C1577 sg13cmos5l_o21ai_1_2.A2 sg13cmos5l_buf_8_2.X 0.05556f
C1578 a_25109_12972# sg13cmos5l_a21oi_1_3.A1 0.02752f
C1579 a_15579_14854# sg13cmos5l_a21oi_1_0.Y 0.03237f
C1580 a_9963_15356# sg13cmos5l_nand4_1_0.Y 0.02274f
C1581 a_7680_15549# VDD 0.1878f
C1582 sg13cmos5l_or3_1_2.C sg13cmos5l_buf_8_2.X 0.15474f
C1583 a_9963_15356# sg13cmos5l_dfrbpq_1_2.CLK 0.02366f
C1584 sg13cmos5l_inv_1_0.Y sg13cmos5l_dlygate4sd3_1_5.A 0.2384f
C1585 a_21466_15202# sg13cmos5l_or3_1_2.B 0.05836f
C1586 a_17238_15302# VDD 0.16045f
C1587 a_6086_14922# a_6660_14909# 0.18486f
C1588 a_11370_15532# sg13cmos5l_dlygate4sd3_1_8.A 0.09118f
C1589 a_21034_14452# sg13cmos5l_or3_1_2.A 0.02529f
C1590 a_27617_15424# a_27898_15202# 0.18796f
C1591 a_17892_14909# a_18123_14495# 0.07823f
C1592 a_23168_15366# sg13cmos5l_dfrbpq_1_2.Q 0.02676f
C1593 counter_value_o[7] VSS 2.33359f
C1594 counter_value_o[6] VSS 1.63261f
C1595 counter_value_o[5] VSS 1.92698f
C1596 counter_value_o[4] VSS 1.56945f
C1597 counter_value_o[3] VSS 1.53899f
C1598 counter_value_o[2] VSS 1.74775f
C1599 counter_value_o[1] VSS 1.5799f
C1600 counter_value_o[0] VSS 1.63892f
C1601 a_38720_3986# VSS 0.07631f ; **FLOATING
C1602 a_38536_3986# VSS 0.10768f ; **FLOATING
C1603 a_38720_10034# VSS 0.07628f ; **FLOATING
C1604 a_38536_10034# VSS 0.10768f ; **FLOATING
C1605 a_38720_13058# VSS 0.08763f ; **FLOATING
C1606 a_25109_12972# VSS 0.25522f
C1607 a_25203_13320# VSS 0.45994f
C1608 a_6575_13342# VSS 0.20137f
C1609 a_6280_13058# VSS 0.09809f ; **FLOATING
C1610 a_38720_13854# VSS 0.07452f ; **FLOATING
C1611 a_38536_13854# VSS 0.10767f ; **FLOATING
C1612 a_27826_13722# VSS 0.39632f
C1613 a_27313_13799# VSS 0.06782f
C1614 a_26374_13735# VSS 0.53262f
C1615 a_26436_13735# VSS 0.53884f
C1616 a_27609_14037# VSS 0.29831f
C1617 a_25956_13722# VSS 0.06121f
C1618 a_26505_14113# VSS 0.13109f
C1619 a_25862_13722# VSS 0.30589f
C1620 a_25037_14020# VSS 0.26318f
C1621 a_24704_13854# VSS 0.0401f ; **FLOATING
C1622 a_24520_13854# VSS 0.1039f ; **FLOATING
C1623 a_24841_13726# VSS 0.15095f
C1624 a_21549_14020# VSS 0.28251f
C1625 a_21460_14020# VSS 0.52082f
C1626 a_20968_13854# VSS 0.09008f ; **FLOATING
C1627 a_19232_13854# VSS 0.03773f ; **FLOATING
C1628 a_19048_13854# VSS 0.09994f ; **FLOATING
C1629 a_21251_13690# VSS 0.03834f
C1630 a_17233_13799# VSS 0.20929f
C1631 a_16356_13735# VSS 0.13271f
C1632 a_17529_14037# VSS 0.07696f
C1633 a_16425_14113# VSS 0.50217f
C1634 a_16068_14040# VSS 0.20049f
C1635 a_15782_13722# VSS 1.15951f
C1636 a_15680_13854# VSS 0.04657f ; **FLOATING
C1637 a_6080_13854# VSS 0.03878f ; **FLOATING
C1638 a_5896_13854# VSS 0.10286f ; **FLOATING
C1639 a_6286_13911# VSS 0.14189f
C1640 a_38720_14570# VSS 0.08673f ; **FLOATING
C1641 a_27417_14607# VSS 0.12686f
C1642 a_26313_14531# VSS 0.09521f
C1643 a_27634_14922# VSS 0.04455f
C1644 a_27121_14845# VSS 0.0678f
C1645 a_27472_14726# VSS 0.02568f
C1646 a_26244_14909# VSS 0.55965f
C1647 a_26182_14909# VSS 0.79375f
C1648 a_24263_14508# VSS 0.59707f
C1649 a_23736_14464# VSS 0.04886f
C1650 a_25764_14922# VSS 0.16376f
C1651 a_25670_14922# VSS 0.72012f
C1652 a_25094_14484# VSS 0.18968f
C1653 a_23552_14570# VSS 0.03863f ; **FLOATING
C1654 a_23368_14570# VSS 0.08476f ; **FLOATING
C1655 a_23638_14862# VSS 0.16918f
C1656 a_21417_14531# VSS 0.57652f
C1657 a_20376_14464# VSS 0.24207f
C1658 a_22225_14845# VSS 0.28476f
C1659 a_21348_14909# VSS 0.03666f
C1660 a_20868_14922# VSS 0.17329f
C1661 a_20774_14922# VSS 0.50797f
C1662 a_20278_14862# VSS 0.18479f
C1663 a_17961_14531# VSS 0.07346f
C1664 a_18769_14845# VSS 0.30331f
C1665 a_17892_14909# VSS 0.54013f
C1666 a_17830_14909# VSS 0.50346f
C1667 a_16955_14484# VSS 0.16646f
C1668 a_15338_14484# VSS 0.31827f
C1669 a_17412_14922# VSS 0.19118f
C1670 a_17057_14832# VSS 0.25488f
C1671 a_17318_14922# VSS 0.55406f
C1672 a_14344_14570# VSS 0.11656f ; **FLOATING
C1673 a_10016_14570# VSS 0.0411f ; **FLOATING
C1674 a_10618_14448# VSS 0.09765f
C1675 a_10222_14751# VSS 0.16058f
C1676 a_9536_14570# VSS 0.04987f ; **FLOATING
C1677 a_7833_14607# VSS 0.21642f
C1678 a_9658_14725# VSS 0.08137f
C1679 a_8779_14832# VSS 2.05795f
C1680 a_6729_14531# VSS 0.50345f
C1681 a_8050_14922# VSS 0.43618f
C1682 a_7537_14845# VSS 0.14418f
C1683 a_6660_14909# VSS 0.35245f
C1684 a_6598_14909# VSS 0.31578f
C1685 a_6180_14922# VSS 0.18831f
C1686 a_5707_14832# VSS 0.04721f
C1687 a_5504_14570# VSS 0.06581f ; **FLOATING
C1688 a_6086_14922# VSS 0.60611f
C1689 sg13cmos5l_dlygate4sd3_1_0.X VSS 0.04225f
C1690 a_3872_14570# VSS 0.06949f ; **FLOATING
C1691 a_2516_14484# VSS 0.22627f
C1692 a_2646_14842# VSS 0.0482f
C1693 a_2059_14832# VSS 0.62272f
C1694 a_1856_14570# VSS 0.06669f ; **FLOATING
C1695 a_1965_14832# VSS 0.07071f
C1696 a_38720_15366# VSS 0.08766f ; **FLOATING
C1697 a_27502_15423# VSS 0.16892f
C1698 a_24310_15230# VSS 1.57381f
C1699 a_24062_15242# VSS 0.06305f
C1700 a_23858_15242# VSS 0.01275f
C1701 a_23480_15242# VSS 0.09203f
C1702 a_23378_15242# VSS 0.04678f
C1703 a_25094_15238# VSS 0.18921f
C1704 sg13cmos5l_o21ai_1_2.Y VSS 0.11754f
C1705 a_24408_15552# VSS 0.41208f
C1706 a_23168_15366# VSS 0.05136f ; **FLOATING
C1707 a_21824_15366# VSS 0.04409f ; **FLOATING
C1708 a_20705_15260# VSS 0.09764f
C1709 a_20603_15532# VSS 0.32519f
C1710 a_20000_15366# VSS 0.03804f ; **FLOATING
C1711 a_19816_15366# VSS 0.08226f ; **FLOATING
C1712 a_21070_15423# VSS 0.03026f
C1713 sg13cmos5l_dlygate4sd3_1_9.X VSS 0.09206f
C1714 a_18665_15180# VSS 0.05051f
C1715 a_16175_15238# VSS 0.37281f
C1716 a_17238_15302# VSS 0.19906f
C1717 sg13cmos5l_a21oi_1_0.Y VSS 0.0238f
C1718 a_15870_15486# VSS 0.0567f
C1719 a_11752_15366# VSS 0.08325f ; **FLOATING
C1720 a_10609_15311# VSS 0.14761f
C1721 a_9670_15247# VSS 0.07864f
C1722 a_9732_15247# VSS 0.1153f
C1723 a_10905_15549# VSS 0.09938f
C1724 a_9252_15234# VSS 0.20127f
C1725 a_7829_15238# VSS 0.09487f
C1726 a_9801_15625# VSS 0.50347f
C1727 a_9158_15234# VSS 1.45711f
C1728 a_9418_15457# VSS 0.0195f
C1729 a_8582_15238# VSS 0.3273f
C1730 a_7058_15242# VSS 0.49023f
C1731 a_6578_15242# VSS 0.56482f
C1732 a_7923_15532# VSS 0.30095f
C1733 sg13cmos5l_nand4_1_0.Y VSS 0.03957f
C1734 a_5600_15366# VSS 0.04738f ; **FLOATING
C1735 a_5886_15486# VSS 0.0851f
C1736 a_4081_15311# VSS 0.14662f
C1737 a_3142_15247# VSS 0.97322f
C1738 a_3204_15247# VSS 0.72225f
C1739 a_3273_15625# VSS 0.02173f
C1740 a_2630_15234# VSS 0.4784f
C1741 sg13cmos5l_and2_1_0.X VSS 0.09449f
C1742 a_2528_15366# VSS 0.06282f ; **FLOATING
C1743 a_2890_15457# VSS 0.09289f
C1744 a_37192_16082# VSS 0.09909f ; **FLOATING
C1745 a_37484_15960# VSS 0.01239f
C1746 a_32200_16082# VSS 0.09676f ; **FLOATING
C1747 a_27296_16082# VSS 0.05227f ; **FLOATING
C1748 a_24923_15996# VSS 0.22259f
C1749 a_26170_16237# VSS 0.08239f
C1750 a_25025_16344# VSS 0.25926f
C1751 sg13cmos5l_dlygate4sd3_1_17.A VSS 0.15997f
C1752 a_26633_16334# VSS 0.07084f
C1753 a_25786_15960# VSS 0.41618f
C1754 a_25390_16263# VSS 0.06506f
C1755 a_22304_16082# VSS 0.04037f ; **FLOATING
C1756 a_21946_16237# VSS 0.05753f
C1757 a_20960_16082# VSS 0.06776f ; **FLOATING
C1758 a_17165_16020# VSS 0.1776f
C1759 sg13cmos5l_dfrbpq_1_6.D VSS 0.18416f
C1760 a_22025_16334# VSS 0.04998f
C1761 a_18454_16374# VSS 0.15119f
C1762 a_16969_16020# VSS 0.10779f
C1763 sg13cmos5l_inv_1_0.Y VSS 0.2253f
C1764 a_12232_16082# VSS 0.09383f ; **FLOATING
C1765 sg13cmos5l_dlygate4sd3_1_1.A VSS 0.09828f
C1766 a_7240_16082# VSS 0.09487f ; **FLOATING
C1767 a_3008_16082# VSS 0.03902f ; **FLOATING
C1768 a_2824_16082# VSS 0.07953f ; **FLOATING
C1769 a_3130_16237# VSS 0.09764f
C1770 a_2248_16082# VSS 0.10237f ; **FLOATING
C1771 VSS.t19 VSS 5.47241f
C1772 VSS.t21 VSS 0.29772f
C1773 VSS.t2964 VSS 0.01995f
C1774 VSS.t2979 VSS 0.17545f
C1775 VSS.t2984 VSS 0.06052f
C1776 VSS.t2999 VSS 0.03687f
C1777 VSS.t3019 VSS 0.04589f
C1778 VSS.t2736 VSS 0.17563f
C1779 VSS.t2743 VSS 0.03253f
C1780 VSS.t2749 VSS 0.45397f
C1781 VSS.t2754 VSS 0.23969f
C1782 VSS.t2753 VSS 0.30286f
C1783 VSS.t2761 VSS 0.11233f
C1784 VSS.t3076 VSS 0.03865f
C1785 VSS.t3071 VSS 0.03516f
C1786 VSS.t3074 VSS 0.03865f
C1787 VSS.t3069 VSS 0.03516f
C1788 VSS.t3054 VSS 0.15458f
C1789 VSS.t3049 VSS 0.06341f
C1790 VSS.t3043 VSS 0.03026f
C1791 VSS.t3044 VSS 0.04523f
C1792 VSS.t3033 VSS 0.14918p
C1793 VSS.t3034 VSS 0.14918p
C1794 VSS.t3099 VSS 0.17977f
C1795 VSS.t3194 VSS 0.14412f
C1796 VSS.t2806 VSS 0.11915f
C1797 VSS.t2931 VSS 0.01768f
C1798 VSS.t2817 VSS 0.14021f
C1799 VSS.t2814 VSS 0.16871f
C1800 VSS.t2820 VSS 0.06319f
C1801 VSS.t2773 VSS 0.01244f
C1802 VSS.t2774 VSS 0.01244f
C1803 VSS.t2781 VSS 0.43125f
C1804 VSS.t2789 VSS 0.01055f
C1805 VSS.t2788 VSS 0.01055f
C1806 VSS.t2792 VSS 0.21872f
C1807 VSS.t2798 VSS 0.0598f
C1808 VSS.t2797 VSS 0.0598f
C1809 VSS.t125 VSS 0.50171f
C1810 VSS.t41 VSS 0.8005f
C1811 VSS.t15 VSS 0.64105f
C1812 VSS.t131 VSS 0.02525f
C1813 VSS.t160 VSS 0.30151f
C1814 VSS.t3 VSS 0.06244f
C1815 VSS.t162 VSS 0.55463f
C1816 VSS.t114 VSS 0.65427f
C1817 VSS.t143 VSS 0.48365f
C1818 VSS.t300 VSS 0.37156f
C1819 VSS.t603 VSS 0.04725f
C1820 VSS.t590 VSS 0.01802f
C1821 VSS.t588 VSS 0.01802f
C1822 VSS.t583 VSS 0.02215f
C1823 VSS.t570 VSS 0.17154f
C1824 VSS.t573 VSS 0.06046f
C1825 VSS.t210 VSS 0.08634f
C1826 VSS.t567 VSS 0.0238f
C1827 VSS.t568 VSS 0.19534f
C1828 VSS.t17 VSS 0.48825f
C1829 VSS.t555 VSS 0.05875f
C1830 VSS.t548 VSS 0.01626f
C1831 VSS.t613 VSS 0.25554f
C1832 VSS.t617 VSS 0.24843f
C1833 VSS.t725 VSS 0.24843f
C1834 VSS.t59 VSS 0.20049f
C1835 VSS.t9 VSS 0.3123f
C1836 VSS.t620 VSS 0.35549f
C1837 VSS.t752 VSS 0.03782f
C1838 VSS.t215 VSS 0.03834f
C1839 VSS.t77 VSS 0.78513f
C1840 VSS.t34 VSS 0.0722f
C1841 VSS.t772 VSS 0.42696f
C1842 VSS.t771 VSS 0.40992f
C1843 VSS.t776 VSS 0.76856f
C1844 VSS.t664 VSS 0.07207f
C1845 VSS.t1052 VSS 0.10671f
C1846 VSS.t1042 VSS 0.09974f
C1847 VSS.t1031 VSS 0.02979f
C1848 VSS.t1032 VSS 0.02979f
C1849 VSS.t1022 VSS 0.06261f
C1850 VSS.t1009 VSS 0.05181f
C1851 VSS.t1007 VSS 0.05181f
C1852 VSS.t1002 VSS 0.03542f
C1853 VSS.t996 VSS 0.04799f
C1854 VSS.t997 VSS 0.04799f
C1855 VSS.t992 VSS 0.05104f
C1856 VSS.t987 VSS 0.22936f
C1857 VSS.t981 VSS 0.03603f
C1858 VSS.t982 VSS 0.17669f
C1859 VSS.t962 VSS 0.21343f
C1860 VSS.t937 VSS 0.01475f
C1861 VSS.t931 VSS 0.03536f
C1862 VSS.t932 VSS 0.03536f
C1863 VSS.t917 VSS 0.18356f
C1864 VSS.t906 VSS 0.08348f
C1865 VSS.t907 VSS 0.17946f
C1866 VSS.t897 VSS 0.29837p
C1867 VSS.t887 VSS 0.0696f
C1868 VSS.t881 VSS 0.05691f
C1869 VSS.t882 VSS 0.26304f
C1870 VSS.t859 VSS 0.06159f
C1871 VSS.t857 VSS 0.06159f
C1872 VSS.t847 VSS 0.03373f
C1873 VSS.t837 VSS 0.06676f
C1874 VSS.t831 VSS 0.27354f
C1875 VSS.t832 VSS 0.43719f
C1876 VSS.t1216 VSS 0.0931f
C1877 VSS.t1223 VSS 0.86786f
C1878 VSS.t1221 VSS 0.25677f
C1879 VSS.t1226 VSS 0.14413f
C1880 VSS.t1392 VSS 0.09178f
C1881 VSS.t1237 VSS 0.06547f
C1882 VSS.t1240 VSS 0.18317f
C1883 VSS.t1239 VSS 0.22896f
C1884 VSS.t1242 VSS 0.04651f
C1885 VSS.t1243 VSS 0.0786f
C1886 VSS.t1582 VSS 0.02111f
C1887 VSS.t1577 VSS 0.78981f
C1888 VSS.t1557 VSS 0.08773f
C1889 VSS.t1547 VSS 0.20053f
C1890 VSS.t1537 VSS 0.28211f
C1891 VSS.t1532 VSS 0.08716f
C1892 VSS.t1527 VSS 0.06103f
C1893 VSS.t1522 VSS 0.08206f
C1894 VSS.t1517 VSS 0.28211f
C1895 VSS.t1512 VSS 0.19197f
C1896 VSS.t1507 VSS 0.63743f
C1897 VSS.t1597 VSS 0.11959f
C1898 VSS.t1611 VSS 0.19097f
C1899 VSS.t1612 VSS 0.86215f
C1900 VSS.t1617 VSS 0.02994f
C1901 VSS.t1627 VSS 0.03848f
C1902 VSS.t1632 VSS 0.11899f
C1903 VSS.t1647 VSS 0.50745f
C1904 VSS.t1651 VSS 0.11942f
C1905 VSS.t1652 VSS 0.11942f
C1906 VSS.t389 VSS 0.05949f
C1907 VSS.t11 VSS 0.15287f
C1908 VSS.t45 VSS 0.04333f
C1909 VSS.t414 VSS 0.11596f
C1910 VSS.t394 VSS 0.02098f
C1911 VSS.t56 VSS 0.53349f
C1912 VSS.t371 VSS 0.08338f
C1913 VSS.t197 VSS 0.62967f
C1914 VSS.t267 VSS 0.03386f
C1915 VSS.t446 VSS 0.06284f
C1916 VSS.t65 VSS 0.06284f
C1917 VSS.t135 VSS 0.21698f
C1918 VSS.t98 VSS 0.07668f
C1919 VSS.t174 VSS 0.21743f
C1920 VSS.t23 VSS 0.20865f
C1921 VSS.t123 VSS 0.44774f
C1922 VSS.t73 VSS 0.4511f
C1923 VSS.t13 VSS 0.83323f
C1924 VSS.t108 VSS 0.78927f
C1925 VSS.t1 VSS 0.18968f
C1926 VSS.t3278 VSS 0.4583f
C1927 VSS.t276 VSS 1.46641f
C1928 VSS.t454 VSS 0.04604f
C1929 VSS.t453 VSS 0.04604f
C1930 VSS.t466 VSS 0.20178f
C1931 VSS.t469 VSS 0.08245f
C1932 VSS.t468 VSS 0.08245f
C1933 VSS.t472 VSS 0.33408f
C1934 VSS.t481 VSS 0.14106f
C1935 VSS.t480 VSS 0.14106f
C1936 VSS.t484 VSS 0.05338f
C1937 VSS.t1302 VSS 0.01553f
C1938 VSS.t1314 VSS 0.06847f
C1939 VSS.t1311 VSS 0.05009f
C1940 VSS.t1316 VSS 0.04169f
C1941 VSS.t1317 VSS 0.04169f
C1942 VSS.t1323 VSS 0.08443f
C1943 VSS.t1335 VSS 0.0159f
C1944 VSS.t1478 VSS 0.16019f
C1945 VSS.t1347 VSS 0.11248f
C1946 VSS.t1346 VSS 0.02581f
C1947 VSS.t1352 VSS 0.25174f
C1948 VSS.t1350 VSS 0.25174f
C1949 VSS.t1356 VSS 0.03044f
C1950 VSS.t1357 VSS 0.03044f
C1951 VSS.t1358 VSS 0.07835f
C1952 VSS.t1359 VSS 0.07835f
C1953 VSS.t1361 VSS 0.16935f
C1954 VSS.t1362 VSS 0.1862f
C1955 VSS.t1345 VSS 0.08667f
C1956 VSS.t1344 VSS 0.19736f
C1957 VSS.t1289 VSS 0.04215f
C1958 VSS.t1285 VSS 0.20637f
C1959 VSS.t1284 VSS 0.20637f
C1960 VSS.t1271 VSS 0.09962f
C1961 VSS.t1259 VSS 0.11638f
C1962 VSS.t2049 VSS 0.59675p
C1963 VSS.t2034 VSS 0.12504f
C1964 VSS.t2029 VSS 0.01771f
C1965 VSS.t2019 VSS 0.03942f
C1966 VSS.t2013 VSS 0.01001f
C1967 VSS.t2014 VSS 0.01001f
C1968 VSS.t2009 VSS 0.22939f
C1969 VSS.t2004 VSS 0.0443f
C1970 VSS.t1994 VSS 0.04195f
C1971 VSS.t1989 VSS 0.0888f
C1972 VSS.t1966 VSS 0.1061f
C1973 VSS.t1961 VSS 0.11995f
C1974 VSS.t1964 VSS 0.1061f
C1975 VSS.t1956 VSS 0.14098f
C1976 VSS.t1959 VSS 0.11995f
C1977 VSS.t1954 VSS 0.14098f
C1978 VSS.t1946 VSS 1.52005f
C1979 VSS.t1944 VSS 1.52005f
C1980 VSS.t1928 VSS 0.03386f
C1981 VSS.t1929 VSS 0.03386f
C1982 VSS.t1923 VSS 0.0317f
C1983 VSS.t1924 VSS 0.0317f
C1984 VSS.t1913 VSS 0.17341f
C1985 VSS.t1914 VSS 0.17341f
C1986 VSS.t1909 VSS 0.10324f
C1987 VSS.t1904 VSS 0.32028f
C1988 VSS.t2281 VSS 0.02295f
C1989 VSS.t2275 VSS 0.098f
C1990 VSS.t2276 VSS 0.098f
C1991 VSS.t2301 VSS 0.22698f
C1992 VSS.t2306 VSS 0.3776f
C1993 VSS.t2308 VSS 0.3776f
C1994 VSS.t2316 VSS 0.0348f
C1995 VSS.t2321 VSS 0.57558f
C1996 VSS.t2331 VSS 0.16143f
C1997 VSS.t2330 VSS 0.07476f
C1998 VSS.t2335 VSS 0.14106f
C1999 VSS.t2336 VSS 0.14106f
C2000 VSS.t2345 VSS 0.22939f
C2001 VSS.t2346 VSS 0.26542f
C2002 VSS.t2351 VSS 0.2012f
C2003 VSS.t2355 VSS 0.03273f
C2004 VSS.t2356 VSS 0.03273f
C2005 VSS.t2361 VSS 0.16676f
C2006 VSS.t2371 VSS 0.49836f
C2007 VSS.t2376 VSS 0.26541f
C2008 VSS.t2381 VSS 0.4772f
C2009 VSS.t2386 VSS 0.12129f
C2010 VSS.t2391 VSS 1.63396f
C2011 VSS.t2390 VSS 1.63396f
C2012 VSS.t2396 VSS 0.25173f
C2013 VSS.t2411 VSS 0.12872f
C2014 VSS.t2416 VSS 0.25174f
C2015 VSS.t2431 VSS 0.24918f
C2016 VSS.t2456 VSS 0.06771f
C2017 VSS.t2461 VSS 0.12276f
C2018 VSS.t2466 VSS 0.07206f
C2019 VSS.t2471 VSS 0.01038f
C2020 VSS.t2470 VSS 0.01038f
C2021 VSS.t2476 VSS 0.06925f
C2022 VSS.t2481 VSS 0.05073f
C2023 VSS.t2491 VSS 0.13625f
C2024 VSS.t2501 VSS 0.03463f
C2025 VSS.t2511 VSS 0.19927f
C2026 VSS.t2516 VSS 0.05336f
C2027 VSS.t2521 VSS 0.10848f
C2028 VSS.t2518 VSS 0.05336f
C2029 VSS.t2520 VSS 0.10848f
C2030 VSS.t2531 VSS 0.07787f
C2031 VSS.t2530 VSS 0.07787f
C2032 VSS.t2536 VSS 0.27378f
C2033 VSS.t2545 VSS 0.04219f
C2034 VSS.t2546 VSS 0.05959f
C2035 VSS.t2551 VSS 0.04172f
C2036 VSS.t2548 VSS 0.0174f
C2037 VSS.t2483 VSS 0.05073f
C2038 VSS.t2383 VSS 0.02552f
C2039 VSS.t2333 VSS 0.08667f
C2040 VSS.t2323 VSS 0.17661f
C2041 VSS.t1884 VSS 0.04202f
C2042 VSS.t1973 VSS 0.13296f
C2043 VSS.t1974 VSS 0.13296f
C2044 VSS.t2044 VSS 0.12093f
C2045 VSS.t2054 VSS 0.03687f
C2046 VSS.t2053 VSS 0.03687f
C2047 VSS.t2058 VSS 0.02101f
C2048 VSS.t2059 VSS 0.117f
C2049 VSS.t2064 VSS 0.06283f
C2050 VSS.t2061 VSS 0.09598f
C2051 VSS.t2074 VSS 0.43393f
C2052 VSS.t2099 VSS 0.07071f
C2053 VSS.t2114 VSS 0.08623f
C2054 VSS.t2118 VSS 0.04311f
C2055 VSS.t2119 VSS 0.04311f
C2056 VSS.t2129 VSS 0.28197f
C2057 VSS.t2144 VSS 0.02669f
C2058 VSS.t2143 VSS 0.02669f
C2059 VSS.t2159 VSS 0.02111f
C2060 VSS.t2161 VSS 0.02111f
C2061 VSS.t1732 VSS 0.08907f
C2062 VSS.t1722 VSS 0.21696f
C2063 VSS.t1717 VSS 0.01944f
C2064 VSS.t1711 VSS 0.08182f
C2065 VSS.t1712 VSS 0.20769f
C2066 VSS.t1707 VSS 0.07033f
C2067 VSS.t1702 VSS 0.11685f
C2068 VSS.t1692 VSS 0.05899f
C2069 VSS.t1682 VSS 0.27388f
C2070 VSS.t1674 VSS 0.02568f
C2071 VSS.t1672 VSS 0.1554f
C2072 VSS.t1667 VSS 0.01971f
C2073 VSS.t1727 VSS 0.25691f
C2074 VSS.t1737 VSS 0.07668f
C2075 VSS.t1747 VSS 0.08438f
C2076 VSS.t1752 VSS 0.19179f
C2077 VSS.t1762 VSS 0.05162f
C2078 VSS.t1767 VSS 0.02975f
C2079 VSS.t1766 VSS 0.02975f
C2080 VSS.t2124 VSS 0.08526f
C2081 VSS.t1649 VSS 0.35904f
C2082 VSS.t1244 VSS 0.0321f
C2083 VSS.t1214 VSS 0.03142f
C2084 VSS.t827 VSS 0.11609f
C2085 VSS.t817 VSS 0.03408f
C2086 VSS.t902 VSS 0.25594f
C2087 VSS.t1044 VSS 0.09974f
C2088 VSS.t1057 VSS 0.04005f
C2089 VSS.t1061 VSS 0.04501f
C2090 VSS.t1062 VSS 0.04501f
C2091 VSS.t1072 VSS 0.23946f
C2092 VSS.t1082 VSS 0.2162f
C2093 VSS.t1087 VSS 0.1916f
C2094 VSS.t667 VSS 0.20188f
C2095 VSS.t670 VSS 0.28101f
C2096 VSS.t673 VSS 0.0238f
C2097 VSS.t676 VSS 0.0238f
C2098 VSS.t2670 VSS 0.01049f
C2099 VSS.t2669 VSS 0.01049f
C2100 VSS.t2672 VSS 0.0238f
C2101 VSS.t2675 VSS 0.03603f
C2102 VSS.t2676 VSS 0.03603f
C2103 VSS.t2679 VSS 0.01239f
C2104 VSS.t2683 VSS 0.03687f
C2105 VSS.t2696 VSS 0.04333f
C2106 VSS.t2694 VSS 0.04333f
C2107 VSS.t2702 VSS 0.06747f
C2108 VSS.t2703 VSS 0.13944f
C2109 VSS.t2704 VSS 0.13944f
C2110 VSS.t2708 VSS 0.29777f
C2111 VSS.t2709 VSS 0.29777f
C2112 VSS.t2717 VSS 0.01924f
.ends
