* PEX produced on Tue Aug 25 10:57:59 AM CEST 2026 using /foss/tools/sak/sak-pex.sh with m=3 and s=1 (extresist threshold=10000 mOhm, minres=1000 mOhm, mindelay=1 ps)
* NGSPICE file created from counter_top_pex.ext - technology: ihp-sg13cmos5l

.subckt counter_top_pex VDD VSS clock_i reset_n_i enable_i counter_value_o[0]
+ counter_value_o[1] counter_value_o[2] counter_value_o[3] counter_value_o[4]
+ counter_value_o[5] counter_value_o[6] counter_value_o[7]
X0 VDD VSS.t888 VDD VDD sg13_lv_pmos ad=0.19p pd=1.38u as=3.19196n ps=0.01242 w=1u l=1u
X1 VDD enable_i a_1192_3900# VDD sg13_lv_pmos ad=0.2114p pd=1.54u as=0.2856p ps=2.36u w=0.84u l=0.13u
X2 VDD VSS.t2631 VDD VDD sg13_lv_pmos ad=0.19p pd=1.38u as=0 ps=0 w=1u l=1u
X3 VSS.t15 a_4432_15454# a_4081_15311# VSS.t3277 sg13_lv_nmos ad=79.8f pd=0.8u as=0.1428p ps=1.52u w=0.42u l=0.13u
X4 VDD VSS.t1724 VDD VDD sg13_lv_pmos ad=0.34p pd=2.68u as=0 ps=0 w=1u l=1u
X5 VSS.t2012 VDD VSS.t2014 VSS.t2013 sg13_lv_nmos ad=79.8f pd=0.8u as=0 ps=0 w=0.42u l=1u
X6 VDD sg13cmos5l_and2_1_2.B a_8685_14832# VDD sg13_lv_pmos ad=0.1918p pd=1.5u as=0.1596p ps=1.22u w=0.84u l=0.13u
X7 VDD VSS.t596 VDD VDD sg13_lv_pmos ad=0.34p pd=2.68u as=0 ps=0 w=1u l=1u
X8 VSS.t1575 VDD VSS.t1577 VSS.t1576 sg13_lv_nmos ad=79.8f pd=0.8u as=0 ps=0 w=0.42u l=1u
X9 VSS.t3100 VDD VSS.t3102 VSS.t3101 sg13_lv_nmos ad=79.8f pd=0.8u as=0 ps=0 w=0.42u l=1u
X10 VDD VSS.t1172 VDD VDD sg13_lv_pmos ad=0.34p pd=2.68u as=0 ps=0 w=1u l=1u
X11 VSS.t1967 VDD VSS.t1966 VSS.t1965 sg13_lv_nmos ad=0.1428p pd=1.52u as=0 ps=0 w=0.42u l=1u
X12 VDD VSS.t825 VDD VDD sg13_lv_pmos ad=0.34p pd=2.68u as=0 ps=0 w=1u l=1u
X13 VSS.t2641 VDD VSS.t2642 VSS.t61 sg13_lv_nmos ad=79.8f pd=0.8u as=0 ps=0 w=0.42u l=1u
X14 VSS.t1315 VDD VSS.t1314 VSS.t70 sg13_lv_nmos ad=0.1428p pd=1.52u as=0 ps=0 w=0.42u l=1u
X15 VDD VSS.t2413 VDD VDD sg13_lv_pmos ad=0.34p pd=2.68u as=0 ps=0 w=1u l=1u
X16 VDD VSS.t2071 VDD VDD sg13_lv_pmos ad=0.34p pd=2.68u as=0 ps=0 w=1u l=1u
X17 VDD VSS.t1846 VDD VDD sg13_lv_pmos ad=0.34p pd=2.68u as=0 ps=0 w=1u l=1u
X18 VDD VSS.t2642 VDD VDD sg13_lv_pmos ad=0.34p pd=2.68u as=0 ps=0 w=1u l=1u
X19 VSS.t946 VDD VSS.t945 VSS.t944 sg13_lv_nmos ad=0.1428p pd=1.52u as=0 ps=0 w=0.42u l=1u
X20 VDD VSS.t564 VDD VDD sg13_lv_pmos ad=0.34p pd=2.68u as=0 ps=0 w=1u l=1u
X21 VSS.t991 VDD VSS.t990 VSS.t989 sg13_lv_nmos ad=0.1428p pd=1.52u as=0 ps=0 w=0.42u l=1u
X22 VDD VSS.t1181 VDD VDD sg13_lv_pmos ad=0.34p pd=2.68u as=0 ps=0 w=1u l=1u
X23 a_27500_15960# sg13cmos5l_dfrbpq_1_6.Q VSS.t131 VSS.t3300 sg13_lv_nmos ad=0.187p pd=1.78u as=0.14875p ps=1.16u w=0.55u l=0.13u
X24 VDD VSS.t1043 VDD VDD sg13_lv_pmos ad=0.19p pd=1.38u as=0 ps=0 w=1u l=1u
X25 VDD VSS.t1292 VDD VDD sg13_lv_pmos ad=0.19p pd=1.38u as=0 ps=0 w=1u l=1u
X26 VDD a_27407_13799# a_27664_13942# VDD sg13_lv_pmos ad=2.42015p pd=15.68u as=79.8f ps=0.8u w=0.42u l=0.13u
X27 VDD VSS.t855 VDD VDD sg13_lv_pmos ad=0.34p pd=2.68u as=0 ps=0 w=1u l=1u
X28 VSS.t2693 VDD VSS.t2693 VSS.t61 sg13_lv_nmos ad=0.1428p pd=1.52u as=0 ps=0 w=0.42u l=1u
X29 VDD sg13cmos5l_xnor2_1_2.A sg13cmos5l_nand4_1_0.Y VDD sg13_lv_pmos ad=0.2128p pd=1.5u as=0.2128p ps=1.5u w=1.12u l=0.13u
X30 VSS.t2499 VDD VSS.t2501 VSS.t2500 sg13_lv_nmos ad=79.8f pd=0.8u as=0 ps=0 w=0.42u l=1u
X31 a_19450_15202# sg13cmos5l_dfrbpq_1_3.Q VSS.t204 VSS.t42 sg13_lv_nmos ad=0.1428p pd=1.52u as=79.8f ps=0.8u w=0.42u l=0.13u
X32 VDD VSS.t645 VDD VDD sg13_lv_pmos ad=0.19p pd=1.38u as=0 ps=0 w=1u l=1u
X33 VDD VSS.t1567 VDD VDD sg13_lv_pmos ad=0.19p pd=1.38u as=0 ps=0 w=1u l=1u
X34 VDD VSS.t3034 VDD VDD sg13_lv_pmos ad=0.34p pd=2.68u as=0 ps=0 w=1u l=1u
X35 VSS.t2770 VDD VSS.t2768 VSS.t61 sg13_lv_nmos ad=0.1428p pd=1.52u as=0 ps=0 w=0.42u l=1u
X36 VDD VSS.t1901 VDD VDD sg13_lv_pmos ad=0.34p pd=2.68u as=0 ps=0 w=1u l=1u
X37 a_26436_13735# a_26148_14040# a_26374_13735# VSS.t3296 sg13_lv_nmos ad=0.1428p pd=1.52u as=37.8f ps=0.6u w=0.42u l=0.13u
X38 VSS.t911 VDD VSS.t913 VSS.t912 sg13_lv_nmos ad=79.8f pd=0.8u as=0 ps=0 w=0.42u l=1u
X39 VSS.t1997 VDD VSS.t1999 VSS.t1998 sg13_lv_nmos ad=79.8f pd=0.8u as=0 ps=0 w=0.42u l=1u
X40 VDD VSS.t1572 VDD VDD sg13_lv_pmos ad=0.19p pd=1.38u as=0 ps=0 w=1u l=1u
X41 VSS.t1451 VDD VSS.t1327 VSS.t70 sg13_lv_nmos ad=0.1428p pd=1.52u as=0 ps=0 w=0.42u l=1u
X42 VSS.t2632 VDD VSS.t2633 VSS.t61 sg13_lv_nmos ad=79.8f pd=0.8u as=0 ps=0 w=0.42u l=1u
X43 VDD VSS.t918 VDD VDD sg13_lv_pmos ad=0.19p pd=1.38u as=0 ps=0 w=1u l=1u
X44 VSS.t961 VDD VSS.t960 VSS.t959 sg13_lv_nmos ad=0.1428p pd=1.52u as=0 ps=0 w=0.42u l=1u
X45 VSS.t2369 VDD VSS.t2371 VSS.t2370 sg13_lv_nmos ad=79.8f pd=0.8u as=0 ps=0 w=0.42u l=1u
X46 VSS.t1917 VDD VSS.t1916 VSS.t1915 sg13_lv_nmos ad=0.1428p pd=1.52u as=0 ps=0 w=0.42u l=1u
X47 VDD VSS.t1914 VDD VDD sg13_lv_pmos ad=0.19p pd=1.38u as=0 ps=0 w=1u l=1u
X48 VSS.t786 VDD VSS.t788 VSS.t787 sg13_lv_nmos ad=79.8f pd=0.8u as=0 ps=0 w=0.42u l=1u
X49 VDD VSS.t440 VDD VDD sg13_lv_pmos ad=0.34p pd=2.68u as=0 ps=0 w=1u l=1u
X50 VDD VSS.t845 VDD VDD sg13_lv_pmos ad=0.34p pd=2.68u as=0 ps=0 w=1u l=1u
X51 VDD VSS.t2039 VDD VDD sg13_lv_pmos ad=0.19p pd=1.38u as=0 ps=0 w=1u l=1u
X52 a_17412_14922# sg13cmos5l_dfrbpq_1_3.D a_17318_14922# VSS.t9 sg13_lv_nmos ad=60.89999f pd=0.71u as=0.1428p ps=1.52u w=0.42u l=0.13u
X53 VSS.t1460 VDD VSS.t1459 VSS.t1458 sg13_lv_nmos ad=0.1428p pd=1.52u as=0 ps=0 w=0.42u l=1u
X54 VDD VSS.t1272 VDD VDD sg13_lv_pmos ad=0.34p pd=2.68u as=0 ps=0 w=1u l=1u
X55 VDD VSS.t3149 VDD VDD sg13_lv_pmos ad=0.34p pd=2.68u as=0 ps=0 w=1u l=1u
X56 VSS.t2649 VDD VSS.t2648 VSS.t61 sg13_lv_nmos ad=0.1428p pd=1.52u as=0 ps=0 w=0.42u l=1u
X57 VDD a_25774_15423# sg13cmos5l_dfrbpq_1_7.D VDD sg13_lv_pmos ad=0.2254p pd=1.53u as=0.4256p ps=3u w=1.12u l=0.13u
X58 VDD VSS.t699 VDD VDD sg13_lv_pmos ad=0.19p pd=1.38u as=0 ps=0 w=1u l=1u
X59 VSS.t1021 VDD VSS.t1023 VSS.t1022 sg13_lv_nmos ad=79.8f pd=0.8u as=0 ps=0 w=0.42u l=1u
X60 VSS.t2711 VDD VSS.t2713 VSS.t61 sg13_lv_nmos ad=79.8f pd=0.8u as=0 ps=0 w=0.42u l=1u
X61 VDD VSS.t1722 VDD VDD sg13_lv_pmos ad=0.19p pd=1.38u as=0 ps=0 w=1u l=1u
X62 VDD a_18021_14495# a_18123_14495# VDD sg13_lv_pmos ad=2.42015p pd=15.68u as=0.3864p ps=2.93u w=1.12u l=0.13u
X63 VDD a_22319_14845# a_22986_14484# VDD sg13_lv_pmos ad=0.2128p pd=1.5u as=0.3864p ps=2.93u w=1.12u l=0.13u
X64 VSS.t881 VDD VSS.t880 VSS.t879 sg13_lv_nmos ad=0.1428p pd=1.52u as=0 ps=0 w=0.42u l=1u
X65 VDD VSS.t1552 VDD VDD sg13_lv_pmos ad=0.19p pd=1.38u as=0 ps=0 w=1u l=1u
X66 VSS.t397 VDD VSS.t396 VSS.t395 sg13_lv_nmos ad=0.1428p pd=1.52u as=0 ps=0 w=0.42u l=1u
X67 VDD VSS.t601 VDD VDD sg13_lv_pmos ad=0.34p pd=2.68u as=0 ps=0 w=1u l=1u
X68 VSS.t1217 VDD VSS.t1218 VSS.t70 sg13_lv_nmos ad=79.8f pd=0.8u as=0 ps=0 w=0.42u l=1u
X69 VDD VSS.t1310 VDD VDD sg13_lv_pmos ad=0.19p pd=1.38u as=0 ps=0 w=1u l=1u
X70 VDD VSS.t303 VDD VDD sg13_lv_pmos ad=0.34p pd=2.68u as=0 ps=0 w=1u l=1u
X71 VSS.t2663 VDD VSS.t2662 VSS.t61 sg13_lv_nmos ad=0.1428p pd=1.52u as=0 ps=0 w=0.42u l=1u
X72 VDD VSS.t2466 VDD VDD sg13_lv_pmos ad=0.19p pd=1.38u as=0 ps=0 w=1u l=1u
X73 VDD sg13cmos5l_dlygate4sd3_1_4.X a_17165_16020# VDD sg13_lv_pmos ad=0.3822p pd=1.84u as=0.1575p ps=1.315u w=1u l=0.13u
X74 VSS.t1952 VDD VSS.t1951 VSS.t1950 sg13_lv_nmos ad=0.1428p pd=1.52u as=0 ps=0 w=0.42u l=1u
X75 VSS.t3040 VDD VSS.t3039 VSS.t3038 sg13_lv_nmos ad=0.1428p pd=1.52u as=0 ps=0 w=0.42u l=1u
X76 VSS.t292 VDD VSS.t292 VSS.t294 sg13_lv_nmos ad=0.1428p pd=1.52u as=0 ps=0 w=0.42u l=1u
X77 VDD VSS.t2253 VDD VDD sg13_lv_pmos ad=0.34p pd=2.68u as=0 ps=0 w=1u l=1u
X78 VDD VSS.t808 VDD VDD sg13_lv_pmos ad=0.19p pd=1.38u as=0 ps=0 w=1u l=1u
X79 VDD VSS.t1517 VDD VDD sg13_lv_pmos ad=0.19p pd=1.38u as=0 ps=0 w=1u l=1u
X80 VDD VSS.t2426 VDD VDD sg13_lv_pmos ad=0.19p pd=1.38u as=0 ps=0 w=1u l=1u
X81 VSS.t2484 VDD VSS.t2486 VSS.t2485 sg13_lv_nmos ad=79.8f pd=0.8u as=0 ps=0 w=0.42u l=1u
X82 VSS.t417 VDD VSS.t418 VSS.t15 sg13_lv_nmos ad=79.8f pd=0.8u as=0 ps=0 w=0.42u l=1u
X83 VDD VSS.t32 VDD VDD sg13_lv_pmos ad=0.34p pd=2.68u as=0 ps=0 w=1u l=1u
X84 VDD VSS.t518 VDD VDD sg13_lv_pmos ad=0.34p pd=2.68u as=0 ps=0 w=1u l=1u
X85 VSS.t991 VDD VSS.t990 VSS.t989 sg13_lv_nmos ad=0.1428p pd=1.52u as=0 ps=0 w=0.42u l=1u
X86 VSS.t1862 VDD VSS.t1861 VSS.t1860 sg13_lv_nmos ad=0.1428p pd=1.52u as=0 ps=0 w=0.42u l=1u
X87 VDD VSS.t564 VDD VDD sg13_lv_pmos ad=0.34p pd=2.68u as=0 ps=0 w=1u l=1u
X88 VSS.t1650 VDD VSS.t1652 VSS.t1651 sg13_lv_nmos ad=79.8f pd=0.8u as=0 ps=0 w=0.42u l=1u
X89 VSS.t2032 VDD VSS.t2034 VSS.t2033 sg13_lv_nmos ad=79.8f pd=0.8u as=0 ps=0 w=0.42u l=1u
X90 VSS.t1200 VDD VSS.t1201 VSS.t70 sg13_lv_nmos ad=79.8f pd=0.8u as=0 ps=0 w=0.42u l=1u
X91 VDD VSS.t1961 VDD VDD sg13_lv_pmos ad=0.34p pd=2.68u as=0 ps=0 w=1u l=1u
X92 VSS.t30 a_26633_16334# a_26554_16237# VSS.t138 sg13_lv_nmos ad=7.70437p pd=50.66u as=0.27427p ps=2.28u w=0.795u l=0.13u
X93 VDD VSS.t1319 VDD VDD sg13_lv_pmos ad=0.19p pd=1.38u as=0 ps=0 w=1u l=1u
X94 sg13cmos5l_dfrbpq_1_2.D sg13cmos5l_a21oi_1_3.B1 VSS.t47 VSS.t107 sg13_lv_nmos ad=0.1406p pd=1.12u as=0.2516p ps=2.16u w=0.74u l=0.13u
X95 a_2516_14484# a_2490_14447# sg13cmos5l_xor2_1_0.X VDD sg13_lv_pmos ad=0.2128p pd=1.5u as=0.3808p ps=2.92u w=1.12u l=0.13u
X96 VSS.t2685 VDD VSS.t2684 VSS.t61 sg13_lv_nmos ad=0.1428p pd=1.52u as=0 ps=0 w=0.42u l=1u
X97 VDD VSS.t448 VDD VDD sg13_lv_pmos ad=0.19p pd=1.38u as=0 ps=0 w=1u l=1u
X98 VSS.t911 VDD VSS.t913 VSS.t912 sg13_lv_nmos ad=79.8f pd=0.8u as=0 ps=0 w=0.42u l=1u
X99 VDD VSS.t900 VDD VDD sg13_lv_pmos ad=0.34p pd=2.68u as=0 ps=0 w=1u l=1u
X100 VDD VSS.t1729 VDD VDD sg13_lv_pmos ad=0.34p pd=2.68u as=0 ps=0 w=1u l=1u
X101 VDD VSS.t337 VDD VDD sg13_lv_pmos ad=0.19p pd=1.38u as=0 ps=0 w=1u l=1u
X102 VSS.t1580 VDD VSS.t1582 VSS.t1581 sg13_lv_nmos ad=79.8f pd=0.8u as=0 ps=0 w=0.42u l=1u
X103 VSS.t3105 VDD VSS.t3107 VSS.t3106 sg13_lv_nmos ad=79.8f pd=0.8u as=0 ps=0 w=0.42u l=1u
X104 VDD VSS.t587 VDD VDD sg13_lv_pmos ad=0.34p pd=2.68u as=0 ps=0 w=1u l=1u
X105 VSS.t621 VDD VSS.t618 VSS.t620 sg13_lv_nmos ad=0.1428p pd=1.52u as=0 ps=0 w=0.42u l=1u
X106 VDD VSS.t1025 VDD VDD sg13_lv_pmos ad=0.34p pd=2.68u as=0 ps=0 w=1u l=1u
X107 VDD a_3130_16237# sg13cmos5l_dfrbpq_1_0.RESET_B VDD sg13_lv_pmos ad=2.8961p pd=18.25u as=0.3927p ps=2.99u w=1.155u l=0.13u
X108 VSS.t633 VDD VSS.t633 VSS.t762 sg13_lv_nmos ad=0.1428p pd=1.52u as=0 ps=0 w=0.42u l=1u
X109 VSS.t2354 VDD VSS.t2356 VSS.t2355 sg13_lv_nmos ad=79.8f pd=0.8u as=0 ps=0 w=0.42u l=1u
X110 VDD VSS.t2418 VDD VDD sg13_lv_pmos ad=0.34p pd=2.68u as=0 ps=0 w=1u l=1u
X111 VSS.t786 VDD VSS.t788 VSS.t787 sg13_lv_nmos ad=79.8f pd=0.8u as=0 ps=0 w=0.42u l=1u
X112 VDD VSS.t775 VDD VDD sg13_lv_pmos ad=0.34p pd=2.68u as=0 ps=0 w=1u l=1u
X113 VDD VSS.t963 VDD VDD sg13_lv_pmos ad=0.19p pd=1.38u as=0 ps=0 w=1u l=1u
X114 VDD VSS.t2076 VDD VDD sg13_lv_pmos ad=0.34p pd=2.68u as=0 ps=0 w=1u l=1u
X115 VSS.t545 VDD VSS.t547 VSS.t546 sg13_lv_nmos ad=79.8f pd=0.8u as=0 ps=0 w=0.42u l=1u
X116 VDD VSS.t381 VDD VDD sg13_lv_pmos ad=0.34p pd=2.68u as=0 ps=0 w=1u l=1u
X117 VDD sg13cmos5l_dlygate4sd3_1_0.X a_5613_14832# VDD sg13_lv_pmos ad=0.1918p pd=1.5u as=0.1596p ps=1.22u w=0.84u l=0.13u
X118 VDD VSS.t532 VDD VDD sg13_lv_pmos ad=0.19p pd=1.38u as=0 ps=0 w=1u l=1u
X119 VDD VSS.t1241 VDD VDD sg13_lv_pmos ad=0.19p pd=1.38u as=0 ps=0 w=1u l=1u
X120 VDD VSS.t2746 VDD VDD sg13_lv_pmos ad=0.19p pd=1.38u as=0 ps=0 w=1u l=1u
X121 VSS.t2439 VDD VSS.t2438 VSS.t2437 sg13_lv_nmos ad=0.1428p pd=1.52u as=0 ps=0 w=0.42u l=1u
X122 VSS.t2052 VDD VSS.t2054 VSS.t2053 sg13_lv_nmos ad=79.8f pd=0.8u as=0 ps=0 w=0.42u l=1u
X123 sg13cmos5l_a21oi_1_0.A2 a_16969_16020# VSS.t128 VSS.t3246 sg13_lv_nmos ad=0.2516p pd=2.16u as=0.13395p ps=1.12u w=0.74u l=0.13u
X124 VSS.t881 VDD VSS.t880 VSS.t879 sg13_lv_nmos ad=0.1428p pd=1.52u as=0 ps=0 w=0.42u l=1u
X125 VSS.t1175 VDD VSS.t1176 VSS.t70 sg13_lv_nmos ad=79.8f pd=0.8u as=0 ps=0 w=0.42u l=1u
X126 VDD VSS.t2119 VDD VDD sg13_lv_pmos ad=0.19p pd=1.38u as=0 ps=0 w=1u l=1u
X127 VSS.t435 VDD VSS.t436 VSS.t15 sg13_lv_nmos ad=79.8f pd=0.8u as=0 ps=0 w=0.42u l=1u
X128 VDD VSS.t428 VDD VDD sg13_lv_pmos ad=0.34p pd=2.68u as=0 ps=0 w=1u l=1u
X129 VSS.t2676 VDD VSS.t2676 VSS.t61 sg13_lv_nmos ad=0.1428p pd=1.52u as=0 ps=0 w=0.42u l=1u
X130 VDD VSS.t273 VDD VDD sg13_lv_pmos ad=0.19p pd=1.38u as=0 ps=0 w=1u l=1u
X131 VSS.t926 VDD VSS.t925 VSS.t924 sg13_lv_nmos ad=0.1428p pd=1.52u as=0 ps=0 w=0.42u l=1u
X132 VSS.t2504 VDD VSS.t2506 VSS.t2505 sg13_lv_nmos ad=79.8f pd=0.8u as=0 ps=0 w=0.42u l=1u
X133 a_27407_13799# a_26565_13701# a_26148_14040# VDD sg13_lv_pmos ad=0.2048p pd=1.63u as=0.34p ps=2.68u w=1u l=0.13u
X134 VDD VSS.t3004 VDD VDD sg13_lv_pmos ad=0.34p pd=2.68u as=0 ps=0 w=1u l=1u
X135 VDD VSS.t1906 VDD VDD sg13_lv_pmos ad=0.34p pd=2.68u as=0 ps=0 w=1u l=1u
X136 VSS.t60 a_22319_14845# a_22986_14484# VSS.t56 sg13_lv_nmos ad=0.1406p pd=1.12u as=0.2516p ps=2.16u w=0.74u l=0.13u
X137 VDD VSS.t1537 VDD VDD sg13_lv_pmos ad=0.19p pd=1.38u as=0 ps=0 w=1u l=1u
X138 VDD VSS.t1714 VDD VDD sg13_lv_pmos ad=0.34p pd=2.68u as=0 ps=0 w=1u l=1u
X139 VSS.t2002 VDD VSS.t2004 VSS.t2003 sg13_lv_nmos ad=79.8f pd=0.8u as=0 ps=0 w=0.42u l=1u
X140 VDD VSS.t282 VDD VDD sg13_lv_pmos ad=0.19p pd=1.38u as=0 ps=0 w=1u l=1u
X141 VDD VSS.t1577 VDD VDD sg13_lv_pmos ad=0.19p pd=1.38u as=0 ps=0 w=1u l=1u
X142 VSS.t2653 VDD VSS.t2653 VSS.t61 sg13_lv_nmos ad=0.1428p pd=1.52u as=0 ps=0 w=0.42u l=1u
X143 VSS.t535 VDD VSS.t534 VSS.t533 sg13_lv_nmos ad=0.1428p pd=1.52u as=0 ps=0 w=0.42u l=1u
X144 VDD VSS.t1225 VDD VDD sg13_lv_pmos ad=0.34p pd=2.68u as=0 ps=0 w=1u l=1u
X145 VDD VSS.t2705 VDD VDD sg13_lv_pmos ad=0.19p pd=1.38u as=0 ps=0 w=1u l=1u
X146 VDD VSS.t930 VDD VDD sg13_lv_pmos ad=0.34p pd=2.68u as=0 ps=0 w=1u l=1u
X147 a_17892_14909# a_17604_14488# a_17830_14909# VSS.t260 sg13_lv_nmos ad=0.1428p pd=1.52u as=37.8f ps=0.6u w=0.42u l=0.13u
X148 VDD VSS.t518 VDD VDD sg13_lv_pmos ad=0.34p pd=2.68u as=0 ps=0 w=1u l=1u
X149 VSS.t1262 VDD VSS.t1263 VSS.t70 sg13_lv_nmos ad=79.8f pd=0.8u as=0 ps=0 w=0.42u l=1u
X150 VDD VSS.t2238 VDD VDD sg13_lv_pmos ad=0.34p pd=2.68u as=0 ps=0 w=1u l=1u
X151 VSS.t2299 VDD VSS.t2301 VSS.t2300 sg13_lv_nmos ad=79.8f pd=0.8u as=0 ps=0 w=0.42u l=1u
X152 VSS.t1847 VDD VSS.t1846 VSS.t1845 sg13_lv_nmos ad=0.1428p pd=1.52u as=0 ps=0 w=0.42u l=1u
X153 a_16425_14113# a_16068_14040# VDD VDD sg13_lv_pmos ad=63f pd=0.72u as=0.1563p ps=1.22u w=0.42u l=0.13u
X154 VSS.t2652 VDD VSS.t2651 VSS.t61 sg13_lv_nmos ad=0.1428p pd=1.52u as=0 ps=0 w=0.42u l=1u
X155 VSS.t1400 VDD VSS.t1267 VSS.t70 sg13_lv_nmos ad=79.8f pd=0.8u as=0 ps=0 w=0.42u l=1u
X156 VSS.t2752 VDD VSS.t2753 VSS.t61 sg13_lv_nmos ad=79.8f pd=0.8u as=0 ps=0 w=0.42u l=1u
X157 VDD a_17584_13942# a_17529_14037# VDD sg13_lv_pmos ad=2.42015p pd=15.68u as=93.45f ps=0.865u w=0.42u l=0.13u
X158 VSS.t1590 VDD VSS.t1589 VSS.t1588 sg13_lv_nmos ad=0.1428p pd=1.52u as=0 ps=0 w=0.42u l=1u
X159 VDD VSS.t3072 VDD VDD sg13_lv_pmos ad=0.19p pd=1.38u as=0 ps=0 w=1u l=1u
X160 VSS.t2339 VDD VSS.t2341 VSS.t2340 sg13_lv_nmos ad=79.8f pd=0.8u as=0 ps=0 w=0.42u l=1u
X161 VDD VSS.t2281 VDD VDD sg13_lv_pmos ad=0.19p pd=1.38u as=0 ps=0 w=1u l=1u
X162 VDD VSS.t945 VDD VDD sg13_lv_pmos ad=0.34p pd=2.68u as=0 ps=0 w=1u l=1u
X163 VDD VSS.t1248 VDD VDD sg13_lv_pmos ad=0.34p pd=2.68u as=0 ps=0 w=1u l=1u
X164 VDD VSS.t2753 VDD VDD sg13_lv_pmos ad=0.34p pd=2.68u as=0 ps=0 w=1u l=1u
X165 VSS.t1565 VDD VSS.t1567 VSS.t1566 sg13_lv_nmos ad=79.8f pd=0.8u as=0 ps=0 w=0.42u l=1u
X166 VDD VSS.t1204 VDD VDD sg13_lv_pmos ad=0.19p pd=1.38u as=0 ps=0 w=1u l=1u
X167 a_9252_15234# sg13cmos5l_and2_1_2.X a_9158_15234# VSS.t205 sg13_lv_nmos ad=60.89999f pd=0.71u as=0.1428p ps=1.52u w=0.42u l=0.13u
X168 a_17806_15423# a_17921_15424# VDD VDD sg13_lv_pmos ad=0.34p pd=2.68u as=0.2254p ps=1.53u w=1u l=0.5u
X169 VSS.t1957 VDD VSS.t1956 VSS.t1955 sg13_lv_nmos ad=0.1428p pd=1.52u as=0 ps=0 w=0.42u l=1u
X170 VSS.t456 VDD VSS.t455 VSS.t15 sg13_lv_nmos ad=0.1428p pd=1.52u as=0 ps=0 w=0.42u l=1u
X171 VSS.t216 VDD VSS.t216 VSS.t713 sg13_lv_nmos ad=79.8f pd=0.8u as=0 ps=0 w=0.42u l=1u
X172 VDD VSS.t1008 VDD VDD sg13_lv_pmos ad=0.19p pd=1.38u as=0 ps=0 w=1u l=1u
X173 VSS.t1408 VDD VSS.t1276 VSS.t70 sg13_lv_nmos ad=79.8f pd=0.8u as=0 ps=0 w=0.42u l=1u
X174 VDD VSS.t1584 VDD VDD sg13_lv_pmos ad=0.34p pd=2.68u as=0 ps=0 w=1u l=1u
X175 VDD VSS.t2431 VDD VDD sg13_lv_pmos ad=0.19p pd=1.38u as=0 ps=0 w=1u l=1u
X176 VSS.t2489 VDD VSS.t2491 VSS.t2490 sg13_lv_nmos ad=79.8f pd=0.8u as=0 ps=0 w=0.42u l=1u
X177 VDD VSS.t624 VDD VDD sg13_lv_pmos ad=0.19p pd=1.38u as=0 ps=0 w=1u l=1u
X178 VSS.t1655 VDD VSS.t1657 VSS.t1656 sg13_lv_nmos ad=79.8f pd=0.8u as=0 ps=0 w=0.42u l=1u
X179 VSS.t2037 VDD VSS.t2039 VSS.t2038 sg13_lv_nmos ad=79.8f pd=0.8u as=0 ps=0 w=0.42u l=1u
X180 VSS.t1041 VDD VSS.t1043 VSS.t1042 sg13_lv_nmos ad=79.8f pd=0.8u as=0 ps=0 w=0.42u l=1u
X181 VDD VSS.t303 VDD VDD sg13_lv_pmos ad=0.19p pd=1.38u as=0 ps=0 w=1u l=1u
X182 VSS.t926 VDD VSS.t925 VSS.t924 sg13_lv_nmos ad=0.1428p pd=1.52u as=0 ps=0 w=0.42u l=1u
X183 VDD VSS.t1931 VDD VDD sg13_lv_pmos ad=0.34p pd=2.68u as=0 ps=0 w=1u l=1u
X184 VDD VSS.t908 VDD VDD sg13_lv_pmos ad=0.19p pd=1.38u as=0 ps=0 w=1u l=1u
X185 VDD VSS.t3057 VDD VDD sg13_lv_pmos ad=0.19p pd=1.38u as=0 ps=0 w=1u l=1u
X186 VDD VSS.t2266 VDD VDD sg13_lv_pmos ad=0.19p pd=1.38u as=0 ps=0 w=1u l=1u
X187 VDD VSS.t2104 VDD VDD sg13_lv_pmos ad=0.19p pd=1.38u as=0 ps=0 w=1u l=1u
X188 VSS.t265 a_4078_14751# sg13cmos5l_xor2_1_0.B VSS.t264 sg13_lv_nmos ad=0.1426p pd=1.16u as=0.2516p ps=2.16u w=0.74u l=0.13u
X189 VSS.t2669 VDD VSS.t2668 VSS.t61 sg13_lv_nmos ad=0.1428p pd=1.52u as=0 ps=0 w=0.42u l=1u
X190 a_12010_15202# sg13cmos5l_buf_8_2.A VDD VDD sg13_lv_pmos ad=0.2128p pd=1.5u as=0.2128p ps=1.5u w=1.12u l=0.13u
X191 VDD sg13cmos5l_buf_8_2.A a_19323_13726# VDD sg13_lv_pmos ad=0.2128p pd=1.5u as=0.3808p ps=2.92u w=1.12u l=0.13u
X192 VDD VSS.t2056 VDD VDD sg13_lv_pmos ad=0.34p pd=2.68u as=0 ps=0 w=1u l=1u
X193 VDD VSS.t1184 VDD VDD sg13_lv_pmos ad=0.34p pd=2.68u as=0 ps=0 w=1u l=1u
X194 VDD VSS.t1891 VDD VDD sg13_lv_pmos ad=0.34p pd=2.68u as=0 ps=0 w=1u l=1u
X195 VDD VSS.t419 VDD VDD sg13_lv_pmos ad=0.34p pd=2.68u as=0 ps=0 w=1u l=1u
X196 VDD VSS.t1699 VDD VDD sg13_lv_pmos ad=0.34p pd=2.68u as=0 ps=0 w=1u l=1u
X197 VSS.t2284 VDD VSS.t2286 VSS.t2285 sg13_lv_nmos ad=79.8f pd=0.8u as=0 ps=0 w=0.42u l=1u
X198 VSS.t1987 VDD VSS.t1989 VSS.t1988 sg13_lv_nmos ad=79.8f pd=0.8u as=0 ps=0 w=0.42u l=1u
X199 VSS.t450 VDD VSS.t449 VSS.t15 sg13_lv_nmos ad=0.1428p pd=1.52u as=0 ps=0 w=0.42u l=1u
X200 VDD VSS.t518 VDD VDD sg13_lv_pmos ad=0.19p pd=1.38u as=0 ps=0 w=1u l=1u
X201 VSS.t1550 VDD VSS.t1552 VSS.t1551 sg13_lv_nmos ad=79.8f pd=0.8u as=0 ps=0 w=0.42u l=1u
X202 VSS.t3075 VDD VSS.t3077 VSS.t3076 sg13_lv_nmos ad=79.8f pd=0.8u as=0 ps=0 w=0.42u l=1u
X203 VDD VSS.t1252 VDD VDD sg13_lv_pmos ad=0.34p pd=2.68u as=0 ps=0 w=1u l=1u
X204 VSS.t1244 VDD VSS.t1245 VSS.t70 sg13_lv_nmos ad=79.8f pd=0.8u as=0 ps=0 w=0.42u l=1u
X205 VDD VSS.t1562 VDD VDD sg13_lv_pmos ad=0.19p pd=1.38u as=0 ps=0 w=1u l=1u
X206 a_10905_15549# a_9963_15356# a_10703_15311# VDD sg13_lv_pmos ad=93.45f pd=0.865u as=0.2048p ps=1.63u w=0.42u l=0.13u
X207 VDD sg13cmos5l_xnor2_1_2.A a_6714_12972# VDD sg13_lv_pmos ad=0.2891p pd=1.695u as=0.1428p ps=1.375u w=1.12u l=0.13u
X208 VDD VSS.t783 VDD VDD sg13_lv_pmos ad=0.19p pd=1.38u as=0 ps=0 w=1u l=1u
X209 VSS.t2359 VDD VSS.t2361 VSS.t2360 sg13_lv_nmos ad=79.8f pd=0.8u as=0 ps=0 w=0.42u l=1u
X210 VDD VSS.t2423 VDD VDD sg13_lv_pmos ad=0.34p pd=2.68u as=0 ps=0 w=1u l=1u
X211 VSS.t187 a_12010_15202# sg13cmos5l_dfrbpq_1_2.CLK VSS.t189 sg13_lv_nmos ad=0.1406p pd=1.12u as=0.1406p ps=1.12u w=0.74u l=0.13u
X212 a_22426_15202# sg13cmos5l_dfrbpq_1_6.Q VSS.t67 VSS.t65 sg13_lv_nmos ad=0.1428p pd=1.52u as=79.8f ps=0.8u w=0.42u l=0.13u
X213 sg13cmos5l_a21oi_1_0.Y sg13cmos5l_a21oi_1_3.B1 VSS.t64 VSS.t105 sg13_lv_nmos ad=0.1406p pd=1.12u as=0.2516p ps=2.16u w=0.74u l=0.13u
X214 VDD VSS.t2632 VDD VDD sg13_lv_pmos ad=0.34p pd=2.68u as=0 ps=0 w=1u l=1u
X215 VDD sg13cmos5l_o21ai_1_2.B1 sg13cmos5l_or3_1_1.C VDD sg13_lv_pmos ad=0.3808p pd=2.92u as=0.2128p ps=1.5u w=1.12u l=0.13u
X216 a_19120_14726# sg13cmos5l_dfrbpq_1_3.RESET_B VDD VDD sg13_lv_pmos ad=79.8f pd=0.8u as=2.42015p ps=15.68u w=0.42u l=0.13u
X217 a_23480_15242# sg13cmos5l_dfrbpq_1_3.Q a_23378_15242# VSS.t65 sg13_lv_nmos ad=0.1406p pd=1.12u as=0.1406p ps=1.12u w=0.74u l=0.13u
X218 VDD VSS.t1193 VDD VDD sg13_lv_pmos ad=0.34p pd=2.68u as=0 ps=0 w=1u l=1u
X219 VSS.t1293 VDD VSS.t1294 VSS.t70 sg13_lv_nmos ad=79.8f pd=0.8u as=0 ps=0 w=0.42u l=1u
X220 VSS.t2644 VDD VSS.t2643 VSS.t61 sg13_lv_nmos ad=0.1428p pd=1.52u as=0 ps=0 w=0.42u l=1u
X221 VSS.t316 VDD VSS.t315 VSS.t314 sg13_lv_nmos ad=0.1428p pd=1.52u as=0 ps=0 w=0.42u l=1u
X222 VDD a_21562_15960# a_21281_16262# VDD sg13_lv_pmos ad=0.1523p pd=1.38u as=0.34p ps=2.68u w=1u l=0.5u
X223 VDD sg13cmos5l_o21ai_1_2.Y a_24824_15238# VDD sg13_lv_pmos ad=0.1523p pd=1.38u as=0.1428p ps=1.52u w=0.42u l=0.13u
X224 VDD a_18863_14845# a_19530_14484# VDD sg13_lv_pmos ad=0.2128p pd=1.5u as=0.3864p ps=2.93u w=1.12u l=0.13u
X225 VDD VSS.t853 VDD VDD sg13_lv_pmos ad=0.19p pd=1.38u as=0 ps=0 w=1u l=1u
X226 VDD VSS.t1279 VDD VDD sg13_lv_pmos ad=0.19p pd=1.38u as=0 ps=0 w=1u l=1u
X227 VDD VSS.t2784 VDD VDD sg13_lv_pmos ad=0.19p pd=1.38u as=0 ps=0 w=1u l=1u
X228 VDD VSS.t2089 VDD VDD sg13_lv_pmos ad=0.19p pd=1.38u as=0 ps=0 w=1u l=1u
X229 a_20603_15532# sg13cmos5l_a21oi_1_3.B1 sg13cmos5l_a21oi_1_1.Y VDD sg13_lv_pmos ad=0.2128p pd=1.5u as=0.3808p ps=2.92u w=1.12u l=0.13u
X230 VSS.t2679 VDD VSS.t2678 VSS.t61 sg13_lv_nmos ad=0.1428p pd=1.52u as=0 ps=0 w=0.42u l=1u
X231 VSS.t2504 VDD VSS.t2503 VSS.t2502 sg13_lv_nmos ad=0.1428p pd=1.52u as=0 ps=0 w=0.42u l=1u
X232 VSS.t2324 VDD VSS.t2326 VSS.t2325 sg13_lv_nmos ad=79.8f pd=0.8u as=0 ps=0 w=0.42u l=1u
X233 VDD VSS.t3009 VDD VDD sg13_lv_pmos ad=0.34p pd=2.68u as=0 ps=0 w=1u l=1u
X234 VSS.t2755 VDD VSS.t2754 VSS.t61 sg13_lv_nmos ad=0.1428p pd=1.52u as=0 ps=0 w=0.42u l=1u
X235 sg13cmos5l_dfrbpq_1_2.CLK a_12010_15202# VDD VDD sg13_lv_pmos ad=0.2128p pd=1.5u as=0.2128p ps=1.5u w=1.12u l=0.13u
X236 VDD VSS.t1876 VDD VDD sg13_lv_pmos ad=0.34p pd=2.68u as=0 ps=0 w=1u l=1u
X237 VSS.t417 VDD VSS.t416 VSS.t15 sg13_lv_nmos ad=0.1428p pd=1.52u as=0 ps=0 w=0.42u l=1u
X238 VDD VSS.t938 VDD VDD sg13_lv_pmos ad=0.19p pd=1.38u as=0 ps=0 w=1u l=1u
X239 VSS.t1730 VDD VSS.t1729 VSS.t1728 sg13_lv_nmos ad=0.1428p pd=1.52u as=0 ps=0 w=0.42u l=1u
X240 VDD VSS.t1582 VDD VDD sg13_lv_pmos ad=0.19p pd=1.38u as=0 ps=0 w=1u l=1u
X241 VDD VSS.t2456 VDD VDD sg13_lv_pmos ad=0.19p pd=1.38u as=0 ps=0 w=1u l=1u
X242 VSS.t3030 VDD VSS.t3029 VSS.t3028 sg13_lv_nmos ad=0.1428p pd=1.52u as=0 ps=0 w=0.42u l=1u
X243 VDD a_15579_14854# sg13cmos5l_buf_8_2.A VDD sg13_lv_pmos ad=0.3864p pd=2.93u as=0.2128p ps=1.5u w=1.12u l=0.13u
X244 VDD VSS.t298 VDD VDD sg13_lv_pmos ad=0.34p pd=2.68u as=0 ps=0 w=1u l=1u
X245 VSS.t88 a_22508_15960# counter_value_o[4] VSS.t87 sg13_lv_nmos ad=0.14875p pd=1.16u as=0.2886p ps=2.26u w=0.74u l=0.13u
X246 VSS.t184 a_12010_15202# sg13cmos5l_dfrbpq_1_2.CLK VSS.t183 sg13_lv_nmos ad=0.1406p pd=1.12u as=0.1406p ps=1.12u w=0.74u l=0.13u
X247 VDD VSS.t427 VDD VDD sg13_lv_pmos ad=0.19p pd=1.38u as=0 ps=0 w=1u l=1u
X248 VDD VSS.t2743 VDD VDD sg13_lv_pmos ad=0.19p pd=1.38u as=0 ps=0 w=1u l=1u
X249 VSS.t2474 VDD VSS.t2476 VSS.t2475 sg13_lv_nmos ad=79.8f pd=0.8u as=0 ps=0 w=0.42u l=1u
X250 VSS.t1041 VDD VSS.t1043 VSS.t1042 sg13_lv_nmos ad=79.8f pd=0.8u as=0 ps=0 w=0.42u l=1u
X251 VDD VSS.t1284 VDD VDD sg13_lv_pmos ad=0.34p pd=2.68u as=0 ps=0 w=1u l=1u
X252 VDD VSS.t207 VDD VDD sg13_lv_pmos ad=0.19p pd=1.38u as=0 ps=0 w=1u l=1u
X253 VSS.t2635 VDD VSS.t2634 VSS.t61 sg13_lv_nmos ad=0.1428p pd=1.52u as=0 ps=0 w=0.42u l=1u
X254 VSS.t1235 VDD VSS.t1234 VSS.t70 sg13_lv_nmos ad=0.1428p pd=1.52u as=0 ps=0 w=0.42u l=1u
X255 VDD VSS.t2511 VDD VDD sg13_lv_pmos ad=0.19p pd=1.38u as=0 ps=0 w=1u l=1u
X256 VDD VSS.t1916 VDD VDD sg13_lv_pmos ad=0.34p pd=2.68u as=0 ps=0 w=1u l=1u
X257 VSS.t545 VDD VSS.t547 VSS.t546 sg13_lv_nmos ad=79.8f pd=0.8u as=0 ps=0 w=0.42u l=1u
X258 VSS.t901 VDD VSS.t900 VSS.t899 sg13_lv_nmos ad=0.1428p pd=1.52u as=0 ps=0 w=0.42u l=1u
X259 VSS.t2344 VDD VSS.t2346 VSS.t2345 sg13_lv_nmos ad=79.8f pd=0.8u as=0 ps=0 w=0.42u l=1u
X260 VDD VSS.t2251 VDD VDD sg13_lv_pmos ad=0.19p pd=1.38u as=0 ps=0 w=1u l=1u
X261 VDD sg13cmos5l_dlygate4sd3_1_17.A a_24824_14525# VDD sg13_lv_pmos ad=0.1523p pd=1.38u as=0.1428p ps=1.52u w=0.42u l=0.13u
X262 VSS.t1228 VDD VSS.t1229 VSS.t70 sg13_lv_nmos ad=79.8f pd=0.8u as=0 ps=0 w=0.42u l=1u
X263 VSS.t2117 VDD VSS.t2119 VSS.t2118 sg13_lv_nmos ad=79.8f pd=0.8u as=0 ps=0 w=0.42u l=1u
X264 VDD VSS.t2041 VDD VDD sg13_lv_pmos ad=0.34p pd=2.68u as=0 ps=0 w=1u l=1u
X265 VDD VSS.t518 VDD VDD sg13_lv_pmos ad=0.19p pd=1.38u as=0 ps=0 w=1u l=1u
X266 VDD VSS.t1322 VDD VDD sg13_lv_pmos ad=0.19p pd=1.38u as=0 ps=0 w=1u l=1u
X267 VDD a_19450_15202# a_19169_15424# VDD sg13_lv_pmos ad=0.1523p pd=1.38u as=0.34p ps=2.68u w=1u l=0.5u
X268 a_26373_14495# sg13cmos5l_buf_8_2.X VSS.t15 VSS.t195 sg13_lv_nmos ad=0.2516p pd=2.16u as=3.8707p ps=25.555u w=0.74u l=0.13u
X269 VSS.t1715 VDD VSS.t1714 VSS.t1713 sg13_lv_nmos ad=0.1428p pd=1.52u as=0 ps=0 w=0.42u l=1u
X270 a_26170_15202# sg13cmos5l_a21oi_1_3.Y VSS.t41 VSS.t40 sg13_lv_nmos ad=0.1428p pd=1.52u as=79.8f ps=0.8u w=0.42u l=0.13u
X271 VDD VSS.t1724 VDD VDD sg13_lv_pmos ad=0.34p pd=2.68u as=0 ps=0 w=1u l=1u
X272 VDD VSS.t292 VDD VDD sg13_lv_pmos ad=0.34p pd=2.68u as=0 ps=0 w=1u l=1u
X273 VSS.t776 VDD VSS.t775 VSS.t774 sg13_lv_nmos ad=0.1428p pd=1.52u as=0 ps=0 w=0.42u l=1u
X274 VSS.t961 VDD VSS.t963 VSS.t962 sg13_lv_nmos ad=79.8f pd=0.8u as=0 ps=0 w=0.42u l=1u
X275 VSS.t174 sg13cmos5l_or3_1_2.B a_24310_15230# VSS.t65 sg13_lv_nmos ad=0.1406p pd=1.12u as=0.2516p ps=2.16u w=0.74u l=0.15u
X276 VDD VSS.t2408 VDD VDD sg13_lv_pmos ad=0.34p pd=2.68u as=0 ps=0 w=1u l=1u
X277 a_16042_13945# a_16485_13701# a_15782_13722# VSS.t228 sg13_lv_nmos ad=79.8f pd=0.8u as=0.1296p ps=1.52u w=0.42u l=0.13u
X278 VDD VSS.t1554 VDD VDD sg13_lv_pmos ad=0.34p pd=2.68u as=0 ps=0 w=1u l=1u
X279 VSS.t2459 VDD VSS.t2461 VSS.t2460 sg13_lv_nmos ad=79.8f pd=0.8u as=0 ps=0 w=0.42u l=1u
X280 VSS.t435 VDD VSS.t434 VSS.t15 sg13_lv_nmos ad=0.1428p pd=1.52u as=0 ps=0 w=0.42u l=1u
X281 VDD VSS.t585 VDD VDD sg13_lv_pmos ad=0.34p pd=2.68u as=0 ps=0 w=1u l=1u
X282 VSS.t1625 VDD VSS.t1627 VSS.t1626 sg13_lv_nmos ad=79.8f pd=0.8u as=0 ps=0 w=0.42u l=1u
X283 VSS.t340 VDD VSS.t342 VSS.t341 sg13_lv_nmos ad=79.8f pd=0.8u as=0 ps=0 w=0.42u l=1u
X284 VDD VSS.t383 VDD VDD sg13_lv_pmos ad=0.19p pd=1.38u as=0 ps=0 w=1u l=1u
X285 VDD VSS.t1168 VDD VDD sg13_lv_pmos ad=0.34p pd=2.68u as=0 ps=0 w=1u l=1u
X286 VDD VSS.t1936 VDD VDD sg13_lv_pmos ad=0.34p pd=2.68u as=0 ps=0 w=1u l=1u
X287 a_17710_16263# a_17825_16262# VDD VDD sg13_lv_pmos ad=0.34p pd=2.68u as=0.2254p ps=1.53u w=1u l=0.5u
X288 a_19120_14726# a_18863_14845# a_19282_14922# VSS.t16 sg13_lv_nmos ad=0.1428p pd=1.52u as=37.8f ps=0.6u w=0.42u l=0.13u
X289 VSS.t1211 VDD VSS.t1210 VSS.t70 sg13_lv_nmos ad=0.1428p pd=1.52u as=0 ps=0 w=0.42u l=1u
X290 VDD VSS.t1270 VDD VDD sg13_lv_pmos ad=0.19p pd=1.38u as=0 ps=0 w=1u l=1u
X291 VDD VSS.t2776 VDD VDD sg13_lv_pmos ad=0.19p pd=1.38u as=0 ps=0 w=1u l=1u
X292 VSS.t204 a_18863_14845# a_19530_14484# VSS.t16 sg13_lv_nmos ad=0.1406p pd=1.12u as=0.2516p ps=2.16u w=0.74u l=0.13u
X293 VDD VSS.t1302 VDD VDD sg13_lv_pmos ad=0.34p pd=2.68u as=0 ps=0 w=1u l=1u
X294 VSS.t2671 VDD VSS.t2671 VSS.t61 sg13_lv_nmos ad=0.1428p pd=1.52u as=0 ps=0 w=0.42u l=1u
X295 VSS.t2489 VDD VSS.t2488 VSS.t2487 sg13_lv_nmos ad=0.1428p pd=1.52u as=0 ps=0 w=0.42u l=1u
X296 VSS.t2102 VDD VSS.t2104 VSS.t2103 sg13_lv_nmos ad=79.8f pd=0.8u as=0 ps=0 w=0.42u l=1u
X297 VDD VSS.t15 VDD VDD sg13_lv_pmos ad=0.34p pd=2.68u as=0 ps=0 w=1u l=1u
X298 VSS.t633 VDD VSS.t630 VSS.t632 sg13_lv_nmos ad=0.1428p pd=1.52u as=0 ps=0 w=0.42u l=1u
X299 VDD VSS.t1045 VDD VDD sg13_lv_pmos ad=0.34p pd=2.68u as=0 ps=0 w=1u l=1u
X300 VSS.t1253 VDD VSS.t1252 VSS.t70 sg13_lv_nmos ad=0.1428p pd=1.52u as=0 ps=0 w=0.42u l=1u
X301 VSS.t2289 VDD VSS.t2291 VSS.t2290 sg13_lv_nmos ad=79.8f pd=0.8u as=0 ps=0 w=0.42u l=1u
X302 VSS.t1992 VDD VSS.t1994 VSS.t1993 sg13_lv_nmos ad=79.8f pd=0.8u as=0 ps=0 w=0.42u l=1u
X303 VSS.t383 VDD VSS.t383 VSS.t385 sg13_lv_nmos ad=0.1428p pd=1.52u as=0 ps=0 w=0.42u l=1u
X304 VSS.t444 VDD VSS.t443 VSS.t15 sg13_lv_nmos ad=0.1428p pd=1.52u as=0 ps=0 w=0.42u l=1u
X305 VSS.t3080 VDD VSS.t3082 VSS.t3081 sg13_lv_nmos ad=79.8f pd=0.8u as=0 ps=0 w=0.42u l=1u
X306 VSS.t931 VDD VSS.t930 VSS.t929 sg13_lv_nmos ad=0.1428p pd=1.52u as=0 ps=0 w=0.42u l=1u
X307 VDD VSS.t1567 VDD VDD sg13_lv_pmos ad=0.19p pd=1.38u as=0 ps=0 w=1u l=1u
X308 VDD VSS.t983 VDD VDD sg13_lv_pmos ad=0.19p pd=1.38u as=0 ps=0 w=1u l=1u
X309 VDD VSS.t1622 VDD VDD sg13_lv_pmos ad=0.19p pd=1.38u as=0 ps=0 w=1u l=1u
X310 VSS.t411 VDD VSS.t32 VSS.t15 sg13_lv_nmos ad=0.1428p pd=1.52u as=0 ps=0 w=0.42u l=1u
X311 VSS.t2364 VDD VSS.t2366 VSS.t2365 sg13_lv_nmos ad=79.8f pd=0.8u as=0 ps=0 w=0.42u l=1u
X312 VDD VSS.t287 VDD VDD sg13_lv_pmos ad=0.19p pd=1.38u as=0 ps=0 w=1u l=1u
X313 a_27034_15202# sg13cmos5l_dfrbpq_1_7.Q VDD VDD sg13_lv_pmos ad=0.1428p pd=1.52u as=0.1523p ps=1.38u w=0.42u l=0.13u
X314 VSS.t2670 VDD VSS.t2669 VSS.t61 sg13_lv_nmos ad=0.1428p pd=1.52u as=0 ps=0 w=0.42u l=1u
X315 VDD VSS.t2393 VDD VDD sg13_lv_pmos ad=0.34p pd=2.68u as=0 ps=0 w=1u l=1u
X316 VDD VSS.t609 VDD VDD sg13_lv_pmos ad=0.19p pd=1.38u as=0 ps=0 w=1u l=1u
X317 VDD VSS.t222 VDD VDD sg13_lv_pmos ad=0.19p pd=1.38u as=0 ps=0 w=1u l=1u
X318 VDD VSS.t1904 VDD VDD sg13_lv_pmos ad=0.19p pd=1.38u as=0 ps=0 w=1u l=1u
X319 VDD VSS.t2735 VDD VDD sg13_lv_pmos ad=0.19p pd=1.38u as=0 ps=0 w=1u l=1u
X320 VSS.t1585 VDD VSS.t1584 VSS.t1583 sg13_lv_nmos ad=0.1428p pd=1.52u as=0 ps=0 w=0.42u l=1u
X321 VSS.t3110 VDD VSS.t3109 VSS.t3108 sg13_lv_nmos ad=0.1428p pd=1.52u as=0 ps=0 w=0.42u l=1u
X322 VDD VSS.t2311 VDD VDD sg13_lv_pmos ad=0.19p pd=1.38u as=0 ps=0 w=1u l=1u
X323 VSS.t64 a_18202_15202# a_17921_15424# VSS.t154 sg13_lv_nmos ad=79.8f pd=0.8u as=0.1428p ps=1.52u w=0.42u l=0.5u
X324 VDD VSS.t2705 VDD VDD sg13_lv_pmos ad=0.34p pd=2.68u as=0 ps=0 w=1u l=1u
X325 a_25390_16263# a_25505_16262# VDD VDD sg13_lv_pmos ad=0.34p pd=2.68u as=0.2254p ps=1.53u w=1u l=0.5u
X326 VSS.t447 VDD VSS.t448 VSS.t15 sg13_lv_nmos ad=79.8f pd=0.8u as=0 ps=0 w=0.42u l=1u
X327 VDD VSS.t440 VDD VDD sg13_lv_pmos ad=0.34p pd=2.68u as=0 ps=0 w=1u l=1u
X328 VDD VSS.t858 VDD VDD sg13_lv_pmos ad=0.19p pd=1.38u as=0 ps=0 w=1u l=1u
X329 VSS.t901 VDD VSS.t900 VSS.t899 sg13_lv_nmos ad=0.1428p pd=1.52u as=0 ps=0 w=0.42u l=1u
X330 VDD VSS.t2496 VDD VDD sg13_lv_pmos ad=0.19p pd=1.38u as=0 ps=0 w=1u l=1u
X331 VDD VSS.t1282 VDD VDD sg13_lv_pmos ad=0.19p pd=1.38u as=0 ps=0 w=1u l=1u
X332 VSS.t1580 VDD VSS.t1579 VSS.t1578 sg13_lv_nmos ad=0.1428p pd=1.52u as=0 ps=0 w=0.42u l=1u
X333 VDD VSS.t2786 VDD VDD sg13_lv_pmos ad=0.19p pd=1.38u as=0 ps=0 w=1u l=1u
X334 VDD VSS.t2094 VDD VDD sg13_lv_pmos ad=0.19p pd=1.38u as=0 ps=0 w=1u l=1u
X335 VDD VSS.t2448 VDD VDD sg13_lv_pmos ad=0.34p pd=2.68u as=0 ps=0 w=1u l=1u
X336 VSS.t2509 VDD VSS.t2508 VSS.t2507 sg13_lv_nmos ad=0.1428p pd=1.52u as=0 ps=0 w=0.42u l=1u
X337 VSS.t2329 VDD VSS.t2331 VSS.t2330 sg13_lv_nmos ad=79.8f pd=0.8u as=0 ps=0 w=0.42u l=1u
X338 VDD VSS.t3014 VDD VDD sg13_lv_pmos ad=0.34p pd=2.68u as=0 ps=0 w=1u l=1u
X339 VSS.t591 VDD VSS.t593 VSS.t592 sg13_lv_nmos ad=79.8f pd=0.8u as=0 ps=0 w=0.42u l=1u
X340 VSS.t2057 VDD VSS.t2056 VSS.t2055 sg13_lv_nmos ad=0.1428p pd=1.52u as=0 ps=0 w=0.42u l=1u
X341 VDD VSS.t1237 VDD VDD sg13_lv_pmos ad=0.34p pd=2.68u as=0 ps=0 w=1u l=1u
X342 VDD VSS.t2054 VDD VDD sg13_lv_pmos ad=0.19p pd=1.38u as=0 ps=0 w=1u l=1u
X343 VSS.t776 VDD VSS.t775 VSS.t774 sg13_lv_nmos ad=0.1428p pd=1.52u as=0 ps=0 w=0.42u l=1u
X344 VSS.t961 VDD VSS.t963 VSS.t962 sg13_lv_nmos ad=79.8f pd=0.8u as=0 ps=0 w=0.42u l=1u
X345 VDD VSS.t1552 VDD VDD sg13_lv_pmos ad=0.19p pd=1.38u as=0 ps=0 w=1u l=1u
X346 VDD VSS.t1607 VDD VDD sg13_lv_pmos ad=0.19p pd=1.38u as=0 ps=0 w=1u l=1u
X347 VDD a_8218_13690# a_7937_13912# VDD sg13_lv_pmos ad=0.1523p pd=1.38u as=0.34p ps=2.68u w=1u l=0.5u
X348 sg13cmos5l_dfrbpq_1_2.Q a_17994_14020# VDD VDD sg13_lv_pmos ad=0.3808p pd=2.92u as=0.2128p ps=1.5u w=1.12u l=0.13u
X349 VDD VSS.t172 VDD VDD sg13_lv_pmos ad=0.34p pd=2.68u as=0 ps=0 w=1u l=1u
X350 VDD VSS.t890 VDD VDD sg13_lv_pmos ad=0.34p pd=2.68u as=0 ps=0 w=1u l=1u
X351 VDD VSS.t2667 VDD VDD sg13_lv_pmos ad=0.19p pd=1.38u as=0 ps=0 w=1u l=1u
X352 VDD VSS.t2747 VDD VDD sg13_lv_pmos ad=0.19p pd=1.38u as=0 ps=0 w=1u l=1u
X353 VSS.t2007 VDD VSS.t2006 VSS.t2005 sg13_lv_nmos ad=0.1428p pd=1.52u as=0 ps=0 w=0.42u l=1u
X354 VDD VSS.t15 VDD VDD sg13_lv_pmos ad=0.34p pd=2.68u as=0 ps=0 w=1u l=1u
X355 a_23960_15242# sg13cmos5l_dfrbpq_1_3.Q a_23858_15242# VSS.t65 sg13_lv_nmos ad=0.1406p pd=1.12u as=0.1406p ps=1.12u w=0.74u l=0.13u
X356 VSS.t3095 VDD VSS.t3094 VSS.t3093 sg13_lv_nmos ad=0.1428p pd=1.52u as=0 ps=0 w=0.42u l=1u
X357 VSS.t2304 VDD VSS.t2303 VSS.t2302 sg13_lv_nmos ad=0.1428p pd=1.52u as=0 ps=0 w=0.42u l=1u
X358 VDD VSS.t328 VDD VDD sg13_lv_pmos ad=0.19p pd=1.38u as=0 ps=0 w=1u l=1u
X359 a_7680_15549# sg13cmos5l_dlygate4sd3_1_8.X VDD VDD sg13_lv_pmos ad=0.1596p pd=1.22u as=0.4536p ps=2.76u w=0.84u l=0.13u
X360 VSS.t429 VDD VSS.t428 VSS.t15 sg13_lv_nmos ad=0.1428p pd=1.52u as=0 ps=0 w=0.42u l=1u
X361 VSS.t2638 VDD VSS.t2637 VSS.t61 sg13_lv_nmos ad=0.1428p pd=1.52u as=0 ps=0 w=0.42u l=1u
X362 a_24923_15996# sg13cmos5l_or3_1_1.X VDD VDD sg13_lv_pmos ad=0.3808p pd=2.92u as=0.2128p ps=1.5u w=1.12u l=0.13u
X363 VDD sg13cmos5l_xnor2_1_0.Y a_8312_15238# VDD sg13_lv_pmos ad=0.1523p pd=1.38u as=0.1428p ps=1.52u w=0.42u l=0.13u
X364 VSS.t2737 VDD VSS.t2737 VSS.t61 sg13_lv_nmos ad=79.8f pd=0.8u as=0 ps=0 w=0.42u l=1u
X365 VDD VSS.t2481 VDD VDD sg13_lv_pmos ad=0.19p pd=1.38u as=0 ps=0 w=1u l=1u
X366 VDD VSS.t627 VDD VDD sg13_lv_pmos ad=0.19p pd=1.38u as=0 ps=0 w=1u l=1u
X367 VDD VSS.t1921 VDD VDD sg13_lv_pmos ad=0.34p pd=2.68u as=0 ps=0 w=1u l=1u
X368 VDD VSS.t2256 VDD VDD sg13_lv_pmos ad=0.19p pd=1.38u as=0 ps=0 w=1u l=1u
X369 VDD VSS.t3047 VDD VDD sg13_lv_pmos ad=0.19p pd=1.38u as=0 ps=0 w=1u l=1u
X370 VSS.t2087 VDD VSS.t2089 VSS.t2088 sg13_lv_nmos ad=79.8f pd=0.8u as=0 ps=0 w=0.42u l=1u
X371 VDD VSS.t253 VDD VDD sg13_lv_pmos ad=0.19p pd=1.38u as=0 ps=0 w=1u l=1u
X372 a_20868_14922# sg13cmos5l_dfrbpq_1_6.D a_20774_14922# VSS.t16 sg13_lv_nmos ad=60.89999f pd=0.71u as=0.1428p ps=1.52u w=0.42u l=0.13u
X373 VDD VSS.t2046 VDD VDD sg13_lv_pmos ad=0.34p pd=2.68u as=0 ps=0 w=1u l=1u
X374 VSS.t1310 VDD VSS.t1438 VSS.t70 sg13_lv_nmos ad=0.1428p pd=1.52u as=0 ps=0 w=0.42u l=1u
X375 VSS.t367 VDD VSS.t367 VSS.t370 sg13_lv_nmos ad=79.8f pd=0.8u as=0 ps=0 w=0.42u l=1u
X376 VDD VSS.t549 VDD VDD sg13_lv_pmos ad=0.34p pd=2.68u as=0 ps=0 w=1u l=1u
X377 VSS.t931 VDD VSS.t930 VSS.t929 sg13_lv_nmos ad=0.1428p pd=1.52u as=0 ps=0 w=0.42u l=1u
X378 VDD sg13cmos5l_dlygate4sd3_1_1.A sg13cmos5l_nand3_1_0.Y VDD sg13_lv_pmos ad=0.2128p pd=1.5u as=0.2128p ps=1.5u w=1.12u l=0.13u
X379 VSS.t3065 VDD VSS.t3067 VSS.t3066 sg13_lv_nmos ad=79.8f pd=0.8u as=0 ps=0 w=0.42u l=1u
X380 VSS.t2274 VDD VSS.t2276 VSS.t2275 sg13_lv_nmos ad=79.8f pd=0.8u as=0 ps=0 w=0.42u l=1u
X381 a_21562_15960# sg13cmos5l_a21oi_1_1.Y VSS.t222 VSS.t3242 sg13_lv_nmos ad=0.1428p pd=1.52u as=79.8f ps=0.8u w=0.42u l=0.13u
X382 VDD VSS.t1729 VDD VDD sg13_lv_pmos ad=0.34p pd=2.68u as=0 ps=0 w=1u l=1u
X383 VDD a_21477_14495# a_21579_14495# VDD sg13_lv_pmos ad=2.42015p pd=15.68u as=0.3864p ps=2.93u w=1.12u l=0.13u
X384 VSS.t1635 VDD VSS.t1637 VSS.t1636 sg13_lv_nmos ad=79.8f pd=0.8u as=0 ps=0 w=0.42u l=1u
X385 VSS.t2349 VDD VSS.t2351 VSS.t2350 sg13_lv_nmos ad=79.8f pd=0.8u as=0 ps=0 w=0.42u l=1u
X386 a_17830_14909# sg13cmos5l_dfrbpq_1_3.RESET_B VSS.t64 VSS.t236 sg13_lv_nmos ad=37.8f pd=0.6u as=0.1701p ps=1.65u w=0.42u l=0.13u
X387 VDD VSS.t636 VDD VDD sg13_lv_pmos ad=0.19p pd=1.38u as=0 ps=0 w=1u l=1u
X388 VDD VSS.t1559 VDD VDD sg13_lv_pmos ad=0.34p pd=2.68u as=0 ps=0 w=1u l=1u
X389 VSS.t1630 VDD VSS.t1632 VSS.t1631 sg13_lv_nmos ad=79.8f pd=0.8u as=0 ps=0 w=0.42u l=1u
X390 VDD VSS.t2697 VDD VDD sg13_lv_pmos ad=0.34p pd=2.68u as=0 ps=0 w=1u l=1u
X391 VDD VSS.t2473 VDD VDD sg13_lv_pmos ad=0.34p pd=2.68u as=0 ps=0 w=1u l=1u
X392 VSS.t851 VDD VSS.t853 VSS.t852 sg13_lv_nmos ad=79.8f pd=0.8u as=0 ps=0 w=0.42u l=1u
X393 VSS.t2749 VDD VSS.t2749 VSS.t61 sg13_lv_nmos ad=79.8f pd=0.8u as=0 ps=0 w=0.42u l=1u
X394 VDD VSS.t1171 VDD VDD sg13_lv_pmos ad=0.34p pd=2.68u as=0 ps=0 w=1u l=1u
X395 a_26565_13701# sg13cmos5l_buf_8_2.X VSS.t197 VSS.t196 sg13_lv_nmos ad=0.2516p pd=2.16u as=15.38618p ps=0.10091m w=0.74u l=0.13u
X396 VDD VSS.t1273 VDD VDD sg13_lv_pmos ad=0.19p pd=1.38u as=0 ps=0 w=1u l=1u
X397 VDD VSS.t2778 VDD VDD sg13_lv_pmos ad=0.19p pd=1.38u as=0 ps=0 w=1u l=1u
X398 VDD VSS.t2079 VDD VDD sg13_lv_pmos ad=0.19p pd=1.38u as=0 ps=0 w=1u l=1u
X399 VDD VSS.t2433 VDD VDD sg13_lv_pmos ad=0.34p pd=2.68u as=0 ps=0 w=1u l=1u
X400 VSS.t2494 VDD VSS.t2493 VSS.t2492 sg13_lv_nmos ad=0.1428p pd=1.52u as=0 ps=0 w=0.42u l=1u
X401 VDD VSS.t2749 VDD VDD sg13_lv_pmos ad=0.34p pd=2.68u as=0 ps=0 w=1u l=1u
X402 VSS.t47 a_15579_14854# sg13cmos5l_buf_8_2.A VSS.t3239 sg13_lv_nmos ad=0.1406p pd=1.12u as=0.1406p ps=1.12u w=0.74u l=0.13u
X403 VDD VSS.t528 VDD VDD sg13_lv_pmos ad=0.19p pd=1.38u as=0 ps=0 w=1u l=1u
X404 VSS.t1660 VDD VSS.t1659 VSS.t1658 sg13_lv_nmos ad=0.1428p pd=1.52u as=0 ps=0 w=0.42u l=1u
X405 VDD VSS.t2999 VDD VDD sg13_lv_pmos ad=0.34p pd=2.68u as=0 ps=0 w=1u l=1u
X406 sg13cmos5l_o21ai_1_3.Y sg13cmos5l_or3_1_1.C a_24408_15552# VDD sg13_lv_pmos ad=0.2128p pd=1.5u as=0.2128p ps=1.5u w=1.12u l=0.15u
X407 VDD sg13cmos5l_inv_1_0.Y a_16140_15424# VDD sg13_lv_pmos ad=0.4536p pd=2.76u as=0.1596p ps=1.22u w=0.84u l=0.13u
X408 a_27664_13942# a_27407_13799# a_27826_13722# VSS.t44 sg13_lv_nmos ad=0.1428p pd=1.52u as=37.8f ps=0.6u w=0.42u l=0.13u
X409 VDD VSS.t1949 VDD VDD sg13_lv_pmos ad=0.19p pd=1.38u as=0 ps=0 w=1u l=1u
X410 a_17584_13942# sg13cmos5l_dfrbpq_1_2.RESET_B VDD VDD sg13_lv_pmos ad=79.8f pd=0.8u as=2.42015p ps=15.68u w=0.42u l=0.13u
X411 VDD VSS.t1537 VDD VDD sg13_lv_pmos ad=0.19p pd=1.38u as=0 ps=0 w=1u l=1u
X412 VDD VSS.t1714 VDD VDD sg13_lv_pmos ad=0.34p pd=2.68u as=0 ps=0 w=1u l=1u
X413 VDD VSS.t615 VDD VDD sg13_lv_pmos ad=0.34p pd=2.68u as=0 ps=0 w=1u l=1u
X414 VSS.t2334 VDD VSS.t2336 VSS.t2335 sg13_lv_nmos ad=79.8f pd=0.8u as=0 ps=0 w=0.42u l=1u
X415 VDD a_25786_15960# a_25505_16262# VDD sg13_lv_pmos ad=0.1523p pd=1.38u as=0.34p ps=2.68u w=1u l=0.5u
X416 VSS.t1182 VDD VSS.t1183 VSS.t70 sg13_lv_nmos ad=79.8f pd=0.8u as=0 ps=0 w=0.42u l=1u
X417 VDD VSS.t2658 VDD VDD sg13_lv_pmos ad=0.19p pd=1.38u as=0 ps=0 w=1u l=1u
X418 VSS.t1555 VDD VSS.t1554 VSS.t1553 sg13_lv_nmos ad=0.1428p pd=1.52u as=0 ps=0 w=0.42u l=1u
X419 VSS.t3080 VDD VSS.t3079 VSS.t3078 sg13_lv_nmos ad=0.1428p pd=1.52u as=0 ps=0 w=0.42u l=1u
X420 VSS.t2289 VDD VSS.t2288 VSS.t2287 sg13_lv_nmos ad=0.1428p pd=1.52u as=0 ps=0 w=0.42u l=1u
X421 VDD VSS.t2316 VDD VDD sg13_lv_pmos ad=0.19p pd=1.38u as=0 ps=0 w=1u l=1u
X422 VSS.t2630 VDD VSS.t62 VSS.t61 sg13_lv_nmos ad=0.1428p pd=1.52u as=0 ps=0 w=0.42u l=1u
X423 a_21466_15202# sg13cmos5l_o21ai_1_1.Y VSS.t3212 VSS.t3268 sg13_lv_nmos ad=0.1428p pd=1.52u as=79.8f ps=0.8u w=0.42u l=0.13u
X424 VDD VSS.t2770 VDD VDD sg13_lv_pmos ad=0.19p pd=1.38u as=0 ps=0 w=1u l=1u
X425 VDD VSS.t2099 VDD VDD sg13_lv_pmos ad=0.19p pd=1.38u as=0 ps=0 w=1u l=1u
X426 a_3209_16334# a_3333_16033# VDD VDD sg13_lv_pmos ad=0.2442p pd=2.06u as=2.8961p ps=18.25u w=0.66u l=0.13u
X427 VDD VSS.t512 VDD VDD sg13_lv_pmos ad=0.34p pd=2.68u as=0 ps=0 w=1u l=1u
X428 VDD VSS.t810 VDD VDD sg13_lv_pmos ad=0.34p pd=2.68u as=0 ps=0 w=1u l=1u
X429 VSS.t1238 VDD VSS.t1237 VSS.t70 sg13_lv_nmos ad=0.1428p pd=1.52u as=0 ps=0 w=0.42u l=1u
X430 VSS.t47 a_15579_14854# sg13cmos5l_buf_8_2.A VSS.t3235 sg13_lv_nmos ad=0.1406p pd=1.12u as=0.1406p ps=1.12u w=0.74u l=0.13u
X431 VSS.t580 VDD VSS.t582 VSS.t581 sg13_lv_nmos ad=79.8f pd=0.8u as=0 ps=0 w=0.42u l=1u
X432 VDD VSS.t549 VDD VDD sg13_lv_pmos ad=0.34p pd=2.68u as=0 ps=0 w=1u l=1u
X433 VSS.t1645 VDD VSS.t1644 VSS.t1643 sg13_lv_nmos ad=0.1428p pd=1.52u as=0 ps=0 w=0.42u l=1u
X434 VSS.t1191 VDD VSS.t1192 VSS.t70 sg13_lv_nmos ad=79.8f pd=0.8u as=0 ps=0 w=0.42u l=1u
X435 VSS.t47 VDD VSS.t47 VSS.t407 sg13_lv_nmos ad=0.1428p pd=1.52u as=0 ps=0 w=0.42u l=1u
X436 VSS.t15 a_15671_15315# a_15671_15315# VSS.t232 sg13_lv_nmos ad=4.11262p pd=27.15u as=0.111p ps=1.34u w=0.3u l=0.13u
X437 VDD a_25094_14484# a_25206_14508# VDD sg13_lv_pmos ad=0.2254p pd=1.53u as=0.34p ps=2.68u w=1u l=0.5u
X438 VSS.t2514 VDD VSS.t2513 VSS.t2512 sg13_lv_nmos ad=0.1428p pd=1.52u as=0 ps=0 w=0.42u l=1u
X439 VSS.t1196 VDD VSS.t1197 VSS.t70 sg13_lv_nmos ad=79.8f pd=0.8u as=0 ps=0 w=0.42u l=1u
X440 VSS.t1620 VDD VSS.t1622 VSS.t1621 sg13_lv_nmos ad=79.8f pd=0.8u as=0 ps=0 w=0.42u l=1u
X441 VDD VSS.t2296 VDD VDD sg13_lv_pmos ad=0.19p pd=1.38u as=0 ps=0 w=1u l=1u
X442 a_19054_15423# a_19169_15424# VDD VDD sg13_lv_pmos ad=0.34p pd=2.68u as=0.2254p ps=1.53u w=1u l=0.5u
X443 VDD VSS.t1894 VDD VDD sg13_lv_pmos ad=0.19p pd=1.38u as=0 ps=0 w=1u l=1u
X444 VDD VSS.t2729 VDD VDD sg13_lv_pmos ad=0.19p pd=1.38u as=0 ps=0 w=1u l=1u
X445 VSS.t2012 VDD VSS.t2011 VSS.t2010 sg13_lv_nmos ad=0.1428p pd=1.52u as=0 ps=0 w=0.42u l=1u
X446 VDD VSS.t409 VDD VDD sg13_lv_pmos ad=0.34p pd=2.68u as=0 ps=0 w=1u l=1u
X447 VSS.t1575 VDD VSS.t1574 VSS.t1573 sg13_lv_nmos ad=0.1428p pd=1.52u as=0 ps=0 w=0.42u l=1u
X448 VSS.t3100 VDD VSS.t3099 VSS.t3098 sg13_lv_nmos ad=0.1428p pd=1.52u as=0 ps=0 w=0.42u l=1u
X449 VSS.t851 VDD VSS.t853 VSS.t852 sg13_lv_nmos ad=79.8f pd=0.8u as=0 ps=0 w=0.42u l=1u
X450 VDD VSS.t1584 VDD VDD sg13_lv_pmos ad=0.34p pd=2.68u as=0 ps=0 w=1u l=1u
X451 VSS.t1615 VDD VSS.t1617 VSS.t1616 sg13_lv_nmos ad=79.8f pd=0.8u as=0 ps=0 w=0.42u l=1u
X452 VDD VSS.t2458 VDD VDD sg13_lv_pmos ad=0.34p pd=2.68u as=0 ps=0 w=1u l=1u
X453 VDD VSS.t413 VDD VDD sg13_lv_pmos ad=0.34p pd=2.68u as=0 ps=0 w=1u l=1u
X454 VSS.t2740 VDD VSS.t2741 VSS.t61 sg13_lv_nmos ad=79.8f pd=0.8u as=0 ps=0 w=0.42u l=1u
X455 VDD VSS.t2486 VDD VDD sg13_lv_pmos ad=0.19p pd=1.38u as=0 ps=0 w=1u l=1u
X456 VDD VSS.t1926 VDD VDD sg13_lv_pmos ad=0.34p pd=2.68u as=0 ps=0 w=1u l=1u
X457 VSS.t2319 VDD VSS.t2321 VSS.t2320 sg13_lv_nmos ad=79.8f pd=0.8u as=0 ps=0 w=0.42u l=1u
X458 VDD VSS.t2261 VDD VDD sg13_lv_pmos ad=0.19p pd=1.38u as=0 ps=0 w=1u l=1u
X459 a_9801_15625# a_9444_15552# VDD VDD sg13_lv_pmos ad=63f pd=0.72u as=0.1563p ps=1.22u w=0.42u l=0.13u
X460 VDD VSS.t965 VDD VDD sg13_lv_pmos ad=0.34p pd=2.68u as=0 ps=0 w=1u l=1u
X461 VDD VSS.t3052 VDD VDD sg13_lv_pmos ad=0.19p pd=1.38u as=0 ps=0 w=1u l=1u
X462 VSS.t2092 VDD VSS.t2094 VSS.t2093 sg13_lv_nmos ad=79.8f pd=0.8u as=0 ps=0 w=0.42u l=1u
X463 VSS.t550 VDD VSS.t549 VSS.t548 sg13_lv_nmos ad=0.1428p pd=1.52u as=0 ps=0 w=0.42u l=1u
X464 VDD VSS.t528 VDD VDD sg13_lv_pmos ad=0.19p pd=1.38u as=0 ps=0 w=1u l=1u
X465 VDD VSS.t1210 VDD VDD sg13_lv_pmos ad=0.19p pd=1.38u as=0 ps=0 w=1u l=1u
X466 VSS.t1282 VDD VSS.t1282 VSS.t70 sg13_lv_nmos ad=79.8f pd=0.8u as=0 ps=0 w=0.42u l=1u
X467 VDD VSS.t1236 VDD VDD sg13_lv_pmos ad=0.34p pd=2.68u as=0 ps=0 w=1u l=1u
X468 VDD VSS.t2741 VDD VDD sg13_lv_pmos ad=0.34p pd=2.68u as=0 ps=0 w=1u l=1u
X469 VDD a_25094_15238# a_25206_15302# VDD sg13_lv_pmos ad=0.2254p pd=1.53u as=0.34p ps=2.68u w=1u l=0.5u
X470 VDD VSS.t2111 VDD VDD sg13_lv_pmos ad=0.34p pd=2.68u as=0 ps=0 w=1u l=1u
X471 VDD VSS.t1934 VDD VDD sg13_lv_pmos ad=0.19p pd=1.38u as=0 ps=0 w=1u l=1u
X472 VDD VSS.t419 VDD VDD sg13_lv_pmos ad=0.34p pd=2.68u as=0 ps=0 w=1u l=1u
X473 VDD VSS.t1699 VDD VDD sg13_lv_pmos ad=0.34p pd=2.68u as=0 ps=0 w=1u l=1u
X474 VSS.t2499 VDD VSS.t2498 VSS.t2497 sg13_lv_nmos ad=0.1428p pd=1.52u as=0 ps=0 w=0.42u l=1u
X475 VSS.t447 VDD VSS.t446 VSS.t15 sg13_lv_nmos ad=0.1428p pd=1.52u as=0 ps=0 w=0.42u l=1u
X476 VSS.t1605 VDD VSS.t1607 VSS.t1606 sg13_lv_nmos ad=79.8f pd=0.8u as=0 ps=0 w=0.42u l=1u
X477 VSS.t3130 VDD VSS.t3132 VSS.t3131 sg13_lv_nmos ad=79.8f pd=0.8u as=0 ps=0 w=0.42u l=1u
X478 VDD VSS.t81 VDD VDD sg13_lv_pmos ad=0.34p pd=2.68u as=0 ps=0 w=1u l=1u
X479 VDD VSS.t1564 VDD VDD sg13_lv_pmos ad=0.34p pd=2.68u as=0 ps=0 w=1u l=1u
X480 VSS.t2788 VDD VSS.t2789 VSS.t61 sg13_lv_nmos ad=79.8f pd=0.8u as=0 ps=0 w=0.42u l=1u
X481 VDD a_21946_16237# sg13cmos5l_dfrbpq_1_6.RESET_B VDD sg13_lv_pmos ad=2.8961p pd=18.25u as=0.3927p ps=2.99u w=1.155u l=0.13u
X482 VDD a_12010_15202# sg13cmos5l_dfrbpq_1_2.CLK VDD sg13_lv_pmos ad=0.2128p pd=1.5u as=0.2128p ps=1.5u w=1.12u l=0.13u
X483 VDD VSS.t980 VDD VDD sg13_lv_pmos ad=0.34p pd=2.68u as=0 ps=0 w=1u l=1u
X484 VDD VSS.t2699 VDD VDD sg13_lv_pmos ad=0.34p pd=2.68u as=0 ps=0 w=1u l=1u
X485 VDD VSS.t2478 VDD VDD sg13_lv_pmos ad=0.34p pd=2.68u as=0 ps=0 w=1u l=1u
X486 VDD VSS.t512 VDD VDD sg13_lv_pmos ad=0.34p pd=2.68u as=0 ps=0 w=1u l=1u
X487 VDD VSS.t1276 VDD VDD sg13_lv_pmos ad=0.19p pd=1.38u as=0 ps=0 w=1u l=1u
X488 VDD VSS.t2084 VDD VDD sg13_lv_pmos ad=0.19p pd=1.38u as=0 ps=0 w=1u l=1u
X489 VSS.t521 VDD VSS.t528 VSS.t527 sg13_lv_nmos ad=79.8f pd=0.8u as=0 ps=0 w=0.42u l=1u
X490 VSS.t645 VDD VSS.t642 VSS.t644 sg13_lv_nmos ad=0.1428p pd=1.52u as=0 ps=0 w=0.42u l=1u
X491 VDD VSS.t2761 VDD VDD sg13_lv_pmos ad=0.19p pd=1.38u as=0 ps=0 w=1u l=1u
X492 VDD VSS.t2438 VDD VDD sg13_lv_pmos ad=0.34p pd=2.68u as=0 ps=0 w=1u l=1u
X493 VSS.t2464 VDD VSS.t2463 VSS.t2462 sg13_lv_nmos ad=0.1428p pd=1.52u as=0 ps=0 w=0.42u l=1u
X494 VSS.t170 a_6286_13911# sg13cmos5l_dlygate4sd3_1_0.X VSS.t3305 sg13_lv_nmos ad=0.1426p pd=1.16u as=0.2516p ps=2.16u w=0.74u l=0.13u
X495 VSS.t1265 VDD VSS.t1264 VSS.t70 sg13_lv_nmos ad=0.1428p pd=1.52u as=0 ps=0 w=0.42u l=1u
X496 VSS.t287 VDD VSS.t287 VSS.t290 sg13_lv_nmos ad=79.8f pd=0.8u as=0 ps=0 w=0.42u l=1u
X497 VSS.t2960 VDD VSS.t2962 VSS.t2961 sg13_lv_nmos ad=79.8f pd=0.8u as=0 ps=0 w=0.42u l=1u
X498 VSS.t2047 VDD VSS.t2046 VSS.t2045 sg13_lv_nmos ad=0.1428p pd=1.52u as=0 ps=0 w=0.42u l=1u
X499 VSS.t1258 VDD VSS.t1259 VSS.t70 sg13_lv_nmos ad=79.8f pd=0.8u as=0 ps=0 w=0.42u l=1u
X500 VSS.t1630 VDD VSS.t1629 VSS.t1628 sg13_lv_nmos ad=0.1428p pd=1.52u as=0 ps=0 w=0.42u l=1u
X501 VDD VSS.t136 VDD VDD sg13_lv_pmos ad=0.34p pd=2.68u as=0 ps=0 w=1u l=1u
X502 a_26638_15423# a_26753_15424# VDD VDD sg13_lv_pmos ad=0.34p pd=2.68u as=0.2254p ps=1.53u w=1u l=0.5u
X503 VDD VSS.t803 VDD VDD sg13_lv_pmos ad=0.19p pd=1.38u as=0 ps=0 w=1u l=1u
X504 VDD VSS.t2273 VDD VDD sg13_lv_pmos ad=0.34p pd=2.68u as=0 ps=0 w=1u l=1u
X505 VDD VSS.t612 VDD VDD sg13_lv_pmos ad=0.19p pd=1.38u as=0 ps=0 w=1u l=1u
X506 VDD VSS.t1597 VDD VDD sg13_lv_pmos ad=0.19p pd=1.38u as=0 ps=0 w=1u l=1u
X507 VDD VSS.t3064 VDD VDD sg13_lv_pmos ad=0.34p pd=2.68u as=0 ps=0 w=1u l=1u
X508 VSS.t606 VDD VSS.t606 VSS.t744 sg13_lv_nmos ad=0.1428p pd=1.52u as=0 ps=0 w=0.42u l=1u
X509 VDD VSS.t1242 VDD VDD sg13_lv_pmos ad=0.19p pd=1.38u as=0 ps=0 w=1u l=1u
X510 VSS.t1300 VDD VSS.t1300 VSS.t70 sg13_lv_nmos ad=79.8f pd=0.8u as=0 ps=0 w=0.42u l=1u
X511 VDD a_26170_15202# a_25889_15424# VDD sg13_lv_pmos ad=0.1523p pd=1.38u as=0.34p ps=2.68u w=1u l=0.5u
X512 VDD VSS.t1879 VDD VDD sg13_lv_pmos ad=0.19p pd=1.38u as=0 ps=0 w=1u l=1u
X513 VDD VSS.t2661 VDD VDD sg13_lv_pmos ad=0.19p pd=1.38u as=0 ps=0 w=1u l=1u
X514 VDD VSS.t2720 VDD VDD sg13_lv_pmos ad=0.19p pd=1.38u as=0 ps=0 w=1u l=1u
X515 VSS.t1997 VDD VSS.t1996 VSS.t1995 sg13_lv_nmos ad=0.1428p pd=1.52u as=0 ps=0 w=0.42u l=1u
X516 VDD a_12010_15202# sg13cmos5l_dfrbpq_1_2.CLK VDD sg13_lv_pmos ad=0.2128p pd=1.5u as=0.2128p ps=1.5u w=1.12u l=0.13u
X517 a_6789_14495# sg13cmos5l_dfrbpq_1_2.CLK VSS.t15 VSS.t94 sg13_lv_nmos ad=0.2516p pd=2.16u as=3.8707p ps=25.555u w=0.74u l=0.13u
X518 VSS.t1560 VDD VSS.t1559 VSS.t1558 sg13_lv_nmos ad=0.1428p pd=1.52u as=0 ps=0 w=0.42u l=1u
X519 VSS.t3085 VDD VSS.t3084 VSS.t3083 sg13_lv_nmos ad=0.1428p pd=1.52u as=0 ps=0 w=0.42u l=1u
X520 VSS.t2294 VDD VSS.t2293 VSS.t2292 sg13_lv_nmos ad=0.1428p pd=1.52u as=0 ps=0 w=0.42u l=1u
X521 VSS.t397 VDD VSS.t399 VSS.t398 sg13_lv_nmos ad=79.8f pd=0.8u as=0 ps=0 w=0.42u l=1u
X522 VDD VSS.t1205 VDD VDD sg13_lv_pmos ad=0.34p pd=2.68u as=0 ps=0 w=1u l=1u
X523 VDD VSS.t591 VDD VDD sg13_lv_pmos ad=0.34p pd=2.68u as=0 ps=0 w=1u l=1u
X524 VSS.t2369 VDD VSS.t2368 VSS.t2367 sg13_lv_nmos ad=0.1428p pd=1.52u as=0 ps=0 w=0.42u l=1u
X525 VDD VSS.t1168 VDD VDD sg13_lv_pmos ad=0.19p pd=1.38u as=0 ps=0 w=1u l=1u
X526 VDD VSS.t2773 VDD VDD sg13_lv_pmos ad=0.19p pd=1.38u as=0 ps=0 w=1u l=1u
X527 VDD VSS.t2471 VDD VDD sg13_lv_pmos ad=0.19p pd=1.38u as=0 ps=0 w=1u l=1u
X528 VDD VSS.t2069 VDD VDD sg13_lv_pmos ad=0.19p pd=1.38u as=0 ps=0 w=1u l=1u
X529 sg13cmos5l_buf_8_2.A a_15579_14854# VDD VDD sg13_lv_pmos ad=0.2128p pd=1.5u as=0.2128p ps=1.5u w=1.12u l=0.13u
X530 VSS.t57 sg13cmos5l_dlygate4sd3_1_17.A a_24824_14525# VSS.t56 sg13_lv_nmos ad=79.8f pd=0.8u as=0.1428p ps=1.52u w=0.42u l=0.13u
X531 VDD VSS.t1010 VDD VDD sg13_lv_pmos ad=0.34p pd=2.68u as=0 ps=0 w=1u l=1u
X532 VDD VSS.t1267 VDD VDD sg13_lv_pmos ad=0.19p pd=1.38u as=0 ps=0 w=1u l=1u
X533 VSS.t2484 VDD VSS.t2483 VSS.t2482 sg13_lv_nmos ad=0.1428p pd=1.52u as=0 ps=0 w=0.42u l=1u
X534 VSS.t2304 VDD VSS.t2306 VSS.t2305 sg13_lv_nmos ad=79.8f pd=0.8u as=0 ps=0 w=0.42u l=1u
X535 a_22576_14726# sg13cmos5l_dfrbpq_1_6.RESET_B VDD VDD sg13_lv_pmos ad=79.8f pd=0.8u as=2.42015p ps=15.68u w=0.42u l=0.13u
X536 VDD VSS.t818 VDD VDD sg13_lv_pmos ad=0.19p pd=1.38u as=0 ps=0 w=1u l=1u
X537 VDD VSS.t2246 VDD VDD sg13_lv_pmos ad=0.19p pd=1.38u as=0 ps=0 w=1u l=1u
X538 a_27609_14037# a_26667_13844# a_27407_13799# VDD sg13_lv_pmos ad=93.45f pd=0.865u as=0.2048p ps=1.63u w=0.42u l=0.13u
X539 VSS.t2786 VDD VSS.t2787 VSS.t61 sg13_lv_nmos ad=79.8f pd=0.8u as=0 ps=0 w=0.42u l=1u
X540 VSS.t15 a_26373_14495# a_26475_14495# VSS.t168 sg13_lv_nmos ad=4.11262p pd=27.15u as=0.2516p ps=2.16u w=0.74u l=0.13u
X541 VSS.t1650 VDD VSS.t1649 VSS.t1648 sg13_lv_nmos ad=0.1428p pd=1.52u as=0 ps=0 w=0.42u l=1u
X542 VDD VSS.t2341 VDD VDD sg13_lv_pmos ad=0.19p pd=1.38u as=0 ps=0 w=1u l=1u
X543 VSS.t331 VDD VSS.t218 VSS.t332 sg13_lv_nmos ad=79.8f pd=0.8u as=0 ps=0 w=0.42u l=1u
X544 VDD sg13cmos5l_dfrbpq_1_1.RESET_B a_6086_14922# VDD sg13_lv_pmos ad=0.36237p pd=2.605u as=79.8f ps=0.8u w=0.42u l=0.13u
X545 VDD VSS.t102 VDD VDD sg13_lv_pmos ad=0.34p pd=2.68u as=0 ps=0 w=1u l=1u
X546 VSS.t1046 VDD VSS.t1045 VSS.t1044 sg13_lv_nmos ad=0.1428p pd=1.52u as=0 ps=0 w=0.42u l=1u
X547 VDD VSS.t1282 VDD VDD sg13_lv_pmos ad=0.34p pd=2.68u as=0 ps=0 w=1u l=1u
X548 VDD VSS.t2787 VDD VDD sg13_lv_pmos ad=0.34p pd=2.68u as=0 ps=0 w=1u l=1u
X549 VDD VSS.t2096 VDD VDD sg13_lv_pmos ad=0.34p pd=2.68u as=0 ps=0 w=1u l=1u
X550 VDD a_37484_15960# counter_value_o[7] VDD sg13_lv_pmos ad=0.2114p pd=1.54u as=0.42p ps=2.99u w=1.12u l=0.13u
X551 a_20774_14922# a_21579_14495# a_21034_14452# VDD sg13_lv_pmos ad=0.1428p pd=1.52u as=79.8f ps=0.8u w=0.42u l=0.13u
X552 VSS.t1314 VDD VSS.t1315 VSS.t70 sg13_lv_nmos ad=79.8f pd=0.8u as=0 ps=0 w=0.42u l=1u
X553 VSS.t1947 VDD VSS.t1949 VSS.t1948 sg13_lv_nmos ad=79.8f pd=0.8u as=0 ps=0 w=0.42u l=1u
X554 VDD VSS.t557 VDD VDD sg13_lv_pmos ad=0.19p pd=1.38u as=0 ps=0 w=1u l=1u
X555 VDD VSS.t601 VDD VDD sg13_lv_pmos ad=0.34p pd=2.68u as=0 ps=0 w=1u l=1u
X556 VDD VSS.t2124 VDD VDD sg13_lv_pmos ad=0.19p pd=1.38u as=0 ps=0 w=1u l=1u
X557 VDD VSS.t1549 VDD VDD sg13_lv_pmos ad=0.34p pd=2.68u as=0 ps=0 w=1u l=1u
X558 VDD VSS.t1899 VDD VDD sg13_lv_pmos ad=0.19p pd=1.38u as=0 ps=0 w=1u l=1u
X559 VSS.t2780 VDD VSS.t2781 VSS.t61 sg13_lv_nmos ad=79.8f pd=0.8u as=0 ps=0 w=0.42u l=1u
X560 VDD VSS.t2731 VDD VDD sg13_lv_pmos ad=0.19p pd=1.38u as=0 ps=0 w=1u l=1u
X561 VSS.t441 VDD VSS.t440 VSS.t15 sg13_lv_nmos ad=0.1428p pd=1.52u as=0 ps=0 w=0.42u l=1u
X562 sg13cmos5l_dlygate4sd3_1_17.A sg13cmos5l_a21oi_1_3.B1 VSS.t104 VSS.t103 sg13_lv_nmos ad=0.1406p pd=1.12u as=0.2516p ps=2.16u w=0.74u l=0.13u
X563 VSS.t1235 VDD VSS.t1236 VSS.t70 sg13_lv_nmos ad=79.8f pd=0.8u as=0 ps=0 w=0.42u l=1u
X564 VDD VSS.t639 VDD VDD sg13_lv_pmos ad=0.19p pd=1.38u as=0 ps=0 w=1u l=1u
X565 VDD VSS.t630 VDD VDD sg13_lv_pmos ad=0.19p pd=1.38u as=0 ps=0 w=1u l=1u
X566 VDD VSS.t1554 VDD VDD sg13_lv_pmos ad=0.34p pd=2.68u as=0 ps=0 w=1u l=1u
X567 VDD VSS.t2491 VDD VDD sg13_lv_pmos ad=0.19p pd=1.38u as=0 ps=0 w=1u l=1u
X568 VSS.t36 sg13cmos5l_buf_1_0.X a_2490_14447# VSS.t3292 sg13_lv_nmos ad=0.374p pd=2.46u as=0.17462p ps=1.185u w=0.55u l=0.13u
X569 VDD VSS.t973 VDD VDD sg13_lv_pmos ad=0.19p pd=1.38u as=0 ps=0 w=1u l=1u
X570 VSS.t1680 VDD VSS.t1682 VSS.t1681 sg13_lv_nmos ad=79.8f pd=0.8u as=0 ps=0 w=0.42u l=1u
X571 VDD VSS.t2748 VDD VDD sg13_lv_pmos ad=0.34p pd=2.68u as=0 ps=0 w=1u l=1u
X572 VSS.t2097 VDD VSS.t2099 VSS.t2098 sg13_lv_nmos ad=79.8f pd=0.8u as=0 ps=0 w=0.42u l=1u
X573 VSS.t2778 VDD VSS.t2779 VSS.t61 sg13_lv_nmos ad=79.8f pd=0.8u as=0 ps=0 w=0.42u l=1u
X574 VSS.t856 VDD VSS.t858 VSS.t857 sg13_lv_nmos ad=79.8f pd=0.8u as=0 ps=0 w=0.42u l=1u
X575 VSS.t2945 VDD VSS.t2947 VSS.t2946 sg13_lv_nmos ad=79.8f pd=0.8u as=0 ps=0 w=0.42u l=1u
X576 a_2916_15552# a_3435_15356# a_4175_15311# VSS.t3244 sg13_lv_nmos ad=0.3473p pd=2.71u as=0.12665p ps=1.145u w=0.74u l=0.13u
X577 VDD a_22030_15423# sg13cmos5l_or3_1_2.A VDD sg13_lv_pmos ad=0.2254p pd=1.53u as=0.4256p ps=3u w=1.12u l=0.13u
X578 VSS.t1982 VDD VSS.t1984 VSS.t1983 sg13_lv_nmos ad=79.8f pd=0.8u as=0 ps=0 w=0.42u l=1u
X579 VDD VSS.t1939 VDD VDD sg13_lv_pmos ad=0.19p pd=1.38u as=0 ps=0 w=1u l=1u
X580 VDD VSS.t2675 VDD VDD sg13_lv_pmos ad=0.19p pd=1.38u as=0 ps=0 w=1u l=1u
X581 VSS.t2354 VDD VSS.t2353 VSS.t2352 sg13_lv_nmos ad=0.1428p pd=1.52u as=0 ps=0 w=0.42u l=1u
X582 VDD VSS.t648 VDD VDD sg13_lv_pmos ad=0.19p pd=1.38u as=0 ps=0 w=1u l=1u
X583 VDD VSS.t3049 VDD VDD sg13_lv_pmos ad=0.34p pd=2.68u as=0 ps=0 w=1u l=1u
X584 VDD VSS.t2258 VDD VDD sg13_lv_pmos ad=0.34p pd=2.68u as=0 ps=0 w=1u l=1u
X585 VSS.t1610 VDD VSS.t1612 VSS.t1611 sg13_lv_nmos ad=79.8f pd=0.8u as=0 ps=0 w=0.42u l=1u
X586 VSS.t3135 VDD VSS.t3137 VSS.t3136 sg13_lv_nmos ad=79.8f pd=0.8u as=0 ps=0 w=0.42u l=1u
X587 VDD VSS.t2286 VDD VDD sg13_lv_pmos ad=0.19p pd=1.38u as=0 ps=0 w=1u l=1u
X588 a_4175_15311# a_3333_15213# a_2916_15552# VDD sg13_lv_pmos ad=0.2048p pd=1.63u as=0.34p ps=2.68u w=1u l=0.13u
X589 VSS.t580 VDD VSS.t582 VSS.t581 sg13_lv_nmos ad=79.8f pd=0.8u as=0 ps=0 w=0.42u l=1u
X590 VDD VSS.t1622 VDD VDD sg13_lv_pmos ad=0.19p pd=1.38u as=0 ps=0 w=1u l=1u
X591 a_7532_15960# sg13cmos5l_dlygate4sd3_1_1.A VDD VDD sg13_lv_pmos ad=0.2856p pd=2.36u as=0.2114p ps=1.54u w=0.84u l=0.13u
X592 VSS.t1218 VDD VSS.t1217 VSS.t70 sg13_lv_nmos ad=0.1428p pd=1.52u as=0 ps=0 w=0.42u l=1u
X593 a_26182_14909# sg13cmos5l_dfrbpq_1_7.RESET_B VSS.t41 VSS.t49 sg13_lv_nmos ad=37.8f pd=0.6u as=0.1701p ps=1.65u w=0.42u l=0.13u
X594 VSS.t1510 VDD VSS.t1512 VSS.t1511 sg13_lv_nmos ad=79.8f pd=0.8u as=0 ps=0 w=0.42u l=1u
X595 VSS.t2419 VDD VSS.t2421 VSS.t2420 sg13_lv_nmos ad=79.8f pd=0.8u as=0 ps=0 w=0.42u l=1u
X596 VSS.t1892 VDD VSS.t1894 VSS.t1893 sg13_lv_nmos ad=79.8f pd=0.8u as=0 ps=0 w=0.42u l=1u
X597 VDD VSS.t593 VDD VDD sg13_lv_pmos ad=0.34p pd=2.68u as=0 ps=0 w=1u l=1u
X598 VDD VSS.t940 VDD VDD sg13_lv_pmos ad=0.34p pd=2.68u as=0 ps=0 w=1u l=1u
X599 VSS.t273 VDD VSS.t273 VSS.t375 sg13_lv_nmos ad=0.1428p pd=1.52u as=0 ps=0 w=0.42u l=1u
X600 VSS.t811 VDD VSS.t810 VSS.t809 sg13_lv_nmos ad=0.1428p pd=1.52u as=0 ps=0 w=0.42u l=1u
X601 VDD VSS.t1259 VDD VDD sg13_lv_pmos ad=0.19p pd=1.38u as=0 ps=0 w=1u l=1u
X602 VDD VSS.t1911 VDD VDD sg13_lv_pmos ad=0.34p pd=2.68u as=0 ps=0 w=1u l=1u
X603 VDD VSS.t2764 VDD VDD sg13_lv_pmos ad=0.19p pd=1.38u as=0 ps=0 w=1u l=1u
X604 VSS.t2703 VDD VSS.t2704 VSS.t61 sg13_lv_nmos ad=79.8f pd=0.8u as=0 ps=0 w=0.42u l=1u
X605 VDD VSS.t2739 VDD VDD sg13_lv_pmos ad=0.34p pd=2.68u as=0 ps=0 w=1u l=1u
X606 VSS.t2469 VDD VSS.t2468 VSS.t2467 sg13_lv_nmos ad=0.1428p pd=1.52u as=0 ps=0 w=0.42u l=1u
X607 a_17318_14922# a_18123_14495# a_17578_14452# VDD sg13_lv_pmos ad=0.1428p pd=1.52u as=79.8f ps=0.8u w=0.42u l=0.13u
X608 VSS.t444 VDD VSS.t445 VSS.t15 sg13_lv_nmos ad=79.8f pd=0.8u as=0 ps=0 w=0.42u l=1u
X609 VSS.t2930 VDD VSS.t2932 VSS.t2931 sg13_lv_nmos ad=79.8f pd=0.8u as=0 ps=0 w=0.42u l=1u
X610 VDD VSS.t1003 VDD VDD sg13_lv_pmos ad=0.19p pd=1.38u as=0 ps=0 w=1u l=1u
X611 VSS.t1046 VDD VSS.t1045 VSS.t1044 sg13_lv_nmos ad=0.1428p pd=1.52u as=0 ps=0 w=0.42u l=1u
X612 VSS.t1635 VDD VSS.t1634 VSS.t1633 sg13_lv_nmos ad=0.1428p pd=1.52u as=0 ps=0 w=0.42u l=1u
X613 VSS.t2752 VDD VSS.t2751 VSS.t61 sg13_lv_nmos ad=0.1428p pd=1.52u as=0 ps=0 w=0.42u l=1u
X614 VDD VSS.t2503 VDD VDD sg13_lv_pmos ad=0.34p pd=2.68u as=0 ps=0 w=1u l=1u
X615 VDD VSS.t2326 VDD VDD sg13_lv_pmos ad=0.19p pd=1.38u as=0 ps=0 w=1u l=1u
X616 VSS.t406 VDD VSS.t406 VSS.t405 sg13_lv_nmos ad=0.1428p pd=1.52u as=0 ps=0 w=0.42u l=1u
X617 VDD VSS.t2278 VDD VDD sg13_lv_pmos ad=0.34p pd=2.68u as=0 ps=0 w=1u l=1u
X618 a_16175_15238# a_16140_15424# sg13cmos5l_nor2_1_0.B VSS.t129 sg13_lv_nmos ad=0.1406p pd=1.12u as=0.2516p ps=2.16u w=0.74u l=0.13u
X619 VDD VSS.t557 VDD VDD sg13_lv_pmos ad=0.19p pd=1.38u as=0 ps=0 w=1u l=1u
X620 VDD VSS.t1602 VDD VDD sg13_lv_pmos ad=0.19p pd=1.38u as=0 ps=0 w=1u l=1u
X621 VDD VSS.t3069 VDD VDD sg13_lv_pmos ad=0.34p pd=2.68u as=0 ps=0 w=1u l=1u
X622 VSS.t2112 VDD VSS.t2111 VSS.t2110 sg13_lv_nmos ad=0.1428p pd=1.52u as=0 ps=0 w=0.42u l=1u
X623 VSS.t1932 VDD VSS.t1934 VSS.t1933 sg13_lv_nmos ad=79.8f pd=0.8u as=0 ps=0 w=0.42u l=1u
X624 VSS.t550 VDD VSS.t549 VSS.t548 sg13_lv_nmos ad=0.1428p pd=1.52u as=0 ps=0 w=0.42u l=1u
X625 VDD VSS.t2451 VDD VDD sg13_lv_pmos ad=0.19p pd=1.38u as=0 ps=0 w=1u l=1u
X626 VDD VSS.t2109 VDD VDD sg13_lv_pmos ad=0.19p pd=1.38u as=0 ps=0 w=1u l=1u
X627 VSS.t1194 VDD VSS.t1195 VSS.t70 sg13_lv_nmos ad=79.8f pd=0.8u as=0 ps=0 w=0.42u l=1u
X628 VSS.t1231 VDD VSS.t1230 VSS.t70 sg13_lv_nmos ad=0.1428p pd=1.52u as=0 ps=0 w=0.42u l=1u
X629 VDD VSS.t1607 VDD VDD sg13_lv_pmos ad=0.19p pd=1.38u as=0 ps=0 w=1u l=1u
X630 VDD VSS.t1884 VDD VDD sg13_lv_pmos ad=0.19p pd=1.38u as=0 ps=0 w=1u l=1u
X631 VDD VSS.t2664 VDD VDD sg13_lv_pmos ad=0.19p pd=1.38u as=0 ps=0 w=1u l=1u
X632 VDD VSS.t2723 VDD VDD sg13_lv_pmos ad=0.19p pd=1.38u as=0 ps=0 w=1u l=1u
X633 a_4175_15311# a_3333_15213# a_4081_15311# VSS.t3299 sg13_lv_nmos ad=0.12665p pd=1.145u as=0.1428p ps=1.52u w=0.42u l=0.13u
X634 VDD VSS.t1323 VDD VDD sg13_lv_pmos ad=0.34p pd=2.68u as=0 ps=0 w=1u l=1u
X635 VSS.t1565 VDD VSS.t1564 VSS.t1563 sg13_lv_nmos ad=0.1428p pd=1.52u as=0 ps=0 w=0.42u l=1u
X636 VSS.t3090 VDD VSS.t3089 VSS.t3088 sg13_lv_nmos ad=0.1428p pd=1.52u as=0 ps=0 w=0.42u l=1u
X637 VSS.t2299 VDD VSS.t2298 VSS.t2297 sg13_lv_nmos ad=0.1428p pd=1.52u as=0 ps=0 w=0.42u l=1u
X638 VSS.t124 a_7888_14726# a_7537_14845# VSS.t245 sg13_lv_nmos ad=79.8f pd=0.8u as=0.1428p ps=1.52u w=0.42u l=0.13u
X639 VSS.t615 VDD VSS.t615 VSS.t616 sg13_lv_nmos ad=79.8f pd=0.8u as=0 ps=0 w=0.42u l=1u
X640 VSS.t966 VDD VSS.t965 VSS.t964 sg13_lv_nmos ad=0.1428p pd=1.52u as=0 ps=0 w=0.42u l=1u
X641 VDD VSS.t2476 VDD VDD sg13_lv_pmos ad=0.19p pd=1.38u as=0 ps=0 w=1u l=1u
X642 VSS.t2339 VDD VSS.t2338 VSS.t2337 sg13_lv_nmos ad=0.1428p pd=1.52u as=0 ps=0 w=0.42u l=1u
X643 VSS.t856 VDD VSS.t858 VSS.t857 sg13_lv_nmos ad=79.8f pd=0.8u as=0 ps=0 w=0.42u l=1u
X644 VDD VSS.t830 VDD VDD sg13_lv_pmos ad=0.34p pd=2.68u as=0 ps=0 w=1u l=1u
X645 VSS.t2693 VDD VSS.t2695 VSS.t61 sg13_lv_nmos ad=79.8f pd=0.8u as=0 ps=0 w=0.42u l=1u
X646 VSS.t426 VDD VSS.t425 VSS.t15 sg13_lv_nmos ad=0.1428p pd=1.52u as=0 ps=0 w=0.42u l=1u
X647 VSS.t2082 VDD VSS.t2084 VSS.t2083 sg13_lv_nmos ad=79.8f pd=0.8u as=0 ps=0 w=0.42u l=1u
X648 VSS.t2770 VDD VSS.t2771 VSS.t61 sg13_lv_nmos ad=79.8f pd=0.8u as=0 ps=0 w=0.42u l=1u
X649 VDD VSS.t378 VDD VDD sg13_lv_pmos ad=0.19p pd=1.38u as=0 ps=0 w=1u l=1u
X650 a_27826_13722# sg13cmos5l_dfrbpq_1_5.RESET_B VSS.t110 VSS.t3303 sg13_lv_nmos ad=37.8f pd=0.6u as=79.8f ps=0.8u w=0.42u l=0.13u
X651 VSS.t521 VDD VSS.t528 VSS.t527 sg13_lv_nmos ad=79.8f pd=0.8u as=0 ps=0 w=0.42u l=1u
X652 VDD VSS.t1286 VDD VDD sg13_lv_pmos ad=0.34p pd=2.68u as=0 ps=0 w=1u l=1u
X653 VDD VSS.t2101 VDD VDD sg13_lv_pmos ad=0.34p pd=2.68u as=0 ps=0 w=1u l=1u
X654 VDD VSS.t355 VDD VDD sg13_lv_pmos ad=0.19p pd=1.38u as=0 ps=0 w=1u l=1u
X655 VSS.t1176 VDD VSS.t1175 VSS.t70 sg13_lv_nmos ad=0.1428p pd=1.52u as=0 ps=0 w=0.42u l=1u
X656 VDD VSS.t2771 VDD VDD sg13_lv_pmos ad=0.34p pd=2.68u as=0 ps=0 w=1u l=1u
X657 VSS.t1952 VDD VSS.t1954 VSS.t1953 sg13_lv_nmos ad=79.8f pd=0.8u as=0 ps=0 w=0.42u l=1u
X658 VDD VSS.t893 VDD VDD sg13_lv_pmos ad=0.19p pd=1.38u as=0 ps=0 w=1u l=1u
X659 VSS.t981 VDD VSS.t980 VSS.t979 sg13_lv_nmos ad=0.1428p pd=1.52u as=0 ps=0 w=0.42u l=1u
X660 VSS.t1595 VDD VSS.t1597 VSS.t1596 sg13_lv_nmos ad=79.8f pd=0.8u as=0 ps=0 w=0.42u l=1u
X661 VSS.t3120 VDD VSS.t3122 VSS.t3121 sg13_lv_nmos ad=79.8f pd=0.8u as=0 ps=0 w=0.42u l=1u
X662 VDD VSS.t2271 VDD VDD sg13_lv_pmos ad=0.19p pd=1.38u as=0 ps=0 w=1u l=1u
X663 sg13cmos5l_a21oi_1_3.A1 a_25206_15302# VSS.t66 VSS.t65 sg13_lv_nmos ad=0.2516p pd=2.16u as=0.1426p ps=1.16u w=0.74u l=0.13u
X664 VDD VSS.t2655 VDD VDD sg13_lv_pmos ad=0.19p pd=1.38u as=0 ps=0 w=1u l=1u
X665 VSS.t1987 VDD VSS.t1986 VSS.t1985 sg13_lv_nmos ad=0.1428p pd=1.52u as=0 ps=0 w=0.42u l=1u
X666 VSS.t3075 VDD VSS.t3074 VSS.t3073 sg13_lv_nmos ad=0.1428p pd=1.52u as=0 ps=0 w=0.42u l=1u
X667 VSS.t2284 VDD VSS.t2283 VSS.t2282 sg13_lv_nmos ad=0.1428p pd=1.52u as=0 ps=0 w=0.42u l=1u
X668 VSS.t1495 VDD VSS.t1497 VSS.t1496 sg13_lv_nmos ad=79.8f pd=0.8u as=0 ps=0 w=0.42u l=1u
X669 VSS.t2404 VDD VSS.t2406 VSS.t2405 sg13_lv_nmos ad=79.8f pd=0.8u as=0 ps=0 w=0.42u l=1u
X670 a_6729_14531# a_6372_14488# VDD VDD sg13_lv_pmos ad=63f pd=0.72u as=0.1563p ps=1.22u w=0.42u l=0.13u
X671 VDD VSS.t1559 VDD VDD sg13_lv_pmos ad=0.34p pd=2.68u as=0 ps=0 w=1u l=1u
X672 VSS.t28 a_27034_15202# a_26753_15424# VSS.t151 sg13_lv_nmos ad=79.8f pd=0.8u as=0.1428p ps=1.52u w=0.42u l=0.5u
X673 VDD VSS.t1614 VDD VDD sg13_lv_pmos ad=0.34p pd=2.68u as=0 ps=0 w=1u l=1u
X674 VSS.t2359 VDD VSS.t2358 VSS.t2357 sg13_lv_nmos ad=0.1428p pd=1.52u as=0 ps=0 w=0.42u l=1u
X675 VSS.t811 VDD VSS.t810 VSS.t809 sg13_lv_nmos ad=0.1428p pd=1.52u as=0 ps=0 w=0.42u l=1u
X676 VDD VSS.t985 VDD VDD sg13_lv_pmos ad=0.34p pd=2.68u as=0 ps=0 w=1u l=1u
X677 VDD VSS.t2461 VDD VDD sg13_lv_pmos ad=0.19p pd=1.38u as=0 ps=0 w=1u l=1u
X678 VSS.t570 VDD VSS.t569 VSS.t568 sg13_lv_nmos ad=0.1428p pd=1.52u as=0 ps=0 w=0.42u l=1u
X679 VDD VSS.t1221 VDD VDD sg13_lv_pmos ad=0.19p pd=1.38u as=0 ps=0 w=1u l=1u
X680 VSS.t1685 VDD VSS.t1687 VSS.t1686 sg13_lv_nmos ad=79.8f pd=0.8u as=0 ps=0 w=0.42u l=1u
X681 VDD VSS.t1896 VDD VDD sg13_lv_pmos ad=0.34p pd=2.68u as=0 ps=0 w=1u l=1u
X682 VDD VSS.t2729 VDD VDD sg13_lv_pmos ad=0.34p pd=2.68u as=0 ps=0 w=1u l=1u
X683 VDD VSS.t923 VDD VDD sg13_lv_pmos ad=0.19p pd=1.38u as=0 ps=0 w=1u l=1u
X684 VSS.t2067 VDD VSS.t2069 VSS.t2068 sg13_lv_nmos ad=79.8f pd=0.8u as=0 ps=0 w=0.42u l=1u
X685 a_37484_15960# sg13cmos5l_dfrbpq_1_5.Q VSS.t34 VSS.t33 sg13_lv_nmos ad=0.187p pd=1.78u as=0.14875p ps=1.16u w=0.55u l=0.13u
X686 VDD VSS.t1306 VDD VDD sg13_lv_pmos ad=0.19p pd=1.38u as=0 ps=0 w=1u l=1u
X687 VSS.t2915 VDD VSS.t2917 VSS.t2916 sg13_lv_nmos ad=79.8f pd=0.8u as=0 ps=0 w=0.42u l=1u
X688 VDD a_26170_16237# sg13cmos5l_dfrbpq_1_7.RESET_B VDD sg13_lv_pmos ad=2.8961p pd=18.25u as=0.3927p ps=2.99u w=1.155u l=0.13u
X689 VSS.t1267 VDD VSS.t1267 VSS.t70 sg13_lv_nmos ad=0.1428p pd=1.52u as=0 ps=0 w=0.42u l=1u
X690 VSS.t1190 VDD VSS.t1189 VSS.t70 sg13_lv_nmos ad=0.1428p pd=1.52u as=0 ps=0 w=0.42u l=1u
X691 VDD VSS.t2488 VDD VDD sg13_lv_pmos ad=0.34p pd=2.68u as=0 ps=0 w=1u l=1u
X692 VDD sg13cmos5l_tiehi_1.L_HI a_9158_15234# VDD sg13_lv_pmos ad=0.36237p pd=2.605u as=79.8f ps=0.8u w=0.42u l=0.13u
X693 sg13cmos5l_and2_1_0.X a_1965_14832# VSS.t11 VSS.t77 sg13_lv_nmos ad=0.2516p pd=2.16u as=0.1331p ps=1.12u w=0.74u l=0.13u
X694 VDD VSS.t860 VDD VDD sg13_lv_pmos ad=0.34p pd=2.68u as=0 ps=0 w=1u l=1u
X695 VDD VSS.t2677 VDD VDD sg13_lv_pmos ad=0.19p pd=1.38u as=0 ps=0 w=1u l=1u
X696 VSS.t2324 VDD VSS.t2323 VSS.t2322 sg13_lv_nmos ad=0.1428p pd=1.52u as=0 ps=0 w=0.42u l=1u
X697 VDD VSS.t3054 VDD VDD sg13_lv_pmos ad=0.34p pd=2.68u as=0 ps=0 w=1u l=1u
X698 VDD VSS.t2263 VDD VDD sg13_lv_pmos ad=0.34p pd=2.68u as=0 ps=0 w=1u l=1u
X699 VDD VSS.t2291 VDD VDD sg13_lv_pmos ad=0.19p pd=1.38u as=0 ps=0 w=1u l=1u
X700 VSS.t2097 VDD VSS.t2096 VSS.t2095 sg13_lv_nmos ad=0.1428p pd=1.52u as=0 ps=0 w=0.42u l=1u
X701 a_27898_15202# sg13cmos5l_dfrbpq_1_5.Q VSS.t32 VSS.t15 sg13_lv_nmos ad=0.1428p pd=1.52u as=79.8f ps=0.8u w=0.42u l=0.13u
X702 VSS.t1480 VDD VSS.t1482 VSS.t1481 sg13_lv_nmos ad=79.8f pd=0.8u as=0 ps=0 w=0.42u l=1u
X703 VSS.t2389 VDD VSS.t2391 VSS.t2390 sg13_lv_nmos ad=79.8f pd=0.8u as=0 ps=0 w=0.42u l=1u
X704 VSS.t1897 VDD VSS.t1899 VSS.t1898 sg13_lv_nmos ad=79.8f pd=0.8u as=0 ps=0 w=0.42u l=1u
X705 a_26633_16334# a_26757_16033# VDD VDD sg13_lv_pmos ad=0.2442p pd=2.06u as=2.8961p ps=18.25u w=0.66u l=0.13u
X706 VDD VSS.t2453 VDD VDD sg13_lv_pmos ad=0.34p pd=2.68u as=0 ps=0 w=1u l=1u
X707 a_18863_14845# a_18021_14495# a_18769_14845# VSS.t16 sg13_lv_nmos ad=0.12665p pd=1.145u as=0.1428p ps=1.52u w=0.42u l=0.13u
X708 VSS.t966 VDD VSS.t965 VSS.t964 sg13_lv_nmos ad=0.1428p pd=1.52u as=0 ps=0 w=0.42u l=1u
X709 a_3204_15247# a_2916_15552# a_3142_15247# VSS.t3233 sg13_lv_nmos ad=0.1428p pd=1.52u as=37.8f ps=0.6u w=0.42u l=0.13u
X710 VSS.t1011 VDD VSS.t1010 VSS.t1009 sg13_lv_nmos ad=0.1428p pd=1.52u as=0 ps=0 w=0.42u l=1u
X711 VDD VSS.t1964 VDD VDD sg13_lv_pmos ad=0.19p pd=1.38u as=0 ps=0 w=1u l=1u
X712 VSS.t1276 VDD VSS.t1275 VSS.t70 sg13_lv_nmos ad=0.1428p pd=1.52u as=0 ps=0 w=0.42u l=1u
X713 a_10960_15454# sg13cmos5l_tiehi_1.L_HI VDD VDD sg13_lv_pmos ad=79.8f pd=0.8u as=2.8961p ps=18.25u w=0.42u l=0.13u
X714 VSS.t1847 VDD VSS.t1849 VSS.t1848 sg13_lv_nmos ad=79.8f pd=0.8u as=0 ps=0 w=0.42u l=1u
X715 VSS.t2935 VDD VSS.t2937 VSS.t2936 sg13_lv_nmos ad=79.8f pd=0.8u as=0 ps=0 w=0.42u l=1u
X716 VDD VSS.t330 VDD VDD sg13_lv_pmos ad=0.34p pd=2.68u as=0 ps=0 w=1u l=1u
X717 sg13cmos5l_nand4_1_0.Y sg13cmos5l_dlygate4sd3_1_8.X a_7262_15242# VSS.t3215 sg13_lv_nmos ad=0.2516p pd=2.16u as=0.1406p ps=1.12u w=0.74u l=0.13u
X718 VSS.t1640 VDD VSS.t1639 VSS.t1638 sg13_lv_nmos ad=0.1428p pd=1.52u as=0 ps=0 w=0.42u l=1u
X719 VDD VSS.t2331 VDD VDD sg13_lv_pmos ad=0.19p pd=1.38u as=0 ps=0 w=1u l=1u
X720 VDD VSS.t618 VDD VDD sg13_lv_pmos ad=0.19p pd=1.38u as=0 ps=0 w=1u l=1u
X721 VDD VSS.t823 VDD VDD sg13_lv_pmos ad=0.19p pd=1.38u as=0 ps=0 w=1u l=1u
X722 VSS.t981 VDD VSS.t980 VSS.t979 sg13_lv_nmos ad=0.1428p pd=1.52u as=0 ps=0 w=0.42u l=1u
X723 VSS.t1312 VDD VSS.t1312 VSS.t70 sg13_lv_nmos ad=79.8f pd=0.8u as=0 ps=0 w=0.42u l=1u
X724 VDD VSS.t1276 VDD VDD sg13_lv_pmos ad=0.34p pd=2.68u as=0 ps=0 w=1u l=1u
X725 VDD VSS.t2248 VDD VDD sg13_lv_pmos ad=0.34p pd=2.68u as=0 ps=0 w=1u l=1u
X726 VSS.t2117 VDD VSS.t2116 VSS.t2115 sg13_lv_nmos ad=0.1428p pd=1.52u as=0 ps=0 w=0.42u l=1u
X727 VSS.t1937 VDD VSS.t1939 VSS.t1938 sg13_lv_nmos ad=79.8f pd=0.8u as=0 ps=0 w=0.42u l=1u
X728 VDD VSS.t98 VDD VDD sg13_lv_pmos ad=0.19p pd=1.38u as=0 ps=0 w=1u l=1u
X729 VDD VSS.t2114 VDD VDD sg13_lv_pmos ad=0.19p pd=1.38u as=0 ps=0 w=1u l=1u
X730 VDD VSS.t2646 VDD VDD sg13_lv_pmos ad=0.19p pd=1.38u as=0 ps=0 w=1u l=1u
X731 VDD VSS.t452 VDD VDD sg13_lv_pmos ad=0.34p pd=2.68u as=0 ps=0 w=1u l=1u
X732 VSS.t3060 VDD VSS.t3059 VSS.t3058 sg13_lv_nmos ad=0.1428p pd=1.52u as=0 ps=0 w=0.42u l=1u
X733 VSS.t2269 VDD VSS.t2268 VSS.t2267 sg13_lv_nmos ad=0.1428p pd=1.52u as=0 ps=0 w=0.42u l=1u
X734 VDD VSS.t1180 VDD VDD sg13_lv_pmos ad=0.19p pd=1.38u as=0 ps=0 w=1u l=1u
X735 VDD VSS.t1030 VDD VDD sg13_lv_pmos ad=0.34p pd=2.68u as=0 ps=0 w=1u l=1u
X736 VDD VSS.t1599 VDD VDD sg13_lv_pmos ad=0.34p pd=2.68u as=0 ps=0 w=1u l=1u
X737 VDD VSS.t2761 VDD VDD sg13_lv_pmos ad=0.19p pd=1.38u as=0 ps=0 w=1u l=1u
X738 VSS.t2067 VDD VSS.t2066 VSS.t2065 sg13_lv_nmos ad=0.1428p pd=1.52u as=0 ps=0 w=0.42u l=1u
X739 VSS.t282 VDD VSS.t282 VSS.t284 sg13_lv_nmos ad=0.1428p pd=1.52u as=0 ps=0 w=0.42u l=1u
X740 VSS.t2975 VDD VSS.t2977 VSS.t2976 sg13_lv_nmos ad=79.8f pd=0.8u as=0 ps=0 w=0.42u l=1u
X741 VDD VSS.t2303 VDD VDD sg13_lv_pmos ad=0.34p pd=2.68u as=0 ps=0 w=1u l=1u
X742 VSS.t2344 VDD VSS.t2343 VSS.t2342 sg13_lv_nmos ad=0.1428p pd=1.52u as=0 ps=0 w=0.42u l=1u
X743 VSS.t2697 VDD VSS.t2698 VSS.t61 sg13_lv_nmos ad=79.8f pd=0.8u as=0 ps=0 w=0.42u l=1u
X744 VDD VSS.t413 VDD VDD sg13_lv_pmos ad=0.34p pd=2.68u as=0 ps=0 w=1u l=1u
X745 VDD VSS.t636 VDD VDD sg13_lv_pmos ad=0.34p pd=2.68u as=0 ps=0 w=1u l=1u
X746 VSS.t1670 VDD VSS.t1672 VSS.t1671 sg13_lv_nmos ad=79.8f pd=0.8u as=0 ps=0 w=0.42u l=1u
X747 VSS.t2773 VDD VSS.t2774 VSS.t61 sg13_lv_nmos ad=79.8f pd=0.8u as=0 ps=0 w=0.42u l=1u
X748 VSS.t1912 VDD VSS.t1911 VSS.t1910 sg13_lv_nmos ad=0.1428p pd=1.52u as=0 ps=0 w=0.42u l=1u
X749 VDD VSS.t790 VDD VDD sg13_lv_pmos ad=0.34p pd=2.68u as=0 ps=0 w=1u l=1u
X750 VDD VSS.t3042 VDD VDD sg13_lv_pmos ad=0.19p pd=1.38u as=0 ps=0 w=1u l=1u
X751 VDD VSS.t1909 VDD VDD sg13_lv_pmos ad=0.19p pd=1.38u as=0 ps=0 w=1u l=1u
X752 VSS.t15 a_3333_15213# a_3435_15356# VSS.t3298 sg13_lv_nmos ad=4.11262p pd=27.15u as=0.2516p ps=2.16u w=0.74u l=0.13u
X753 VSS.t4 a_14261_15238# sg13cmos5l_or3_1_1.B VSS.t248 sg13_lv_nmos ad=0.1406p pd=1.12u as=0.1406p ps=1.12u w=0.74u l=0.13u
X754 VDD VSS.t8 VDD VDD sg13_lv_pmos ad=0.34p pd=2.68u as=0 ps=0 w=1u l=1u
X755 VSS.t1625 VDD VSS.t1624 VSS.t1623 sg13_lv_nmos ad=0.1428p pd=1.52u as=0 ps=0 w=0.42u l=1u
X756 VSS.t1294 VDD VSS.t1293 VSS.t70 sg13_lv_nmos ad=0.1428p pd=1.52u as=0 ps=0 w=0.42u l=1u
X757 VSS.t1326 VDD VSS.t1327 VSS.t70 sg13_lv_nmos ad=79.8f pd=0.8u as=0 ps=0 w=0.42u l=1u
X758 VDD VSS.t1268 VDD VDD sg13_lv_pmos ad=0.34p pd=2.68u as=0 ps=0 w=1u l=1u
X759 VDD VSS.t2774 VDD VDD sg13_lv_pmos ad=0.34p pd=2.68u as=0 ps=0 w=1u l=1u
X760 VDD VSS.t2071 VDD VDD sg13_lv_pmos ad=0.34p pd=2.68u as=0 ps=0 w=1u l=1u
X761 VSS.t253 VDD VSS.t253 VSS.t474 sg13_lv_nmos ad=0.1428p pd=1.52u as=0 ps=0 w=0.42u l=1u
X762 VSS.t1600 VDD VSS.t1602 VSS.t1601 sg13_lv_nmos ad=79.8f pd=0.8u as=0 ps=0 w=0.42u l=1u
X763 VDD VSS.t2276 VDD VDD sg13_lv_pmos ad=0.19p pd=1.38u as=0 ps=0 w=1u l=1u
X764 a_2890_15457# a_3333_15213# a_3273_15625# VDD sg13_lv_pmos ad=79.8f pd=0.8u as=63f ps=0.72u w=0.42u l=0.13u
X765 VSS.t4 VDD VSS.t47 VSS.t478 sg13_lv_nmos ad=0.1428p pd=1.52u as=0 ps=0 w=0.42u l=1u
X766 VDD VSS.t642 VDD VDD sg13_lv_pmos ad=0.19p pd=1.38u as=0 ps=0 w=1u l=1u
X767 VDD VSS.t843 VDD VDD sg13_lv_pmos ad=0.19p pd=1.38u as=0 ps=0 w=1u l=1u
X768 VSS.t1247 VDD VSS.t1248 VSS.t70 sg13_lv_nmos ad=79.8f pd=0.8u as=0 ps=0 w=0.42u l=1u
X769 VDD VSS.t1271 VDD VDD sg13_lv_pmos ad=0.19p pd=1.38u as=0 ps=0 w=1u l=1u
X770 VSS.t1465 VDD VSS.t1467 VSS.t1466 sg13_lv_nmos ad=79.8f pd=0.8u as=0 ps=0 w=0.42u l=1u
X771 VSS.t1882 VDD VSS.t1884 VSS.t1883 sg13_lv_nmos ad=79.8f pd=0.8u as=0 ps=0 w=0.42u l=1u
X772 VSS.t1011 VDD VSS.t1010 VSS.t1009 sg13_lv_nmos ad=0.1428p pd=1.52u as=0 ps=0 w=0.42u l=1u
X773 VDD VSS.t1564 VDD VDD sg13_lv_pmos ad=0.34p pd=2.68u as=0 ps=0 w=1u l=1u
X774 VDD VSS.t1619 VDD VDD sg13_lv_pmos ad=0.34p pd=2.68u as=0 ps=0 w=1u l=1u
X775 VSS.t1173 VDD VSS.t1174 VSS.t70 sg13_lv_nmos ad=79.8f pd=0.8u as=0 ps=0 w=0.42u l=1u
X776 VDD VSS.t1901 VDD VDD sg13_lv_pmos ad=0.34p pd=2.68u as=0 ps=0 w=1u l=1u
X777 VDD VSS.t2733 VDD VDD sg13_lv_pmos ad=0.34p pd=2.68u as=0 ps=0 w=1u l=1u
X778 VSS.t321 VDD VSS.t320 VSS.t319 sg13_lv_nmos ad=0.1428p pd=1.52u as=0 ps=0 w=0.42u l=1u
X779 VDD VSS.t298 VDD VDD sg13_lv_pmos ad=0.19p pd=1.38u as=0 ps=0 w=1u l=1u
X780 VSS.t1436 VDD VSS.t1306 VSS.t70 sg13_lv_nmos ad=0.1428p pd=1.52u as=0 ps=0 w=0.42u l=1u
X781 VSS.t2922 VDD VSS.t2920 VSS.t2921 sg13_lv_nmos ad=79.8f pd=0.8u as=0 ps=0 w=0.42u l=1u
X782 VSS.t645 VDD VSS.t645 VSS.t770 sg13_lv_nmos ad=0.1428p pd=1.52u as=0 ps=0 w=0.42u l=1u
X783 VDD VSS.t1914 VDD VDD sg13_lv_pmos ad=0.19p pd=1.38u as=0 ps=0 w=1u l=1u
X784 VSS.t2746 VDD VSS.t2745 VSS.t61 sg13_lv_nmos ad=0.1428p pd=1.52u as=0 ps=0 w=0.42u l=1u
X785 VDD VSS.t2493 VDD VDD sg13_lv_pmos ad=0.34p pd=2.68u as=0 ps=0 w=1u l=1u
X786 VDD VSS.t216 VDD VDD sg13_lv_pmos ad=0.34p pd=2.68u as=0 ps=0 w=1u l=1u
X787 VDD VSS.t2680 VDD VDD sg13_lv_pmos ad=0.19p pd=1.38u as=0 ps=0 w=1u l=1u
X788 VSS.t2329 VDD VSS.t2328 VSS.t2327 sg13_lv_nmos ad=0.1428p pd=1.52u as=0 ps=0 w=0.42u l=1u
X789 VSS.t702 VDD VSS.t81 VSS.t703 sg13_lv_nmos ad=79.8f pd=0.8u as=0 ps=0 w=0.42u l=1u
X790 VDD VSS.t795 VDD VDD sg13_lv_pmos ad=0.34p pd=2.68u as=0 ps=0 w=1u l=1u
X791 VSS.t1229 VDD VSS.t1228 VSS.t70 sg13_lv_nmos ad=0.1428p pd=1.52u as=0 ps=0 w=0.42u l=1u
X792 VSS.t2102 VDD VSS.t2101 VSS.t2100 sg13_lv_nmos ad=0.1428p pd=1.52u as=0 ps=0 w=0.42u l=1u
X793 a_3333_16033# a_3333_16033# VSS.t18 VSS.t17 sg13_lv_nmos ad=0.111p pd=1.34u as=7.70437p ps=50.66u w=0.3u l=0.13u
X794 VSS.t303 VDD VSS.t303 VSS.t305 sg13_lv_nmos ad=0.1428p pd=1.52u as=0 ps=0 w=0.42u l=1u
X795 VSS.t15 a_6789_14495# a_6891_14495# VSS.t239 sg13_lv_nmos ad=4.11262p pd=27.15u as=0.2516p ps=2.16u w=0.74u l=0.13u
X796 VSS.t565 VDD VSS.t567 VSS.t566 sg13_lv_nmos ad=79.8f pd=0.8u as=0 ps=0 w=0.42u l=1u
X797 VDD VSS.t621 VDD VDD sg13_lv_pmos ad=0.34p pd=2.68u as=0 ps=0 w=1u l=1u
X798 VSS.t53 a_10222_14751# sg13cmos5l_dlygate4sd3_1_8.X VSS.t178 sg13_lv_nmos ad=0.1426p pd=1.16u as=0.2516p ps=2.16u w=0.74u l=0.13u
X799 VDD VSS.t1597 VDD VDD sg13_lv_pmos ad=0.19p pd=1.38u as=0 ps=0 w=1u l=1u
X800 VDD a_21070_15423# sg13cmos5l_dlygate4sd3_1_9.X VDD sg13_lv_pmos ad=0.2254p pd=1.53u as=0.4256p ps=3u w=1.12u l=0.13u
X801 VDD VSS.t960 VDD VDD sg13_lv_pmos ad=0.34p pd=2.68u as=0 ps=0 w=1u l=1u
X802 VSS.t1485 VDD VSS.t1487 VSS.t1486 sg13_lv_nmos ad=79.8f pd=0.8u as=0 ps=0 w=0.42u l=1u
X803 VSS.t2394 VDD VSS.t2396 VSS.t2395 sg13_lv_nmos ad=79.8f pd=0.8u as=0 ps=0 w=0.42u l=1u
X804 VDD VSS.t273 VDD VDD sg13_lv_pmos ad=0.34p pd=2.68u as=0 ps=0 w=1u l=1u
X805 VSS.t831 VDD VSS.t830 VSS.t829 sg13_lv_nmos ad=0.1428p pd=1.52u as=0 ps=0 w=0.42u l=1u
X806 VDD VSS.t1188 VDD VDD sg13_lv_pmos ad=0.19p pd=1.38u as=0 ps=0 w=1u l=1u
X807 VDD VSS.t1969 VDD VDD sg13_lv_pmos ad=0.19p pd=1.38u as=0 ps=0 w=1u l=1u
X808 VSS.t1187 VDD VSS.t1188 VSS.t70 sg13_lv_nmos ad=79.8f pd=0.8u as=0 ps=0 w=0.42u l=1u
X809 VSS.t1615 VDD VSS.t1614 VSS.t1613 sg13_lv_nmos ad=0.1428p pd=1.52u as=0 ps=0 w=0.42u l=1u
X810 VSS.t3140 VDD VSS.t3139 VSS.t3138 sg13_lv_nmos ad=0.1428p pd=1.52u as=0 ps=0 w=0.42u l=1u
X811 VDD VSS.t2288 VDD VDD sg13_lv_pmos ad=0.34p pd=2.68u as=0 ps=0 w=1u l=1u
X812 VSS.t2687 VDD VSS.t2689 VSS.t61 sg13_lv_nmos ad=79.8f pd=0.8u as=0 ps=0 w=0.42u l=1u
X813 VSS.t216 a_19323_13726# sg13cmos5l_buf_8_2.X VSS.t215 sg13_lv_nmos ad=0.2516p pd=2.16u as=0.1406p ps=1.12u w=0.74u l=0.13u
X814 a_9418_15457# a_9861_15213# a_9158_15234# VSS.t89 sg13_lv_nmos ad=79.8f pd=0.8u as=0.1296p ps=1.52u w=0.42u l=0.13u
X815 VSS.t1897 VDD VSS.t1896 VSS.t1895 sg13_lv_nmos ad=0.1428p pd=1.52u as=0 ps=0 w=0.42u l=1u
X816 VSS.t618 VDD VSS.t618 VSS.t619 sg13_lv_nmos ad=79.8f pd=0.8u as=0 ps=0 w=0.42u l=1u
X817 VDD VSS.t1023 VDD VDD sg13_lv_pmos ad=0.19p pd=1.38u as=0 ps=0 w=1u l=1u
X818 VSS.t1610 VDD VSS.t1609 VSS.t1608 sg13_lv_nmos ad=0.1428p pd=1.52u as=0 ps=0 w=0.42u l=1u
X819 VDD VSS.t363 VDD VDD sg13_lv_pmos ad=0.19p pd=1.38u as=0 ps=0 w=1u l=1u
X820 VSS.t570 VDD VSS.t569 VSS.t568 sg13_lv_nmos ad=0.1428p pd=1.52u as=0 ps=0 w=0.42u l=1u
X821 VDD VSS.t950 VDD VDD sg13_lv_pmos ad=0.34p pd=2.68u as=0 ps=0 w=1u l=1u
X822 VSS.t1243 VDD VSS.t1242 VSS.t70 sg13_lv_nmos ad=0.1428p pd=1.52u as=0 ps=0 w=0.42u l=1u
X823 VSS.t1525 VDD VSS.t1527 VSS.t1526 sg13_lv_nmos ad=79.8f pd=0.8u as=0 ps=0 w=0.42u l=1u
X824 VDD VSS.t3044 VDD VDD sg13_lv_pmos ad=0.34p pd=2.68u as=0 ps=0 w=1u l=1u
X825 VDD VSS.t2253 VDD VDD sg13_lv_pmos ad=0.34p pd=2.68u as=0 ps=0 w=1u l=1u
X826 VDD a_3333_15213# a_3435_15356# VDD sg13_lv_pmos ad=2.8961p pd=18.25u as=0.3864p ps=2.93u w=1.12u l=0.13u
X827 VDD sg13cmos5l_dfrbpq_1_2.RESET_B a_16042_13945# VDD sg13_lv_pmos ad=0.1563p pd=1.22u as=0.147p ps=1.54u w=0.42u l=0.13u
X828 VSS.t2686 VDD VSS.t2687 VSS.t61 sg13_lv_nmos ad=79.8f pd=0.8u as=0 ps=0 w=0.42u l=1u
X829 VDD VSS.t2426 VDD VDD sg13_lv_pmos ad=0.19p pd=1.38u as=0 ps=0 w=1u l=1u
X830 VDD VSS.t2653 VDD VDD sg13_lv_pmos ad=0.19p pd=1.38u as=0 ps=0 w=1u l=1u
X831 VDD VSS.t104 VDD VDD sg13_lv_pmos ad=0.19p pd=1.38u as=0 ps=0 w=1u l=1u
X832 VDD VSS.t1961 VDD VDD sg13_lv_pmos ad=0.34p pd=2.68u as=0 ps=0 w=1u l=1u
X833 VSS.t715 VDD VSS.t591 VSS.t716 sg13_lv_nmos ad=79.8f pd=0.8u as=0 ps=0 w=0.42u l=1u
X834 VSS.t986 VDD VSS.t985 VSS.t984 sg13_lv_nmos ad=0.1428p pd=1.52u as=0 ps=0 w=0.42u l=1u
X835 VDD VSS.t1549 VDD VDD sg13_lv_pmos ad=0.34p pd=2.68u as=0 ps=0 w=1u l=1u
X836 VSS.t1169 VDD VSS.t1168 VSS.t70 sg13_lv_nmos ad=0.1428p pd=1.52u as=0 ps=0 w=0.42u l=1u
X837 VSS.t1411 VDD VSS.t1279 VSS.t70 sg13_lv_nmos ad=79.8f pd=0.8u as=0 ps=0 w=0.42u l=1u
X838 VDD VSS.t1604 VDD VDD sg13_lv_pmos ad=0.34p pd=2.68u as=0 ps=0 w=1u l=1u
X839 VSS.t438 VDD VSS.t437 VSS.t15 sg13_lv_nmos ad=0.1428p pd=1.52u as=0 ps=0 w=0.42u l=1u
X840 VSS.t2980 VDD VSS.t2982 VSS.t2981 sg13_lv_nmos ad=79.8f pd=0.8u as=0 ps=0 w=0.42u l=1u
X841 VSS.t2349 VDD VSS.t2348 VSS.t2347 sg13_lv_nmos ad=0.1428p pd=1.52u as=0 ps=0 w=0.42u l=1u
X842 VSS.t921 VDD VSS.t923 VSS.t922 sg13_lv_nmos ad=79.8f pd=0.8u as=0 ps=0 w=0.42u l=1u
X843 VSS.t2699 VDD VSS.t2701 VSS.t61 sg13_lv_nmos ad=79.8f pd=0.8u as=0 ps=0 w=0.42u l=1u
X844 a_21460_14020# sg13cmos5l_or3_1_2.A VDD VDD sg13_lv_pmos ad=0.1575p pd=1.315u as=0.3822p ps=1.84u w=1u l=0.13u
X845 VDD VSS.t990 VDD VDD sg13_lv_pmos ad=0.34p pd=2.68u as=0 ps=0 w=1u l=1u
X846 VDD VSS.t2665 VDD VDD sg13_lv_pmos ad=0.34p pd=2.68u as=0 ps=0 w=1u l=1u
X847 VSS.t211 a_19323_13726# sg13cmos5l_buf_8_2.X VSS.t210 sg13_lv_nmos ad=0.1406p pd=1.12u as=0.1406p ps=1.12u w=0.74u l=0.13u
X848 VSS.t2776 VDD VSS.t2776 VSS.t61 sg13_lv_nmos ad=79.8f pd=0.8u as=0 ps=0 w=0.42u l=1u
X849 VSS.t142 VDD VSS.t142 VSS.t668 sg13_lv_nmos ad=79.8f pd=0.8u as=0 ps=0 w=0.42u l=1u
X850 VDD VSS.t1224 VDD VDD sg13_lv_pmos ad=0.19p pd=1.38u as=0 ps=0 w=1u l=1u
X851 VDD a_12524_15960# counter_value_o[2] VDD sg13_lv_pmos ad=0.2114p pd=1.54u as=0.42p ps=2.99u w=1.12u l=0.13u
X852 VSS.t518 VDD VSS.t521 VSS.t520 sg13_lv_nmos ad=79.8f pd=0.8u as=0 ps=0 w=0.42u l=1u
X853 VSS.t599 VDD VSS.t601 VSS.t722 sg13_lv_nmos ad=79.8f pd=0.8u as=0 ps=0 w=0.42u l=1u
X854 VDD VSS.t913 VDD VDD sg13_lv_pmos ad=0.19p pd=1.38u as=0 ps=0 w=1u l=1u
X855 VDD VSS.t1271 VDD VDD sg13_lv_pmos ad=0.34p pd=2.68u as=0 ps=0 w=1u l=1u
X856 VDD VSS.t2672 VDD VDD sg13_lv_pmos ad=0.19p pd=1.38u as=0 ps=0 w=1u l=1u
X857 VDD VSS.t2776 VDD VDD sg13_lv_pmos ad=0.34p pd=2.68u as=0 ps=0 w=1u l=1u
X858 VSS.t2314 VDD VSS.t2313 VSS.t2312 sg13_lv_nmos ad=0.1428p pd=1.52u as=0 ps=0 w=0.42u l=1u
X859 VDD VSS.t2076 VDD VDD sg13_lv_pmos ad=0.34p pd=2.68u as=0 ps=0 w=1u l=1u
X860 VSS.t1256 VDD VSS.t1255 VSS.t70 sg13_lv_nmos ad=0.1428p pd=1.52u as=0 ps=0 w=0.42u l=1u
X861 VSS.t1927 VDD VSS.t1929 VSS.t1928 sg13_lv_nmos ad=79.8f pd=0.8u as=0 ps=0 w=0.42u l=1u
X862 VSS.t282 VDD VSS.t282 VSS.t283 sg13_lv_nmos ad=79.8f pd=0.8u as=0 ps=0 w=0.42u l=1u
X863 sg13cmos5l_o21ai_1_2.A2 sg13cmos5l_dfrbpq_1_2.Q VDD VDD sg13_lv_pmos ad=0.2128p pd=1.5u as=0.3808p ps=2.92u w=1.12u l=0.13u
X864 VDD VSS.t2645 VDD VDD sg13_lv_pmos ad=0.19p pd=1.38u as=0 ps=0 w=1u l=1u
X865 VSS.t1867 VDD VSS.t1866 VSS.t1865 sg13_lv_nmos ad=0.1428p pd=1.52u as=0 ps=0 w=0.42u l=1u
X866 VSS.t15 a_4474_14448# a_4193_14750# VSS.t117 sg13_lv_nmos ad=79.8f pd=0.8u as=0.1428p ps=1.52u w=0.42u l=0.5u
X867 a_24263_14508# sg13cmos5l_o21ai_1_2.A2 a_24169_14508# VDD sg13_lv_pmos ad=0.19p pd=1.38u as=0.34p ps=2.68u w=1u l=0.13u
X868 a_21060_14488# a_21034_14452# VDD VDD sg13_lv_pmos ad=0.34p pd=2.68u as=0.36237p ps=2.605u w=1u l=0.13u
X869 VSS.t1470 VDD VSS.t1472 VSS.t1471 sg13_lv_nmos ad=79.8f pd=0.8u as=0 ps=0 w=0.42u l=1u
X870 VSS.t831 VDD VSS.t830 VSS.t829 sg13_lv_nmos ad=0.1428p pd=1.52u as=0 ps=0 w=0.42u l=1u
X871 VSS.t1261 VDD VSS.t1260 VSS.t70 sg13_lv_nmos ad=0.1428p pd=1.52u as=0 ps=0 w=0.42u l=1u
X872 VSS.t2655 VDD VSS.t2656 VSS.t61 sg13_lv_nmos ad=79.8f pd=0.8u as=0 ps=0 w=0.42u l=1u
X873 VSS.t2379 VDD VSS.t2381 VSS.t2380 sg13_lv_nmos ad=79.8f pd=0.8u as=0 ps=0 w=0.42u l=1u
X874 VDD VSS.t788 VDD VDD sg13_lv_pmos ad=0.19p pd=1.38u as=0 ps=0 w=1u l=1u
X875 VDD VSS.t1233 VDD VDD sg13_lv_pmos ad=0.19p pd=1.38u as=0 ps=0 w=1u l=1u
X876 VDD VSS.t2907 VDD VDD sg13_lv_pmos ad=0.19p pd=1.38u as=0 ps=0 w=1u l=1u
X877 VDD VSS.t1954 VDD VDD sg13_lv_pmos ad=0.19p pd=1.38u as=0 ps=0 w=1u l=1u
X878 VSS.t47 sg13cmos5l_or3_1_2.B a_16175_15238# VSS.t3259 sg13_lv_nmos ad=0.1898p pd=1.36u as=0.1406p ps=1.12u w=0.74u l=0.13u
X879 VSS.t587 VDD VSS.t587 VSS.t588 sg13_lv_nmos ad=79.8f pd=0.8u as=0 ps=0 w=0.42u l=1u
X880 VDD VSS.t1906 VDD VDD sg13_lv_pmos ad=0.34p pd=2.68u as=0 ps=0 w=1u l=1u
X881 VDD VSS.t2735 VDD VDD sg13_lv_pmos ad=0.34p pd=2.68u as=0 ps=0 w=1u l=1u
X882 VSS.t2899 VDD VSS.t2784 VSS.t61 sg13_lv_nmos ad=0.1428p pd=1.52u as=0 ps=0 w=0.42u l=1u
X883 VDD VSS.t2656 VDD VDD sg13_lv_pmos ad=0.34p pd=2.68u as=0 ps=0 w=1u l=1u
X884 VSS.t187 VDD VSS.t192 VSS.t473 sg13_lv_nmos ad=79.8f pd=0.8u as=0 ps=0 w=0.42u l=1u
X885 sg13cmos5l_buf_1_10.X a_1192_9948# VSS.t71 VSS.t70 sg13_lv_nmos ad=0.2886p pd=2.26u as=0.14875p ps=1.16u w=0.74u l=0.13u
X886 VDD VSS.t1196 VDD VDD sg13_lv_pmos ad=0.34p pd=2.68u as=0 ps=0 w=1u l=1u
X887 VSS.t2925 VDD VSS.t2927 VSS.t2926 sg13_lv_nmos ad=79.8f pd=0.8u as=0 ps=0 w=0.42u l=1u
X888 sg13cmos5l_dfrbpq_1_5.Q a_28074_14020# VSS.t8 VSS.t7 sg13_lv_nmos ad=0.2516p pd=2.16u as=0.1406p ps=1.12u w=0.74u l=0.13u
X889 VDD VSS.t880 VDD VDD sg13_lv_pmos ad=0.34p pd=2.68u as=0 ps=0 w=1u l=1u
X890 VSS.t1202 VDD VSS.t1201 VSS.t70 sg13_lv_nmos ad=0.1428p pd=1.52u as=0 ps=0 w=0.42u l=1u
X891 VDD VSS.t2463 VDD VDD sg13_lv_pmos ad=0.34p pd=2.68u as=0 ps=0 w=1u l=1u
X892 sg13cmos5l_or3_1_2.B a_16168_15996# VDD VDD sg13_lv_pmos ad=0.42p pd=2.99u as=0.2114p ps=1.54u w=1.12u l=0.13u
X893 VDD VSS.t995 VDD VDD sg13_lv_pmos ad=0.34p pd=2.68u as=0 ps=0 w=1u l=1u
X894 VDD VSS.t2683 VDD VDD sg13_lv_pmos ad=0.19p pd=1.38u as=0 ps=0 w=1u l=1u
X895 VSS.t2709 VDD VSS.t2708 VSS.t61 sg13_lv_nmos ad=0.1428p pd=1.52u as=0 ps=0 w=0.42u l=1u
X896 VSS.t2334 VDD VSS.t2333 VSS.t2332 sg13_lv_nmos ad=0.1428p pd=1.52u as=0 ps=0 w=0.42u l=1u
X897 VDD VSS.t2238 VDD VDD sg13_lv_pmos ad=0.34p pd=2.68u as=0 ps=0 w=1u l=1u
X898 VSS.t1690 VDD VSS.t1689 VSS.t1688 sg13_lv_nmos ad=0.1428p pd=1.52u as=0 ps=0 w=0.42u l=1u
X899 VSS.t2072 VDD VSS.t2071 VSS.t2070 sg13_lv_nmos ad=0.1428p pd=1.52u as=0 ps=0 w=0.42u l=1u
X900 VDD a_7680_15549# sg13cmos5l_xnor2_1_0.Y VDD sg13_lv_pmos ad=0.3808p pd=2.92u as=0.2408p ps=1.55u w=1.12u l=0.13u
X901 VDD VSS.t1592 VDD VDD sg13_lv_pmos ad=0.19p pd=1.38u as=0 ps=0 w=1u l=1u
X902 VSS.t2784 VDD VSS.t2783 VSS.t61 sg13_lv_nmos ad=0.1428p pd=1.52u as=0 ps=0 w=0.42u l=1u
X903 VSS.t2677 VDD VSS.t2678 VSS.t61 sg13_lv_nmos ad=79.8f pd=0.8u as=0 ps=0 w=0.42u l=1u
X904 VDD VSS.t1602 VDD VDD sg13_lv_pmos ad=0.19p pd=1.38u as=0 ps=0 w=1u l=1u
X905 VSS.t18 a_3209_16334# a_3130_16237# VSS.t3218 sg13_lv_nmos ad=7.70437p pd=50.66u as=0.27427p ps=2.28u w=0.795u l=0.13u
X906 VSS.t986 VDD VSS.t985 VSS.t984 sg13_lv_nmos ad=0.1428p pd=1.52u as=0 ps=0 w=0.42u l=1u
X907 VSS.t1031 VDD VSS.t1030 VSS.t1029 sg13_lv_nmos ad=0.1428p pd=1.52u as=0 ps=0 w=0.42u l=1u
X908 VSS.t921 VDD VSS.t923 VSS.t922 sg13_lv_nmos ad=79.8f pd=0.8u as=0 ps=0 w=0.42u l=1u
X909 VDD VSS.t1214 VDD VDD sg13_lv_pmos ad=0.34p pd=2.68u as=0 ps=0 w=1u l=1u
X910 VSS.t1433 VDD VSS.t1306 VSS.t70 sg13_lv_nmos ad=79.8f pd=0.8u as=0 ps=0 w=0.42u l=1u
X911 VDD VSS.t1191 VDD VDD sg13_lv_pmos ad=0.19p pd=1.38u as=0 ps=0 w=1u l=1u
X912 VDD VSS.t2755 VDD VDD sg13_lv_pmos ad=0.19p pd=1.38u as=0 ps=0 w=1u l=1u
X913 VDD VSS.t1974 VDD VDD sg13_lv_pmos ad=0.19p pd=1.38u as=0 ps=0 w=1u l=1u
X914 VSS.t1620 VDD VSS.t1619 VSS.t1618 sg13_lv_nmos ad=0.1428p pd=1.52u as=0 ps=0 w=0.42u l=1u
X915 VSS.t3145 VDD VSS.t3144 VSS.t3143 sg13_lv_nmos ad=0.1428p pd=1.52u as=0 ps=0 w=0.42u l=1u
X916 VDD VSS.t2293 VDD VDD sg13_lv_pmos ad=0.34p pd=2.68u as=0 ps=0 w=1u l=1u
X917 a_27215_14845# a_26373_14495# a_27121_14845# VSS.t15 sg13_lv_nmos ad=0.12665p pd=1.145u as=0.1428p ps=1.52u w=0.42u l=0.13u
X918 VSS.t2691 VDD VSS.t2692 VSS.t61 sg13_lv_nmos ad=79.8f pd=0.8u as=0 ps=0 w=0.42u l=1u
X919 VDD VSS.t1035 VDD VDD sg13_lv_pmos ad=0.34p pd=2.68u as=0 ps=0 w=1u l=1u
X920 VSS.t1902 VDD VSS.t1901 VSS.t1900 sg13_lv_nmos ad=0.1428p pd=1.52u as=0 ps=0 w=0.42u l=1u
X921 VDD VSS.t621 VDD VDD sg13_lv_pmos ad=0.19p pd=1.38u as=0 ps=0 w=1u l=1u
X922 VSS.t2910 VDD VSS.t2912 VSS.t2911 sg13_lv_nmos ad=79.8f pd=0.8u as=0 ps=0 w=0.42u l=1u
X923 VSS.t2767 VDD VSS.t2768 VSS.t61 sg13_lv_nmos ad=79.8f pd=0.8u as=0 ps=0 w=0.42u l=1u
X924 VDD VSS.t1251 VDD VDD sg13_lv_pmos ad=0.19p pd=1.38u as=0 ps=0 w=1u l=1u
X925 VSS.t1324 VDD VSS.t1325 VSS.t70 sg13_lv_nmos ad=79.8f pd=0.8u as=0 ps=0 w=0.42u l=1u
X926 VDD VSS.t2306 VDD VDD sg13_lv_pmos ad=0.19p pd=1.38u as=0 ps=0 w=1u l=1u
X927 VSS.t345 VDD VSS.t344 VSS.t343 sg13_lv_nmos ad=0.1428p pd=1.52u as=0 ps=0 w=0.42u l=1u
X928 VDD VSS.t958 VDD VDD sg13_lv_pmos ad=0.19p pd=1.38u as=0 ps=0 w=1u l=1u
X929 VDD sg13cmos5l_dfrbpq_1_2.Q a_16552_15996# VDD sg13_lv_pmos ad=0.2114p pd=1.54u as=0.2856p ps=2.36u w=0.84u l=0.13u
X930 VDD VSS.t1263 VDD VDD sg13_lv_pmos ad=0.34p pd=2.68u as=0 ps=0 w=1u l=1u
X931 VSS.t1530 VDD VSS.t1532 VSS.t1531 sg13_lv_nmos ad=79.8f pd=0.8u as=0 ps=0 w=0.42u l=1u
X932 VDD VSS.t2768 VDD VDD sg13_lv_pmos ad=0.34p pd=2.68u as=0 ps=0 w=1u l=1u
X933 VSS.t2689 VDD VSS.t2690 VSS.t61 sg13_lv_nmos ad=79.8f pd=0.8u as=0 ps=0 w=0.42u l=1u
X934 VDD VSS.t2431 VDD VDD sg13_lv_pmos ad=0.19p pd=1.38u as=0 ps=0 w=1u l=1u
X935 VSS.t2092 VDD VSS.t2091 VSS.t2090 sg13_lv_nmos ad=0.1428p pd=1.52u as=0 ps=0 w=0.42u l=1u
X936 VSS.t1912 VDD VSS.t1914 VSS.t1913 sg13_lv_nmos ad=79.8f pd=0.8u as=0 ps=0 w=0.42u l=1u
X937 VSS.t841 VDD VSS.t843 VSS.t842 sg13_lv_nmos ad=79.8f pd=0.8u as=0 ps=0 w=0.42u l=1u
X938 VDD VSS.t2636 VDD VDD sg13_lv_pmos ad=0.19p pd=1.38u as=0 ps=0 w=1u l=1u
X939 VSS.t1852 VDD VSS.t1851 VSS.t1850 sg13_lv_nmos ad=0.1428p pd=1.52u as=0 ps=0 w=0.42u l=1u
X940 a_21417_14531# a_21060_14488# VDD VDD sg13_lv_pmos ad=63f pd=0.72u as=0.1563p ps=1.22u w=0.42u l=0.13u
X941 VSS.t1451 VDD VSS.t1329 VSS.t70 sg13_lv_nmos ad=79.8f pd=0.8u as=0 ps=0 w=0.42u l=1u
X942 VSS.t2940 VDD VSS.t2939 VSS.t2938 sg13_lv_nmos ad=0.1428p pd=1.52u as=0 ps=0 w=0.42u l=1u
X943 VDD VSS.t1319 VDD VDD sg13_lv_pmos ad=0.34p pd=2.68u as=0 ps=0 w=1u l=1u
X944 VDD VSS.t1050 VDD VDD sg13_lv_pmos ad=0.34p pd=2.68u as=0 ps=0 w=1u l=1u
X945 VDD VSS.t2690 VDD VDD sg13_lv_pmos ad=0.34p pd=2.68u as=0 ps=0 w=1u l=1u
X946 VDD VSS.t1931 VDD VDD sg13_lv_pmos ad=0.34p pd=2.68u as=0 ps=0 w=1u l=1u
X947 a_3204_15247# a_3435_15356# a_2890_15457# VSS.t3243 sg13_lv_nmos ad=0.2373p pd=1.97u as=79.8f ps=0.8u w=0.42u l=0.13u
X948 VDD VSS.t2116 VDD VDD sg13_lv_pmos ad=0.34p pd=2.68u as=0 ps=0 w=1u l=1u
X949 a_3142_15247# sg13cmos5l_dfrbpq_1_0.RESET_B VSS.t36 VSS.t3200 sg13_lv_nmos ad=37.8f pd=0.6u as=0.1701p ps=1.65u w=0.42u l=0.13u
X950 VSS.t565 VDD VSS.t567 VSS.t566 sg13_lv_nmos ad=79.8f pd=0.8u as=0 ps=0 w=0.42u l=1u
X951 VDD VSS.t1614 VDD VDD sg13_lv_pmos ad=0.34p pd=2.68u as=0 ps=0 w=1u l=1u
X952 VDD VSS.t1891 VDD VDD sg13_lv_pmos ad=0.34p pd=2.68u as=0 ps=0 w=1u l=1u
X953 VDD VSS.t2727 VDD VDD sg13_lv_pmos ad=0.34p pd=2.68u as=0 ps=0 w=1u l=1u
X954 VSS.t142 a_8218_13690# a_7937_13912# VSS.t141 sg13_lv_nmos ad=79.8f pd=0.8u as=0.1428p ps=1.52u w=0.42u l=0.5u
X955 VSS.t2758 VDD VSS.t2759 VSS.t61 sg13_lv_nmos ad=79.8f pd=0.8u as=0 ps=0 w=0.42u l=1u
X956 VDD VSS.t925 VDD VDD sg13_lv_pmos ad=0.34p pd=2.68u as=0 ps=0 w=1u l=1u
X957 VSS.t47 clock_i a_15579_14854# VSS.t3248 sg13_lv_nmos ad=0.1406p pd=1.12u as=0.2553p ps=2.17u w=0.74u l=0.13u
X958 VSS.t2699 VDD VSS.t2699 VSS.t61 sg13_lv_nmos ad=0.1428p pd=1.52u as=0 ps=0 w=0.42u l=1u
X959 VSS.t2319 VDD VSS.t2318 VSS.t2317 sg13_lv_nmos ad=0.1428p pd=1.52u as=0 ps=0 w=0.42u l=1u
X960 VDD VSS.t298 VDD VDD sg13_lv_pmos ad=0.19p pd=1.38u as=0 ps=0 w=1u l=1u
X961 VDD sg13cmos5l_dfrbpq_1_1.RESET_B a_6346_14452# VDD sg13_lv_pmos ad=0.1563p pd=1.22u as=0.147p ps=1.54u w=0.42u l=0.13u
X962 VDD VSS.t534 VDD VDD sg13_lv_pmos ad=0.34p pd=2.68u as=0 ps=0 w=1u l=1u
X963 VSS.t2776 VDD VSS.t2775 VSS.t61 sg13_lv_nmos ad=0.1428p pd=1.52u as=0 ps=0 w=0.42u l=1u
X964 VSS.t2042 VDD VSS.t2044 VSS.t2043 sg13_lv_nmos ad=79.8f pd=0.8u as=0 ps=0 w=0.42u l=1u
X965 VSS.t1031 VDD VSS.t1030 VSS.t1029 sg13_lv_nmos ad=0.1428p pd=1.52u as=0 ps=0 w=0.42u l=1u
X966 VSS.t1475 VDD VSS.t1477 VSS.t1476 sg13_lv_nmos ad=79.8f pd=0.8u as=0 ps=0 w=0.42u l=1u
X967 VDD VSS.t2353 VDD VDD sg13_lv_pmos ad=0.34p pd=2.68u as=0 ps=0 w=1u l=1u
X968 VSS.t2658 VDD VSS.t2659 VSS.t61 sg13_lv_nmos ad=79.8f pd=0.8u as=0 ps=0 w=0.42u l=1u
X969 VSS.t2384 VDD VSS.t2386 VSS.t2385 sg13_lv_nmos ad=79.8f pd=0.8u as=0 ps=0 w=0.42u l=1u
X970 VSS.t414 VDD VSS.t413 VSS.t15 sg13_lv_nmos ad=0.1428p pd=1.52u as=0 ps=0 w=0.42u l=1u
X971 a_6575_13342# a_6540_13238# sg13cmos5l_dlygate4sd3_1_0.A VSS.t158 sg13_lv_nmos ad=0.1406p pd=1.12u as=0.2516p ps=2.16u w=0.74u l=0.13u
X972 VDD VSS.t1594 VDD VDD sg13_lv_pmos ad=0.34p pd=2.68u as=0 ps=0 w=1u l=1u
X973 VSS.t1962 VDD VSS.t1961 VSS.t1960 sg13_lv_nmos ad=0.1428p pd=1.52u as=0 ps=0 w=0.42u l=1u
X974 VDD VSS.t1182 VDD VDD sg13_lv_pmos ad=0.19p pd=1.38u as=0 ps=0 w=1u l=1u
X975 VDD VSS.t1959 VDD VDD sg13_lv_pmos ad=0.19p pd=1.38u as=0 ps=0 w=1u l=1u
X976 VSS.t1222 VDD VSS.t1369 VSS.t70 sg13_lv_nmos ad=0.1428p pd=1.52u as=0 ps=0 w=0.42u l=1u
X977 VSS.t1605 VDD VSS.t1604 VSS.t1603 sg13_lv_nmos ad=0.1428p pd=1.52u as=0 ps=0 w=0.42u l=1u
X978 sg13cmos5l_o21ai_1_1.Y sg13cmos5l_or3_1_2.C a_20376_14464# VDD sg13_lv_pmos ad=0.2128p pd=1.5u as=0.2128p ps=1.5u w=1.12u l=0.15u
X979 VDD VSS.t1876 VDD VDD sg13_lv_pmos ad=0.34p pd=2.68u as=0 ps=0 w=1u l=1u
X980 VDD VSS.t1314 VDD VDD sg13_lv_pmos ad=0.34p pd=2.68u as=0 ps=0 w=1u l=1u
X981 VDD VSS.t2659 VDD VDD sg13_lv_pmos ad=0.34p pd=2.68u as=0 ps=0 w=1u l=1u
X982 VDD VSS.t2717 VDD VDD sg13_lv_pmos ad=0.34p pd=2.68u as=0 ps=0 w=1u l=1u
X983 a_12524_15960# sg13cmos5l_dlygate4sd3_1_8.A VSS.t136 VSS.t135 sg13_lv_nmos ad=0.187p pd=1.78u as=0.14875p ps=1.16u w=0.55u l=0.13u
X984 VDD VSS.t1294 VDD VDD sg13_lv_pmos ad=0.19p pd=1.38u as=0 ps=0 w=1u l=1u
X985 VDD VSS.t2671 VDD VDD sg13_lv_pmos ad=0.19p pd=1.38u as=0 ps=0 w=1u l=1u
X986 VSS.t951 VDD VSS.t950 VSS.t949 sg13_lv_nmos ad=0.1428p pd=1.52u as=0 ps=0 w=0.42u l=1u
X987 VDD VSS.t2468 VDD VDD sg13_lv_pmos ad=0.34p pd=2.68u as=0 ps=0 w=1u l=1u
X988 VSS.t841 VDD VSS.t843 VSS.t842 sg13_lv_nmos ad=79.8f pd=0.8u as=0 ps=0 w=0.42u l=1u
X989 VSS.t1241 VDD VSS.t1240 VSS.t70 sg13_lv_nmos ad=0.1428p pd=1.52u as=0 ps=0 w=0.42u l=1u
X990 sg13cmos5l_or3_1_1.C sg13cmos5l_dfrbpq_1_2.Q VDD VDD sg13_lv_pmos ad=0.2128p pd=1.5u as=0.3808p ps=2.92u w=1.12u l=0.13u
X991 a_24408_15552# sg13cmos5l_or3_1_2.B VDD VDD sg13_lv_pmos ad=0.2128p pd=1.5u as=0.3808p ps=2.92u w=1.12u l=0.15u
X992 VDD VSS.t633 VDD VDD sg13_lv_pmos ad=0.34p pd=2.68u as=0 ps=0 w=1u l=1u
X993 VSS.t1695 VDD VSS.t1694 VSS.t1693 sg13_lv_nmos ad=0.1428p pd=1.52u as=0 ps=0 w=0.42u l=1u
X994 VSS.t2680 VDD VSS.t2681 VSS.t61 sg13_lv_nmos ad=79.8f pd=0.8u as=0 ps=0 w=0.42u l=1u
X995 VSS.t2077 VDD VSS.t2076 VSS.t2075 sg13_lv_nmos ad=0.1428p pd=1.52u as=0 ps=0 w=0.42u l=1u
X996 VSS.t28 a_27502_15423# sg13cmos5l_or3_1_1.A VSS.t15 sg13_lv_nmos ad=0.1426p pd=1.16u as=0.2516p ps=2.16u w=0.74u l=0.13u
X997 VSS.t2786 VDD VSS.t2786 VSS.t61 sg13_lv_nmos ad=0.1428p pd=1.52u as=0 ps=0 w=0.42u l=1u
X998 VSS.t34 VDD VSS.t34 VSS.t393 sg13_lv_nmos ad=79.8f pd=0.8u as=0 ps=0 w=0.42u l=1u
X999 a_7058_15242# sg13cmos5l_xor2_1_0.B VSS.t124 VSS.t123 sg13_lv_nmos ad=0.1406p pd=1.12u as=0.2516p ps=2.16u w=0.74u l=0.13u
X1000 VSS.t1460 VDD VSS.t1462 VSS.t1461 sg13_lv_nmos ad=79.8f pd=0.8u as=0 ps=0 w=0.42u l=1u
X1001 VDD VSS.t2511 VDD VDD sg13_lv_pmos ad=0.19p pd=1.38u as=0 ps=0 w=1u l=1u
X1002 VDD VSS.t378 VDD VDD sg13_lv_pmos ad=0.34p pd=2.68u as=0 ps=0 w=1u l=1u
X1003 VSS.t518 VDD VSS.t521 VSS.t520 sg13_lv_nmos ad=79.8f pd=0.8u as=0 ps=0 w=0.42u l=1u
X1004 VSS.t1167 VDD VSS.t71 VSS.t70 sg13_lv_nmos ad=0.1428p pd=1.52u as=0 ps=0 w=0.42u l=1u
X1005 VDD VSS.t1916 VDD VDD sg13_lv_pmos ad=0.34p pd=2.68u as=0 ps=0 w=1u l=1u
X1006 VDD VSS.t2827 VDD VDD sg13_lv_pmos ad=0.34p pd=2.68u as=0 ps=0 w=1u l=1u
X1007 VDD VSS.t452 VDD VDD sg13_lv_pmos ad=0.34p pd=2.68u as=0 ps=0 w=1u l=1u
X1008 a_25862_13722# sg13cmos5l_dfrbpq_1_5.D VDD VDD sg13_lv_pmos ad=79.8f pd=0.8u as=0.1428p ps=1.52u w=0.42u l=0.13u
X1009 VSS.t1276 VDD VSS.t1276 VSS.t70 sg13_lv_nmos ad=79.8f pd=0.8u as=0 ps=0 w=0.42u l=1u
X1010 VSS.t1199 VDD VSS.t1200 VSS.t70 sg13_lv_nmos ad=79.8f pd=0.8u as=0 ps=0 w=0.42u l=1u
X1011 VDD VSS.t1944 VDD VDD sg13_lv_pmos ad=0.19p pd=1.38u as=0 ps=0 w=1u l=1u
X1012 a_7822_13911# a_7937_13912# VDD VDD sg13_lv_pmos ad=0.34p pd=2.68u as=0.2254p ps=1.53u w=1u l=0.5u
X1013 VDD VSS.t1173 VDD VDD sg13_lv_pmos ad=0.19p pd=1.38u as=0 ps=0 w=1u l=1u
X1014 VDD VSS.t2298 VDD VDD sg13_lv_pmos ad=0.34p pd=2.68u as=0 ps=0 w=1u l=1u
X1015 a_6286_13911# a_6401_13912# VDD VDD sg13_lv_pmos ad=0.34p pd=2.68u as=0.2254p ps=1.53u w=1u l=0.5u
X1016 VSS.t630 VDD VSS.t630 VSS.t631 sg13_lv_nmos ad=79.8f pd=0.8u as=0 ps=0 w=0.42u l=1u
X1017 VDD VSS.t1043 VDD VDD sg13_lv_pmos ad=0.19p pd=1.38u as=0 ps=0 w=1u l=1u
X1018 VDD VSS.t1599 VDD VDD sg13_lv_pmos ad=0.34p pd=2.68u as=0 ps=0 w=1u l=1u
X1019 a_26249_16334# a_26373_16033# VDD VDD sg13_lv_pmos ad=0.2442p pd=2.06u as=2.8961p ps=18.25u w=0.66u l=0.13u
X1020 VSS.t1490 VDD VSS.t1489 VSS.t1488 sg13_lv_nmos ad=0.1428p pd=1.52u as=0 ps=0 w=0.42u l=1u
X1021 VSS.t1907 VDD VSS.t1906 VSS.t1905 sg13_lv_nmos ad=0.1428p pd=1.52u as=0 ps=0 w=0.42u l=1u
X1022 VSS.t383 VDD VSS.t383 VSS.t384 sg13_lv_nmos ad=79.8f pd=0.8u as=0 ps=0 w=0.42u l=1u
X1023 VSS.t441 VDD VSS.t442 VSS.t15 sg13_lv_nmos ad=79.8f pd=0.8u as=0 ps=0 w=0.42u l=1u
X1024 VDD VSS.t3037 VDD VDD sg13_lv_pmos ad=0.19p pd=1.38u as=0 ps=0 w=1u l=1u
X1025 VSS.t2667 VDD VSS.t2665 VSS.t61 sg13_lv_nmos ad=0.1428p pd=1.52u as=0 ps=0 w=0.42u l=1u
X1026 VSS.t2399 VDD VSS.t2398 VSS.t2397 sg13_lv_nmos ad=0.1428p pd=1.52u as=0 ps=0 w=0.42u l=1u
X1027 a_12010_15202# sg13cmos5l_buf_8_2.A VSS.t253 VSS.t254 sg13_lv_nmos ad=0.2553p pd=2.17u as=0.1406p ps=1.12u w=0.74u l=0.13u
X1028 VSS.t693 VDD VSS.t79 VSS.t692 sg13_lv_nmos ad=0.1428p pd=1.52u as=0 ps=0 w=0.42u l=1u
X1029 VSS.t2729 VDD VSS.t2731 VSS.t61 sg13_lv_nmos ad=79.8f pd=0.8u as=0 ps=0 w=0.42u l=1u
X1030 VDD a_14261_15238# sg13cmos5l_or3_1_1.B VDD sg13_lv_pmos ad=0.2128p pd=1.5u as=0.2128p ps=1.5u w=1.12u l=0.13u
X1031 VDD VSS.t970 VDD VDD sg13_lv_pmos ad=0.34p pd=2.68u as=0 ps=0 w=1u l=1u
X1032 VSS.t147 VDD VSS.t147 VSS.t296 sg13_lv_nmos ad=79.8f pd=0.8u as=0 ps=0 w=0.42u l=1u
X1033 VSS.t555 VDD VSS.t554 VSS.t553 sg13_lv_nmos ad=0.1428p pd=1.52u as=0 ps=0 w=0.42u l=1u
X1034 VDD VSS.t1457 VDD VDD sg13_lv_pmos ad=0.19p pd=1.38u as=0 ps=0 w=1u l=1u
X1035 VDD VSS.t282 VDD VDD sg13_lv_pmos ad=0.34p pd=2.68u as=0 ps=0 w=1u l=1u
X1036 a_9737_14822# a_9861_14521# VDD VDD sg13_lv_pmos ad=0.2442p pd=2.06u as=2.42015p ps=15.68u w=0.66u l=0.13u
X1037 a_17604_14488# a_17578_14452# VDD VDD sg13_lv_pmos ad=0.34p pd=2.68u as=0.36237p ps=2.605u w=1u l=0.13u
X1038 VDD VSS.t534 VDD VDD sg13_lv_pmos ad=0.34p pd=2.68u as=0 ps=0 w=1u l=1u
X1039 VDD VSS.t2639 VDD VDD sg13_lv_pmos ad=0.19p pd=1.38u as=0 ps=0 w=1u l=1u
X1040 sg13cmos5l_dfrbpq_1_3.D a_17238_15302# VDD VDD sg13_lv_pmos ad=0.4256p pd=3u as=0.2254p ps=1.53u w=1.12u l=0.13u
X1041 VDD a_27472_14726# a_27417_14607# VDD sg13_lv_pmos ad=2.42015p pd=15.68u as=93.45f ps=0.865u w=0.42u l=0.13u
X1042 a_19323_13726# sg13cmos5l_buf_8_2.A VSS.t256 VSS.t257 sg13_lv_nmos ad=0.1406p pd=1.12u as=0.1406p ps=1.12u w=0.74u l=0.13u
X1043 VSS.t2945 VDD VSS.t2944 VSS.t2943 sg13_lv_nmos ad=0.1428p pd=1.52u as=0 ps=0 w=0.42u l=1u
X1044 VSS.t724 VDD VSS.t603 VSS.t725 sg13_lv_nmos ad=79.8f pd=0.8u as=0 ps=0 w=0.42u l=1u
X1045 VDD VSS.t1300 VDD VDD sg13_lv_pmos ad=0.34p pd=2.68u as=0 ps=0 w=1u l=1u
X1046 VSS.t1590 VDD VSS.t1592 VSS.t1591 sg13_lv_nmos ad=79.8f pd=0.8u as=0 ps=0 w=0.42u l=1u
X1047 VSS.t3115 VDD VSS.t3117 VSS.t3116 sg13_lv_nmos ad=79.8f pd=0.8u as=0 ps=0 w=0.42u l=1u
X1048 VSS.t1259 VDD VSS.t1258 VSS.t70 sg13_lv_nmos ad=0.1428p pd=1.52u as=0 ps=0 w=0.42u l=1u
X1049 VSS.t1181 VDD VSS.t1180 VSS.t70 sg13_lv_nmos ad=0.1428p pd=1.52u as=0 ps=0 w=0.42u l=1u
X1050 VSS.t1982 VDD VSS.t1981 VSS.t1980 sg13_lv_nmos ad=0.1428p pd=1.52u as=0 ps=0 w=0.42u l=1u
X1051 VDD VSS.t845 VDD VDD sg13_lv_pmos ad=0.34p pd=2.68u as=0 ps=0 w=1u l=1u
X1052 VSS.t1290 VDD VSS.t1291 VSS.t70 sg13_lv_nmos ad=79.8f pd=0.8u as=0 ps=0 w=0.42u l=1u
X1053 VSS.t2649 VDD VSS.t2650 VSS.t61 sg13_lv_nmos ad=79.8f pd=0.8u as=0 ps=0 w=0.42u l=1u
X1054 VDD VSS.t1936 VDD VDD sg13_lv_pmos ad=0.34p pd=2.68u as=0 ps=0 w=1u l=1u
X1055 VDD VSS.t2121 VDD VDD sg13_lv_pmos ad=0.34p pd=2.68u as=0 ps=0 w=1u l=1u
X1056 VSS.t2514 VDD VSS.t2516 VSS.t2515 sg13_lv_nmos ad=79.8f pd=0.8u as=0 ps=0 w=0.42u l=1u
X1057 VDD VSS.t1619 VDD VDD sg13_lv_pmos ad=0.34p pd=2.68u as=0 ps=0 w=1u l=1u
X1058 VDD VSS.t2650 VDD VDD sg13_lv_pmos ad=0.34p pd=2.68u as=0 ps=0 w=1u l=1u
X1059 sg13cmos5l_buf_8_2.A a_15579_14854# VDD VDD sg13_lv_pmos ad=0.2128p pd=1.5u as=0.2128p ps=1.5u w=1.12u l=0.13u
X1060 VSS.t740 VDD VSS.t8 VSS.t741 sg13_lv_nmos ad=79.8f pd=0.8u as=0 ps=0 w=0.42u l=1u
X1061 VSS.t1892 VDD VSS.t1891 VSS.t1890 sg13_lv_nmos ad=0.1428p pd=1.52u as=0 ps=0 w=0.42u l=1u
X1062 VSS.t951 VDD VSS.t950 VSS.t949 sg13_lv_nmos ad=0.1428p pd=1.52u as=0 ps=0 w=0.42u l=1u
X1063 counter_value_o[3] a_16552_15996# VSS.t128 VSS.t127 sg13_lv_nmos ad=0.2886p pd=2.26u as=0.14875p ps=1.16u w=0.74u l=0.13u
X1064 a_26757_16033# a_26757_16033# VSS.t30 VSS.t261 sg13_lv_nmos ad=0.111p pd=1.34u as=7.70437p ps=50.66u w=0.3u l=0.13u
X1065 VDD VSS.t2766 VDD VDD sg13_lv_pmos ad=0.34p pd=2.68u as=0 ps=0 w=1u l=1u
X1066 VSS.t2703 VDD VSS.t2702 VSS.t61 sg13_lv_nmos ad=0.1428p pd=1.52u as=0 ps=0 w=0.42u l=1u
X1067 VDD VSS.t216 VDD VDD sg13_lv_pmos ad=0.19p pd=1.38u as=0 ps=0 w=1u l=1u
X1068 VSS.t530 VDD VSS.t530 VSS.t529 sg13_lv_nmos ad=0.1428p pd=1.52u as=0 ps=0 w=0.42u l=1u
X1069 VSS.t211 VDD VSS.t211 VSS.t710 sg13_lv_nmos ad=0.1428p pd=1.52u as=0 ps=0 w=0.42u l=1u
X1070 VSS.t2778 VDD VSS.t2778 VSS.t61 sg13_lv_nmos ad=0.1428p pd=1.52u as=0 ps=0 w=0.42u l=1u
X1071 VSS.t2047 VDD VSS.t2049 VSS.t2048 sg13_lv_nmos ad=79.8f pd=0.8u as=0 ps=0 w=0.42u l=1u
X1072 VDD VSS.t315 VDD VDD sg13_lv_pmos ad=0.34p pd=2.68u as=0 ps=0 w=1u l=1u
X1073 VDD VSS.t1000 VDD VDD sg13_lv_pmos ad=0.34p pd=2.68u as=0 ps=0 w=1u l=1u
X1074 VSS.t1272 VDD VSS.t1271 VSS.t70 sg13_lv_nmos ad=0.1428p pd=1.52u as=0 ps=0 w=0.42u l=1u
X1075 VDD VSS.t1209 VDD VDD sg13_lv_pmos ad=0.19p pd=1.38u as=0 ps=0 w=1u l=1u
X1076 VDD VSS.t2713 VDD VDD sg13_lv_pmos ad=0.19p pd=1.38u as=0 ps=0 w=1u l=1u
X1077 VSS.t2384 VDD VSS.t2383 VSS.t2382 sg13_lv_nmos ad=0.1428p pd=1.52u as=0 ps=0 w=0.42u l=1u
X1078 VDD VSS.t808 VDD VDD sg13_lv_pmos ad=0.19p pd=1.38u as=0 ps=0 w=1u l=1u
X1079 VDD VSS.t2323 VDD VDD sg13_lv_pmos ad=0.34p pd=2.68u as=0 ps=0 w=1u l=1u
X1080 VDD VSS.t2496 VDD VDD sg13_lv_pmos ad=0.19p pd=1.38u as=0 ps=0 w=1u l=1u
X1081 VDD VSS.t618 VDD VDD sg13_lv_pmos ad=0.34p pd=2.68u as=0 ps=0 w=1u l=1u
X1082 VDD VSS.t1245 VDD VDD sg13_lv_pmos ad=0.19p pd=1.38u as=0 ps=0 w=1u l=1u
X1083 VSS.t335 VDD VSS.t334 VSS.t333 sg13_lv_nmos ad=0.1428p pd=1.52u as=0 ps=0 w=0.42u l=1u
X1084 VDD VSS.t2448 VDD VDD sg13_lv_pmos ad=0.34p pd=2.68u as=0 ps=0 w=1u l=1u
X1085 VDD VSS.t1929 VDD VDD sg13_lv_pmos ad=0.19p pd=1.38u as=0 ps=0 w=1u l=1u
X1086 VSS.t1932 VDD VSS.t1931 VSS.t1930 sg13_lv_nmos ad=0.1428p pd=1.52u as=0 ps=0 w=0.42u l=1u
X1087 VDD VSS.t2106 VDD VDD sg13_lv_pmos ad=0.34p pd=2.68u as=0 ps=0 w=1u l=1u
X1088 VDD VSS.t470 VDD VDD sg13_lv_pmos ad=0.34p pd=2.68u as=0 ps=0 w=1u l=1u
X1089 VDD VSS.t2283 VDD VDD sg13_lv_pmos ad=0.34p pd=2.68u as=0 ps=0 w=1u l=1u
X1090 VSS.t1036 VDD VSS.t1035 VSS.t1034 sg13_lv_nmos ad=0.1428p pd=1.52u as=0 ps=0 w=0.42u l=1u
X1091 VDD VSS.t2662 VDD VDD sg13_lv_pmos ad=0.34p pd=2.68u as=0 ps=0 w=1u l=1u
X1092 VDD VSS.t547 VDD VDD sg13_lv_pmos ad=0.19p pd=1.38u as=0 ps=0 w=1u l=1u
X1093 VSS.t1436 VDD VSS.t1309 VSS.t70 sg13_lv_nmos ad=79.8f pd=0.8u as=0 ps=0 w=0.42u l=1u
X1094 VDD VSS.t2054 VDD VDD sg13_lv_pmos ad=0.19p pd=1.38u as=0 ps=0 w=1u l=1u
X1095 a_17063_16020# sg13cmos5l_or3_1_2.B a_16969_16020# VDD sg13_lv_pmos ad=0.19p pd=1.38u as=0.34p ps=2.68u w=1u l=0.13u
X1096 VDD sg13cmos5l_dlygate4sd3_1_4.X sg13cmos5l_dlygate4sd3_1_5.A VDD sg13_lv_pmos ad=0.3808p pd=2.92u as=0.2128p ps=1.5u w=1.12u l=0.15u
X1097 VSS.t204 a_19450_15202# a_19169_15424# VSS.t42 sg13_lv_nmos ad=79.8f pd=0.8u as=0.1428p ps=1.52u w=0.42u l=0.5u
X1098 VDD VSS.t900 VDD VDD sg13_lv_pmos ad=0.34p pd=2.68u as=0 ps=0 w=1u l=1u
X1099 VDD VSS.t1171 VDD VDD sg13_lv_pmos ad=0.19p pd=1.38u as=0 ps=0 w=1u l=1u
X1100 VSS.t15 a_4175_15311# a_4842_15532# VSS.t122 sg13_lv_nmos ad=0.1406p pd=1.12u as=0.2516p ps=2.16u w=0.74u l=0.13u
X1101 sg13cmos5l_xnor2_1_0.Y sg13cmos5l_nand3_1_0.Y a_7923_15532# VDD sg13_lv_pmos ad=0.2408p pd=1.55u as=0.1428p ps=1.375u w=1.12u l=0.13u
X1102 VDD VSS.t878 VDD VDD sg13_lv_pmos ad=0.19p pd=1.38u as=0 ps=0 w=1u l=1u
X1103 VSS.t2658 VDD VSS.t2657 VSS.t61 sg13_lv_nmos ad=0.1428p pd=1.52u as=0 ps=0 w=0.42u l=1u
X1104 VDD VSS.t2673 VDD VDD sg13_lv_pmos ad=0.19p pd=1.38u as=0 ps=0 w=1u l=1u
X1105 VSS.t2721 VDD VSS.t2722 VSS.t61 sg13_lv_nmos ad=79.8f pd=0.8u as=0 ps=0 w=0.42u l=1u
X1106 VDD a_8582_15238# a_8694_15302# VDD sg13_lv_pmos ad=0.2254p pd=1.53u as=0.34p ps=2.68u w=1u l=0.5u
X1107 VDD VSS.t2909 VDD VDD sg13_lv_pmos ad=0.34p pd=2.68u as=0 ps=0 w=1u l=1u
X1108 VDD sg13cmos5l_xor2_1_0.X a_1965_14832# VDD sg13_lv_pmos ad=0.1918p pd=1.5u as=0.1596p ps=1.22u w=0.84u l=0.13u
X1109 VSS.t618 VDD VSS.t621 VSS.t753 sg13_lv_nmos ad=79.8f pd=0.8u as=0 ps=0 w=0.42u l=1u
X1110 a_17318_14922# sg13cmos5l_dfrbpq_1_3.D VDD VDD sg13_lv_pmos ad=79.8f pd=0.8u as=0.1428p ps=1.52u w=0.42u l=0.13u
X1111 VDD VSS.t775 VDD VDD sg13_lv_pmos ad=0.34p pd=2.68u as=0 ps=0 w=1u l=1u
X1112 VDD VSS.t963 VDD VDD sg13_lv_pmos ad=0.19p pd=1.38u as=0 ps=0 w=1u l=1u
X1113 VSS.t2930 VDD VSS.t2929 VSS.t2928 sg13_lv_nmos ad=0.1428p pd=1.52u as=0 ps=0 w=0.42u l=1u
X1114 VSS.t1051 VDD VSS.t1050 VSS.t1049 sg13_lv_nmos ad=0.1428p pd=1.52u as=0 ps=0 w=0.42u l=1u
X1115 VSS.t1317 VDD VSS.t1318 VSS.t70 sg13_lv_nmos ad=79.8f pd=0.8u as=0 ps=0 w=0.42u l=1u
X1116 VDD VSS.t2481 VDD VDD sg13_lv_pmos ad=0.19p pd=1.38u as=0 ps=0 w=1u l=1u
X1117 VSS.t128 a_17710_16263# sg13cmos5l_a21oi_1_0.A1 VSS.t3247 sg13_lv_nmos ad=0.1426p pd=1.16u as=0.2516p ps=2.16u w=0.74u l=0.13u
X1118 VSS.t66 a_25094_14484# a_25206_14508# VSS.t56 sg13_lv_nmos ad=0.1426p pd=1.16u as=0.1428p ps=1.52u w=0.42u l=0.5u
X1119 sg13cmos5l_or3_1_1.X a_24841_13726# VSS.t157 VSS.t263 sg13_lv_nmos ad=0.2516p pd=2.16u as=0.13395p ps=1.12u w=0.74u l=0.13u
X1120 VDD VSS.t1921 VDD VDD sg13_lv_pmos ad=0.34p pd=2.68u as=0 ps=0 w=1u l=1u
X1121 VDD VSS.t2684 VDD VDD sg13_lv_pmos ad=0.34p pd=2.68u as=0 ps=0 w=1u l=1u
X1122 sg13cmos5l_dfrbpq_1_2.D sg13cmos5l_nor2_1_0.B a_15338_14484# VDD sg13_lv_pmos ad=0.3808p pd=2.92u as=0.1176p ps=1.33u w=1.12u l=0.13u
X1123 VSS.t467 VDD VSS.t53 VSS.t466 sg13_lv_nmos ad=0.1428p pd=1.52u as=0 ps=0 w=0.42u l=1u
X1124 VDD VSS.t1176 VDD VDD sg13_lv_pmos ad=0.19p pd=1.38u as=0 ps=0 w=1u l=1u
X1125 a_25109_12972# sg13cmos5l_a21oi_1_3.A1 VDD VDD sg13_lv_pmos ad=0.2128p pd=1.5u as=0.2128p ps=1.5u w=1.12u l=0.13u
X1126 VSS.t1595 VDD VSS.t1594 VSS.t1593 sg13_lv_nmos ad=0.1428p pd=1.52u as=0 ps=0 w=0.42u l=1u
X1127 VSS.t3120 VDD VSS.t3119 VSS.t3118 sg13_lv_nmos ad=0.1428p pd=1.52u as=0 ps=0 w=0.42u l=1u
X1128 VDD VSS.t2268 VDD VDD sg13_lv_pmos ad=0.34p pd=2.68u as=0 ps=0 w=1u l=1u
X1129 VSS.t2499 VDD VSS.t2501 VSS.t2500 sg13_lv_nmos ad=79.8f pd=0.8u as=0 ps=0 w=0.42u l=1u
X1130 VDD VSS.t521 VDD VDD sg13_lv_pmos ad=0.34p pd=2.68u as=0 ps=0 w=1u l=1u
X1131 VDD VSS.t1604 VDD VDD sg13_lv_pmos ad=0.34p pd=2.68u as=0 ps=0 w=1u l=1u
X1132 VSS.t207 a_19323_13726# sg13cmos5l_buf_8_2.X VSS.t208 sg13_lv_nmos ad=0.1406p pd=1.12u as=0.1406p ps=1.12u w=0.74u l=0.13u
X1133 VDD VSS.t1263 VDD VDD sg13_lv_pmos ad=0.19p pd=1.38u as=0 ps=0 w=1u l=1u
X1134 VSS.t1495 VDD VSS.t1494 VSS.t1493 sg13_lv_nmos ad=0.1428p pd=1.52u as=0 ps=0 w=0.42u l=1u
X1135 VSS.t2404 VDD VSS.t2403 VSS.t2402 sg13_lv_nmos ad=0.1428p pd=1.52u as=0 ps=0 w=0.42u l=1u
X1136 VSS.t1877 VDD VSS.t1876 VSS.t1875 sg13_lv_nmos ad=0.1428p pd=1.52u as=0 ps=0 w=0.42u l=1u
X1137 VSS.t1665 VDD VSS.t1667 VSS.t1666 sg13_lv_nmos ad=79.8f pd=0.8u as=0 ps=0 w=0.42u l=1u
X1138 VSS.t1212 VDD VSS.t1213 VSS.t70 sg13_lv_nmos ad=79.8f pd=0.8u as=0 ps=0 w=0.42u l=1u
X1139 VDD VSS.t1976 VDD VDD sg13_lv_pmos ad=0.34p pd=2.68u as=0 ps=0 w=1u l=1u
X1140 VDD VSS.t2757 VDD VDD sg13_lv_pmos ad=0.34p pd=2.68u as=0 ps=0 w=1u l=1u
X1141 VSS.t2369 VDD VSS.t2371 VSS.t2370 sg13_lv_nmos ad=79.8f pd=0.8u as=0 ps=0 w=0.42u l=1u
X1142 VDD VSS.t3102 VDD VDD sg13_lv_pmos ad=0.19p pd=1.38u as=0 ps=0 w=1u l=1u
X1143 a_16485_13701# sg13cmos5l_dfrbpq_1_2.CLK VDD VDD sg13_lv_pmos ad=0.4088p pd=2.97u as=2.3367p ps=15.135u w=1.12u l=0.13u
X1144 VDD VSS.t930 VDD VDD sg13_lv_pmos ad=0.34p pd=2.68u as=0 ps=0 w=1u l=1u
X1145 VSS.t2675 VDD VSS.t2676 VSS.t61 sg13_lv_nmos ad=79.8f pd=0.8u as=0 ps=0 w=0.42u l=1u
X1146 VDD VSS.t2642 VDD VDD sg13_lv_pmos ad=0.19p pd=1.38u as=0 ps=0 w=1u l=1u
X1147 VDD VSS.t342 VDD VDD sg13_lv_pmos ad=0.19p pd=1.38u as=0 ps=0 w=1u l=1u
X1148 VSS.t1427 VDD VSS.t1298 VSS.t70 sg13_lv_nmos ad=0.1428p pd=1.52u as=0 ps=0 w=0.42u l=1u
X1149 VSS.t2915 VDD VSS.t2914 VSS.t2913 sg13_lv_nmos ad=0.1428p pd=1.52u as=0 ps=0 w=0.42u l=1u
X1150 VDD a_4474_14448# a_4193_14750# VDD sg13_lv_pmos ad=0.1523p pd=1.38u as=0.34p ps=2.68u w=1u l=0.5u
X1151 VDD VSS.t1303 VDD VDD sg13_lv_pmos ad=0.34p pd=2.68u as=0 ps=0 w=1u l=1u
X1152 VDD VSS.t2308 VDD VDD sg13_lv_pmos ad=0.34p pd=2.68u as=0 ps=0 w=1u l=1u
X1153 VDD VSS.t2676 VDD VDD sg13_lv_pmos ad=0.34p pd=2.68u as=0 ps=0 w=1u l=1u
X1154 VDD sg13cmos5l_buf_1_0.X a_2942_14484# VDD sg13_lv_pmos ad=0.36p pd=2.72u as=0.1225p ps=1.245u w=1u l=0.13u
X1155 a_6540_13238# sg13cmos5l_xnor2_1_2.B VDD VDD sg13_lv_pmos ad=0.1596p pd=1.22u as=0.2891p ps=1.695u w=0.84u l=0.13u
X1156 VSS.t1036 VDD VSS.t1035 VSS.t1034 sg13_lv_nmos ad=0.1428p pd=1.52u as=0 ps=0 w=0.42u l=1u
X1157 VDD VSS.t2433 VDD VDD sg13_lv_pmos ad=0.34p pd=2.68u as=0 ps=0 w=1u l=1u
X1158 VDD VSS.t612 VDD VDD sg13_lv_pmos ad=0.34p pd=2.68u as=0 ps=0 w=1u l=1u
X1159 VDD VSS.t2091 VDD VDD sg13_lv_pmos ad=0.34p pd=2.68u as=0 ps=0 w=1u l=1u
X1160 VDD VSS.t547 VDD VDD sg13_lv_pmos ad=0.19p pd=1.38u as=0 ps=0 w=1u l=1u
X1161 VDD VSS.t2653 VDD VDD sg13_lv_pmos ad=0.34p pd=2.68u as=0 ps=0 w=1u l=1u
X1162 VDD VSS.t945 VDD VDD sg13_lv_pmos ad=0.34p pd=2.68u as=0 ps=0 w=1u l=1u
X1163 a_21034_14452# a_21477_14495# a_20774_14922# VSS.t115 sg13_lv_nmos ad=79.8f pd=0.8u as=0.1296p ps=1.52u w=0.42u l=0.13u
X1164 VDD VSS.t2768 VDD VDD sg13_lv_pmos ad=0.34p pd=2.68u as=0 ps=0 w=1u l=1u
X1165 VDD VSS.t1183 VDD VDD sg13_lv_pmos ad=0.34p pd=2.68u as=0 ps=0 w=1u l=1u
X1166 VSS.t2705 VDD VSS.t2705 VSS.t61 sg13_lv_nmos ad=0.1428p pd=1.52u as=0 ps=0 w=0.42u l=1u
X1167 VSS.t1455 VDD VSS.t1457 VSS.t1456 sg13_lv_nmos ad=79.8f pd=0.8u as=0 ps=0 w=0.42u l=1u
X1168 VSS.t1051 VDD VSS.t1050 VSS.t1049 sg13_lv_nmos ad=0.1428p pd=1.52u as=0 ps=0 w=0.42u l=1u
X1169 sg13cmos5l_a21oi_1_3.A2 a_24169_14508# VSS.t3195 VSS.t56 sg13_lv_nmos ad=0.2516p pd=2.16u as=0.13395p ps=1.12u w=0.74u l=0.13u
X1170 VDD VSS.t1008 VDD VDD sg13_lv_pmos ad=0.19p pd=1.38u as=0 ps=0 w=1u l=1u
X1171 VSS.t956 VDD VSS.t958 VSS.t957 sg13_lv_nmos ad=79.8f pd=0.8u as=0 ps=0 w=0.42u l=1u
X1172 VDD reset_n_i a_1192_9948# VDD sg13_lv_pmos ad=0.2114p pd=1.54u as=0.2856p ps=2.36u w=0.84u l=0.13u
X1173 VDD VSS.t1587 VDD VDD sg13_lv_pmos ad=0.19p pd=1.38u as=0 ps=0 w=1u l=1u
X1174 VSS.t2761 VDD VSS.t2760 VSS.t61 sg13_lv_nmos ad=0.1428p pd=1.52u as=0 ps=0 w=0.42u l=1u
X1175 VSS.t2017 VDD VSS.t2019 VSS.t2018 sg13_lv_nmos ad=79.8f pd=0.8u as=0 ps=0 w=0.42u l=1u
X1176 VSS.t420 VDD VSS.t421 VSS.t15 sg13_lv_nmos ad=79.8f pd=0.8u as=0 ps=0 w=0.42u l=1u
X1177 VDD VSS.t2328 VDD VDD sg13_lv_pmos ad=0.34p pd=2.68u as=0 ps=0 w=1u l=1u
X1178 a_16969_16020# sg13cmos5l_inv_1_0.Y VSS.t128 VSS.t3256 sg13_lv_nmos ad=0.198p pd=1.27u as=0.1045p ps=0.93u w=0.55u l=0.13u
X1179 VDD VSS.t363 VDD VDD sg13_lv_pmos ad=0.34p pd=2.68u as=0 ps=0 w=1u l=1u
X1180 VSS.t555 VDD VSS.t554 VSS.t553 sg13_lv_nmos ad=0.1428p pd=1.52u as=0 ps=0 w=0.42u l=1u
X1181 VDD VSS.t1592 VDD VDD sg13_lv_pmos ad=0.19p pd=1.38u as=0 ps=0 w=1u l=1u
X1182 VDD VSS.t4 VDD VDD sg13_lv_pmos ad=0.34p pd=2.68u as=0 ps=0 w=1u l=1u
X1183 VSS.t1937 VDD VSS.t1936 VSS.t1935 sg13_lv_nmos ad=0.1428p pd=1.52u as=0 ps=0 w=0.42u l=1u
X1184 a_25774_15423# a_25889_15424# VDD VDD sg13_lv_pmos ad=0.34p pd=2.68u as=0.2254p ps=1.53u w=1u l=0.5u
X1185 VDD VSS.t1326 VDD VDD sg13_lv_pmos ad=0.34p pd=2.68u as=0 ps=0 w=1u l=1u
X1186 VDD VSS.t2648 VDD VDD sg13_lv_pmos ad=0.34p pd=2.68u as=0 ps=0 w=1u l=1u
X1187 VDD VSS.t521 VDD VDD sg13_lv_pmos ad=0.34p pd=2.68u as=0 ps=0 w=1u l=1u
X1188 a_18552_15976# sg13cmos5l_inv_1_0.Y VDD VDD sg13_lv_pmos ad=0.2128p pd=1.5u as=0.3808p ps=2.92u w=1.12u l=0.15u
X1189 VSS.t367 VDD VSS.t367 VSS.t368 sg13_lv_nmos ad=79.8f pd=0.8u as=0 ps=0 w=0.42u l=1u
X1190 VSS.t1675 VDD VSS.t1674 VSS.t1673 sg13_lv_nmos ad=0.1428p pd=1.52u as=0 ps=0 w=0.42u l=1u
X1191 VSS.t1480 VDD VSS.t1479 VSS.t1478 sg13_lv_nmos ad=0.1428p pd=1.52u as=0 ps=0 w=0.42u l=1u
X1192 VSS.t2389 VDD VSS.t2388 VSS.t2387 sg13_lv_nmos ad=0.1428p pd=1.52u as=0 ps=0 w=0.42u l=1u
X1193 VSS.t2661 VDD VSS.t2659 VSS.t61 sg13_lv_nmos ad=0.1428p pd=1.52u as=0 ps=0 w=0.42u l=1u
X1194 VDD VSS.t15 VDD VDD sg13_lv_pmos ad=0.19p pd=1.38u as=0 ps=0 w=1u l=1u
X1195 VSS.t2723 VDD VSS.t2725 VSS.t61 sg13_lv_nmos ad=79.8f pd=0.8u as=0 ps=0 w=0.42u l=1u
X1196 VSS.t2975 VDD VSS.t2974 VSS.t2973 sg13_lv_nmos ad=0.1428p pd=1.52u as=0 ps=0 w=0.42u l=1u
X1197 a_22319_14845# a_21477_14495# a_21060_14488# VDD sg13_lv_pmos ad=0.2048p pd=1.63u as=0.34p ps=2.68u w=1u l=0.13u
X1198 VSS.t2354 VDD VSS.t2356 VSS.t2355 sg13_lv_nmos ad=79.8f pd=0.8u as=0 ps=0 w=0.42u l=1u
X1199 VDD VSS.t3087 VDD VDD sg13_lv_pmos ad=0.19p pd=1.38u as=0 ps=0 w=1u l=1u
X1200 VDD VSS.t2296 VDD VDD sg13_lv_pmos ad=0.19p pd=1.38u as=0 ps=0 w=1u l=1u
X1201 a_24062_15242# sg13cmos5l_dfrbpq_1_6.Q a_23960_15242# VSS.t65 sg13_lv_nmos ad=0.1406p pd=1.12u as=0.1406p ps=1.12u w=0.74u l=0.13u
X1202 VSS.t1670 VDD VSS.t1669 VSS.t1668 sg13_lv_nmos ad=0.1428p pd=1.52u as=0 ps=0 w=0.42u l=1u
X1203 VDD VSS.t978 VDD VDD sg13_lv_pmos ad=0.19p pd=1.38u as=0 ps=0 w=1u l=1u
X1204 VDD VSS.t3039 VDD VDD sg13_lv_pmos ad=0.34p pd=2.68u as=0 ps=0 w=1u l=1u
X1205 VSS.t2773 VDD VSS.t2772 VSS.t61 sg13_lv_nmos ad=0.1428p pd=1.52u as=0 ps=0 w=0.42u l=1u
X1206 VSS.t2667 VDD VSS.t2668 VSS.t61 sg13_lv_nmos ad=79.8f pd=0.8u as=0 ps=0 w=0.42u l=1u
X1207 VDD VSS.t2633 VDD VDD sg13_lv_pmos ad=0.19p pd=1.38u as=0 ps=0 w=1u l=1u
X1208 a_8779_14832# sg13cmos5l_buf_1_10.X a_8685_14832# VSS.t2 sg13_lv_nmos ad=0.1216p pd=1.02u as=0.2176p ps=1.96u w=0.64u l=0.13u
X1209 VDD VSS.t1216 VDD VDD sg13_lv_pmos ad=0.19p pd=1.38u as=0 ps=0 w=1u l=1u
X1210 VDD VSS.t1295 VDD VDD sg13_lv_pmos ad=0.34p pd=2.68u as=0 ps=0 w=1u l=1u
X1211 VDD VSS.t2486 VDD VDD sg13_lv_pmos ad=0.19p pd=1.38u as=0 ps=0 w=1u l=1u
X1212 VDD VSS.t2668 VDD VDD sg13_lv_pmos ad=0.34p pd=2.68u as=0 ps=0 w=1u l=1u
X1213 VSS.t1972 VDD VSS.t1971 VSS.t1970 sg13_lv_nmos ad=0.1428p pd=1.52u as=0 ps=0 w=0.42u l=1u
X1214 VDD VSS.t1926 VDD VDD sg13_lv_pmos ad=0.34p pd=2.68u as=0 ps=0 w=1u l=1u
X1215 a_15579_14854# clock_i VSS.t47 VSS.t3249 sg13_lv_nmos ad=0.1406p pd=1.12u as=0.1406p ps=1.12u w=0.74u l=0.13u
X1216 VSS.t22 sg13cmos5l_dfrbpq_1_6.RESET_B a_20868_14922# VSS.t69 sg13_lv_nmos ad=0.1626p pd=1.415u as=60.89999f ps=0.71u w=0.42u l=0.13u
X1217 VSS.t521 VDD VSS.t521 VSS.t522 sg13_lv_nmos ad=0.1428p pd=1.52u as=0 ps=0 w=0.42u l=1u
X1218 a_17578_14452# a_18021_14495# a_17318_14922# VSS.t13 sg13_lv_nmos ad=79.8f pd=0.8u as=0.1296p ps=1.52u w=0.42u l=0.13u
X1219 VSS.t2504 VDD VSS.t2506 VSS.t2505 sg13_lv_nmos ad=79.8f pd=0.8u as=0 ps=0 w=0.42u l=1u
X1220 a_25956_14488# a_25930_14452# VSS.t41 VSS.t270 sg13_lv_nmos ad=0.2516p pd=2.16u as=0.1626p ps=1.415u w=0.74u l=0.13u
X1221 VSS.t453 VDD VSS.t454 VSS.t15 sg13_lv_nmos ad=79.8f pd=0.8u as=0 ps=0 w=0.42u l=1u
X1222 VDD VSS.t853 VDD VDD sg13_lv_pmos ad=0.19p pd=1.38u as=0 ps=0 w=1u l=1u
X1223 VDD VSS.t2446 VDD VDD sg13_lv_pmos ad=0.19p pd=1.38u as=0 ps=0 w=1u l=1u
X1224 VSS.t1252 VDD VSS.t1251 VSS.t70 sg13_lv_nmos ad=0.1428p pd=1.52u as=0 ps=0 w=0.42u l=1u
X1225 VSS.t1465 VDD VSS.t1464 VSS.t1463 sg13_lv_nmos ad=0.1428p pd=1.52u as=0 ps=0 w=0.42u l=1u
X1226 VSS.t131 VDD VSS.t131 VSS.t360 sg13_lv_nmos ad=0.1428p pd=1.52u as=0 ps=0 w=0.42u l=1u
X1227 VDD VSS.t287 VDD VDD sg13_lv_pmos ad=0.34p pd=2.68u as=0 ps=0 w=1u l=1u
X1228 a_6372_14488# a_6891_14495# a_7631_14845# VSS.t55 sg13_lv_nmos ad=0.3473p pd=2.71u as=0.12665p ps=1.145u w=0.74u l=0.13u
X1229 VSS.t2715 VDD VSS.t2716 VSS.t61 sg13_lv_nmos ad=79.8f pd=0.8u as=0 ps=0 w=0.42u l=1u
X1230 VDD VSS.t462 VDD VDD sg13_lv_pmos ad=0.19p pd=1.38u as=0 ps=0 w=1u l=1u
X1231 a_20278_14862# sg13cmos5l_or3_1_2.C VSS.t106 VSS.t16 sg13_lv_nmos ad=0.1406p pd=1.12u as=0.1406p ps=1.12u w=0.74u l=0.15u
X1232 a_27634_14922# sg13cmos5l_dfrbpq_1_7.RESET_B VSS.t28 VSS.t15 sg13_lv_nmos ad=37.8f pd=0.6u as=79.8f ps=0.8u w=0.42u l=0.13u
X1233 VSS.t170 sg13cmos5l_xnor2_1_2.B a_6575_13342# VSS.t3219 sg13_lv_nmos ad=0.1898p pd=1.36u as=0.1406p ps=1.12u w=0.74u l=0.13u
X1234 VDD VSS.t1174 VDD VDD sg13_lv_pmos ad=0.34p pd=2.68u as=0 ps=0 w=1u l=1u
X1235 VDD VSS.t1946 VDD VDD sg13_lv_pmos ad=0.34p pd=2.68u as=0 ps=0 w=1u l=1u
X1236 VSS.t8 VDD VSS.t606 VSS.t743 sg13_lv_nmos ad=79.8f pd=0.8u as=0 ps=0 w=0.42u l=1u
X1237 VDD VSS.t1234 VDD VDD sg13_lv_pmos ad=0.34p pd=2.68u as=0 ps=0 w=1u l=1u
X1238 VDD VSS.t3107 VDD VDD sg13_lv_pmos ad=0.19p pd=1.38u as=0 ps=0 w=1u l=1u
X1239 VSS.t956 VDD VSS.t958 VSS.t957 sg13_lv_nmos ad=79.8f pd=0.8u as=0 ps=0 w=0.42u l=1u
X1240 VSS.t1001 VDD VSS.t1000 VSS.t999 sg13_lv_nmos ad=0.1428p pd=1.52u as=0 ps=0 w=0.42u l=1u
X1241 VSS.t2920 VDD VSS.t2919 VSS.t2918 sg13_lv_nmos ad=0.1428p pd=1.52u as=0 ps=0 w=0.42u l=1u
X1242 VSS.t453 VDD VSS.t452 VSS.t15 sg13_lv_nmos ad=0.1428p pd=1.52u as=0 ps=0 w=0.42u l=1u
X1243 a_7888_14726# a_7631_14845# a_8050_14922# VSS.t139 sg13_lv_nmos ad=0.1428p pd=1.52u as=37.8f ps=0.6u w=0.42u l=0.13u
X1244 VSS.t1193 VDD VSS.t1192 VSS.t70 sg13_lv_nmos ad=0.1428p pd=1.52u as=0 ps=0 w=0.42u l=1u
X1245 VSS.t3090 VDD VSS.t3092 VSS.t3091 sg13_lv_nmos ad=79.8f pd=0.8u as=0 ps=0 w=0.42u l=1u
X1246 VSS.t2299 VDD VSS.t2301 VSS.t2300 sg13_lv_nmos ad=79.8f pd=0.8u as=0 ps=0 w=0.42u l=1u
X1247 VSS.t15 a_18665_15180# a_18586_15455# VSS.t133 sg13_lv_nmos ad=4.11262p pd=27.15u as=0.27427p ps=2.28u w=0.795u l=0.13u
X1248 VDD VSS.t439 VDD VDD sg13_lv_pmos ad=0.19p pd=1.38u as=0 ps=0 w=1u l=1u
X1249 VDD VSS.t2313 VDD VDD sg13_lv_pmos ad=0.34p pd=2.68u as=0 ps=0 w=1u l=1u
X1250 VDD VSS.t1459 VDD VDD sg13_lv_pmos ad=0.34p pd=2.68u as=0 ps=0 w=1u l=1u
X1251 VDD a_10703_15311# a_11370_15532# VDD sg13_lv_pmos ad=0.2128p pd=1.5u as=0.3864p ps=2.93u w=1.12u l=0.13u
X1252 VSS.t253 sg13cmos5l_buf_8_2.A a_12010_15202# VSS.t252 sg13_lv_nmos ad=0.1406p pd=1.12u as=0.1406p ps=1.12u w=0.74u l=0.13u
X1253 VSS.t2374 VDD VSS.t2376 VSS.t2375 sg13_lv_nmos ad=79.8f pd=0.8u as=0 ps=0 w=0.42u l=1u
X1254 VDD VSS.t2438 VDD VDD sg13_lv_pmos ad=0.34p pd=2.68u as=0 ps=0 w=1u l=1u
X1255 VSS.t1922 VDD VSS.t1921 VSS.t1920 sg13_lv_nmos ad=0.1428p pd=1.52u as=0 ps=0 w=0.42u l=1u
X1256 VSS.t2695 VDD VSS.t2693 VSS.t61 sg13_lv_nmos ad=0.1428p pd=1.52u as=0 ps=0 w=0.42u l=1u
X1257 VDD VSS.t2640 VDD VDD sg13_lv_pmos ad=0.34p pd=2.68u as=0 ps=0 w=1u l=1u
X1258 VSS.t596 VDD VSS.t596 VSS.t597 sg13_lv_nmos ad=0.1428p pd=1.52u as=0 ps=0 w=0.42u l=1u
X1259 VDD VSS.t1594 VDD VDD sg13_lv_pmos ad=0.34p pd=2.68u as=0 ps=0 w=1u l=1u
X1260 VSS.t353 VDD VSS.t352 VSS.t351 sg13_lv_nmos ad=0.1428p pd=1.52u as=0 ps=0 w=0.42u l=1u
X1261 a_25862_13722# a_26667_13844# a_26122_13945# VDD sg13_lv_pmos ad=0.1428p pd=1.52u as=79.8f ps=0.8u w=0.42u l=0.13u
X1262 VSS.t876 VDD VSS.t878 VSS.t877 sg13_lv_nmos ad=79.8f pd=0.8u as=0 ps=0 w=0.42u l=1u
X1263 VDD VSS.t2014 VDD VDD sg13_lv_pmos ad=0.19p pd=1.38u as=0 ps=0 w=1u l=1u
X1264 VSS.t73 VDD VSS.t73 VSS.t89 sg13_lv_nmos ad=0.1428p pd=1.52u as=0 ps=0 w=0.42u l=1u
X1265 VDD VSS.t187 VDD VDD sg13_lv_pmos ad=0.34p pd=2.68u as=0 ps=0 w=1u l=1u
X1266 VDD VSS.t1186 VDD VDD sg13_lv_pmos ad=0.34p pd=2.68u as=0 ps=0 w=1u l=1u
X1267 VDD VSS.t1288 VDD VDD sg13_lv_pmos ad=0.19p pd=1.38u as=0 ps=0 w=1u l=1u
X1268 VDD a_27664_13942# a_27609_14037# VDD sg13_lv_pmos ad=2.42015p pd=15.68u as=93.45f ps=0.865u w=0.42u l=0.13u
X1269 VSS.t2687 VDD VSS.t2687 VSS.t61 sg13_lv_nmos ad=0.1428p pd=1.52u as=0 ps=0 w=0.42u l=1u
X1270 VDD VSS.t1020 VDD VDD sg13_lv_pmos ad=0.34p pd=2.68u as=0 ps=0 w=1u l=1u
X1271 VDD VSS.t3024 VDD VDD sg13_lv_pmos ad=0.34p pd=2.68u as=0 ps=0 w=1u l=1u
X1272 VSS.t2764 VDD VSS.t2763 VSS.t61 sg13_lv_nmos ad=0.1428p pd=1.52u as=0 ps=0 w=0.42u l=1u
X1273 VSS.t2022 VDD VSS.t2024 VSS.t2023 sg13_lv_nmos ad=79.8f pd=0.8u as=0 ps=0 w=0.42u l=1u
X1274 VSS.t81 a_17327_13799# a_17994_14020# VSS.t3226 sg13_lv_nmos ad=0.1406p pd=1.12u as=0.2516p ps=2.16u w=0.74u l=0.13u
X1275 VSS.t3110 VDD VSS.t3112 VSS.t3111 sg13_lv_nmos ad=79.8f pd=0.8u as=0 ps=0 w=0.42u l=1u
X1276 sg13cmos5l_and2_1_2.B a_8694_15302# VSS.t73 VSS.t72 sg13_lv_nmos ad=0.2516p pd=2.16u as=0.1426p ps=1.16u w=0.74u l=0.13u
X1277 VDD VSS.t630 VDD VDD sg13_lv_pmos ad=0.34p pd=2.68u as=0 ps=0 w=1u l=1u
X1278 VDD VSS.t2471 VDD VDD sg13_lv_pmos ad=0.19p pd=1.38u as=0 ps=0 w=1u l=1u
X1279 VSS.t1327 VDD VSS.t1326 VSS.t70 sg13_lv_nmos ad=0.1428p pd=1.52u as=0 ps=0 w=0.42u l=1u
X1280 VDD VSS.t1652 VDD VDD sg13_lv_pmos ad=0.19p pd=1.38u as=0 ps=0 w=1u l=1u
X1281 VSS.t1525 VDD VSS.t1524 VSS.t1523 sg13_lv_nmos ad=0.1428p pd=1.52u as=0 ps=0 w=0.42u l=1u
X1282 VSS.t1942 VDD VSS.t1941 VSS.t1940 sg13_lv_nmos ad=0.1428p pd=1.52u as=0 ps=0 w=0.42u l=1u
X1283 VSS.t731 VDD VSS.t729 VSS.t730 sg13_lv_nmos ad=0.1428p pd=1.52u as=0 ps=0 w=0.42u l=1u
X1284 VDD VSS.t2651 VDD VDD sg13_lv_pmos ad=0.34p pd=2.68u as=0 ps=0 w=1u l=1u
X1285 VSS.t30 a_22025_16334# a_21946_16237# VSS.t3197 sg13_lv_nmos ad=7.70437p pd=50.66u as=0.27427p ps=2.28u w=0.795u l=0.13u
X1286 VSS.t1320 VDD VSS.t1321 VSS.t70 sg13_lv_nmos ad=79.8f pd=0.8u as=0 ps=0 w=0.42u l=1u
X1287 VDD VSS.t2753 VDD VDD sg13_lv_pmos ad=0.19p pd=1.38u as=0 ps=0 w=1u l=1u
X1288 VSS.t2052 VDD VSS.t2051 VSS.t2050 sg13_lv_nmos ad=0.1428p pd=1.52u as=0 ps=0 w=0.42u l=1u
X1289 VSS.t273 VDD VSS.t273 VSS.t373 sg13_lv_nmos ad=0.1428p pd=1.52u as=0 ps=0 w=0.42u l=1u
X1290 VSS.t846 VDD VSS.t845 VSS.t844 sg13_lv_nmos ad=0.1428p pd=1.52u as=0 ps=0 w=0.42u l=1u
X1291 VDD VSS.t898 VDD VDD sg13_lv_pmos ad=0.19p pd=1.38u as=0 ps=0 w=1u l=1u
X1292 VDD VSS.t2341 VDD VDD sg13_lv_pmos ad=0.19p pd=1.38u as=0 ps=0 w=1u l=1u
X1293 VDD VSS.t1999 VDD VDD sg13_lv_pmos ad=0.19p pd=1.38u as=0 ps=0 w=1u l=1u
X1294 VDD a_27215_14845# a_27882_14484# VDD sg13_lv_pmos ad=0.2128p pd=1.5u as=0.3864p ps=2.93u w=1.12u l=0.13u
X1295 VSS.t2664 VDD VSS.t2663 VSS.t61 sg13_lv_nmos ad=0.1428p pd=1.52u as=0 ps=0 w=0.42u l=1u
X1296 VSS.t20 a_2540_15960# counter_value_o[0] VSS.t19 sg13_lv_nmos ad=0.14875p pd=1.16u as=0.2886p ps=2.26u w=0.74u l=0.13u
X1297 a_12010_15202# sg13cmos5l_buf_8_2.A VDD VDD sg13_lv_pmos ad=0.3808p pd=2.92u as=0.2128p ps=1.5u w=1.12u l=0.13u
X1298 VSS.t630 VDD VSS.t633 VSS.t761 sg13_lv_nmos ad=79.8f pd=0.8u as=0 ps=0 w=0.42u l=1u
X1299 VSS.t2359 VDD VSS.t2361 VSS.t2360 sg13_lv_nmos ad=79.8f pd=0.8u as=0 ps=0 w=0.42u l=1u
X1300 VDD VSS.t2124 VDD VDD sg13_lv_pmos ad=0.19p pd=1.38u as=0 ps=0 w=1u l=1u
X1301 a_25670_14922# a_26475_14495# a_25930_14452# VDD sg13_lv_pmos ad=0.1428p pd=1.52u as=79.8f ps=0.8u w=0.42u l=0.13u
X1302 VDD a_19323_13726# sg13cmos5l_buf_8_2.X VDD sg13_lv_pmos ad=0.3864p pd=2.93u as=0.2128p ps=1.5u w=1.12u l=0.13u
X1303 VSS.t1001 VDD VSS.t1000 VSS.t999 sg13_lv_nmos ad=0.1428p pd=1.52u as=0 ps=0 w=0.42u l=1u
X1304 VDD VSS.t983 VDD VDD sg13_lv_pmos ad=0.19p pd=1.38u as=0 ps=0 w=1u l=1u
X1305 VSS.t62 enable_i a_1192_3900# VSS.t61 sg13_lv_nmos ad=0.14875p pd=1.16u as=0.187p ps=1.78u w=0.55u l=0.13u
X1306 VSS.t1215 VDD VSS.t1216 VSS.t70 sg13_lv_nmos ad=79.8f pd=0.8u as=0 ps=0 w=0.42u l=1u
X1307 VDD VSS.t1457 VDD VDD sg13_lv_pmos ad=0.19p pd=1.38u as=0 ps=0 w=1u l=1u
X1308 VSS.t277 VDD VSS.t276 VSS.t275 sg13_lv_nmos ad=0.1428p pd=1.52u as=0 ps=0 w=0.42u l=1u
X1309 VSS.t15 VDD VSS.t15 VSS.t402 sg13_lv_nmos ad=0.1428p pd=1.52u as=0 ps=0 w=0.42u l=1u
X1310 VSS.t2905 VDD VSS.t2904 VSS.t2903 sg13_lv_nmos ad=0.1428p pd=1.52u as=0 ps=0 w=0.42u l=1u
X1311 VDD VSS.t381 VDD VDD sg13_lv_pmos ad=0.19p pd=1.38u as=0 ps=0 w=1u l=1u
X1312 sg13cmos5l_dfrbpq_1_5.D a_25206_14508# VDD VDD sg13_lv_pmos ad=0.4256p pd=3u as=0.2254p ps=1.53u w=1.12u l=0.13u
X1313 VDD sg13cmos5l_or3_1_1.A a_25037_14020# VDD sg13_lv_pmos ad=0.3822p pd=1.84u as=0.1575p ps=1.315u w=1u l=0.13u
X1314 VDD VSS.t1298 VDD VDD sg13_lv_pmos ad=0.34p pd=2.68u as=0 ps=0 w=1u l=1u
X1315 VDD VSS.t2491 VDD VDD sg13_lv_pmos ad=0.19p pd=1.38u as=0 ps=0 w=1u l=1u
X1316 VSS.t3195 sg13cmos5l_o21ai_1_2.B1 a_24169_14508# VSS.t56 sg13_lv_nmos ad=0.13395p pd=1.12u as=0.198p ps=1.27u w=0.55u l=0.13u
X1317 VDD VSS.t593 VDD VDD sg13_lv_pmos ad=0.19p pd=1.38u as=0 ps=0 w=1u l=1u
X1318 VDD VSS.t2671 VDD VDD sg13_lv_pmos ad=0.34p pd=2.68u as=0 ps=0 w=1u l=1u
X1319 VSS.t64 sg13cmos5l_a21oi_1_0.A2 a_17057_14832# VSS.t3267 sg13_lv_nmos ad=0.2516p pd=2.16u as=0.1406p ps=1.12u w=0.74u l=0.13u
X1320 VSS.t1475 VDD VSS.t1474 VSS.t1473 sg13_lv_nmos ad=0.1428p pd=1.52u as=0 ps=0 w=0.42u l=1u
X1321 VSS.t806 VDD VSS.t808 VSS.t807 sg13_lv_nmos ad=79.8f pd=0.8u as=0 ps=0 w=0.42u l=1u
X1322 VSS.t2037 VDD VSS.t2036 VSS.t2035 sg13_lv_nmos ad=0.1428p pd=1.52u as=0 ps=0 w=0.42u l=1u
X1323 a_4594_15234# sg13cmos5l_dfrbpq_1_0.RESET_B VSS.t15 VSS.t3199 sg13_lv_nmos ad=37.8f pd=0.6u as=79.8f ps=0.8u w=0.42u l=0.13u
X1324 VSS.t64 a_17806_15423# sg13cmos5l_inv_1_0.A VSS.t177 sg13_lv_nmos ad=0.1426p pd=1.16u as=0.2516p ps=2.16u w=0.74u l=0.13u
X1325 a_5707_14832# sg13cmos5l_buf_1_10.X a_5613_14832# VSS.t1 sg13_lv_nmos ad=0.1216p pd=1.02u as=0.2176p ps=1.96u w=0.64u l=0.13u
X1326 VSS.t876 VDD VSS.t878 VSS.t877 sg13_lv_nmos ad=79.8f pd=0.8u as=0 ps=0 w=0.42u l=1u
X1327 VDD VSS.t865 VDD VDD sg13_lv_pmos ad=0.34p pd=2.68u as=0 ps=0 w=1u l=1u
X1328 sg13cmos5l_and2_1_2.X a_8685_14832# VDD VDD sg13_lv_pmos ad=0.3808p pd=2.92u as=0.1918p ps=1.5u w=1.12u l=0.13u
X1329 VSS.t1470 VDD VSS.t1469 VSS.t1468 sg13_lv_nmos ad=0.1428p pd=1.52u as=0 ps=0 w=0.42u l=1u
X1330 VSS.t2379 VDD VSS.t2378 VSS.t2377 sg13_lv_nmos ad=0.1428p pd=1.52u as=0 ps=0 w=0.42u l=1u
X1331 a_6598_14909# sg13cmos5l_dfrbpq_1_1.RESET_B VSS.t15 VSS.t201 sg13_lv_nmos ad=37.8f pd=0.6u as=0.1701p ps=1.65u w=0.42u l=0.13u
X1332 VSS.t612 VDD VSS.t612 VSS.t748 sg13_lv_nmos ad=0.1428p pd=1.52u as=0 ps=0 w=0.42u l=1u
X1333 VSS.t1640 VDD VSS.t1642 VSS.t1641 sg13_lv_nmos ad=79.8f pd=0.8u as=0 ps=0 w=0.42u l=1u
X1334 VSS.t2655 VDD VSS.t2653 VSS.t61 sg13_lv_nmos ad=0.1428p pd=1.52u as=0 ps=0 w=0.42u l=1u
X1335 VDD VSS.t34 VDD VDD sg13_lv_pmos ad=0.19p pd=1.38u as=0 ps=0 w=1u l=1u
X1336 VDD VSS.t1337 VDD VDD sg13_lv_pmos ad=0.34p pd=2.68u as=0 ps=0 w=1u l=1u
X1337 VDD VSS.t1951 VDD VDD sg13_lv_pmos ad=0.34p pd=2.68u as=0 ps=0 w=1u l=1u
X1338 a_9444_15552# a_9418_15457# VDD VDD sg13_lv_pmos ad=0.34p pd=2.68u as=0.36237p ps=2.605u w=1u l=0.13u
X1339 VSS.t41 a_26170_15202# a_25889_15424# VSS.t3280 sg13_lv_nmos ad=79.8f pd=0.8u as=0.1428p ps=1.52u w=0.42u l=0.5u
X1340 VDD VSS.t3077 VDD VDD sg13_lv_pmos ad=0.19p pd=1.38u as=0 ps=0 w=1u l=1u
X1341 VDD VSS.t2286 VDD VDD sg13_lv_pmos ad=0.19p pd=1.38u as=0 ps=0 w=1u l=1u
X1342 VDD a_19323_13726# sg13cmos5l_buf_8_2.X VDD sg13_lv_pmos ad=0.2128p pd=1.5u as=0.2128p ps=1.5u w=1.12u l=0.13u
X1343 VDD VSS.t928 VDD VDD sg13_lv_pmos ad=0.19p pd=1.38u as=0 ps=0 w=1u l=1u
X1344 VSS.t1188 VDD VSS.t1187 VSS.t70 sg13_lv_nmos ad=0.1428p pd=1.52u as=0 ps=0 w=0.42u l=1u
X1345 VSS.t3095 VDD VSS.t3097 VSS.t3096 sg13_lv_nmos ad=79.8f pd=0.8u as=0 ps=0 w=0.42u l=1u
X1346 VSS.t2007 VDD VSS.t2009 VSS.t2008 sg13_lv_nmos ad=79.8f pd=0.8u as=0 ps=0 w=0.42u l=1u
X1347 VSS.t2735 VDD VSS.t2735 VSS.t61 sg13_lv_nmos ad=0.1428p pd=1.52u as=0 ps=0 w=0.42u l=1u
X1348 VDD VSS.t2318 VDD VDD sg13_lv_pmos ad=0.34p pd=2.68u as=0 ps=0 w=1u l=1u
X1349 VDD VSS.t1637 VDD VDD sg13_lv_pmos ad=0.19p pd=1.38u as=0 ps=0 w=1u l=1u
X1350 VSS.t846 VDD VSS.t845 VSS.t844 sg13_lv_nmos ad=0.1428p pd=1.52u as=0 ps=0 w=0.42u l=1u
X1351 VDD VSS.t828 VDD VDD sg13_lv_pmos ad=0.19p pd=1.38u as=0 ps=0 w=1u l=1u
X1352 VSS.t1927 VDD VSS.t1926 VSS.t1925 sg13_lv_nmos ad=0.1428p pd=1.52u as=0 ps=0 w=0.42u l=1u
X1353 sg13cmos5l_nand4_1_0.Y sg13cmos5l_buf_1_0.X VDD VDD sg13_lv_pmos ad=0.2128p pd=1.5u as=0.2128p ps=1.5u w=1.12u l=0.13u
X1354 a_6578_15242# sg13cmos5l_dlygate4sd3_1_3.A VSS.t15 VSS.t3205 sg13_lv_nmos ad=0.1406p pd=1.12u as=0.2886p ps=2.26u w=0.74u l=0.13u
X1355 VSS.t423 VDD VSS.t424 VSS.t15 sg13_lv_nmos ad=79.8f pd=0.8u as=0 ps=0 w=0.42u l=1u
X1356 VDD VSS.t1589 VDD VDD sg13_lv_pmos ad=0.34p pd=2.68u as=0 ps=0 w=1u l=1u
X1357 VSS.t2677 VDD VSS.t2677 VSS.t61 sg13_lv_nmos ad=0.1428p pd=1.52u as=0 ps=0 w=0.42u l=1u
X1358 VDD VSS.t2643 VDD VDD sg13_lv_pmos ad=0.34p pd=2.68u as=0 ps=0 w=1u l=1u
X1359 VDD a_18106_15960# a_17825_16262# VDD sg13_lv_pmos ad=0.1523p pd=1.38u as=0.34p ps=2.68u w=1u l=0.5u
X1360 VDD VSS.t363 VDD VDD sg13_lv_pmos ad=0.34p pd=2.68u as=0 ps=0 w=1u l=1u
X1361 VDD VSS.t943 VDD VDD sg13_lv_pmos ad=0.19p pd=1.38u as=0 ps=0 w=1u l=1u
X1362 a_18863_14845# a_18021_14495# a_17604_14488# VDD sg13_lv_pmos ad=0.2048p pd=1.63u as=0.34p ps=2.68u w=1u l=0.13u
X1363 VSS.t1237 VDD VSS.t1236 VSS.t70 sg13_lv_nmos ad=0.1428p pd=1.52u as=0 ps=0 w=0.42u l=1u
X1364 VDD VSS.t2503 VDD VDD sg13_lv_pmos ad=0.34p pd=2.68u as=0 ps=0 w=1u l=1u
X1365 VDD VSS.t2326 VDD VDD sg13_lv_pmos ad=0.19p pd=1.38u as=0 ps=0 w=1u l=1u
X1366 VSS.t1660 VDD VSS.t1662 VSS.t1661 sg13_lv_nmos ad=79.8f pd=0.8u as=0 ps=0 w=0.42u l=1u
X1367 VSS.t521 VDD VSS.t521 VSS.t522 sg13_lv_nmos ad=0.1428p pd=1.52u as=0 ps=0 w=0.42u l=1u
X1368 VSS.t32 a_27215_14845# a_27882_14484# VSS.t15 sg13_lv_nmos ad=0.1406p pd=1.12u as=0.2516p ps=2.16u w=0.74u l=0.13u
X1369 VDD VSS.t2754 VDD VDD sg13_lv_pmos ad=0.34p pd=2.68u as=0 ps=0 w=1u l=1u
X1370 VSS.t1279 VDD VSS.t1278 VSS.t70 sg13_lv_nmos ad=0.1428p pd=1.52u as=0 ps=0 w=0.42u l=1u
X1371 VDD VSS.t1291 VDD VDD sg13_lv_pmos ad=0.19p pd=1.38u as=0 ps=0 w=1u l=1u
X1372 VDD VSS.t2109 VDD VDD sg13_lv_pmos ad=0.19p pd=1.38u as=0 ps=0 w=1u l=1u
X1373 VSS.t530 VDD VSS.t532 VSS.t531 sg13_lv_nmos ad=79.8f pd=0.8u as=0 ps=0 w=0.42u l=1u
X1374 VSS.t621 VDD VSS.t621 VSS.t622 sg13_lv_nmos ad=79.8f pd=0.8u as=0 ps=0 w=0.42u l=1u
X1375 sg13cmos5l_a21oi_1_3.Y sg13cmos5l_a21oi_1_3.B1 a_25109_12972# VDD sg13_lv_pmos ad=0.3808p pd=2.92u as=0.2128p ps=1.5u w=1.12u l=0.13u
X1376 VSS.t976 VDD VSS.t978 VSS.t977 sg13_lv_nmos ad=79.8f pd=0.8u as=0 ps=0 w=0.42u l=1u
X1377 a_26373_16033# a_26373_16033# VSS.t30 VSS.t29 sg13_lv_nmos ad=0.111p pd=1.34u as=7.70437p ps=50.66u w=0.3u l=0.13u
X1378 a_4377_15549# a_3435_15356# a_4175_15311# VDD sg13_lv_pmos ad=93.45f pd=0.865u as=0.2048p ps=1.63u w=0.42u l=0.13u
X1379 VSS.t432 VDD VSS.t433 VSS.t15 sg13_lv_nmos ad=79.8f pd=0.8u as=0 ps=0 w=0.42u l=1u
X1380 VDD VSS.t3029 VDD VDD sg13_lv_pmos ad=0.34p pd=2.68u as=0 ps=0 w=1u l=1u
X1381 VSS.t2239 VDD VSS.t2241 VSS.t2240 sg13_lv_nmos ad=79.8f pd=0.8u as=0 ps=0 w=0.42u l=1u
X1382 VDD VSS.t2476 VDD VDD sg13_lv_pmos ad=0.19p pd=1.38u as=0 ps=0 w=1u l=1u
X1383 VSS.t806 VDD VSS.t808 VSS.t807 sg13_lv_nmos ad=79.8f pd=0.8u as=0 ps=0 w=0.42u l=1u
X1384 VDD VSS.t1657 VDD VDD sg13_lv_pmos ad=0.19p pd=1.38u as=0 ps=0 w=1u l=1u
X1385 VSS.t298 VDD VSS.t147 VSS.t297 sg13_lv_nmos ad=0.1428p pd=1.52u as=0 ps=0 w=0.42u l=1u
X1386 VDD VSS.t184 VDD VDD sg13_lv_pmos ad=0.19p pd=1.38u as=0 ps=0 w=1u l=1u
X1387 VSS.t1460 VDD VSS.t1459 VSS.t1458 sg13_lv_nmos ad=0.1428p pd=1.52u as=0 ps=0 w=0.42u l=1u
X1388 a_7680_15549# sg13cmos5l_nand3_1_0.Y a_7643_15280# VSS.t3188 sg13_lv_nmos ad=0.2176p pd=1.96u as=78.39999f ps=0.885u w=0.64u l=0.13u
X1389 sg13cmos5l_dfrbpq_1_6.Q a_22986_14484# VDD VDD sg13_lv_pmos ad=0.3808p pd=2.92u as=0.2128p ps=1.5u w=1.12u l=0.13u
X1390 VSS.t1288 VDD VSS.t1287 VSS.t70 sg13_lv_nmos ad=0.1428p pd=1.52u as=0 ps=0 w=0.42u l=1u
X1391 VDD VSS.t2634 VDD VDD sg13_lv_pmos ad=0.34p pd=2.68u as=0 ps=0 w=1u l=1u
X1392 VDD VSS.t1213 VDD VDD sg13_lv_pmos ad=0.34p pd=2.68u as=0 ps=0 w=1u l=1u
X1393 VSS.t2022 VDD VSS.t2021 VSS.t2020 sg13_lv_nmos ad=0.1428p pd=1.52u as=0 ps=0 w=0.42u l=1u
X1394 VSS.t1455 VDD VSS.t1454 VSS.t1453 sg13_lv_nmos ad=0.1428p pd=1.52u as=0 ps=0 w=0.42u l=1u
X1395 VDD VSS.t1183 VDD VDD sg13_lv_pmos ad=0.19p pd=1.38u as=0 ps=0 w=1u l=1u
X1396 VSS.t2646 VDD VSS.t2646 VSS.t61 sg13_lv_nmos ad=0.1428p pd=1.52u as=0 ps=0 w=0.42u l=1u
X1397 VSS.t287 VDD VSS.t282 VSS.t286 sg13_lv_nmos ad=0.1428p pd=1.52u as=0 ps=0 w=0.42u l=1u
X1398 sg13cmos5l_dfrbpq_1_3.D a_17238_15302# VSS.t64 VSS.t63 sg13_lv_nmos ad=0.2516p pd=2.16u as=0.1426p ps=1.16u w=0.74u l=0.13u
X1399 VSS.t1293 VDD VSS.t1292 VSS.t70 sg13_lv_nmos ad=0.1428p pd=1.52u as=0 ps=0 w=0.42u l=1u
X1400 VSS.t2709 VDD VSS.t2710 VSS.t61 sg13_lv_nmos ad=79.8f pd=0.8u as=0 ps=0 w=0.42u l=1u
X1401 VSS.t2364 VDD VSS.t2366 VSS.t2365 sg13_lv_nmos ad=79.8f pd=0.8u as=0 ps=0 w=0.42u l=1u
X1402 VDD VSS.t3062 VDD VDD sg13_lv_pmos ad=0.19p pd=1.38u as=0 ps=0 w=1u l=1u
X1403 VSS.t2459 VDD VSS.t2458 VSS.t2457 sg13_lv_nmos ad=0.1428p pd=1.52u as=0 ps=0 w=0.42u l=1u
X1404 VDD VSS.t2271 VDD VDD sg13_lv_pmos ad=0.19p pd=1.38u as=0 ps=0 w=1u l=1u
X1405 a_9444_15552# a_9418_15457# VSS.t73 VSS.t89 sg13_lv_nmos ad=0.2516p pd=2.16u as=0.1626p ps=1.415u w=0.74u l=0.13u
X1406 VSS.t102 VDD VSS.t729 VSS.t728 sg13_lv_nmos ad=79.8f pd=0.8u as=0 ps=0 w=0.42u l=1u
X1407 VDD VSS.t606 VDD VDD sg13_lv_pmos ad=0.34p pd=2.68u as=0 ps=0 w=1u l=1u
X1408 VSS.t409 VDD VSS.t60 VSS.t65 sg13_lv_nmos ad=0.1428p pd=1.52u as=0 ps=0 w=0.42u l=1u
X1409 sg13cmos5l_a21oi_1_3.B1 sg13cmos5l_buf_1_10.X VSS.t4 VSS.t3 sg13_lv_nmos ad=0.2516p pd=2.16u as=0.2516p ps=2.16u w=0.74u l=0.13u
X1410 VSS.t2727 VDD VSS.t2726 VSS.t61 sg13_lv_nmos ad=0.1428p pd=1.52u as=0 ps=0 w=0.42u l=1u
X1411 VDD VSS.t582 VDD VDD sg13_lv_pmos ad=0.19p pd=1.38u as=0 ps=0 w=1u l=1u
X1412 VSS.t1006 VDD VSS.t1008 VSS.t1007 sg13_lv_nmos ad=79.8f pd=0.8u as=0 ps=0 w=0.42u l=1u
X1413 VDD VSS.t2461 VDD VDD sg13_lv_pmos ad=0.19p pd=1.38u as=0 ps=0 w=1u l=1u
X1414 VSS.t47 sg13cmos5l_nor2_1_0.B sg13cmos5l_dfrbpq_1_2.D VSS.t46 sg13_lv_nmos ad=0.2516p pd=2.16u as=0.1406p ps=1.12u w=0.74u l=0.13u
X1415 VDD VSS.t1192 VDD VDD sg13_lv_pmos ad=0.19p pd=1.38u as=0 ps=0 w=1u l=1u
X1416 VDD sg13cmos5l_xor2_1_0.B a_2516_14484# VDD sg13_lv_pmos ad=0.2128p pd=1.5u as=0.2128p ps=1.5u w=1.12u l=0.13u
X1417 a_20774_14922# sg13cmos5l_dfrbpq_1_6.D VDD VDD sg13_lv_pmos ad=79.8f pd=0.8u as=0.1428p ps=1.52u w=0.42u l=0.13u
X1418 VSS.t1650 VDD VSS.t1652 VSS.t1651 sg13_lv_nmos ad=79.8f pd=0.8u as=0 ps=0 w=0.42u l=1u
X1419 VSS.t3175 VDD VSS.t3177 VSS.t3176 sg13_lv_nmos ad=79.8f pd=0.8u as=0 ps=0 w=0.42u l=1u
X1420 VDD VSS.t1574 VDD VDD sg13_lv_pmos ad=0.34p pd=2.68u as=0 ps=0 w=1u l=1u
X1421 VSS.t2042 VDD VSS.t2041 VSS.t2040 sg13_lv_nmos ad=0.1428p pd=1.52u as=0 ps=0 w=0.42u l=1u
X1422 a_17327_13799# a_16485_13701# a_17233_13799# VSS.t230 sg13_lv_nmos ad=0.12665p pd=1.145u as=0.1428p ps=1.52u w=0.42u l=0.13u
X1423 VDD VSS.t131 VDD VDD sg13_lv_pmos ad=0.34p pd=2.68u as=0 ps=0 w=1u l=1u
X1424 VDD VSS.t2488 VDD VDD sg13_lv_pmos ad=0.34p pd=2.68u as=0 ps=0 w=1u l=1u
X1425 VDD VSS.t810 VDD VDD sg13_lv_pmos ad=0.34p pd=2.68u as=0 ps=0 w=1u l=1u
X1426 VSS.t1645 VDD VSS.t1647 VSS.t1646 sg13_lv_nmos ad=79.8f pd=0.8u as=0 ps=0 w=0.42u l=1u
X1427 VSS.t1306 VDD VSS.t1305 VSS.t70 sg13_lv_nmos ad=0.1428p pd=1.52u as=0 ps=0 w=0.42u l=1u
X1428 VDD VSS.t2516 VDD VDD sg13_lv_pmos ad=0.19p pd=1.38u as=0 ps=0 w=1u l=1u
X1429 VSS.t976 VDD VSS.t978 VSS.t977 sg13_lv_nmos ad=79.8f pd=0.8u as=0 ps=0 w=0.42u l=1u
X1430 VDD VSS.t1180 VDD VDD sg13_lv_pmos ad=0.34p pd=2.68u as=0 ps=0 w=1u l=1u
X1431 VDD VSS.t1956 VDD VDD sg13_lv_pmos ad=0.34p pd=2.68u as=0 ps=0 w=1u l=1u
X1432 VSS.t222 a_21562_15960# a_21281_16262# VSS.t3196 sg13_lv_nmos ad=79.8f pd=0.8u as=0.1428p ps=1.52u w=0.42u l=0.5u
X1433 VSS.t358 VDD VSS.t357 VSS.t356 sg13_lv_nmos ad=0.1428p pd=1.52u as=0 ps=0 w=0.42u l=1u
X1434 a_2490_14447# sg13cmos5l_xor2_1_0.B VSS.t36 VSS.t126 sg13_lv_nmos ad=0.17462p pd=1.185u as=0.15245p ps=1.17u w=0.55u l=0.13u
X1435 VDD VSS.t3082 VDD VDD sg13_lv_pmos ad=0.19p pd=1.38u as=0 ps=0 w=1u l=1u
X1436 VDD VSS.t2291 VDD VDD sg13_lv_pmos ad=0.19p pd=1.38u as=0 ps=0 w=1u l=1u
X1437 VSS.t2122 VDD VSS.t2124 VSS.t2123 sg13_lv_nmos ad=79.8f pd=0.8u as=0 ps=0 w=0.42u l=1u
X1438 VSS.t326 VDD VSS.t325 VSS.t324 sg13_lv_nmos ad=0.1428p pd=1.52u as=0 ps=0 w=0.42u l=1u
X1439 sg13cmos5l_and2_1_1.X a_5613_14832# VDD VDD sg13_lv_pmos ad=0.3808p pd=2.92u as=0.1918p ps=1.5u w=1.12u l=0.13u
X1440 VDD VSS.t451 VDD VDD sg13_lv_pmos ad=0.19p pd=1.38u as=0 ps=0 w=1u l=1u
X1441 VDD VSS.t863 VDD VDD sg13_lv_pmos ad=0.19p pd=1.38u as=0 ps=0 w=1u l=1u
X1442 VSS.t2717 VDD VSS.t2717 VSS.t61 sg13_lv_nmos ad=0.1428p pd=1.52u as=0 ps=0 w=0.42u l=1u
X1443 VSS.t131 a_27500_15960# counter_value_o[5] VSS.t130 sg13_lv_nmos ad=0.14875p pd=1.16u as=0.2886p ps=2.26u w=0.74u l=0.13u
X1444 VDD VSS.t1028 VDD VDD sg13_lv_pmos ad=0.19p pd=1.38u as=0 ps=0 w=1u l=1u
X1445 VDD VSS.t1282 VDD VDD sg13_lv_pmos ad=0.19p pd=1.38u as=0 ps=0 w=1u l=1u
X1446 VDD VSS.t1587 VDD VDD sg13_lv_pmos ad=0.19p pd=1.38u as=0 ps=0 w=1u l=1u
X1447 VDD VSS.t1964 VDD VDD sg13_lv_pmos ad=0.19p pd=1.38u as=0 ps=0 w=1u l=1u
X1448 VDD VSS.t3109 VDD VDD sg13_lv_pmos ad=0.34p pd=2.68u as=0 ps=0 w=1u l=1u
X1449 VSS.t3160 VDD VSS.t3162 VSS.t3161 sg13_lv_nmos ad=79.8f pd=0.8u as=0 ps=0 w=0.42u l=1u
X1450 VSS.t2072 VDD VSS.t2074 VSS.t2073 sg13_lv_nmos ad=79.8f pd=0.8u as=0 ps=0 w=0.42u l=1u
X1451 VSS.t2680 VDD VSS.t2679 VSS.t61 sg13_lv_nmos ad=0.1428p pd=1.52u as=0 ps=0 w=0.42u l=1u
X1452 a_4432_15454# a_4175_15311# a_4594_15234# VSS.t121 sg13_lv_nmos ad=0.1428p pd=1.52u as=37.8f ps=0.6u w=0.42u l=0.13u
X1453 VSS.t896 VDD VSS.t898 VSS.t897 sg13_lv_nmos ad=79.8f pd=0.8u as=0 ps=0 w=0.42u l=1u
X1454 sg13cmos5l_dfrbpq_1_6.Q a_22986_14484# VSS.t60 VSS.t56 sg13_lv_nmos ad=0.2516p pd=2.16u as=0.1406p ps=1.12u w=0.74u l=0.13u
X1455 a_6202_15238# sg13cmos5l_dlygate4sd3_1_3.A VSS.t15 VSS.t3206 sg13_lv_nmos ad=0.1406p pd=1.12u as=0.2516p ps=2.16u w=0.74u l=0.13u
X1456 a_7829_15238# sg13cmos5l_nand3_1_0.Y VSS.t124 VSS.t3189 sg13_lv_nmos ad=0.1406p pd=1.12u as=0.1898p ps=1.36u w=0.74u l=0.13u
X1457 VSS.t53 a_10618_14448# a_10337_14750# VSS.t3186 sg13_lv_nmos ad=79.8f pd=0.8u as=0.1428p ps=1.52u w=0.42u l=0.5u
X1458 VDD VSS.t965 VDD VDD sg13_lv_pmos ad=0.34p pd=2.68u as=0 ps=0 w=1u l=1u
X1459 VDD VSS.t2331 VDD VDD sg13_lv_pmos ad=0.19p pd=1.38u as=0 ps=0 w=1u l=1u
X1460 VSS.t1992 VDD VSS.t1991 VSS.t1990 sg13_lv_nmos ad=0.1428p pd=1.52u as=0 ps=0 w=0.42u l=1u
X1461 VDD VSS.t1989 VDD VDD sg13_lv_pmos ad=0.19p pd=1.38u as=0 ps=0 w=1u l=1u
X1462 VDD sg13cmos5l_or3_1_2.A sg13cmos5l_o21ai_1_1.Y VDD sg13_lv_pmos ad=0.3808p pd=2.92u as=0.2128p ps=1.5u w=1.12u l=0.15u
X1463 VSS.t1320 VDD VSS.t1319 VSS.t70 sg13_lv_nmos ad=0.1428p pd=1.52u as=0 ps=0 w=0.42u l=1u
X1464 a_2630_15234# sg13cmos5l_and2_1_0.X VDD VDD sg13_lv_pmos ad=79.8f pd=0.8u as=0.1428p ps=1.52u w=0.42u l=0.13u
X1465 VSS.t2349 VDD VSS.t2351 VSS.t2350 sg13_lv_nmos ad=79.8f pd=0.8u as=0 ps=0 w=0.42u l=1u
X1466 VDD VSS.t2114 VDD VDD sg13_lv_pmos ad=0.19p pd=1.38u as=0 ps=0 w=1u l=1u
X1467 a_6372_14488# a_6346_14452# VSS.t15 VSS.t155 sg13_lv_nmos ad=0.2516p pd=2.16u as=0.1626p ps=1.415u w=0.74u l=0.13u
X1468 VDD VSS.t431 VDD VDD sg13_lv_pmos ad=0.34p pd=2.68u as=0 ps=0 w=1u l=1u
X1469 VSS.t1902 VDD VSS.t1904 VSS.t1903 sg13_lv_nmos ad=79.8f pd=0.8u as=0 ps=0 w=0.42u l=1u
X1470 VSS.t2757 VDD VSS.t2758 VSS.t61 sg13_lv_nmos ad=79.8f pd=0.8u as=0 ps=0 w=0.42u l=1u
X1471 VDD VSS.t642 VDD VDD sg13_lv_pmos ad=0.34p pd=2.68u as=0 ps=0 w=1u l=1u
X1472 VDD VSS.t1264 VDD VDD sg13_lv_pmos ad=0.34p pd=2.68u as=0 ps=0 w=1u l=1u
X1473 VSS.t30 a_26249_16334# a_26170_16237# VSS.t3306 sg13_lv_nmos ad=7.70437p pd=50.66u as=0.27427p ps=2.28u w=0.795u l=0.13u
X1474 VDD VSS.t363 VDD VDD sg13_lv_pmos ad=0.19p pd=1.38u as=0 ps=0 w=1u l=1u
X1475 VDD VSS.t582 VDD VDD sg13_lv_pmos ad=0.19p pd=1.38u as=0 ps=0 w=1u l=1u
X1476 VSS.t1006 VDD VSS.t1008 VSS.t1007 sg13_lv_nmos ad=79.8f pd=0.8u as=0 ps=0 w=0.42u l=1u
X1477 a_8050_14922# sg13cmos5l_dfrbpq_1_1.RESET_B VSS.t124 VSS.t199 sg13_lv_nmos ad=37.8f pd=0.6u as=79.8f ps=0.8u w=0.42u l=0.13u
X1478 VDD VSS.t980 VDD VDD sg13_lv_pmos ad=0.34p pd=2.68u as=0 ps=0 w=1u l=1u
X1479 VDD VSS.t1627 VDD VDD sg13_lv_pmos ad=0.19p pd=1.38u as=0 ps=0 w=1u l=1u
X1480 VDD VSS.t3094 VDD VDD sg13_lv_pmos ad=0.34p pd=2.68u as=0 ps=0 w=1u l=1u
X1481 VDD VSS.t2303 VDD VDD sg13_lv_pmos ad=0.34p pd=2.68u as=0 ps=0 w=1u l=1u
X1482 VSS.t866 VDD VSS.t865 VSS.t864 sg13_lv_nmos ad=0.1428p pd=1.52u as=0 ps=0 w=0.42u l=1u
X1483 VSS.t1207 VDD VSS.t1209 VSS.t70 sg13_lv_nmos ad=79.8f pd=0.8u as=0 ps=0 w=0.42u l=1u
X1484 VDD VSS.t2637 VDD VDD sg13_lv_pmos ad=0.34p pd=2.68u as=0 ps=0 w=1u l=1u
X1485 VDD VSS.t1300 VDD VDD sg13_lv_pmos ad=0.19p pd=1.38u as=0 ps=0 w=1u l=1u
X1486 VDD VSS.t1909 VDD VDD sg13_lv_pmos ad=0.19p pd=1.38u as=0 ps=0 w=1u l=1u
X1487 VDD VSS.t2737 VDD VDD sg13_lv_pmos ad=0.19p pd=1.38u as=0 ps=0 w=1u l=1u
X1488 VSS.t2027 VDD VSS.t2026 VSS.t2025 sg13_lv_nmos ad=0.1428p pd=1.52u as=0 ps=0 w=0.42u l=1u
X1489 VSS.t1590 VDD VSS.t1589 VSS.t1588 sg13_lv_nmos ad=0.1428p pd=1.52u as=0 ps=0 w=0.42u l=1u
X1490 VSS.t3115 VDD VSS.t3114 VSS.t3113 sg13_lv_nmos ad=0.1428p pd=1.52u as=0 ps=0 w=0.42u l=1u
X1491 VSS.t642 VDD VSS.t645 VSS.t769 sg13_lv_nmos ad=79.8f pd=0.8u as=0 ps=0 w=0.42u l=1u
X1492 VDD VSS.t2501 VDD VDD sg13_lv_pmos ad=0.19p pd=1.38u as=0 ps=0 w=1u l=1u
X1493 sg13cmos5l_dlygate4sd3_1_8.A a_11370_15532# VDD VDD sg13_lv_pmos ad=0.3808p pd=2.92u as=0.2128p ps=1.5u w=1.12u l=0.13u
X1494 sg13cmos5l_a21oi_1_1.Y sg13cmos5l_a21oi_1_3.B1 VSS.t106 VSS.t42 sg13_lv_nmos ad=0.1406p pd=1.12u as=0.2516p ps=2.16u w=0.74u l=0.13u
X1495 VSS.t926 VDD VSS.t928 VSS.t927 sg13_lv_nmos ad=79.8f pd=0.8u as=0 ps=0 w=0.42u l=1u
X1496 VDD VSS.t1941 VDD VDD sg13_lv_pmos ad=0.34p pd=2.68u as=0 ps=0 w=1u l=1u
X1497 VDD VSS.t793 VDD VDD sg13_lv_pmos ad=0.19p pd=1.38u as=0 ps=0 w=1u l=1u
X1498 VDD VSS.t3067 VDD VDD sg13_lv_pmos ad=0.19p pd=1.38u as=0 ps=0 w=1u l=1u
X1499 VSS.t2334 VDD VSS.t2336 VSS.t2335 sg13_lv_nmos ad=79.8f pd=0.8u as=0 ps=0 w=0.42u l=1u
X1500 VDD VSS.t2276 VDD VDD sg13_lv_pmos ad=0.19p pd=1.38u as=0 ps=0 w=1u l=1u
X1501 VSS.t303 VDD VSS.t303 VSS.t304 sg13_lv_nmos ad=79.8f pd=0.8u as=0 ps=0 w=0.42u l=1u
X1502 VSS.t1725 VDD VSS.t1727 VSS.t1726 sg13_lv_nmos ad=79.8f pd=0.8u as=0 ps=0 w=0.42u l=1u
X1503 VSS.t2107 VDD VSS.t2109 VSS.t2108 sg13_lv_nmos ad=79.8f pd=0.8u as=0 ps=0 w=0.42u l=1u
X1504 VDD VSS.t34 VDD VDD sg13_lv_pmos ad=0.19p pd=1.38u as=0 ps=0 w=1u l=1u
X1505 VSS.t826 VDD VSS.t828 VSS.t827 sg13_lv_nmos ad=79.8f pd=0.8u as=0 ps=0 w=0.42u l=1u
X1506 VSS.t1977 VDD VSS.t1979 VSS.t1978 sg13_lv_nmos ad=79.8f pd=0.8u as=0 ps=0 w=0.42u l=1u
X1507 VDD VSS.t439 VDD VDD sg13_lv_pmos ad=0.19p pd=1.38u as=0 ps=0 w=1u l=1u
X1508 VSS.t896 VDD VSS.t898 VSS.t897 sg13_lv_nmos ad=79.8f pd=0.8u as=0 ps=0 w=0.42u l=1u
X1509 VDD VSS.t885 VDD VDD sg13_lv_pmos ad=0.34p pd=2.68u as=0 ps=0 w=1u l=1u
X1510 VSS.t1655 VDD VSS.t1657 VSS.t1656 sg13_lv_nmos ad=79.8f pd=0.8u as=0 ps=0 w=0.42u l=1u
X1511 a_19323_13726# sg13cmos5l_buf_8_2.A VDD VDD sg13_lv_pmos ad=0.2128p pd=1.5u as=0.2128p ps=1.5u w=1.12u l=0.13u
X1512 VSS.t941 VDD VSS.t943 VSS.t942 sg13_lv_nmos ad=79.8f pd=0.8u as=0 ps=0 w=0.42u l=1u
X1513 VDD VSS.t1579 VDD VDD sg13_lv_pmos ad=0.34p pd=2.68u as=0 ps=0 w=1u l=1u
X1514 VDD VSS.t1459 VDD VDD sg13_lv_pmos ad=0.34p pd=2.68u as=0 ps=0 w=1u l=1u
X1515 VSS.t3145 VDD VSS.t3147 VSS.t3146 sg13_lv_nmos ad=79.8f pd=0.8u as=0 ps=0 w=0.42u l=1u
X1516 VSS.t2672 VDD VSS.t2672 VSS.t61 sg13_lv_nmos ad=0.1428p pd=1.52u as=0 ps=0 w=0.42u l=1u
X1517 VDD sg13cmos5l_buf_8_2.A a_12010_15202# VDD sg13_lv_pmos ad=0.2128p pd=1.5u as=0.2128p ps=1.5u w=1.12u l=0.13u
X1518 VSS.t216 VDD VSS.t216 VSS.t589 sg13_lv_nmos ad=0.1428p pd=1.52u as=0 ps=0 w=0.42u l=1u
X1519 VDD VSS.t1010 VDD VDD sg13_lv_pmos ad=0.34p pd=2.68u as=0 ps=0 w=1u l=1u
X1520 VSS.t2259 VDD VSS.t2258 VSS.t2257 sg13_lv_nmos ad=0.1428p pd=1.52u as=0 ps=0 w=0.42u l=1u
X1521 VDD a_22426_15202# a_22145_15424# VDD sg13_lv_pmos ad=0.1523p pd=1.38u as=0.34p ps=2.68u w=1u l=0.5u
X1522 VSS.t624 VDD VSS.t624 VSS.t756 sg13_lv_nmos ad=0.1428p pd=1.52u as=0 ps=0 w=0.42u l=1u
X1523 VDD VSS.t2493 VDD VDD sg13_lv_pmos ad=0.34p pd=2.68u as=0 ps=0 w=1u l=1u
X1524 a_22508_15960# sg13cmos5l_dfrbpq_1_3.Q VDD VDD sg13_lv_pmos ad=0.2856p pd=2.36u as=0.2114p ps=1.54u w=0.84u l=0.13u
X1525 VDD VSS.t948 VDD VDD sg13_lv_pmos ad=0.19p pd=1.38u as=0 ps=0 w=1u l=1u
X1526 VDD VSS.t1236 VDD VDD sg13_lv_pmos ad=0.19p pd=1.38u as=0 ps=0 w=1u l=1u
X1527 VSS.t1200 VDD VSS.t1199 VSS.t70 sg13_lv_nmos ad=0.1428p pd=1.52u as=0 ps=0 w=0.42u l=1u
X1528 VSS.t1240 VDD VSS.t1241 VSS.t70 sg13_lv_nmos ad=79.8f pd=0.8u as=0 ps=0 w=0.42u l=1u
X1529 sg13cmos5l_dfrbpq_1_2.CLK a_12010_15202# VSS.t187 VSS.t190 sg13_lv_nmos ad=0.1406p pd=1.12u as=0.1406p ps=1.12u w=0.74u l=0.13u
X1530 VDD VSS.t102 VDD VDD sg13_lv_pmos ad=0.34p pd=2.68u as=0 ps=0 w=1u l=1u
X1531 VDD VSS.t1285 VDD VDD sg13_lv_pmos ad=0.19p pd=1.38u as=0 ps=0 w=1u l=1u
X1532 VDD VSS.t2789 VDD VDD sg13_lv_pmos ad=0.19p pd=1.38u as=0 ps=0 w=1u l=1u
X1533 VSS.t1710 VDD VSS.t1712 VSS.t1711 sg13_lv_nmos ad=79.8f pd=0.8u as=0 ps=0 w=0.42u l=1u
X1534 VSS.t2514 VDD VSS.t2513 VSS.t2512 sg13_lv_nmos ad=0.1428p pd=1.52u as=0 ps=0 w=0.42u l=1u
X1535 VSS.t1887 VDD VSS.t1889 VSS.t1888 sg13_lv_nmos ad=79.8f pd=0.8u as=0 ps=0 w=0.42u l=1u
X1536 VDD VSS.t88 VDD VDD sg13_lv_pmos ad=0.34p pd=2.68u as=0 ps=0 w=1u l=1u
X1537 VDD a_18863_14845# a_19120_14726# VDD sg13_lv_pmos ad=2.42015p pd=15.68u as=79.8f ps=0.8u w=0.42u l=0.13u
X1538 VSS.t1356 VDD VSS.t1204 VSS.t70 sg13_lv_nmos ad=0.1428p pd=1.52u as=0 ps=0 w=0.42u l=1u
X1539 VSS.t367 VDD VSS.t367 VSS.t369 sg13_lv_nmos ad=0.1428p pd=1.52u as=0 ps=0 w=0.42u l=1u
X1540 a_20218_15238# sg13cmos5l_dfrbpq_1_2.Q VSS.t479 VSS.t42 sg13_lv_nmos ad=0.1406p pd=1.12u as=0.2516p ps=2.16u w=0.74u l=0.13u
X1541 sg13cmos5l_o21ai_1_2.A2 sg13cmos5l_dfrbpq_1_6.Q a_23480_15242# VSS.t65 sg13_lv_nmos ad=0.2516p pd=2.16u as=0.1406p ps=1.12u w=0.74u l=0.13u
X1542 a_15338_14484# sg13cmos5l_a21oi_1_3.B1 VDD VDD sg13_lv_pmos ad=0.1176p pd=1.33u as=0.4032p ps=2.96u w=1.12u l=0.13u
X1543 VSS.t2721 VDD VSS.t2720 VSS.t61 sg13_lv_nmos ad=0.1428p pd=1.52u as=0 ps=0 w=0.42u l=1u
X1544 VDD VSS.t412 VDD VDD sg13_lv_pmos ad=0.19p pd=1.38u as=0 ps=0 w=1u l=1u
X1545 VSS.t866 VDD VSS.t865 VSS.t864 sg13_lv_nmos ad=0.1428p pd=1.52u as=0 ps=0 w=0.42u l=1u
X1546 VSS.t981 VDD VSS.t983 VSS.t982 sg13_lv_nmos ad=79.8f pd=0.8u as=0 ps=0 w=0.42u l=1u
X1547 VDD VSS.t1969 VDD VDD sg13_lv_pmos ad=0.19p pd=1.38u as=0 ps=0 w=1u l=1u
X1548 sg13cmos5l_dlygate4sd3_1_5.A sg13cmos5l_dlygate4sd3_1_4.X a_18454_16374# VSS.t3270 sg13_lv_nmos ad=0.2516p pd=2.16u as=0.1406p ps=1.12u w=0.74u l=0.15u
X1549 VSS.t426 VDD VSS.t427 VSS.t15 sg13_lv_nmos ad=79.8f pd=0.8u as=0 ps=0 w=0.42u l=1u
X1550 VDD VSS.t3079 VDD VDD sg13_lv_pmos ad=0.34p pd=2.68u as=0 ps=0 w=1u l=1u
X1551 VDD VSS.t2288 VDD VDD sg13_lv_pmos ad=0.34p pd=2.68u as=0 ps=0 w=1u l=1u
X1552 VDD sg13cmos5l_dlygate4sd3_1_9.X a_20603_15532# VDD sg13_lv_pmos ad=0.2128p pd=1.5u as=0.2128p ps=1.5u w=1.12u l=0.13u
X1553 VDD VSS.t1612 VDD VDD sg13_lv_pmos ad=0.19p pd=1.38u as=0 ps=0 w=1u l=1u
X1554 VSS.t2077 VDD VSS.t2079 VSS.t2078 sg13_lv_nmos ad=79.8f pd=0.8u as=0 ps=0 w=0.42u l=1u
X1555 VSS.t2683 VDD VSS.t2682 VSS.t61 sg13_lv_nmos ad=0.1428p pd=1.52u as=0 ps=0 w=0.42u l=1u
X1556 VDD VSS.t1652 VDD VDD sg13_lv_pmos ad=0.19p pd=1.38u as=0 ps=0 w=1u l=1u
X1557 VDD VSS.t62 VDD VDD sg13_lv_pmos ad=0.34p pd=2.68u as=0 ps=0 w=1u l=1u
X1558 a_20376_14464# sg13cmos5l_or3_1_2.B VDD VDD sg13_lv_pmos ad=0.2128p pd=1.5u as=0.3808p ps=2.92u w=1.12u l=0.15u
X1559 sg13cmos5l_dfrbpq_1_5.D a_25206_14508# VSS.t66 VSS.t56 sg13_lv_nmos ad=0.2516p pd=2.16u as=0.1426p ps=1.16u w=0.74u l=0.13u
X1560 VDD VSS.t1217 VDD VDD sg13_lv_pmos ad=0.34p pd=2.68u as=0 ps=0 w=1u l=1u
X1561 VDD VSS.t1994 VDD VDD sg13_lv_pmos ad=0.19p pd=1.38u as=0 ps=0 w=1u l=1u
X1562 VSS.t926 VDD VSS.t928 VSS.t927 sg13_lv_nmos ad=79.8f pd=0.8u as=0 ps=0 w=0.42u l=1u
X1563 VDD VSS.t915 VDD VDD sg13_lv_pmos ad=0.34p pd=2.68u as=0 ps=0 w=1u l=1u
X1564 VSS.t1291 VDD VSS.t1290 VSS.t70 sg13_lv_nmos ad=0.1428p pd=1.52u as=0 ps=0 w=0.42u l=1u
X1565 VSS.t512 VDD VSS.t512 VSS.t514 sg13_lv_nmos ad=0.1428p pd=1.52u as=0 ps=0 w=0.42u l=1u
X1566 VSS.t1253 VDD VSS.t1254 VSS.t70 sg13_lv_nmos ad=79.8f pd=0.8u as=0 ps=0 w=0.42u l=1u
X1567 VDD VSS.t2781 VDD VDD sg13_lv_pmos ad=0.19p pd=1.38u as=0 ps=0 w=1u l=1u
X1568 VSS.t2499 VDD VSS.t2498 VSS.t2497 sg13_lv_nmos ad=0.1428p pd=1.52u as=0 ps=0 w=0.42u l=1u
X1569 VDD VSS.t367 VDD VDD sg13_lv_pmos ad=0.34p pd=2.68u as=0 ps=0 w=1u l=1u
X1570 sg13cmos5l_dfrbpq_1_2.CLK a_12010_15202# VSS.t184 VSS.t185 sg13_lv_nmos ad=0.1406p pd=1.12u as=0.1406p ps=1.12u w=0.74u l=0.13u
X1571 VSS.t1872 VDD VSS.t1874 VSS.t1873 sg13_lv_nmos ad=79.8f pd=0.8u as=0 ps=0 w=0.42u l=1u
X1572 VDD a_27407_13799# a_28074_14020# VDD sg13_lv_pmos ad=0.2128p pd=1.5u as=0.3864p ps=2.93u w=1.12u l=0.13u
X1573 VSS.t1665 VDD VSS.t1664 VSS.t1663 sg13_lv_nmos ad=0.1428p pd=1.52u as=0 ps=0 w=0.42u l=1u
X1574 VSS.t826 VDD VSS.t828 VSS.t827 sg13_lv_nmos ad=79.8f pd=0.8u as=0 ps=0 w=0.42u l=1u
X1575 VDD VSS.t2356 VDD VDD sg13_lv_pmos ad=0.19p pd=1.38u as=0 ps=0 w=1u l=1u
X1576 VSS.t731 VDD VSS.t733 VSS.t732 sg13_lv_nmos ad=79.8f pd=0.8u as=0 ps=0 w=0.42u l=1u
X1577 VDD VSS.t1292 VDD VDD sg13_lv_pmos ad=0.34p pd=2.68u as=0 ps=0 w=1u l=1u
X1578 VDD VSS.t1632 VDD VDD sg13_lv_pmos ad=0.19p pd=1.38u as=0 ps=0 w=1u l=1u
X1579 VSS.t941 VDD VSS.t943 VSS.t942 sg13_lv_nmos ad=79.8f pd=0.8u as=0 ps=0 w=0.42u l=1u
X1580 VSS.t1962 VDD VSS.t1964 VSS.t1963 sg13_lv_nmos ad=79.8f pd=0.8u as=0 ps=0 w=0.42u l=1u
X1581 sg13cmos5l_a21oi_1_0.A2 a_16969_16020# VDD VDD sg13_lv_pmos ad=0.3808p pd=2.92u as=0.3822p ps=1.84u w=1.12u l=0.13u
X1582 VDD VSS.t2741 VDD VDD sg13_lv_pmos ad=0.19p pd=1.38u as=0 ps=0 w=1u l=1u
X1583 VSS.t2032 VDD VSS.t2031 VSS.t2030 sg13_lv_nmos ad=0.1428p pd=1.52u as=0 ps=0 w=0.42u l=1u
X1584 VDD VSS.t430 VDD VDD sg13_lv_pmos ad=0.19p pd=1.38u as=0 ps=0 w=1u l=1u
X1585 VDD VSS.t1195 VDD VDD sg13_lv_pmos ad=0.19p pd=1.38u as=0 ps=0 w=1u l=1u
X1586 VSS.t2244 VDD VSS.t2243 VSS.t2242 sg13_lv_nmos ad=0.1428p pd=1.52u as=0 ps=0 w=0.42u l=1u
X1587 VDD VSS.t1659 VDD VDD sg13_lv_pmos ad=0.34p pd=2.68u as=0 ps=0 w=1u l=1u
X1588 VSS.t2640 VDD VSS.t2641 VSS.t61 sg13_lv_nmos ad=79.8f pd=0.8u as=0 ps=0 w=0.42u l=1u
X1589 VDD VSS.t993 VDD VDD sg13_lv_pmos ad=0.19p pd=1.38u as=0 ps=0 w=1u l=1u
X1590 VDD VSS.t2506 VDD VDD sg13_lv_pmos ad=0.19p pd=1.38u as=0 ps=0 w=1u l=1u
X1591 VSS.t43 a_19054_15423# sg13cmos5l_dlygate4sd3_1_4.X VSS.t42 sg13_lv_nmos ad=0.1426p pd=1.16u as=0.2516p ps=2.16u w=0.74u l=0.13u
X1592 a_16356_13735# a_16587_13844# a_16042_13945# VSS.t179 sg13_lv_nmos ad=0.2373p pd=1.97u as=79.8f ps=0.8u w=0.42u l=0.13u
X1593 VDD a_19323_13726# sg13cmos5l_buf_8_2.X VDD sg13_lv_pmos ad=0.2128p pd=1.5u as=0.2128p ps=1.5u w=1.12u l=0.13u
X1594 VDD VSS.t615 VDD VDD sg13_lv_pmos ad=0.19p pd=1.38u as=0 ps=0 w=1u l=1u
X1595 VSS.t1695 VDD VSS.t1697 VSS.t1696 sg13_lv_nmos ad=79.8f pd=0.8u as=0 ps=0 w=0.42u l=1u
X1596 VSS.t2112 VDD VSS.t2114 VSS.t2113 sg13_lv_nmos ad=79.8f pd=0.8u as=0 ps=0 w=0.42u l=1u
X1597 a_16294_13735# sg13cmos5l_dfrbpq_1_2.RESET_B VSS.t79 VSS.t82 sg13_lv_nmos ad=37.8f pd=0.6u as=0.1701p ps=1.65u w=0.42u l=0.13u
X1598 a_25956_13722# sg13cmos5l_dfrbpq_1_5.D a_25862_13722# VSS.t76 sg13_lv_nmos ad=60.89999f pd=0.71u as=0.1428p ps=1.52u w=0.42u l=0.13u
X1599 VSS.t861 VDD VSS.t863 VSS.t862 sg13_lv_nmos ad=79.8f pd=0.8u as=0 ps=0 w=0.42u l=1u
X1600 VSS.t981 VDD VSS.t983 VSS.t982 sg13_lv_nmos ad=79.8f pd=0.8u as=0 ps=0 w=0.42u l=1u
X1601 VDD VSS.t2006 VDD VDD sg13_lv_pmos ad=0.34p pd=2.68u as=0 ps=0 w=1u l=1u
X1602 VSS.t540 VDD VSS.t539 VSS.t538 sg13_lv_nmos ad=0.1428p pd=1.52u as=0 ps=0 w=0.42u l=1u
X1603 VSS.t1026 VDD VSS.t1028 VSS.t1027 sg13_lv_nmos ad=79.8f pd=0.8u as=0 ps=0 w=0.42u l=1u
X1604 VDD VSS.t3132 VDD VDD sg13_lv_pmos ad=0.19p pd=1.38u as=0 ps=0 w=1u l=1u
X1605 sg13cmos5l_nor2_1_0.B a_16140_15424# VDD VDD sg13_lv_pmos ad=0.2408p pd=1.55u as=0.3808p ps=2.92u w=1.12u l=0.13u
X1606 VSS.t2711 VDD VSS.t2711 VSS.t61 sg13_lv_nmos ad=0.1428p pd=1.52u as=0 ps=0 w=0.42u l=1u
X1607 VSS.t460 VDD VSS.t36 VSS.t459 sg13_lv_nmos ad=0.1428p pd=1.52u as=0 ps=0 w=0.42u l=1u
X1608 VDD VSS.t2704 VDD VDD sg13_lv_pmos ad=0.19p pd=1.38u as=0 ps=0 w=1u l=1u
X1609 VDD VSS.t1954 VDD VDD sg13_lv_pmos ad=0.19p pd=1.38u as=0 ps=0 w=1u l=1u
X1610 VSS.t2369 VDD VSS.t2368 VSS.t2367 sg13_lv_nmos ad=0.1428p pd=1.52u as=0 ps=0 w=0.42u l=1u
X1611 VSS.t2062 VDD VSS.t2064 VSS.t2063 sg13_lv_nmos ad=79.8f pd=0.8u as=0 ps=0 w=0.42u l=1u
X1612 VSS.t1625 VDD VSS.t1627 VSS.t1626 sg13_lv_nmos ad=79.8f pd=0.8u as=0 ps=0 w=0.42u l=1u
X1613 VSS.t3150 VDD VSS.t3152 VSS.t3151 sg13_lv_nmos ad=79.8f pd=0.8u as=0 ps=0 w=0.42u l=1u
X1614 VSS.t2675 VDD VSS.t2674 VSS.t61 sg13_lv_nmos ad=0.1428p pd=1.52u as=0 ps=0 w=0.42u l=1u
X1615 VDD VSS.t2301 VDD VDD sg13_lv_pmos ad=0.19p pd=1.38u as=0 ps=0 w=1u l=1u
X1616 VDD VSS.t1175 VDD VDD sg13_lv_pmos ad=0.34p pd=2.68u as=0 ps=0 w=1u l=1u
X1617 VDD VSS.t1637 VDD VDD sg13_lv_pmos ad=0.19p pd=1.38u as=0 ps=0 w=1u l=1u
X1618 VSS.t2017 VDD VSS.t2016 VSS.t2015 sg13_lv_nmos ad=0.1428p pd=1.52u as=0 ps=0 w=0.42u l=1u
X1619 VSS.t24 a_25786_15960# a_25505_16262# VSS.t23 sg13_lv_nmos ad=79.8f pd=0.8u as=0.1428p ps=1.52u w=0.42u l=0.5u
X1620 VDD VSS.t830 VDD VDD sg13_lv_pmos ad=0.34p pd=2.68u as=0 ps=0 w=1u l=1u
X1621 VDD VSS.t1589 VDD VDD sg13_lv_pmos ad=0.34p pd=2.68u as=0 ps=0 w=1u l=1u
X1622 VSS.t2434 VDD VSS.t2436 VSS.t2435 sg13_lv_nmos ad=79.8f pd=0.8u as=0 ps=0 w=0.42u l=1u
X1623 VSS.t1907 VDD VSS.t1909 VSS.t1908 sg13_lv_nmos ad=79.8f pd=0.8u as=0 ps=0 w=0.42u l=1u
X1624 VSS.t1318 VDD VSS.t1317 VSS.t70 sg13_lv_nmos ad=0.1428p pd=1.52u as=0 ps=0 w=0.42u l=1u
X1625 VDD VSS.t1644 VDD VDD sg13_lv_pmos ad=0.34p pd=2.68u as=0 ps=0 w=1u l=1u
X1626 VDD VSS.t2463 VDD VDD sg13_lv_pmos ad=0.34p pd=2.68u as=0 ps=0 w=1u l=1u
X1627 a_8218_13690# sg13cmos5l_dlygate4sd3_1_1.A VSS.t142 VSS.t3228 sg13_lv_nmos ad=0.1428p pd=1.52u as=79.8f ps=0.8u w=0.42u l=0.13u
X1628 VSS.t64 a_17126_15238# a_17238_15302# VSS.t267 sg13_lv_nmos ad=0.1426p pd=1.16u as=0.1428p ps=1.52u w=0.42u l=0.5u
X1629 a_16042_13945# a_16485_13701# a_16425_14113# VDD sg13_lv_pmos ad=79.8f pd=0.8u as=63f ps=0.72u w=0.42u l=0.13u
X1630 VDD VSS.t883 VDD VDD sg13_lv_pmos ad=0.19p pd=1.38u as=0 ps=0 w=1u l=1u
X1631 VSS.t1323 VDD VSS.t1322 VSS.t70 sg13_lv_nmos ad=0.1428p pd=1.52u as=0 ps=0 w=0.42u l=1u
X1632 VDD VSS.t569 VDD VDD sg13_lv_pmos ad=0.34p pd=2.68u as=0 ps=0 w=1u l=1u
X1633 VSS.t1857 VDD VSS.t1859 VSS.t1858 sg13_lv_nmos ad=79.8f pd=0.8u as=0 ps=0 w=0.42u l=1u
X1634 VDD VSS.t1324 VDD VDD sg13_lv_pmos ad=0.19p pd=1.38u as=0 ps=0 w=1u l=1u
X1635 VSS.t2723 VDD VSS.t2723 VSS.t61 sg13_lv_nmos ad=0.1428p pd=1.52u as=0 ps=0 w=0.42u l=1u
X1636 VSS.t334 sg13cmos5l_inv_1_0.Y a_18454_16374# VSS.t3253 sg13_lv_nmos ad=0.1406p pd=1.12u as=0.2516p ps=2.16u w=0.74u l=0.15u
X1637 VDD VSS.t34 VDD VDD sg13_lv_pmos ad=0.34p pd=2.68u as=0 ps=0 w=1u l=1u
X1638 VSS.t621 VDD VSS.t624 VSS.t755 sg13_lv_nmos ad=79.8f pd=0.8u as=0 ps=0 w=0.42u l=1u
X1639 VDD VSS.t2695 VDD VDD sg13_lv_pmos ad=0.19p pd=1.38u as=0 ps=0 w=1u l=1u
X1640 VDD VSS.t1974 VDD VDD sg13_lv_pmos ad=0.19p pd=1.38u as=0 ps=0 w=1u l=1u
X1641 VDD VSS.t3084 VDD VDD sg13_lv_pmos ad=0.34p pd=2.68u as=0 ps=0 w=1u l=1u
X1642 VDD VSS.t2293 VDD VDD sg13_lv_pmos ad=0.34p pd=2.68u as=0 ps=0 w=1u l=1u
X1643 VDD VSS.t1617 VDD VDD sg13_lv_pmos ad=0.19p pd=1.38u as=0 ps=0 w=1u l=1u
X1644 VSS.t1206 VDD VSS.t1207 VSS.t70 sg13_lv_nmos ad=79.8f pd=0.8u as=0 ps=0 w=0.42u l=1u
X1645 VDD VSS.t985 VDD VDD sg13_lv_pmos ad=0.34p pd=2.68u as=0 ps=0 w=1u l=1u
X1646 VDD VSS.t1657 VDD VDD sg13_lv_pmos ad=0.19p pd=1.38u as=0 ps=0 w=1u l=1u
X1647 VDD VSS.t11 VDD VDD sg13_lv_pmos ad=0.34p pd=2.68u as=0 ps=0 w=1u l=1u
X1648 VSS.t41 a_26638_15423# sg13cmos5l_o21ai_1_2.B1 VSS.t120 sg13_lv_nmos ad=0.1426p pd=1.16u as=0.2516p ps=2.16u w=0.74u l=0.13u
X1649 VDD VSS.t923 VDD VDD sg13_lv_pmos ad=0.19p pd=1.38u as=0 ps=0 w=1u l=1u
X1650 VSS.t1580 VDD VSS.t1579 VSS.t1578 sg13_lv_nmos ad=0.1428p pd=1.52u as=0 ps=0 w=0.42u l=1u
X1651 VSS.t3105 VDD VSS.t3104 VSS.t3103 sg13_lv_nmos ad=0.1428p pd=1.52u as=0 ps=0 w=0.42u l=1u
X1652 VDD VSS.t2306 VDD VDD sg13_lv_pmos ad=0.19p pd=1.38u as=0 ps=0 w=1u l=1u
X1653 VSS.t2631 VDD VSS.t2632 VSS.t61 sg13_lv_nmos ad=79.8f pd=0.8u as=0 ps=0 w=0.42u l=1u
X1654 VSS.t791 VDD VSS.t793 VSS.t792 sg13_lv_nmos ad=79.8f pd=0.8u as=0 ps=0 w=0.42u l=1u
X1655 VDD VSS.t2787 VDD VDD sg13_lv_pmos ad=0.19p pd=1.38u as=0 ps=0 w=1u l=1u
X1656 VDD VSS.t147 VDD VDD sg13_lv_pmos ad=0.34p pd=2.68u as=0 ps=0 w=1u l=1u
X1657 sg13cmos5l_dlygate4sd3_1_5.A sg13cmos5l_or3_1_2.B a_18552_15976# VDD sg13_lv_pmos ad=0.2128p pd=1.5u as=0.2128p ps=1.5u w=1.12u l=0.15u
X1658 VDD VSS.t73 VDD VDD sg13_lv_pmos ad=0.34p pd=2.68u as=0 ps=0 w=1u l=1u
X1659 VDD VSS.t645 VDD VDD sg13_lv_pmos ad=0.34p pd=2.68u as=0 ps=0 w=1u l=1u
X1660 VSS.t861 VDD VSS.t863 VSS.t862 sg13_lv_nmos ad=79.8f pd=0.8u as=0 ps=0 w=0.42u l=1u
X1661 VDD VSS.t850 VDD VDD sg13_lv_pmos ad=0.34p pd=2.68u as=0 ps=0 w=1u l=1u
X1662 VSS.t1877 VDD VSS.t1879 VSS.t1878 sg13_lv_nmos ad=79.8f pd=0.8u as=0 ps=0 w=0.42u l=1u
X1663 VSS.t1026 VDD VSS.t1028 VSS.t1027 sg13_lv_nmos ad=79.8f pd=0.8u as=0 ps=0 w=0.42u l=1u
X1664 VDD VSS.t1275 VDD VDD sg13_lv_pmos ad=0.34p pd=2.68u as=0 ps=0 w=1u l=1u
X1665 VSS.t606 VDD VSS.t8 VSS.t605 sg13_lv_nmos ad=0.1428p pd=1.52u as=0 ps=0 w=0.42u l=1u
X1666 VDD VSS.t81 VDD VDD sg13_lv_pmos ad=0.19p pd=1.38u as=0 ps=0 w=1u l=1u
X1667 VSS.t2419 VDD VSS.t2421 VSS.t2420 sg13_lv_nmos ad=79.8f pd=0.8u as=0 ps=0 w=0.42u l=1u
X1668 VDD VSS.t1991 VDD VDD sg13_lv_pmos ad=0.34p pd=2.68u as=0 ps=0 w=1u l=1u
X1669 VDD sg13cmos5l_nand3_1_0.Y a_7680_15549# VDD sg13_lv_pmos ad=0.2891p pd=1.695u as=0.1596p ps=1.22u w=0.84u l=0.13u
X1670 VDD VSS.t2361 VDD VDD sg13_lv_pmos ad=0.19p pd=1.38u as=0 ps=0 w=1u l=1u
X1671 VSS.t411 VDD VSS.t412 VSS.t15 sg13_lv_nmos ad=79.8f pd=0.8u as=0 ps=0 w=0.42u l=1u
X1672 VSS.t886 VDD VSS.t885 VSS.t884 sg13_lv_nmos ad=0.1428p pd=1.52u as=0 ps=0 w=0.42u l=1u
X1673 VDD VSS.t2116 VDD VDD sg13_lv_pmos ad=0.34p pd=2.68u as=0 ps=0 w=1u l=1u
X1674 VSS.t1367 VDD VSS.t1220 VSS.t70 sg13_lv_nmos ad=79.8f pd=0.8u as=0 ps=0 w=0.42u l=1u
X1675 VSS.t1967 VDD VSS.t1969 VSS.t1968 sg13_lv_nmos ad=79.8f pd=0.8u as=0 ps=0 w=0.42u l=1u
X1676 VDD VSS.t1312 VDD VDD sg13_lv_pmos ad=0.19p pd=1.38u as=0 ps=0 w=1u l=1u
X1677 VSS.t2002 VDD VSS.t2001 VSS.t2000 sg13_lv_nmos ad=0.1428p pd=1.52u as=0 ps=0 w=0.42u l=1u
X1678 VSS.t642 VDD VSS.t642 VSS.t643 sg13_lv_nmos ad=79.8f pd=0.8u as=0 ps=0 w=0.42u l=1u
X1679 sg13cmos5l_nand3_1_0.Y sg13cmos5l_buf_1_0.X VDD VDD sg13_lv_pmos ad=0.3808p pd=2.92u as=0.2128p ps=1.5u w=1.12u l=0.13u
X1680 VSS.t1184 VDD VSS.t1183 VSS.t70 sg13_lv_nmos ad=0.1428p pd=1.52u as=0 ps=0 w=0.42u l=1u
X1681 VSS.t946 VDD VSS.t948 VSS.t947 sg13_lv_nmos ad=79.8f pd=0.8u as=0 ps=0 w=0.42u l=1u
X1682 VDD VSS.t1574 VDD VDD sg13_lv_pmos ad=0.34p pd=2.68u as=0 ps=0 w=1u l=1u
X1683 VSS.t64 sg13cmos5l_a21oi_1_0.Y a_16856_15238# VSS.t160 sg13_lv_nmos ad=79.8f pd=0.8u as=0.1428p ps=1.52u w=0.42u l=0.13u
X1684 VSS.t587 VDD VSS.t587 VSS.t706 sg13_lv_nmos ad=0.1428p pd=1.52u as=0 ps=0 w=0.42u l=1u
X1685 VDD VSS.t813 VDD VDD sg13_lv_pmos ad=0.19p pd=1.38u as=0 ps=0 w=1u l=1u
X1686 VDD VSS.t1629 VDD VDD sg13_lv_pmos ad=0.34p pd=2.68u as=0 ps=0 w=1u l=1u
X1687 VSS.t3005 VDD VSS.t3007 VSS.t3006 sg13_lv_nmos ad=79.8f pd=0.8u as=0 ps=0 w=0.42u l=1u
X1688 VSS.t2374 VDD VSS.t2373 VSS.t2372 sg13_lv_nmos ad=0.1428p pd=1.52u as=0 ps=0 w=0.42u l=1u
X1689 VSS.t1917 VDD VSS.t1919 VSS.t1918 sg13_lv_nmos ad=79.8f pd=0.8u as=0 ps=0 w=0.42u l=1u
X1690 VDD VSS.t2947 VDD VDD sg13_lv_pmos ad=0.19p pd=1.38u as=0 ps=0 w=1u l=1u
X1691 a_22030_15423# a_22145_15424# VDD VDD sg13_lv_pmos ad=0.34p pd=2.68u as=0.2254p ps=1.53u w=1u l=0.5u
X1692 VDD VSS.t569 VDD VDD sg13_lv_pmos ad=0.34p pd=2.68u as=0 ps=0 w=1u l=1u
X1693 VSS.t1700 VDD VSS.t1702 VSS.t1701 sg13_lv_nmos ad=79.8f pd=0.8u as=0 ps=0 w=0.42u l=1u
X1694 a_18106_15960# sg13cmos5l_dlygate4sd3_1_5.A VDD VDD sg13_lv_pmos ad=0.1428p pd=1.52u as=0.1523p ps=1.38u w=0.42u l=0.13u
X1695 VSS.t2789 VDD VSS.t2790 VSS.t61 sg13_lv_nmos ad=79.8f pd=0.8u as=0 ps=0 w=0.42u l=1u
X1696 VDD VSS.t2353 VDD VDD sg13_lv_pmos ad=0.34p pd=2.68u as=0 ps=0 w=1u l=1u
X1697 VDD VSS.t2011 VDD VDD sg13_lv_pmos ad=0.34p pd=2.68u as=0 ps=0 w=1u l=1u
X1698 sg13cmos5l_o21ai_1_1.Y sg13cmos5l_or3_1_2.A a_20278_14862# VSS.t16 sg13_lv_nmos ad=0.2516p pd=2.16u as=0.1406p ps=1.12u w=0.74u l=0.15u
X1699 VDD VSS.t1315 VDD VDD sg13_lv_pmos ad=0.19p pd=1.38u as=0 ps=0 w=1u l=1u
X1700 VSS.t512 VDD VSS.t512 VSS.t514 sg13_lv_nmos ad=0.1428p pd=1.52u as=0 ps=0 w=0.42u l=1u
X1701 VSS.t2715 VDD VSS.t2714 VSS.t61 sg13_lv_nmos ad=0.1428p pd=1.52u as=0 ps=0 w=0.42u l=1u
X1702 VSS.t1270 VDD VSS.t1269 VSS.t70 sg13_lv_nmos ad=0.1428p pd=1.52u as=0 ps=0 w=0.42u l=1u
X1703 VDD VSS.t2686 VDD VDD sg13_lv_pmos ad=0.19p pd=1.38u as=0 ps=0 w=1u l=1u
X1704 VDD VSS.t1959 VDD VDD sg13_lv_pmos ad=0.19p pd=1.38u as=0 ps=0 w=1u l=1u
X1705 VDD VSS.t451 VDD VDD sg13_lv_pmos ad=0.19p pd=1.38u as=0 ps=0 w=1u l=1u
X1706 VDD VSS.t1293 VDD VDD sg13_lv_pmos ad=0.34p pd=2.68u as=0 ps=0 w=1u l=1u
X1707 VSS.t2339 VDD VSS.t2338 VSS.t2337 sg13_lv_nmos ad=0.1428p pd=1.52u as=0 ps=0 w=0.42u l=1u
X1708 VDD sg13cmos5l_a21oi_1_0.A1 a_16955_14484# VDD sg13_lv_pmos ad=0.2128p pd=1.5u as=0.2128p ps=1.5u w=1.12u l=0.13u
X1709 VDD VSS.t591 VDD VDD sg13_lv_pmos ad=0.19p pd=1.38u as=0 ps=0 w=1u l=1u
X1710 VSS.t624 VDD VSS.t621 VSS.t623 sg13_lv_nmos ad=0.1428p pd=1.52u as=0 ps=0 w=0.42u l=1u
X1711 VDD VSS.t1030 VDD VDD sg13_lv_pmos ad=0.34p pd=2.68u as=0 ps=0 w=1u l=1u
X1712 VSS.t1630 VDD VSS.t1632 VSS.t1631 sg13_lv_nmos ad=79.8f pd=0.8u as=0 ps=0 w=0.42u l=1u
X1713 VSS.t3155 VDD VSS.t3157 VSS.t3156 sg13_lv_nmos ad=79.8f pd=0.8u as=0 ps=0 w=0.42u l=1u
X1714 sg13cmos5l_buf_8_2.A a_15579_14854# VSS.t47 VSS.t3240 sg13_lv_nmos ad=0.1406p pd=1.12u as=0.1406p ps=1.12u w=0.74u l=0.13u
X1715 VSS.t273 VDD VSS.t273 VSS.t376 sg13_lv_nmos ad=0.1428p pd=1.52u as=0 ps=0 w=0.42u l=1u
X1716 VDD VSS.t415 VDD VDD sg13_lv_pmos ad=0.19p pd=1.38u as=0 ps=0 w=1u l=1u
X1717 VSS.t916 VDD VSS.t915 VSS.t914 sg13_lv_nmos ad=0.1428p pd=1.52u as=0 ps=0 w=0.42u l=1u
X1718 VSS.t2439 VDD VSS.t2441 VSS.t2440 sg13_lv_nmos ad=79.8f pd=0.8u as=0 ps=0 w=0.42u l=1u
X1719 a_17126_15238# a_16856_15238# VDD VDD sg13_lv_pmos ad=0.34p pd=2.68u as=0.1523p ps=1.38u w=1u l=0.5u
X1720 VSS.t791 VDD VSS.t793 VSS.t792 sg13_lv_nmos ad=79.8f pd=0.8u as=0 ps=0 w=0.42u l=1u
X1721 VDD VSS.t968 VDD VDD sg13_lv_pmos ad=0.19p pd=1.38u as=0 ps=0 w=1u l=1u
X1722 VDD VSS.t1248 VDD VDD sg13_lv_pmos ad=0.19p pd=1.38u as=0 ps=0 w=1u l=1u
X1723 VSS.t2713 VDD VSS.t2711 VSS.t61 sg13_lv_nmos ad=0.1428p pd=1.52u as=0 ps=0 w=0.42u l=1u
X1724 VDD VSS.t2468 VDD VDD sg13_lv_pmos ad=0.34p pd=2.68u as=0 ps=0 w=1u l=1u
X1725 VSS.t340 VDD VSS.t339 VSS.t338 sg13_lv_nmos ad=0.1428p pd=1.52u as=0 ps=0 w=0.42u l=1u
X1726 sg13cmos5l_xnor2_1_2.B sg13cmos5l_dlygate4sd3_1_3.A VDD VDD sg13_lv_pmos ad=0.2128p pd=1.5u as=0.3808p ps=2.92u w=1.12u l=0.13u
X1727 VDD a_10618_14448# a_10337_14750# VDD sg13_lv_pmos ad=0.1523p pd=1.38u as=0.34p ps=2.68u w=1u l=0.5u
X1728 VDD a_17327_13799# a_17584_13942# VDD sg13_lv_pmos ad=2.42015p pd=15.68u as=79.8f ps=0.8u w=0.42u l=0.13u
X1729 VSS.t1660 VDD VSS.t1659 VSS.t1658 sg13_lv_nmos ad=0.1428p pd=1.52u as=0 ps=0 w=0.42u l=1u
X1730 VDD VSS.t2932 VDD VDD sg13_lv_pmos ad=0.19p pd=1.38u as=0 ps=0 w=1u l=1u
X1731 VDD VSS.t2779 VDD VDD sg13_lv_pmos ad=0.19p pd=1.38u as=0 ps=0 w=1u l=1u
X1732 VDD VSS.t142 VDD VDD sg13_lv_pmos ad=0.19p pd=1.38u as=0 ps=0 w=1u l=1u
X1733 VDD a_21466_15202# a_21185_15424# VDD sg13_lv_pmos ad=0.1523p pd=1.38u as=0.34p ps=2.68u w=1u l=0.5u
X1734 a_16356_13735# a_16068_14040# a_16294_13735# VSS.t3184 sg13_lv_nmos ad=0.1428p pd=1.52u as=37.8f ps=0.6u w=0.42u l=0.13u
X1735 VSS.t532 VDD VSS.t530 VSS.t665 sg13_lv_nmos ad=0.1428p pd=1.52u as=0 ps=0 w=0.42u l=1u
X1736 VDD VSS.t2751 VDD VDD sg13_lv_pmos ad=0.34p pd=2.68u as=0 ps=0 w=1u l=1u
X1737 VSS.t512 VDD VSS.t512 VSS.t516 sg13_lv_nmos ad=0.1428p pd=1.52u as=0 ps=0 w=0.42u l=1u
X1738 VSS.t596 VDD VSS.t593 VSS.t719 sg13_lv_nmos ad=0.1428p pd=1.52u as=0 ps=0 w=0.42u l=1u
X1739 VDD VSS.t601 VDD VDD sg13_lv_pmos ad=0.19p pd=1.38u as=0 ps=0 w=1u l=1u
X1740 VSS.t2950 VDD VSS.t2952 VSS.t2951 sg13_lv_nmos ad=79.8f pd=0.8u as=0 ps=0 w=0.42u l=1u
X1741 VSS.t1862 VDD VSS.t1864 VSS.t1863 sg13_lv_nmos ad=79.8f pd=0.8u as=0 ps=0 w=0.42u l=1u
X1742 VDD VSS.t1174 VDD VDD sg13_lv_pmos ad=0.19p pd=1.38u as=0 ps=0 w=1u l=1u
X1743 VDD VSS.t1327 VDD VDD sg13_lv_pmos ad=0.19p pd=1.38u as=0 ps=0 w=1u l=1u
X1744 VSS.t1655 VDD VSS.t1654 VSS.t1653 sg13_lv_nmos ad=0.1428p pd=1.52u as=0 ps=0 w=0.42u l=1u
X1745 VSS.t438 VDD VSS.t439 VSS.t15 sg13_lv_nmos ad=79.8f pd=0.8u as=0 ps=0 w=0.42u l=1u
X1746 VDD VSS.t431 VDD VDD sg13_lv_pmos ad=0.34p pd=2.68u as=0 ps=0 w=1u l=1u
X1747 VDD VSS.t843 VDD VDD sg13_lv_pmos ad=0.19p pd=1.38u as=0 ps=0 w=1u l=1u
X1748 VSS.t886 VDD VSS.t885 VSS.t884 sg13_lv_nmos ad=0.1428p pd=1.52u as=0 ps=0 w=0.42u l=1u
X1749 VSS.t1416 VDD VSS.t1282 VSS.t70 sg13_lv_nmos ad=0.1428p pd=1.52u as=0 ps=0 w=0.42u l=1u
X1750 VDD VSS.t2346 VDD VDD sg13_lv_pmos ad=0.19p pd=1.38u as=0 ps=0 w=1u l=1u
X1751 VSS.t2404 VDD VSS.t2406 VSS.t2405 sg13_lv_nmos ad=79.8f pd=0.8u as=0 ps=0 w=0.42u l=1u
X1752 VDD VSS.t2698 VDD VDD sg13_lv_pmos ad=0.19p pd=1.38u as=0 ps=0 w=1u l=1u
X1753 VDD VSS.t1944 VDD VDD sg13_lv_pmos ad=0.19p pd=1.38u as=0 ps=0 w=1u l=1u
X1754 VDD VSS.t3089 VDD VDD sg13_lv_pmos ad=0.34p pd=2.68u as=0 ps=0 w=1u l=1u
X1755 VSS.t2359 VDD VSS.t2358 VSS.t2357 sg13_lv_nmos ad=0.1428p pd=1.52u as=0 ps=0 w=0.42u l=1u
X1756 VDD VSS.t2298 VDD VDD sg13_lv_pmos ad=0.34p pd=2.68u as=0 ps=0 w=1u l=1u
X1757 VDD VSS.t735 VDD VDD sg13_lv_pmos ad=0.34p pd=2.68u as=0 ps=0 w=1u l=1u
X1758 VDD VSS.t1627 VDD VDD sg13_lv_pmos ad=0.19p pd=1.38u as=0 ps=0 w=1u l=1u
X1759 VSS.t540 VDD VSS.t539 VSS.t538 sg13_lv_nmos ad=0.1428p pd=1.52u as=0 ps=0 w=0.42u l=1u
X1760 VDD VSS.t1228 VDD VDD sg13_lv_pmos ad=0.34p pd=2.68u as=0 ps=0 w=1u l=1u
X1761 VDD a_7888_14726# a_7833_14607# VDD sg13_lv_pmos ad=2.42015p pd=15.68u as=93.45f ps=0.865u w=0.42u l=0.13u
X1762 sg13cmos5l_buf_8_2.A a_15579_14854# VSS.t47 VSS.t3236 sg13_lv_nmos ad=0.1406p pd=1.12u as=0.1406p ps=1.12u w=0.74u l=0.13u
X1763 VSS.t946 VDD VSS.t948 VSS.t947 sg13_lv_nmos ad=79.8f pd=0.8u as=0 ps=0 w=0.42u l=1u
X1764 VDD VSS.t1682 VDD VDD sg13_lv_pmos ad=0.19p pd=1.38u as=0 ps=0 w=1u l=1u
X1765 VSS.t34 VDD VSS.t34 VSS.t394 sg13_lv_nmos ad=0.1428p pd=1.52u as=0 ps=0 w=0.42u l=1u
X1766 VSS.t521 VDD VSS.t521 VSS.t524 sg13_lv_nmos ad=0.1428p pd=1.52u as=0 ps=0 w=0.42u l=1u
X1767 VDD VSS.t567 VDD VDD sg13_lv_pmos ad=0.19p pd=1.38u as=0 ps=0 w=1u l=1u
X1768 VSS.t991 VDD VSS.t993 VSS.t992 sg13_lv_nmos ad=79.8f pd=0.8u as=0 ps=0 w=0.42u l=1u
X1769 VDD VSS.t1206 VDD VDD sg13_lv_pmos ad=0.19p pd=1.38u as=0 ps=0 w=1u l=1u
X1770 VDD VSS.t2771 VDD VDD sg13_lv_pmos ad=0.19p pd=1.38u as=0 ps=0 w=1u l=1u
X1771 VSS.t2082 VDD VSS.t2081 VSS.t2080 sg13_lv_nmos ad=0.1428p pd=1.52u as=0 ps=0 w=0.42u l=1u
X1772 VDD VSS.t279 VDD VDD sg13_lv_pmos ad=0.19p pd=1.38u as=0 ps=0 w=1u l=1u
X1773 VSS.t1645 VDD VSS.t1644 VSS.t1643 sg13_lv_nmos ad=0.1428p pd=1.52u as=0 ps=0 w=0.42u l=1u
X1774 VSS.t3170 VDD VSS.t3169 VSS.t3168 sg13_lv_nmos ad=0.1428p pd=1.52u as=0 ps=0 w=0.42u l=1u
X1775 VSS.t2990 VDD VSS.t2992 VSS.t2991 sg13_lv_nmos ad=79.8f pd=0.8u as=0 ps=0 w=0.42u l=1u
X1776 a_6346_14452# a_6789_14495# a_6729_14531# VDD sg13_lv_pmos ad=79.8f pd=0.8u as=63f ps=0.72u w=0.42u l=0.13u
X1777 VSS.t2705 VDD VSS.t2707 VSS.t61 sg13_lv_nmos ad=79.8f pd=0.8u as=0 ps=0 w=0.42u l=1u
X1778 VDD VSS.t313 VDD VDD sg13_lv_pmos ad=0.19p pd=1.38u as=0 ps=0 w=1u l=1u
X1779 VDD VSS.t998 VDD VDD sg13_lv_pmos ad=0.19p pd=1.38u as=0 ps=0 w=1u l=1u
X1780 VSS.t2781 VDD VSS.t2782 VSS.t61 sg13_lv_nmos ad=79.8f pd=0.8u as=0 ps=0 w=0.42u l=1u
X1781 VSS.t420 VDD VSS.t419 VSS.t15 sg13_lv_nmos ad=0.1428p pd=1.52u as=0 ps=0 w=0.42u l=1u
X1782 VDD VSS.t795 VDD VDD sg13_lv_pmos ad=0.34p pd=2.68u as=0 ps=0 w=1u l=1u
X1783 VDD VSS.t1996 VDD VDD sg13_lv_pmos ad=0.34p pd=2.68u as=0 ps=0 w=1u l=1u
X1784 VSS.t606 VDD VSS.t609 VSS.t745 sg13_lv_nmos ad=79.8f pd=0.8u as=0 ps=0 w=0.42u l=1u
X1785 VDD VSS.t3122 VDD VDD sg13_lv_pmos ad=0.19p pd=1.38u as=0 ps=0 w=1u l=1u
X1786 VDD VSS.t2366 VDD VDD sg13_lv_pmos ad=0.19p pd=1.38u as=0 ps=0 w=1u l=1u
X1787 VSS.t2389 VDD VSS.t2391 VSS.t2390 sg13_lv_nmos ad=79.8f pd=0.8u as=0 ps=0 w=0.42u l=1u
X1788 VDD VSS.t2121 VDD VDD sg13_lv_pmos ad=0.34p pd=2.68u as=0 ps=0 w=1u l=1u
X1789 VSS.t1555 VDD VSS.t1557 VSS.t1556 sg13_lv_nmos ad=79.8f pd=0.8u as=0 ps=0 w=0.42u l=1u
X1790 VDD VSS.t2782 VDD VDD sg13_lv_pmos ad=0.34p pd=2.68u as=0 ps=0 w=1u l=1u
X1791 VSS.t1972 VDD VSS.t1974 VSS.t1973 sg13_lv_nmos ad=79.8f pd=0.8u as=0 ps=0 w=0.42u l=1u
X1792 VSS.t406 VDD VSS.t253 VSS.t476 sg13_lv_nmos ad=0.1428p pd=1.52u as=0 ps=0 w=0.42u l=1u
X1793 VSS.t2704 VDD VSS.t2705 VSS.t61 sg13_lv_nmos ad=79.8f pd=0.8u as=0 ps=0 w=0.42u l=1u
X1794 VSS.t1615 VDD VSS.t1617 VSS.t1616 sg13_lv_nmos ad=79.8f pd=0.8u as=0 ps=0 w=0.42u l=1u
X1795 VSS.t3140 VDD VSS.t3142 VSS.t3141 sg13_lv_nmos ad=79.8f pd=0.8u as=0 ps=0 w=0.42u l=1u
X1796 VDD VSS.t442 VDD VDD sg13_lv_pmos ad=0.19p pd=1.38u as=0 ps=0 w=1u l=1u
X1797 VSS.t916 VDD VSS.t915 VSS.t914 sg13_lv_nmos ad=0.1428p pd=1.52u as=0 ps=0 w=0.42u l=1u
X1798 VSS.t1430 VDD VSS.t1300 VSS.t70 sg13_lv_nmos ad=0.1428p pd=1.52u as=0 ps=0 w=0.42u l=1u
X1799 a_26244_14909# a_25956_14488# a_26182_14909# VSS.t226 sg13_lv_nmos ad=0.1428p pd=1.52u as=37.8f ps=0.6u w=0.42u l=0.13u
X1800 VDD VSS.t1013 VDD VDD sg13_lv_pmos ad=0.19p pd=1.38u as=0 ps=0 w=1u l=1u
X1801 VDD VSS.t1274 VDD VDD sg13_lv_pmos ad=0.19p pd=1.38u as=0 ps=0 w=1u l=1u
X1802 VSS.t34 VDD VSS.t34 VSS.t391 sg13_lv_nmos ad=0.1428p pd=1.52u as=0 ps=0 w=0.42u l=1u
X1803 VDD VSS.t1579 VDD VDD sg13_lv_pmos ad=0.34p pd=2.68u as=0 ps=0 w=1u l=1u
X1804 a_19450_15202# sg13cmos5l_dfrbpq_1_3.Q VDD VDD sg13_lv_pmos ad=0.1428p pd=1.52u as=0.1523p ps=1.38u w=0.42u l=0.13u
X1805 VDD VSS.t1634 VDD VDD sg13_lv_pmos ad=0.34p pd=2.68u as=0 ps=0 w=1u l=1u
X1806 VSS.t3010 VDD VSS.t3012 VSS.t3011 sg13_lv_nmos ad=79.8f pd=0.8u as=0 ps=0 w=0.42u l=1u
X1807 VSS.t1922 VDD VSS.t1924 VSS.t1923 sg13_lv_nmos ad=79.8f pd=0.8u as=0 ps=0 w=0.42u l=1u
X1808 a_20603_15532# sg13cmos5l_or3_1_2.X VDD VDD sg13_lv_pmos ad=0.3808p pd=2.92u as=0.2128p ps=1.5u w=1.12u l=0.13u
X1809 VDD VSS.t2917 VDD VDD sg13_lv_pmos ad=0.19p pd=1.38u as=0 ps=0 w=1u l=1u
X1810 VSS.t1321 VDD VSS.t1320 VSS.t70 sg13_lv_nmos ad=0.1428p pd=1.52u as=0 ps=0 w=0.42u l=1u
X1811 VSS.t1705 VDD VSS.t1707 VSS.t1706 sg13_lv_nmos ad=79.8f pd=0.8u as=0 ps=0 w=0.42u l=1u
X1812 VDD VSS.t2742 VDD VDD sg13_lv_pmos ad=0.34p pd=2.68u as=0 ps=0 w=1u l=1u
X1813 sg13cmos5l_dfrbpq_1_2.CLK a_12010_15202# VDD VDD sg13_lv_pmos ad=0.2128p pd=1.5u as=0.2128p ps=1.5u w=1.12u l=0.13u
X1814 VDD VSS.t253 VDD VDD sg13_lv_pmos ad=0.34p pd=2.68u as=0 ps=0 w=1u l=1u
X1815 VSS.t106 sg13cmos5l_or3_1_2.B a_20278_14862# VSS.t16 sg13_lv_nmos ad=0.1406p pd=1.12u as=0.2516p ps=2.16u w=0.74u l=0.15u
X1816 VDD VSS.t950 VDD VDD sg13_lv_pmos ad=0.34p pd=2.68u as=0 ps=0 w=1u l=1u
X1817 VDD VSS.t303 VDD VDD sg13_lv_pmos ad=0.19p pd=1.38u as=0 ps=0 w=1u l=1u
X1818 VDD VSS.t2323 VDD VDD sg13_lv_pmos ad=0.34p pd=2.68u as=0 ps=0 w=1u l=1u
X1819 VDD VSS.t1318 VDD VDD sg13_lv_pmos ad=0.19p pd=1.38u as=0 ps=0 w=1u l=1u
X1820 VDD VSS.t2508 VDD VDD sg13_lv_pmos ad=0.34p pd=2.68u as=0 ps=0 w=1u l=1u
X1821 VDD VSS.t1289 VDD VDD sg13_lv_pmos ad=0.34p pd=2.68u as=0 ps=0 w=1u l=1u
X1822 VDD VSS.t2689 VDD VDD sg13_lv_pmos ad=0.19p pd=1.38u as=0 ps=0 w=1u l=1u
X1823 VDD VSS.t2106 VDD VDD sg13_lv_pmos ad=0.34p pd=2.68u as=0 ps=0 w=1u l=1u
X1824 VDD VSS.t1929 VDD VDD sg13_lv_pmos ad=0.19p pd=1.38u as=0 ps=0 w=1u l=1u
X1825 sg13cmos5l_or3_1_2.C sg13cmos5l_dfrbpq_1_2.Q VDD VDD sg13_lv_pmos ad=0.2128p pd=1.5u as=0.3808p ps=2.92u w=1.12u l=0.13u
X1826 VSS.t2344 VDD VSS.t2343 VSS.t2342 sg13_lv_nmos ad=0.1428p pd=1.52u as=0 ps=0 w=0.42u l=1u
X1827 VDD VSS.t2283 VDD VDD sg13_lv_pmos ad=0.34p pd=2.68u as=0 ps=0 w=1u l=1u
X1828 VDD VSS.t422 VDD VDD sg13_lv_pmos ad=0.34p pd=2.68u as=0 ps=0 w=1u l=1u
X1829 VDD VSS.t3074 VDD VDD sg13_lv_pmos ad=0.34p pd=2.68u as=0 ps=0 w=1u l=1u
X1830 VDD VSS.t521 VDD VDD sg13_lv_pmos ad=0.19p pd=1.38u as=0 ps=0 w=1u l=1u
X1831 VSS.t3125 VDD VSS.t3127 VSS.t3126 sg13_lv_nmos ad=79.8f pd=0.8u as=0 ps=0 w=0.42u l=1u
X1832 VDD VSS.t412 VDD VDD sg13_lv_pmos ad=0.19p pd=1.38u as=0 ps=0 w=1u l=1u
X1833 VDD VSS.t1255 VDD VDD sg13_lv_pmos ad=0.34p pd=2.68u as=0 ps=0 w=1u l=1u
X1834 VDD VSS.t567 VDD VDD sg13_lv_pmos ad=0.19p pd=1.38u as=0 ps=0 w=1u l=1u
X1835 VSS.t991 VDD VSS.t993 VSS.t992 sg13_lv_nmos ad=79.8f pd=0.8u as=0 ps=0 w=0.42u l=1u
X1836 VSS.t1329 VDD VSS.t1329 VSS.t70 sg13_lv_nmos ad=0.1428p pd=1.52u as=0 ps=0 w=0.42u l=1u
X1837 VDD VSS.t1612 VDD VDD sg13_lv_pmos ad=0.19p pd=1.38u as=0 ps=0 w=1u l=1u
X1838 VSS.t1500 VDD VSS.t1502 VSS.t1501 sg13_lv_nmos ad=79.8f pd=0.8u as=0 ps=0 w=0.42u l=1u
X1839 VSS.t2409 VDD VSS.t2411 VSS.t2410 sg13_lv_nmos ad=79.8f pd=0.8u as=0 ps=0 w=0.42u l=1u
X1840 VSS.t851 VDD VSS.t850 VSS.t849 sg13_lv_nmos ad=0.1428p pd=1.52u as=0 ps=0 w=0.42u l=1u
X1841 VDD VSS.t1197 VDD VDD sg13_lv_pmos ad=0.19p pd=1.38u as=0 ps=0 w=1u l=1u
X1842 VDD VSS.t1984 VDD VDD sg13_lv_pmos ad=0.19p pd=1.38u as=0 ps=0 w=1u l=1u
X1843 VSS.t1630 VDD VSS.t1629 VSS.t1628 sg13_lv_nmos ad=0.1428p pd=1.52u as=0 ps=0 w=0.42u l=1u
X1844 VSS.t3155 VDD VSS.t3154 VSS.t3153 sg13_lv_nmos ad=0.1428p pd=1.52u as=0 ps=0 w=0.42u l=1u
X1845 a_17327_13799# a_16485_13701# a_16068_14040# VDD sg13_lv_pmos ad=0.2048p pd=1.63u as=0.34p ps=2.68u w=1u l=0.13u
X1846 sg13cmos5l_dfrbpq_1_2.CLK a_12010_15202# VDD VDD sg13_lv_pmos ad=0.2128p pd=1.5u as=0.2128p ps=1.5u w=1.12u l=0.13u
X1847 VDD VSS.t587 VDD VDD sg13_lv_pmos ad=0.19p pd=1.38u as=0 ps=0 w=1u l=1u
X1848 VSS.t2955 VDD VSS.t2957 VSS.t2956 sg13_lv_nmos ad=79.8f pd=0.8u as=0 ps=0 w=0.42u l=1u
X1849 VSS.t1867 VDD VSS.t1869 VSS.t1868 sg13_lv_nmos ad=79.8f pd=0.8u as=0 ps=0 w=0.42u l=1u
X1850 VDD VSS.t1309 VDD VDD sg13_lv_pmos ad=0.19p pd=1.38u as=0 ps=0 w=1u l=1u
X1851 VDD sg13cmos5l_dfrbpq_1_5.RESET_B a_25862_13722# VDD sg13_lv_pmos ad=0.36237p pd=2.605u as=79.8f ps=0.8u w=0.42u l=0.13u
X1852 VDD VSS.t2351 VDD VDD sg13_lv_pmos ad=0.19p pd=1.38u as=0 ps=0 w=1u l=1u
X1853 VDD VSS.t1497 VDD VDD sg13_lv_pmos ad=0.19p pd=1.38u as=0 ps=0 w=1u l=1u
X1854 VDD a_15579_14854# sg13cmos5l_buf_8_2.A VDD sg13_lv_pmos ad=0.2128p pd=1.5u as=0.2128p ps=1.5u w=1.12u l=0.13u
X1855 VSS.t1540 VDD VSS.t1542 VSS.t1541 sg13_lv_nmos ad=79.8f pd=0.8u as=0 ps=0 w=0.42u l=1u
X1856 VSS.t1720 VDD VSS.t1719 VSS.t1718 sg13_lv_nmos ad=0.1428p pd=1.52u as=0 ps=0 w=0.42u l=1u
X1857 VDD VSS.t3059 VDD VDD sg13_lv_pmos ad=0.34p pd=2.68u as=0 ps=0 w=1u l=1u
X1858 VDD VSS.t2268 VDD VDD sg13_lv_pmos ad=0.34p pd=2.68u as=0 ps=0 w=1u l=1u
X1859 VSS.t1957 VDD VSS.t1959 VSS.t1958 sg13_lv_nmos ad=79.8f pd=0.8u as=0 ps=0 w=0.42u l=1u
X1860 VDD a_22319_14845# a_22576_14726# VDD sg13_lv_pmos ad=2.42015p pd=15.68u as=79.8f ps=0.8u w=0.42u l=0.13u
X1861 a_25094_14484# a_24824_14525# VSS.t57 VSS.t56 sg13_lv_nmos ad=0.1428p pd=1.52u as=79.8f ps=0.8u w=0.42u l=0.5u
X1862 VSS.t609 VDD VSS.t606 VSS.t608 sg13_lv_nmos ad=0.1428p pd=1.52u as=0 ps=0 w=0.42u l=1u
X1863 VSS.t2695 VDD VSS.t2696 VSS.t61 sg13_lv_nmos ad=79.8f pd=0.8u as=0 ps=0 w=0.42u l=1u
X1864 VDD VSS.t2662 VDD VDD sg13_lv_pmos ad=0.19p pd=1.38u as=0 ps=0 w=1u l=1u
X1865 VDD VSS.t1632 VDD VDD sg13_lv_pmos ad=0.19p pd=1.38u as=0 ps=0 w=1u l=1u
X1866 VDD VSS.t2977 VDD VDD sg13_lv_pmos ad=0.19p pd=1.38u as=0 ps=0 w=1u l=1u
X1867 VDD VSS.t1976 VDD VDD sg13_lv_pmos ad=0.34p pd=2.68u as=0 ps=0 w=1u l=1u
X1868 VSS.t811 VDD VSS.t813 VSS.t812 sg13_lv_nmos ad=79.8f pd=0.8u as=0 ps=0 w=0.42u l=1u
X1869 VDD VSS.t430 VDD VDD sg13_lv_pmos ad=0.19p pd=1.38u as=0 ps=0 w=1u l=1u
X1870 VDD VSS.t870 VDD VDD sg13_lv_pmos ad=0.34p pd=2.68u as=0 ps=0 w=1u l=1u
X1871 VDD VSS.t2774 VDD VDD sg13_lv_pmos ad=0.19p pd=1.38u as=0 ps=0 w=1u l=1u
X1872 VSS.t2364 VDD VSS.t2363 VSS.t2362 sg13_lv_nmos ad=0.1428p pd=1.52u as=0 ps=0 w=0.42u l=1u
X1873 VSS.t2087 VDD VSS.t2086 VSS.t2085 sg13_lv_nmos ad=0.1428p pd=1.52u as=0 ps=0 w=0.42u l=1u
X1874 VSS.t1650 VDD VSS.t1649 VSS.t1648 sg13_lv_nmos ad=0.1428p pd=1.52u as=0 ps=0 w=0.42u l=1u
X1875 VSS.t3175 VDD VSS.t3174 VSS.t3173 sg13_lv_nmos ad=0.1428p pd=1.52u as=0 ps=0 w=0.42u l=1u
X1876 VSS.t2995 VDD VSS.t2997 VSS.t2996 sg13_lv_nmos ad=79.8f pd=0.8u as=0 ps=0 w=0.42u l=1u
X1877 VDD a_16485_13701# a_16587_13844# VDD sg13_lv_pmos ad=2.42015p pd=15.68u as=0.3864p ps=2.93u w=1.12u l=0.13u
X1878 VDD VSS.t1659 VDD VDD sg13_lv_pmos ad=0.34p pd=2.68u as=0 ps=0 w=1u l=1u
X1879 a_10618_14448# sg13cmos5l_dlygate4sd3_1_8.A VDD VDD sg13_lv_pmos ad=0.1428p pd=1.52u as=0.1523p ps=1.38u w=0.42u l=0.13u
X1880 VDD VSS.t995 VDD VDD sg13_lv_pmos ad=0.34p pd=2.68u as=0 ps=0 w=1u l=1u
X1881 VSS.t1690 VDD VSS.t1692 VSS.t1691 sg13_lv_nmos ad=79.8f pd=0.8u as=0 ps=0 w=0.42u l=1u
X1882 VSS.t207 VDD VSS.t256 VSS.t708 sg13_lv_nmos ad=0.1428p pd=1.52u as=0 ps=0 w=0.42u l=1u
X1883 VSS.t615 VDD VSS.t615 VSS.t750 sg13_lv_nmos ad=0.1428p pd=1.52u as=0 ps=0 w=0.42u l=1u
X1884 VSS.t2784 VDD VSS.t2784 VSS.t61 sg13_lv_nmos ad=79.8f pd=0.8u as=0 ps=0 w=0.42u l=1u
X1885 VSS.t1852 VDD VSS.t1854 VSS.t1853 sg13_lv_nmos ad=79.8f pd=0.8u as=0 ps=0 w=0.42u l=1u
X1886 a_25025_16344# sg13cmos5l_a21oi_1_2.A1 sg13cmos5l_dlygate4sd3_1_17.A VSS.t219 sg13_lv_nmos ad=0.1406p pd=1.12u as=0.1406p ps=1.12u w=0.74u l=0.13u
X1887 VDD VSS.t2308 VDD VDD sg13_lv_pmos ad=0.34p pd=2.68u as=0 ps=0 w=1u l=1u
X1888 VSS.t580 VDD VSS.t579 VSS.t578 sg13_lv_nmos ad=0.1428p pd=1.52u as=0 ps=0 w=0.42u l=1u
X1889 VDD VSS.t2336 VDD VDD sg13_lv_pmos ad=0.19p pd=1.38u as=0 ps=0 w=1u l=1u
X1890 VSS.t2394 VDD VSS.t2396 VSS.t2395 sg13_lv_nmos ad=79.8f pd=0.8u as=0 ps=0 w=0.42u l=1u
X1891 VDD VSS.t933 VDD VDD sg13_lv_pmos ad=0.19p pd=1.38u as=0 ps=0 w=1u l=1u
X1892 VSS.t1231 VDD VSS.t1232 VSS.t70 sg13_lv_nmos ad=79.8f pd=0.8u as=0 ps=0 w=0.42u l=1u
X1893 VDD VSS.t1482 VDD VDD sg13_lv_pmos ad=0.19p pd=1.38u as=0 ps=0 w=1u l=1u
X1894 a_22025_16334# a_22149_16033# VDD VDD sg13_lv_pmos ad=0.2442p pd=2.06u as=2.8961p ps=18.25u w=0.66u l=0.13u
X1895 VDD VSS.t2091 VDD VDD sg13_lv_pmos ad=0.34p pd=2.68u as=0 ps=0 w=1u l=1u
X1896 VDD VSS.t1325 VDD VDD sg13_lv_pmos ad=0.19p pd=1.38u as=0 ps=0 w=1u l=1u
X1897 VDD VSS.t1280 VDD VDD sg13_lv_pmos ad=0.34p pd=2.68u as=0 ps=0 w=1u l=1u
X1898 VSS.t1560 VDD VSS.t1562 VSS.t1561 sg13_lv_nmos ad=79.8f pd=0.8u as=0 ps=0 w=0.42u l=1u
X1899 VDD VSS.t2784 VDD VDD sg13_lv_pmos ad=0.34p pd=2.68u as=0 ps=0 w=1u l=1u
X1900 VSS.t1942 VDD VSS.t1944 VSS.t1943 sg13_lv_nmos ad=79.8f pd=0.8u as=0 ps=0 w=0.42u l=1u
X1901 VDD VSS.t521 VDD VDD sg13_lv_pmos ad=0.19p pd=1.38u as=0 ps=0 w=1u l=1u
X1902 VDD a_15579_14854# sg13cmos5l_buf_8_2.A VDD sg13_lv_pmos ad=0.2128p pd=1.5u as=0.2128p ps=1.5u w=1.12u l=0.13u
X1903 VSS.t512 VDD VSS.t512 VSS.t516 sg13_lv_nmos ad=0.1428p pd=1.52u as=0 ps=0 w=0.42u l=1u
X1904 VSS.t1273 VDD VSS.t1274 VSS.t70 sg13_lv_nmos ad=79.8f pd=0.8u as=0 ps=0 w=0.42u l=1u
X1905 VSS.t2970 VDD VSS.t2969 VSS.t2968 sg13_lv_nmos ad=0.1428p pd=1.52u as=0 ps=0 w=0.42u l=1u
X1906 VSS.t1882 VDD VSS.t1881 VSS.t1880 sg13_lv_nmos ad=0.1428p pd=1.52u as=0 ps=0 w=0.42u l=1u
X1907 VSS.t1196 VDD VSS.t1195 VSS.t70 sg13_lv_nmos ad=0.1428p pd=1.52u as=0 ps=0 w=0.42u l=1u
X1908 VSS.t131 VDD VSS.t131 VSS.t361 sg13_lv_nmos ad=0.1428p pd=1.52u as=0 ps=0 w=0.42u l=1u
X1909 a_16314_15532# sg13cmos5l_or3_1_2.B sg13cmos5l_nor2_1_0.B VDD sg13_lv_pmos ad=0.1428p pd=1.375u as=0.2408p ps=1.55u w=1.12u l=0.13u
X1910 VSS.t966 VDD VSS.t968 VSS.t967 sg13_lv_nmos ad=79.8f pd=0.8u as=0 ps=0 w=0.42u l=1u
X1911 VDD VSS.t1035 VDD VDD sg13_lv_pmos ad=0.34p pd=2.68u as=0 ps=0 w=1u l=1u
X1912 VSS.t851 VDD VSS.t850 VSS.t849 sg13_lv_nmos ad=0.1428p pd=1.52u as=0 ps=0 w=0.42u l=1u
X1913 VSS.t1680 VDD VSS.t1682 VSS.t1681 sg13_lv_nmos ad=79.8f pd=0.8u as=0 ps=0 w=0.42u l=1u
X1914 VSS.t2664 VDD VSS.t2665 VSS.t61 sg13_lv_nmos ad=79.8f pd=0.8u as=0 ps=0 w=0.42u l=1u
X1915 a_25930_14452# a_26373_14495# a_25670_14922# VSS.t167 sg13_lv_nmos ad=79.8f pd=0.8u as=0.1296p ps=1.52u w=0.42u l=0.13u
X1916 VDD VSS.t1639 VDD VDD sg13_lv_pmos ad=0.34p pd=2.68u as=0 ps=0 w=1u l=1u
X1917 VDD VSS.t2922 VDD VDD sg13_lv_pmos ad=0.19p pd=1.38u as=0 ps=0 w=1u l=1u
X1918 VDD VSS.t79 VDD VDD sg13_lv_pmos ad=0.34p pd=2.68u as=0 ps=0 w=1u l=1u
X1919 VDD VSS.t1644 VDD VDD sg13_lv_pmos ad=0.34p pd=2.68u as=0 ps=0 w=1u l=1u
X1920 VDD VSS.t2745 VDD VDD sg13_lv_pmos ad=0.34p pd=2.68u as=0 ps=0 w=1u l=1u
X1921 VDD a_27502_15423# sg13cmos5l_or3_1_1.A VDD sg13_lv_pmos ad=0.2254p pd=1.53u as=0.4256p ps=3u w=1.12u l=0.13u
X1922 VSS.t1675 VDD VSS.t1677 VSS.t1676 sg13_lv_nmos ad=79.8f pd=0.8u as=0 ps=0 w=0.42u l=1u
X1923 VSS.t540 VDD VSS.t542 VSS.t541 sg13_lv_nmos ad=79.8f pd=0.8u as=0 ps=0 w=0.42u l=1u
X1924 VSS.t521 VDD VSS.t521 VSS.t524 sg13_lv_nmos ad=0.1428p pd=1.52u as=0 ps=0 w=0.42u l=1u
X1925 VDD VSS.t1208 VDD VDD sg13_lv_pmos ad=0.34p pd=2.68u as=0 ps=0 w=1u l=1u
X1926 VDD VSS.t2328 VDD VDD sg13_lv_pmos ad=0.34p pd=2.68u as=0 ps=0 w=1u l=1u
X1927 VDD VSS.t1986 VDD VDD sg13_lv_pmos ad=0.34p pd=2.68u as=0 ps=0 w=1u l=1u
X1928 VSS.t174 sg13cmos5l_o21ai_1_2.A2 a_24169_14508# VSS.t56 sg13_lv_nmos ad=0.1045p pd=0.93u as=0.187p ps=1.78u w=0.55u l=0.13u
X1929 VSS.t2940 VDD VSS.t2942 VSS.t2941 sg13_lv_nmos ad=79.8f pd=0.8u as=0 ps=0 w=0.42u l=1u
X1930 VDD VSS.t1300 VDD VDD sg13_lv_pmos ad=0.19p pd=1.38u as=0 ps=0 w=1u l=1u
X1931 VDD VSS.t2513 VDD VDD sg13_lv_pmos ad=0.34p pd=2.68u as=0 ps=0 w=1u l=1u
X1932 a_3333_15213# sg13cmos5l_dfrbpq_1_2.CLK VSS.t15 VSS.t93 sg13_lv_nmos ad=0.2516p pd=2.16u as=3.8707p ps=25.555u w=0.74u l=0.13u
X1933 a_21070_15423# a_21185_15424# VDD VDD sg13_lv_pmos ad=0.34p pd=2.68u as=0.2254p ps=1.53u w=1u l=0.5u
X1934 VDD VSS.t2692 VDD VDD sg13_lv_pmos ad=0.19p pd=1.38u as=0 ps=0 w=1u l=1u
X1935 sg13cmos5l_dfrbpq_1_3.Q a_19530_14484# VDD VDD sg13_lv_pmos ad=0.3808p pd=2.92u as=0.2128p ps=1.5u w=1.12u l=0.13u
X1936 VDD VSS.t603 VDD VDD sg13_lv_pmos ad=0.19p pd=1.38u as=0 ps=0 w=1u l=1u
X1937 VDD VSS.t1050 VDD VDD sg13_lv_pmos ad=0.34p pd=2.68u as=0 ps=0 w=1u l=1u
X1938 VSS.t1510 VDD VSS.t1512 VSS.t1511 sg13_lv_nmos ad=79.8f pd=0.8u as=0 ps=0 w=0.42u l=1u
X1939 VSS.t2349 VDD VSS.t2348 VSS.t2347 sg13_lv_nmos ad=0.1428p pd=1.52u as=0 ps=0 w=0.42u l=1u
X1940 a_26373_14495# sg13cmos5l_buf_8_2.X VDD VDD sg13_lv_pmos ad=0.4088p pd=2.97u as=2.3367p ps=15.135u w=1.12u l=0.13u
X1941 VSS.t636 VDD VSS.t633 VSS.t635 sg13_lv_nmos ad=0.1428p pd=1.52u as=0 ps=0 w=0.42u l=1u
X1942 VSS.t1705 VDD VSS.t1704 VSS.t1703 sg13_lv_nmos ad=0.1428p pd=1.52u as=0 ps=0 w=0.42u l=1u
X1943 VSS.t2122 VDD VSS.t2121 VSS.t2120 sg13_lv_nmos ad=0.1428p pd=1.52u as=0 ps=0 w=0.42u l=1u
X1944 VSS.t34 VDD VSS.t383 VSS.t387 sg13_lv_nmos ad=0.1428p pd=1.52u as=0 ps=0 w=0.42u l=1u
X1945 sg13cmos5l_dlygate4sd3_1_3.A a_4842_15532# VSS.t15 VSS.t3278 sg13_lv_nmos ad=0.2516p pd=2.16u as=0.1406p ps=1.12u w=0.74u l=0.13u
X1946 VSS.t811 VDD VSS.t813 VSS.t812 sg13_lv_nmos ad=79.8f pd=0.8u as=0 ps=0 w=0.42u l=1u
X1947 VSS.t1249 VDD VSS.t1250 VSS.t70 sg13_lv_nmos ad=79.8f pd=0.8u as=0 ps=0 w=0.42u l=1u
X1948 VDD VSS.t1617 VDD VDD sg13_lv_pmos ad=0.19p pd=1.38u as=0 ps=0 w=1u l=1u
X1949 VDD VSS.t1672 VDD VDD sg13_lv_pmos ad=0.19p pd=1.38u as=0 ps=0 w=1u l=1u
X1950 VSS.t1505 VDD VSS.t1507 VSS.t1506 sg13_lv_nmos ad=79.8f pd=0.8u as=0 ps=0 w=0.42u l=1u
X1951 VDD VSS.t3139 VDD VDD sg13_lv_pmos ad=0.34p pd=2.68u as=0 ps=0 w=1u l=1u
X1952 VSS.t2414 VDD VSS.t2416 VSS.t2415 sg13_lv_nmos ad=79.8f pd=0.8u as=0 ps=0 w=0.42u l=1u
X1953 VDD VSS.t8 VDD VDD sg13_lv_pmos ad=0.19p pd=1.38u as=0 ps=0 w=1u l=1u
X1954 VSS.t532 a_7822_13911# sg13cmos5l_xnor2_1_2.A VSS.t3187 sg13_lv_nmos ad=0.1426p pd=1.16u as=0.2516p ps=2.16u w=0.74u l=0.13u
X1955 VSS.t736 VDD VSS.t735 VSS.t734 sg13_lv_nmos ad=0.1428p pd=1.52u as=0 ps=0 w=0.42u l=1u
X1956 VDD VSS.t1200 VDD VDD sg13_lv_pmos ad=0.19p pd=1.38u as=0 ps=0 w=1u l=1u
X1957 VDD VSS.t2765 VDD VDD sg13_lv_pmos ad=0.19p pd=1.38u as=0 ps=0 w=1u l=1u
X1958 VSS.t1635 VDD VSS.t1634 VSS.t1633 sg13_lv_nmos ad=0.1428p pd=1.52u as=0 ps=0 w=0.42u l=1u
X1959 sg13cmos5l_buf_1_0.X a_1192_3900# VDD VDD sg13_lv_pmos ad=0.42p pd=2.99u as=0.2114p ps=1.54u w=1.12u l=0.13u
X1960 VSS.t3160 VDD VSS.t3159 VSS.t3158 sg13_lv_nmos ad=0.1428p pd=1.52u as=0 ps=0 w=0.42u l=1u
X1961 VSS.t521 VDD VSS.t521 VSS.t526 sg13_lv_nmos ad=0.1428p pd=1.52u as=0 ps=0 w=0.42u l=1u
X1962 VSS.t996 VDD VSS.t998 VSS.t997 sg13_lv_nmos ad=79.8f pd=0.8u as=0 ps=0 w=0.42u l=1u
X1963 VDD VSS.t1186 VDD VDD sg13_lv_pmos ad=0.19p pd=1.38u as=0 ps=0 w=1u l=1u
X1964 VSS.t287 VDD VSS.t287 VSS.t289 sg13_lv_nmos ad=0.1428p pd=1.52u as=0 ps=0 w=0.42u l=1u
X1965 VSS.t450 VDD VSS.t451 VSS.t15 sg13_lv_nmos ad=79.8f pd=0.8u as=0 ps=0 w=0.42u l=1u
X1966 a_16955_14484# sg13cmos5l_a21oi_1_3.B1 sg13cmos5l_a21oi_1_0.Y VDD sg13_lv_pmos ad=0.2128p pd=1.5u as=0.3808p ps=2.92u w=1.12u l=0.13u
X1967 VSS.t2444 VDD VSS.t2443 VSS.t2442 sg13_lv_nmos ad=0.1428p pd=1.52u as=0 ps=0 w=0.42u l=1u
X1968 VDD VSS.t1312 VDD VDD sg13_lv_pmos ad=0.19p pd=1.38u as=0 ps=0 w=1u l=1u
X1969 VSS.t2636 VDD VSS.t2636 VSS.t61 sg13_lv_nmos ad=0.1428p pd=1.52u as=0 ps=0 w=0.42u l=1u
X1970 VDD VSS.t211 VDD VDD sg13_lv_pmos ad=0.34p pd=2.68u as=0 ps=0 w=1u l=1u
X1971 VDD VSS.t2687 VDD VDD sg13_lv_pmos ad=0.19p pd=1.38u as=0 ps=0 w=1u l=1u
X1972 VSS.t2379 VDD VSS.t2381 VSS.t2380 sg13_lv_nmos ad=79.8f pd=0.8u as=0 ps=0 w=0.42u l=1u
X1973 a_9418_15457# a_9861_15213# a_9801_15625# VDD sg13_lv_pmos ad=79.8f pd=0.8u as=63f ps=0.72u w=0.42u l=0.13u
X1974 VDD VSS.t2498 VDD VDD sg13_lv_pmos ad=0.34p pd=2.68u as=0 ps=0 w=1u l=1u
X1975 VDD VSS.t2321 VDD VDD sg13_lv_pmos ad=0.19p pd=1.38u as=0 ps=0 w=1u l=1u
X1976 VDD VSS.t1467 VDD VDD sg13_lv_pmos ad=0.19p pd=1.38u as=0 ps=0 w=1u l=1u
X1977 VSS.t41 sg13cmos5l_dfrbpq_1_7.RESET_B a_25764_14922# VSS.t50 sg13_lv_nmos ad=0.1626p pd=1.415u as=60.89999f ps=0.71u w=0.42u l=0.13u
X1978 VSS.t1545 VDD VSS.t1547 VSS.t1546 sg13_lv_nmos ad=79.8f pd=0.8u as=0 ps=0 w=0.42u l=1u
X1979 VSS.t1725 VDD VSS.t1724 VSS.t1723 sg13_lv_nmos ad=0.1428p pd=1.52u as=0 ps=0 w=0.42u l=1u
X1980 VSS.t2698 VDD VSS.t2699 VSS.t61 sg13_lv_nmos ad=79.8f pd=0.8u as=0 ps=0 w=0.42u l=1u
X1981 VDD VSS.t2446 VDD VDD sg13_lv_pmos ad=0.19p pd=1.38u as=0 ps=0 w=1u l=1u
X1982 VSS.t2107 VDD VSS.t2106 VSS.t2105 sg13_lv_nmos ad=0.1428p pd=1.52u as=0 ps=0 w=0.42u l=1u
X1983 VSS.t966 VDD VSS.t968 VSS.t967 sg13_lv_nmos ad=79.8f pd=0.8u as=0 ps=0 w=0.42u l=1u
X1984 VDD VSS.t1240 VDD VDD sg13_lv_pmos ad=0.34p pd=2.68u as=0 ps=0 w=1u l=1u
X1985 VSS.t1300 VDD VSS.t1299 VSS.t70 sg13_lv_nmos ad=0.1428p pd=1.52u as=0 ps=0 w=0.42u l=1u
X1986 VSS.t348 VDD VSS.t350 VSS.t349 sg13_lv_nmos ad=79.8f pd=0.8u as=0 ps=0 w=0.42u l=1u
X1987 VDD VSS.t1327 VDD VDD sg13_lv_pmos ad=0.34p pd=2.68u as=0 ps=0 w=1u l=1u
X1988 VDD VSS.t2982 VDD VDD sg13_lv_pmos ad=0.19p pd=1.38u as=0 ps=0 w=1u l=1u
X1989 VSS.t2955 VDD VSS.t2954 VSS.t2953 sg13_lv_nmos ad=0.1428p pd=1.52u as=0 ps=0 w=0.42u l=1u
X1990 VDD VSS.t34 VDD VDD sg13_lv_pmos ad=0.34p pd=2.68u as=0 ps=0 w=1u l=1u
X1991 VSS.t1011 VDD VSS.t1013 VSS.t1012 sg13_lv_nmos ad=79.8f pd=0.8u as=0 ps=0 w=0.42u l=1u
X1992 VDD VSS.t1849 VDD VDD sg13_lv_pmos ad=0.19p pd=1.38u as=0 ps=0 w=1u l=1u
X1993 VSS.t316 VDD VSS.t318 VSS.t317 sg13_lv_nmos ad=79.8f pd=0.8u as=0 ps=0 w=0.42u l=1u
X1994 VSS.t397 VDD VSS.t396 VSS.t395 sg13_lv_nmos ad=0.1428p pd=1.52u as=0 ps=0 w=0.42u l=1u
X1995 VDD VSS.t2699 VDD VDD sg13_lv_pmos ad=0.34p pd=2.68u as=0 ps=0 w=1u l=1u
X1996 VDD VSS.t1946 VDD VDD sg13_lv_pmos ad=0.34p pd=2.68u as=0 ps=0 w=1u l=1u
X1997 VSS.t729 sg13cmos5l_dfrbpq_1_5.RESET_B a_25956_13722# VSS.t3304 sg13_lv_nmos ad=0.1626p pd=1.415u as=60.89999f ps=0.71u w=0.42u l=0.13u
X1998 VDD VSS.t1624 VDD VDD sg13_lv_pmos ad=0.34p pd=2.68u as=0 ps=0 w=1u l=1u
X1999 VDD VSS.t2776 VDD VDD sg13_lv_pmos ad=0.19p pd=1.38u as=0 ps=0 w=1u l=1u
X2000 VDD VSS.t71 VDD VDD sg13_lv_pmos ad=0.34p pd=2.68u as=0 ps=0 w=1u l=1u
X2001 VDD VSS.t1276 VDD VDD sg13_lv_pmos ad=0.19p pd=1.38u as=0 ps=0 w=1u l=1u
X2002 VSS.t432 VDD VSS.t431 VSS.t15 sg13_lv_nmos ad=0.1428p pd=1.52u as=0 ps=0 w=0.42u l=1u
X2003 VSS.t456 VDD VSS.t455 VSS.t15 sg13_lv_nmos ad=0.1428p pd=1.52u as=0 ps=0 w=0.42u l=1u
X2004 VDD VSS.t1629 VDD VDD sg13_lv_pmos ad=0.34p pd=2.68u as=0 ps=0 w=1u l=1u
X2005 VSS.t606 VDD VSS.t606 VSS.t607 sg13_lv_nmos ad=79.8f pd=0.8u as=0 ps=0 w=0.42u l=1u
X2006 VSS.t1226 VDD VSS.t1227 VSS.t70 sg13_lv_nmos ad=79.8f pd=0.8u as=0 ps=0 w=0.42u l=1u
X2007 VSS.t1520 VDD VSS.t1519 VSS.t1518 sg13_lv_nmos ad=0.1428p pd=1.52u as=0 ps=0 w=0.42u l=1u
X2008 VSS.t2429 VDD VSS.t2428 VSS.t2427 sg13_lv_nmos ad=0.1428p pd=1.52u as=0 ps=0 w=0.42u l=1u
X2009 VDD VSS.t2313 VDD VDD sg13_lv_pmos ad=0.34p pd=2.68u as=0 ps=0 w=1u l=1u
X2010 VSS.t417 VDD VSS.t418 VSS.t15 sg13_lv_nmos ad=79.8f pd=0.8u as=0 ps=0 w=0.42u l=1u
X2011 VDD VSS.t630 VDD VDD sg13_lv_pmos ad=0.19p pd=1.38u as=0 ps=0 w=1u l=1u
X2012 VDD sg13cmos5l_xnor2_1_2.A a_6540_13238# VDD sg13_lv_pmos ad=0.4536p pd=2.76u as=0.1596p ps=1.22u w=0.84u l=0.13u
X2013 a_22426_15202# sg13cmos5l_dfrbpq_1_6.Q VDD VDD sg13_lv_pmos ad=0.1428p pd=1.52u as=0.1523p ps=1.38u w=0.42u l=0.13u
X2014 VDD VSS.t406 VDD VDD sg13_lv_pmos ad=0.19p pd=1.38u as=0 ps=0 w=1u l=1u
X2015 VSS.t1495 VDD VSS.t1497 VSS.t1496 sg13_lv_nmos ad=79.8f pd=0.8u as=0 ps=0 w=0.42u l=1u
X2016 sg13cmos5l_dfrbpq_1_3.Q a_19530_14484# VSS.t204 VSS.t16 sg13_lv_nmos ad=0.2516p pd=2.16u as=0.1406p ps=1.12u w=0.74u l=0.13u
X2017 VSS.t1314 VDD VSS.t1312 VSS.t70 sg13_lv_nmos ad=0.1428p pd=1.52u as=0 ps=0 w=0.42u l=1u
X2018 VDD VSS.t554 VDD VDD sg13_lv_pmos ad=0.34p pd=2.68u as=0 ps=0 w=1u l=1u
X2019 VDD VSS.t2656 VDD VDD sg13_lv_pmos ad=0.19p pd=1.38u as=0 ps=0 w=1u l=1u
X2020 VSS.t1887 VDD VSS.t1886 VSS.t1885 sg13_lv_nmos ad=0.1428p pd=1.52u as=0 ps=0 w=0.42u l=1u
X2021 a_3333_15213# sg13cmos5l_dfrbpq_1_2.CLK VDD VDD sg13_lv_pmos ad=0.4088p pd=2.97u as=2.77542p ps=17.49u w=1.12u l=0.13u
X2022 VSS.t2057 VDD VSS.t2059 VSS.t2058 sg13_lv_nmos ad=79.8f pd=0.8u as=0 ps=0 w=0.42u l=1u
X2023 VDD VSS.t2014 VDD VDD sg13_lv_pmos ad=0.19p pd=1.38u as=0 ps=0 w=1u l=1u
X2024 VDD VSS.t1215 VDD VDD sg13_lv_pmos ad=0.19p pd=1.38u as=0 ps=0 w=1u l=1u
X2025 VDD VSS.t2368 VDD VDD sg13_lv_pmos ad=0.34p pd=2.68u as=0 ps=0 w=1u l=1u
X2026 VDD VSS.t34 VDD VDD sg13_lv_pmos ad=0.34p pd=2.68u as=0 ps=0 w=1u l=1u
X2027 VSS.t1490 VDD VSS.t1492 VSS.t1491 sg13_lv_nmos ad=79.8f pd=0.8u as=0 ps=0 w=0.42u l=1u
X2028 VDD VSS.t3124 VDD VDD sg13_lv_pmos ad=0.34p pd=2.68u as=0 ps=0 w=1u l=1u
X2029 VSS.t2399 VDD VSS.t2401 VSS.t2400 sg13_lv_nmos ad=79.8f pd=0.8u as=0 ps=0 w=0.42u l=1u
X2030 VSS.t1685 VDD VSS.t1687 VSS.t1686 sg13_lv_nmos ad=79.8f pd=0.8u as=0 ps=0 w=0.42u l=1u
X2031 VDD VSS.t415 VDD VDD sg13_lv_pmos ad=0.19p pd=1.38u as=0 ps=0 w=1u l=1u
X2032 VDD VSS.t1609 VDD VDD sg13_lv_pmos ad=0.34p pd=2.68u as=0 ps=0 w=1u l=1u
X2033 VSS.t1977 VDD VSS.t1976 VSS.t1975 sg13_lv_nmos ad=0.1428p pd=1.52u as=0 ps=0 w=0.42u l=1u
X2034 VSS.t996 VDD VSS.t998 VSS.t997 sg13_lv_nmos ad=79.8f pd=0.8u as=0 ps=0 w=0.42u l=1u
X2035 VDD VSS.t1258 VDD VDD sg13_lv_pmos ad=0.34p pd=2.68u as=0 ps=0 w=1u l=1u
X2036 VDD VSS.t2927 VDD VDD sg13_lv_pmos ad=0.19p pd=1.38u as=0 ps=0 w=1u l=1u
X2037 VSS.t2985 VDD VSS.t2987 VSS.t2986 sg13_lv_nmos ad=79.8f pd=0.8u as=0 ps=0 w=0.42u l=1u
X2038 VDD a_7532_15960# counter_value_o[1] VDD sg13_lv_pmos ad=0.2114p pd=1.54u as=0.42p ps=2.99u w=1.12u l=0.13u
X2039 VDD VSS.t970 VDD VDD sg13_lv_pmos ad=0.34p pd=2.68u as=0 ps=0 w=1u l=1u
X2040 VSS.t1209 VDD VSS.t1208 VSS.t70 sg13_lv_nmos ad=0.1428p pd=1.52u as=0 ps=0 w=0.42u l=1u
X2041 VDD VSS.t1527 VDD VDD sg13_lv_pmos ad=0.19p pd=1.38u as=0 ps=0 w=1u l=1u
X2042 VSS.t47 a_15579_14854# sg13cmos5l_buf_8_2.A VSS.t3237 sg13_lv_nmos ad=0.1406p pd=1.12u as=0.1406p ps=1.12u w=0.74u l=0.13u
X2043 a_27502_15423# a_27617_15424# VSS.t28 VSS.t15 sg13_lv_nmos ad=0.1428p pd=1.52u as=0.1426p ps=1.16u w=0.42u l=0.5u
X2044 VDD VSS.t1303 VDD VDD sg13_lv_pmos ad=0.19p pd=1.38u as=0 ps=0 w=1u l=1u
X2045 VDD VSS.t2783 VDD VDD sg13_lv_pmos ad=0.34p pd=2.68u as=0 ps=0 w=1u l=1u
X2046 VDD VSS.t2678 VDD VDD sg13_lv_pmos ad=0.19p pd=1.38u as=0 ps=0 w=1u l=1u
X2047 VSS.t53 a_10960_15454# a_10609_15311# VSS.t52 sg13_lv_nmos ad=79.8f pd=0.8u as=0.1428p ps=1.52u w=0.42u l=0.13u
X2048 VDD VSS.t2483 VDD VDD sg13_lv_pmos ad=0.34p pd=2.68u as=0 ps=0 w=1u l=1u
X2049 VSS.t796 VDD VSS.t795 VSS.t794 sg13_lv_nmos ad=0.1428p pd=1.52u as=0 ps=0 w=0.42u l=1u
X2050 VSS.t43 a_19120_14726# a_18769_14845# VSS.t16 sg13_lv_nmos ad=79.8f pd=0.8u as=0.1428p ps=1.52u w=0.42u l=0.13u
X2051 VSS.t1480 VDD VSS.t1482 VSS.t1481 sg13_lv_nmos ad=79.8f pd=0.8u as=0 ps=0 w=0.42u l=1u
X2052 VSS.t1710 VDD VSS.t1709 VSS.t1708 sg13_lv_nmos ad=0.1428p pd=1.52u as=0 ps=0 w=0.42u l=1u
X2053 VDD a_10703_15311# a_10960_15454# VDD sg13_lv_pmos ad=2.8961p pd=18.25u as=79.8f ps=0.8u w=0.42u l=0.13u
X2054 a_6086_14922# a_6891_14495# a_6346_14452# VDD sg13_lv_pmos ad=0.1428p pd=1.52u as=79.8f ps=0.8u w=0.42u l=0.13u
X2055 VSS.t435 VDD VSS.t436 VSS.t15 sg13_lv_nmos ad=79.8f pd=0.8u as=0 ps=0 w=0.42u l=1u
X2056 VSS.t1011 VDD VSS.t1013 VSS.t1012 sg13_lv_nmos ad=79.8f pd=0.8u as=0 ps=0 w=0.42u l=1u
X2057 VDD VSS.t1267 VDD VDD sg13_lv_pmos ad=0.34p pd=2.68u as=0 ps=0 w=1u l=1u
X2058 VDD VSS.t691 VDD VDD sg13_lv_pmos ad=0.19p pd=1.38u as=0 ps=0 w=1u l=1u
X2059 VDD VSS.t1999 VDD VDD sg13_lv_pmos ad=0.19p pd=1.38u as=0 ps=0 w=1u l=1u
X2060 VDD VSS.t528 VDD VDD sg13_lv_pmos ad=0.34p pd=2.68u as=0 ps=0 w=1u l=1u
X2061 VSS.t580 VDD VSS.t579 VSS.t578 sg13_lv_nmos ad=0.1428p pd=1.52u as=0 ps=0 w=0.42u l=1u
X2062 VDD VSS.t530 VDD VDD sg13_lv_pmos ad=0.34p pd=2.68u as=0 ps=0 w=1u l=1u
X2063 VDD VSS.t3144 VDD VDD sg13_lv_pmos ad=0.34p pd=2.68u as=0 ps=0 w=1u l=1u
X2064 VDD VSS.t1203 VDD VDD sg13_lv_pmos ad=0.19p pd=1.38u as=0 ps=0 w=1u l=1u
X2065 VDD VSS.t1682 VDD VDD sg13_lv_pmos ad=0.19p pd=1.38u as=0 ps=0 w=1u l=1u
X2066 VDD VSS.t2768 VDD VDD sg13_lv_pmos ad=0.19p pd=1.38u as=0 ps=0 w=1u l=1u
X2067 VDD VSS.t1303 VDD VDD sg13_lv_pmos ad=0.19p pd=1.38u as=0 ps=0 w=1u l=1u
X2068 VSS.t1185 VDD VSS.t1186 VSS.t70 sg13_lv_nmos ad=79.8f pd=0.8u as=0 ps=0 w=0.42u l=1u
X2069 VSS.t1640 VDD VSS.t1639 VSS.t1638 sg13_lv_nmos ad=0.1428p pd=1.52u as=0 ps=0 w=0.42u l=1u
X2070 VSS.t3130 VDD VSS.t3129 VSS.t3128 sg13_lv_nmos ad=0.1428p pd=1.52u as=0 ps=0 w=0.42u l=1u
X2071 a_26170_15202# sg13cmos5l_a21oi_1_3.Y VDD VDD sg13_lv_pmos ad=0.1428p pd=1.52u as=0.1523p ps=1.38u w=0.42u l=0.13u
X2072 VSS.t1505 VDD VSS.t1504 VSS.t1503 sg13_lv_nmos ad=0.1428p pd=1.52u as=0 ps=0 w=0.42u l=1u
X2073 VSS.t2414 VDD VSS.t2413 VSS.t2412 sg13_lv_nmos ad=0.1428p pd=1.52u as=0 ps=0 w=0.42u l=1u
X2074 VSS.t36 sg13cmos5l_dfrbpq_1_0.RESET_B a_2724_15234# VSS.t3201 sg13_lv_nmos ad=0.1626p pd=1.415u as=60.89999f ps=0.71u w=0.42u l=0.13u
X2075 VSS.t2739 VDD VSS.t2740 VSS.t61 sg13_lv_nmos ad=79.8f pd=0.8u as=0 ps=0 w=0.42u l=1u
X2076 VSS.t2384 VDD VSS.t2386 VSS.t2385 sg13_lv_nmos ad=79.8f pd=0.8u as=0 ps=0 w=0.42u l=1u
X2077 VDD VSS.t1000 VDD VDD sg13_lv_pmos ad=0.34p pd=2.68u as=0 ps=0 w=1u l=1u
X2078 VDD VSS.t2939 VDD VDD sg13_lv_pmos ad=0.34p pd=2.68u as=0 ps=0 w=1u l=1u
X2079 VDD VSS.t253 VDD VDD sg13_lv_pmos ad=0.19p pd=1.38u as=0 ps=0 w=1u l=1u
X2080 VDD VSS.t815 VDD VDD sg13_lv_pmos ad=0.34p pd=2.68u as=0 ps=0 w=1u l=1u
X2081 VDD VSS.t1472 VDD VDD sg13_lv_pmos ad=0.19p pd=1.38u as=0 ps=0 w=1u l=1u
X2082 VSS.t15 VDD VSS.t15 VSS.t463 sg13_lv_nmos ad=0.1428p pd=1.52u as=0 ps=0 w=0.42u l=1u
X2083 VDD VSS.t554 VDD VDD sg13_lv_pmos ad=0.34p pd=2.68u as=0 ps=0 w=1u l=1u
X2084 VSS.t540 VDD VSS.t542 VSS.t541 sg13_lv_nmos ad=79.8f pd=0.8u as=0 ps=0 w=0.42u l=1u
X2085 VSS.t2701 VDD VSS.t2702 VSS.t61 sg13_lv_nmos ad=79.8f pd=0.8u as=0 ps=0 w=0.42u l=1u
X2086 VSS.t20 VDD VSS.t20 VSS.t280 sg13_lv_nmos ad=0.1428p pd=1.52u as=0 ps=0 w=0.42u l=1u
X2087 VDD VSS.t2647 VDD VDD sg13_lv_pmos ad=0.19p pd=1.38u as=0 ps=0 w=1u l=1u
X2088 VSS.t1872 VDD VSS.t1871 VSS.t1870 sg13_lv_nmos ad=0.1428p pd=1.52u as=0 ps=0 w=0.42u l=1u
X2089 VSS.t2960 VDD VSS.t2959 VSS.t2958 sg13_lv_nmos ad=0.1428p pd=1.52u as=0 ps=0 w=0.42u l=1u
X2090 sg13cmos5l_or3_1_1.B a_14261_15238# VSS.t4 VSS.t249 sg13_lv_nmos ad=0.1406p pd=1.12u as=0.1406p ps=1.12u w=0.74u l=0.13u
X2091 VDD VSS.t1438 VDD VDD sg13_lv_pmos ad=0.34p pd=2.68u as=0 ps=0 w=1u l=1u
X2092 VSS.t2027 VDD VSS.t2029 VSS.t2028 sg13_lv_nmos ad=79.8f pd=0.8u as=0 ps=0 w=0.42u l=1u
X2093 VDD VSS.t2702 VDD VDD sg13_lv_pmos ad=0.34p pd=2.68u as=0 ps=0 w=1u l=1u
X2094 VDD VSS.t1951 VDD VDD sg13_lv_pmos ad=0.34p pd=2.68u as=0 ps=0 w=1u l=1u
X2095 VDD VSS.t442 VDD VDD sg13_lv_pmos ad=0.19p pd=1.38u as=0 ps=0 w=1u l=1u
X2096 VSS.t1670 VDD VSS.t1672 VSS.t1671 sg13_lv_nmos ad=79.8f pd=0.8u as=0 ps=0 w=0.42u l=1u
X2097 VDD VSS.t878 VDD VDD sg13_lv_pmos ad=0.19p pd=1.38u as=0 ps=0 w=1u l=1u
X2098 VDD VSS.t1194 VDD VDD sg13_lv_pmos ad=0.19p pd=1.38u as=0 ps=0 w=1u l=1u
X2099 VDD VSS.t2759 VDD VDD sg13_lv_pmos ad=0.19p pd=1.38u as=0 ps=0 w=1u l=1u
X2100 VSS.t2062 VDD VSS.t2061 VSS.t2060 sg13_lv_nmos ad=0.1428p pd=1.52u as=0 ps=0 w=0.42u l=1u
X2101 a_24923_15996# sg13cmos5l_a21oi_1_3.B1 sg13cmos5l_dlygate4sd3_1_17.A VDD sg13_lv_pmos ad=0.2128p pd=1.5u as=0.3808p ps=2.92u w=1.12u l=0.13u
X2102 VSS.t615 VDD VSS.t612 VSS.t614 sg13_lv_nmos ad=0.1428p pd=1.52u as=0 ps=0 w=0.42u l=1u
X2103 VSS.t1625 VDD VSS.t1624 VSS.t1623 sg13_lv_nmos ad=0.1428p pd=1.52u as=0 ps=0 w=0.42u l=1u
X2104 VDD VSS.t2912 VDD VDD sg13_lv_pmos ad=0.19p pd=1.38u as=0 ps=0 w=1u l=1u
X2105 VSS.t3150 VDD VSS.t3149 VSS.t3148 sg13_lv_nmos ad=0.1428p pd=1.52u as=0 ps=0 w=0.42u l=1u
X2106 VSS.t2970 VDD VSS.t2972 VSS.t2971 sg13_lv_nmos ad=79.8f pd=0.8u as=0 ps=0 w=0.42u l=1u
X2107 a_18202_15202# sg13cmos5l_dfrbpq_1_2.Q VSS.t64 VSS.t3273 sg13_lv_nmos ad=0.1428p pd=1.52u as=79.8f ps=0.8u w=0.42u l=0.13u
X2108 VDD VSS.t1634 VDD VDD sg13_lv_pmos ad=0.34p pd=2.68u as=0 ps=0 w=1u l=1u
X2109 a_2630_15234# a_3435_15356# a_2890_15457# VDD sg13_lv_pmos ad=0.1428p pd=1.52u as=79.8f ps=0.8u w=0.42u l=0.13u
X2110 VDD VSS.t1689 VDD VDD sg13_lv_pmos ad=0.34p pd=2.68u as=0 ps=0 w=1u l=1u
X2111 VSS.t2434 VDD VSS.t2433 VSS.t2432 sg13_lv_nmos ad=0.1428p pd=1.52u as=0 ps=0 w=0.42u l=1u
X2112 VDD VSS.t416 VDD VDD sg13_lv_pmos ad=0.34p pd=2.68u as=0 ps=0 w=1u l=1u
X2113 VDD VSS.t2318 VDD VDD sg13_lv_pmos ad=0.34p pd=2.68u as=0 ps=0 w=1u l=1u
X2114 VSS.t796 VDD VSS.t795 VSS.t794 sg13_lv_nmos ad=0.1428p pd=1.52u as=0 ps=0 w=0.42u l=1u
X2115 VDD VSS.t2775 VDD VDD sg13_lv_pmos ad=0.34p pd=2.68u as=0 ps=0 w=1u l=1u
X2116 a_25956_14488# a_25930_14452# VDD VDD sg13_lv_pmos ad=0.34p pd=2.68u as=0.36237p ps=2.605u w=1u l=0.13u
X2117 VDD a_4432_15454# a_4377_15549# VDD sg13_lv_pmos ad=2.8961p pd=18.25u as=93.45f ps=0.865u w=0.42u l=0.13u
X2118 VSS.t521 VDD VSS.t521 VSS.t526 sg13_lv_nmos ad=0.1428p pd=1.52u as=0 ps=0 w=0.42u l=1u
X2119 VDD VSS.t1213 VDD VDD sg13_lv_pmos ad=0.19p pd=1.38u as=0 ps=0 w=1u l=1u
X2120 VSS.t1535 VDD VSS.t1537 VSS.t1536 sg13_lv_nmos ad=79.8f pd=0.8u as=0 ps=0 w=0.42u l=1u
X2121 VSS.t1285 VDD VSS.t1286 VSS.t70 sg13_lv_nmos ad=79.8f pd=0.8u as=0 ps=0 w=0.42u l=1u
X2122 VSS.t1465 VDD VSS.t1467 VSS.t1466 sg13_lv_nmos ad=79.8f pd=0.8u as=0 ps=0 w=0.42u l=1u
X2123 VDD VSS.t2659 VDD VDD sg13_lv_pmos ad=0.19p pd=1.38u as=0 ps=0 w=1u l=1u
X2124 VSS.t1857 VDD VSS.t1856 VSS.t1855 sg13_lv_nmos ad=0.1428p pd=1.52u as=0 ps=0 w=0.42u l=1u
X2125 VSS.t34 a_37484_15960# counter_value_o[7] VSS.t246 sg13_lv_nmos ad=0.14875p pd=1.16u as=0.2886p ps=2.26u w=0.74u l=0.13u
X2126 VSS.t429 VDD VSS.t430 VSS.t15 sg13_lv_nmos ad=79.8f pd=0.8u as=0 ps=0 w=0.42u l=1u
X2127 VDD VSS.t422 VDD VDD sg13_lv_pmos ad=0.34p pd=2.68u as=0 ps=0 w=1u l=1u
X2128 VDD VSS.t1218 VDD VDD sg13_lv_pmos ad=0.19p pd=1.38u as=0 ps=0 w=1u l=1u
X2129 VDD VSS.t2722 VDD VDD sg13_lv_pmos ad=0.19p pd=1.38u as=0 ps=0 w=1u l=1u
X2130 VSS.t2399 VDD VSS.t2398 VSS.t2397 sg13_lv_nmos ad=0.1428p pd=1.52u as=0 ps=0 w=0.42u l=1u
X2131 VSS.t4 sg13cmos5l_nand4_1_0.Y a_14261_15238# VSS.t3245 sg13_lv_nmos ad=0.3293p pd=1.63u as=0.2516p ps=2.16u w=0.74u l=0.13u
X2132 VSS.t81 a_17584_13942# a_17233_13799# VSS.t3207 sg13_lv_nmos ad=79.8f pd=0.8u as=0.1428p ps=1.52u w=0.42u l=0.13u
X2133 VDD VSS.t2338 VDD VDD sg13_lv_pmos ad=0.34p pd=2.68u as=0 ps=0 w=1u l=1u
X2134 a_16596_15280# sg13cmos5l_or3_1_2.B a_16140_15424# VSS.t3261 sg13_lv_nmos ad=78.39999f pd=0.885u as=0.2176p ps=1.96u w=0.64u l=0.13u
X2135 a_7833_14607# a_6891_14495# a_7631_14845# VDD sg13_lv_pmos ad=93.45f pd=0.865u as=0.2048p ps=1.63u w=0.42u l=0.13u
X2136 a_16485_13701# sg13cmos5l_dfrbpq_1_2.CLK VSS.t92 VSS.t91 sg13_lv_nmos ad=0.2516p pd=2.16u as=15.38618p ps=0.10091m w=0.74u l=0.13u
X2137 VSS.t303 VDD VSS.t303 VSS.t309 sg13_lv_nmos ad=0.1428p pd=1.52u as=0 ps=0 w=0.42u l=1u
X2138 VSS.t34 VDD VSS.t34 VSS.t389 sg13_lv_nmos ad=0.1428p pd=1.52u as=0 ps=0 w=0.42u l=1u
X2139 VSS.t450 VDD VSS.t449 VSS.t15 sg13_lv_nmos ad=0.1428p pd=1.52u as=0 ps=0 w=0.42u l=1u
X2140 VDD VSS.t1979 VDD VDD sg13_lv_pmos ad=0.19p pd=1.38u as=0 ps=0 w=1u l=1u
X2141 VSS.t1947 VDD VSS.t1946 VSS.t1945 sg13_lv_nmos ad=0.1428p pd=1.52u as=0 ps=0 w=0.42u l=1u
X2142 VSS.t2464 VDD VSS.t2466 VSS.t2465 sg13_lv_nmos ad=79.8f pd=0.8u as=0 ps=0 w=0.42u l=1u
X2143 VDD VSS.t1532 VDD VDD sg13_lv_pmos ad=0.19p pd=1.38u as=0 ps=0 w=1u l=1u
X2144 a_17584_13942# a_17327_13799# a_17746_13722# VSS.t3225 sg13_lv_nmos ad=0.1428p pd=1.52u as=37.8f ps=0.6u w=0.42u l=0.13u
X2145 VSS.t2631 VDD VSS.t2631 VSS.t61 sg13_lv_nmos ad=0.1428p pd=1.52u as=0 ps=0 w=0.42u l=1u
X2146 VSS.t996 VDD VSS.t995 VSS.t994 sg13_lv_nmos ad=0.1428p pd=1.52u as=0 ps=0 w=0.42u l=1u
X2147 VDD VSS.t2681 VDD VDD sg13_lv_pmos ad=0.19p pd=1.38u as=0 ps=0 w=1u l=1u
X2148 VSS.t3020 VDD VSS.t3019 VSS.t3018 sg13_lv_nmos ad=0.1428p pd=1.52u as=0 ps=0 w=0.42u l=1u
X2149 VSS.t292 VDD VSS.t292 VSS.t293 sg13_lv_nmos ad=79.8f pd=0.8u as=0 ps=0 w=0.42u l=1u
X2150 VDD VSS.t1048 VDD VDD sg13_lv_pmos ad=0.19p pd=1.38u as=0 ps=0 w=1u l=1u
X2151 VDD VSS.t2924 VDD VDD sg13_lv_pmos ad=0.34p pd=2.68u as=0 ps=0 w=1u l=1u
X2152 VSS.t1485 VDD VSS.t1487 VSS.t1486 sg13_lv_nmos ad=79.8f pd=0.8u as=0 ps=0 w=0.42u l=1u
X2153 VSS.t1680 VDD VSS.t1679 VSS.t1678 sg13_lv_nmos ad=0.1428p pd=1.52u as=0 ps=0 w=0.42u l=1u
X2154 VDD VSS.t1497 VDD VDD sg13_lv_pmos ad=0.19p pd=1.38u as=0 ps=0 w=1u l=1u
X2155 VSS.t2692 VDD VSS.t2693 VSS.t61 sg13_lv_nmos ad=79.8f pd=0.8u as=0 ps=0 w=0.42u l=1u
X2156 VDD VSS.t2406 VDD VDD sg13_lv_pmos ad=0.19p pd=1.38u as=0 ps=0 w=1u l=1u
X2157 a_18454_16374# sg13cmos5l_or3_1_2.B VSS.t334 VSS.t3258 sg13_lv_nmos ad=0.1406p pd=1.12u as=0.1406p ps=1.12u w=0.74u l=0.15u
X2158 a_9732_15247# a_9963_15356# a_9418_15457# VSS.t89 sg13_lv_nmos ad=0.2373p pd=1.97u as=79.8f ps=0.8u w=0.42u l=0.13u
X2159 a_9670_15247# sg13cmos5l_tiehi_1.L_HI VSS.t73 VSS.t89 sg13_lv_nmos ad=37.8f pd=0.6u as=0.1701p ps=1.65u w=0.42u l=0.13u
X2160 a_25094_14484# a_24824_14525# VDD VDD sg13_lv_pmos ad=0.34p pd=2.68u as=0.1523p ps=1.38u w=1u l=0.5u
X2161 sg13cmos5l_dfrbpq_1_7.Q a_27882_14484# VDD VDD sg13_lv_pmos ad=0.3808p pd=2.92u as=0.2128p ps=1.5u w=1.12u l=0.13u
X2162 VSS.t2294 VDD VSS.t2296 VSS.t2295 sg13_lv_nmos ad=79.8f pd=0.8u as=0 ps=0 w=0.42u l=1u
X2163 VSS.t2012 VDD VSS.t2014 VSS.t2013 sg13_lv_nmos ad=79.8f pd=0.8u as=0 ps=0 w=0.42u l=1u
X2164 VSS.t609 VDD VSS.t609 VSS.t746 sg13_lv_nmos ad=0.1428p pd=1.52u as=0 ps=0 w=0.42u l=1u
X2165 a_7532_15960# sg13cmos5l_dlygate4sd3_1_1.A VSS.t147 VSS.t3229 sg13_lv_nmos ad=0.187p pd=1.78u as=0.14875p ps=1.16u w=0.55u l=0.13u
X2166 VSS.t1303 VDD VSS.t1303 VSS.t70 sg13_lv_nmos ad=79.8f pd=0.8u as=0 ps=0 w=0.42u l=1u
X2167 VDD VSS.t2693 VDD VDD sg13_lv_pmos ad=0.34p pd=2.68u as=0 ps=0 w=1u l=1u
X2168 VSS.t1967 VDD VSS.t1966 VSS.t1965 sg13_lv_nmos ad=0.1428p pd=1.52u as=0 ps=0 w=0.42u l=1u
X2169 VDD VSS.t1185 VDD VDD sg13_lv_pmos ad=0.19p pd=1.38u as=0 ps=0 w=1u l=1u
X2170 VSS.t1610 VDD VSS.t1609 VSS.t1608 sg13_lv_nmos ad=0.1428p pd=1.52u as=0 ps=0 w=0.42u l=1u
X2171 VSS.t3135 VDD VSS.t3134 VSS.t3133 sg13_lv_nmos ad=0.1428p pd=1.52u as=0 ps=0 w=0.42u l=1u
X2172 VDD VSS.t2665 VDD VDD sg13_lv_pmos ad=0.34p pd=2.68u as=0 ps=0 w=1u l=1u
X2173 VSS.t321 VDD VSS.t323 VSS.t322 sg13_lv_nmos ad=79.8f pd=0.8u as=0 ps=0 w=0.42u l=1u
X2174 a_10618_14448# sg13cmos5l_dlygate4sd3_1_8.A VSS.t53 VSS.t134 sg13_lv_nmos ad=0.1428p pd=1.52u as=79.8f ps=0.8u w=0.42u l=0.13u
X2175 VDD VSS.t443 VDD VDD sg13_lv_pmos ad=0.34p pd=2.68u as=0 ps=0 w=1u l=1u
X2176 VDD VSS.t1674 VDD VDD sg13_lv_pmos ad=0.34p pd=2.68u as=0 ps=0 w=1u l=1u
X2177 VSS.t1510 VDD VSS.t1509 VSS.t1508 sg13_lv_nmos ad=0.1428p pd=1.52u as=0 ps=0 w=0.42u l=1u
X2178 VSS.t2419 VDD VSS.t2418 VSS.t2417 sg13_lv_nmos ad=0.1428p pd=1.52u as=0 ps=0 w=0.42u l=1u
X2179 VSS.t1525 VDD VSS.t1527 VSS.t1526 sg13_lv_nmos ad=79.8f pd=0.8u as=0 ps=0 w=0.42u l=1u
X2180 VDD VSS.t1015 VDD VDD sg13_lv_pmos ad=0.34p pd=2.68u as=0 ps=0 w=1u l=1u
X2181 VSS.t2742 VDD VSS.t2743 VSS.t61 sg13_lv_nmos ad=79.8f pd=0.8u as=0 ps=0 w=0.42u l=1u
X2182 VSS.t1917 VDD VSS.t1916 VSS.t1915 sg13_lv_nmos ad=0.1428p pd=1.52u as=0 ps=0 w=0.42u l=1u
X2183 VDD VSS.t1477 VDD VDD sg13_lv_pmos ad=0.19p pd=1.38u as=0 ps=0 w=1u l=1u
X2184 VDD VSS.t2944 VDD VDD sg13_lv_pmos ad=0.34p pd=2.68u as=0 ps=0 w=1u l=1u
X2185 VDD VSS.t3117 VDD VDD sg13_lv_pmos ad=0.19p pd=1.38u as=0 ps=0 w=1u l=1u
X2186 VSS.t1520 VDD VSS.t1522 VSS.t1521 sg13_lv_nmos ad=79.8f pd=0.8u as=0 ps=0 w=0.42u l=1u
X2187 VSS.t1700 VDD VSS.t1699 VSS.t1698 sg13_lv_nmos ad=0.1428p pd=1.52u as=0 ps=0 w=0.42u l=1u
X2188 VDD VSS.t1482 VDD VDD sg13_lv_pmos ad=0.19p pd=1.38u as=0 ps=0 w=1u l=1u
X2189 sg13cmos5l_buf_8_2.X a_19323_13726# VSS.t211 VSS.t212 sg13_lv_nmos ad=0.1406p pd=1.12u as=0.1406p ps=1.12u w=0.74u l=0.13u
X2190 VSS.t2683 VDD VSS.t2684 VSS.t61 sg13_lv_nmos ad=79.8f pd=0.8u as=0 ps=0 w=0.42u l=1u
X2191 VDD VSS.t2650 VDD VDD sg13_lv_pmos ad=0.19p pd=1.38u as=0 ps=0 w=1u l=1u
X2192 VDD VSS.t2391 VDD VDD sg13_lv_pmos ad=0.19p pd=1.38u as=0 ps=0 w=1u l=1u
X2193 VSS.t11 VDD VSS.t11 VSS.t400 sg13_lv_nmos ad=0.1428p pd=1.52u as=0 ps=0 w=0.42u l=1u
X2194 VDD VSS.t729 VDD VDD sg13_lv_pmos ad=0.34p pd=2.68u as=0 ps=0 w=1u l=1u
X2195 VSS.t2965 VDD VSS.t2964 VSS.t2963 sg13_lv_nmos ad=0.1428p pd=1.52u as=0 ps=0 w=0.42u l=1u
X2196 VDD VSS.t1312 VDD VDD sg13_lv_pmos ad=0.34p pd=2.68u as=0 ps=0 w=1u l=1u
X2197 VSS.t1997 VDD VSS.t1999 VSS.t1998 sg13_lv_nmos ad=79.8f pd=0.8u as=0 ps=0 w=0.42u l=1u
X2198 VDD a_9658_14725# sg13cmos5l_tiehi_1.L_HI VDD sg13_lv_pmos ad=2.42015p pd=15.68u as=0.3927p ps=2.99u w=1.155u l=0.13u
X2199 VDD VSS.t2705 VDD VDD sg13_lv_pmos ad=0.34p pd=2.68u as=0 ps=0 w=1u l=1u
X2200 VDD VSS.t2516 VDD VDD sg13_lv_pmos ad=0.19p pd=1.38u as=0 ps=0 w=1u l=1u
X2201 VDD VSS.t1956 VDD VDD sg13_lv_pmos ad=0.34p pd=2.68u as=0 ps=0 w=1u l=1u
X2202 a_6789_14495# sg13cmos5l_dfrbpq_1_2.CLK VDD VDD sg13_lv_pmos ad=0.4088p pd=2.97u as=2.3367p ps=15.135u w=1.12u l=0.13u
X2203 VDD VSS.t1289 VDD VDD sg13_lv_pmos ad=0.19p pd=1.38u as=0 ps=0 w=1u l=1u
X2204 VDD sg13cmos5l_dfrbpq_1_3.Q sg13cmos5l_o21ai_1_2.A2 VDD sg13_lv_pmos ad=0.2128p pd=1.5u as=0.2128p ps=1.5u w=1.12u l=0.13u
X2205 a_25764_14922# sg13cmos5l_dfrbpq_1_7.D a_25670_14922# VSS.t56 sg13_lv_nmos ad=60.89999f pd=0.71u as=0.1428p ps=1.52u w=0.42u l=0.13u
X2206 a_24365_14508# sg13cmos5l_or3_1_2.B a_24263_14508# VDD sg13_lv_pmos ad=0.1575p pd=1.315u as=0.19p ps=1.38u w=1u l=0.13u
X2207 VDD VSS.t633 VDD VDD sg13_lv_pmos ad=0.19p pd=1.38u as=0 ps=0 w=1u l=1u
X2208 VSS.t1238 VDD VSS.t1239 VSS.t70 sg13_lv_nmos ad=79.8f pd=0.8u as=0 ps=0 w=0.42u l=1u
X2209 VDD VSS.t1639 VDD VDD sg13_lv_pmos ad=0.34p pd=2.68u as=0 ps=0 w=1u l=1u
X2210 VSS.t627 VDD VSS.t627 VSS.t758 sg13_lv_nmos ad=0.1428p pd=1.52u as=0 ps=0 w=0.42u l=1u
X2211 VDD VSS.t1694 VDD VDD sg13_lv_pmos ad=0.34p pd=2.68u as=0 ps=0 w=1u l=1u
X2212 VDD VSS.t1851 VDD VDD sg13_lv_pmos ad=0.34p pd=2.68u as=0 ps=0 w=1u l=1u
X2213 VSS.t996 VDD VSS.t995 VSS.t994 sg13_lv_nmos ad=0.1428p pd=1.52u as=0 ps=0 w=0.42u l=1u
X2214 VDD VSS.t978 VDD VDD sg13_lv_pmos ad=0.19p pd=1.38u as=0 ps=0 w=1u l=1u
X2215 VDD VSS.t2778 VDD VDD sg13_lv_pmos ad=0.34p pd=2.68u as=0 ps=0 w=1u l=1u
X2216 VDD a_26373_14495# a_26475_14495# VDD sg13_lv_pmos ad=2.42015p pd=15.68u as=0.3864p ps=2.93u w=1.12u l=0.13u
X2217 sg13cmos5l_or3_1_1.X a_24841_13726# VDD VDD sg13_lv_pmos ad=0.3808p pd=2.92u as=0.3822p ps=1.84u w=1.12u l=0.13u
X2218 VSS.t1326 VDD VSS.t1325 VSS.t70 sg13_lv_nmos ad=0.1428p pd=1.52u as=0 ps=0 w=0.42u l=1u
X2219 VDD VSS.t574 VDD VDD sg13_lv_pmos ad=0.34p pd=2.68u as=0 ps=0 w=1u l=1u
X2220 VDD VSS.t905 VDD VDD sg13_lv_pmos ad=0.34p pd=2.68u as=0 ps=0 w=1u l=1u
X2221 VSS.t1470 VDD VSS.t1472 VSS.t1471 sg13_lv_nmos ad=79.8f pd=0.8u as=0 ps=0 w=0.42u l=1u
X2222 VSS.t1862 VDD VSS.t1861 VSS.t1860 sg13_lv_nmos ad=0.1428p pd=1.52u as=0 ps=0 w=0.42u l=1u
X2223 a_21466_15202# sg13cmos5l_o21ai_1_1.Y VDD VDD sg13_lv_pmos ad=0.1428p pd=1.52u as=0.1523p ps=1.38u w=0.42u l=0.13u
X2224 VSS.t2950 VDD VSS.t2949 VSS.t2948 sg13_lv_nmos ad=0.1428p pd=1.52u as=0 ps=0 w=0.42u l=1u
X2225 VSS.t2789 VDD VSS.t2788 VSS.t61 sg13_lv_nmos ad=0.1428p pd=1.52u as=0 ps=0 w=0.42u l=1u
X2226 VSS.t2032 VDD VSS.t2034 VSS.t2033 sg13_lv_nmos ad=79.8f pd=0.8u as=0 ps=0 w=0.42u l=1u
X2227 VDD VSS.t1989 VDD VDD sg13_lv_pmos ad=0.19p pd=1.38u as=0 ps=0 w=1u l=1u
X2228 sg13cmos5l_dfrbpq_1_7.Q a_27882_14484# VSS.t32 VSS.t15 sg13_lv_nmos ad=0.2516p pd=2.16u as=0.1406p ps=1.12u w=0.74u l=0.13u
X2229 VDD VSS.t1220 VDD VDD sg13_lv_pmos ad=0.19p pd=1.38u as=0 ps=0 w=1u l=1u
X2230 VDD VSS.t2725 VDD VDD sg13_lv_pmos ad=0.19p pd=1.38u as=0 ps=0 w=1u l=1u
X2231 VSS.t2279 VDD VSS.t2281 VSS.t2280 sg13_lv_nmos ad=79.8f pd=0.8u as=0 ps=0 w=0.42u l=1u
X2232 VSS.t2404 VDD VSS.t2403 VSS.t2402 sg13_lv_nmos ad=0.1428p pd=1.52u as=0 ps=0 w=0.42u l=1u
X2233 VSS.t636 VDD VSS.t636 VSS.t764 sg13_lv_nmos ad=0.1428p pd=1.52u as=0 ps=0 w=0.42u l=1u
X2234 VDD VSS.t2343 VDD VDD sg13_lv_pmos ad=0.34p pd=2.68u as=0 ps=0 w=1u l=1u
X2235 VDD sg13cmos5l_tiehi_1.L_HI a_9418_15457# VDD sg13_lv_pmos ad=0.1563p pd=1.22u as=0.147p ps=1.54u w=0.42u l=0.13u
X2236 VDD VSS.t1489 VDD VDD sg13_lv_pmos ad=0.34p pd=2.68u as=0 ps=0 w=1u l=1u
X2237 VSS.t584 VDD VSS.t691 VSS.t690 sg13_lv_nmos ad=79.8f pd=0.8u as=0 ps=0 w=0.42u l=1u
X2238 VSS.t1570 VDD VSS.t1569 VSS.t1568 sg13_lv_nmos ad=0.1428p pd=1.52u as=0 ps=0 w=0.42u l=1u
X2239 VDD VSS.t780 VDD VDD sg13_lv_pmos ad=0.34p pd=2.68u as=0 ps=0 w=1u l=1u
X2240 VSS.t1220 VDD VSS.t1220 VSS.t70 sg13_lv_nmos ad=0.1428p pd=1.52u as=0 ps=0 w=0.42u l=1u
X2241 VDD VSS.t1672 VDD VDD sg13_lv_pmos ad=0.19p pd=1.38u as=0 ps=0 w=1u l=1u
X2242 VSS.t1952 VDD VSS.t1951 VSS.t1950 sg13_lv_nmos ad=0.1428p pd=1.52u as=0 ps=0 w=0.42u l=1u
X2243 VDD VSS.t2657 VDD VDD sg13_lv_pmos ad=0.34p pd=2.68u as=0 ps=0 w=1u l=1u
X2244 VSS.t2469 VDD VSS.t2471 VSS.t2470 sg13_lv_nmos ad=79.8f pd=0.8u as=0 ps=0 w=0.42u l=1u
X2245 VDD VSS.t383 VDD VDD sg13_lv_pmos ad=0.34p pd=2.68u as=0 ps=0 w=1u l=1u
X2246 VSS.t411 VDD VSS.t32 VSS.t15 sg13_lv_nmos ad=0.1428p pd=1.52u as=0 ps=0 w=0.42u l=1u
X2247 VSS.t550 VDD VSS.t552 VSS.t551 sg13_lv_nmos ad=79.8f pd=0.8u as=0 ps=0 w=0.42u l=1u
X2248 a_25786_15960# sg13cmos5l_o21ai_1_3.Y VDD VDD sg13_lv_pmos ad=0.1428p pd=1.52u as=0.1523p ps=1.38u w=0.42u l=0.13u
X2249 VDD VSS.t596 VDD VDD sg13_lv_pmos ad=0.34p pd=2.68u as=0 ps=0 w=1u l=1u
X2250 VDD VSS.t2044 VDD VDD sg13_lv_pmos ad=0.19p pd=1.38u as=0 ps=0 w=1u l=1u
X2251 VSS.t1690 VDD VSS.t1689 VSS.t1688 sg13_lv_nmos ad=0.1428p pd=1.52u as=0 ps=0 w=0.42u l=1u
X2252 VSS.t2634 VDD VSS.t2633 VSS.t61 sg13_lv_nmos ad=0.1428p pd=1.52u as=0 ps=0 w=0.42u l=1u
X2253 VSS.t2733 VDD VSS.t2734 VSS.t61 sg13_lv_nmos ad=79.8f pd=0.8u as=0 ps=0 w=0.42u l=1u
X2254 VSS.t816 VDD VSS.t815 VSS.t814 sg13_lv_nmos ad=0.1428p pd=1.52u as=0 ps=0 w=0.42u l=1u
X2255 VSS.t1256 VDD VSS.t1256 VSS.t70 sg13_lv_nmos ad=79.8f pd=0.8u as=0 ps=0 w=0.42u l=1u
X2256 VSS.t2990 VDD VSS.t2989 VSS.t2988 sg13_lv_nmos ad=0.1428p pd=1.52u as=0 ps=0 w=0.42u l=1u
X2257 VSS.t1178 VDD VSS.t1179 VSS.t70 sg13_lv_nmos ad=79.8f pd=0.8u as=0 ps=0 w=0.42u l=1u
X2258 VDD VSS.t1462 VDD VDD sg13_lv_pmos ad=0.19p pd=1.38u as=0 ps=0 w=1u l=1u
X2259 VDD VSS.t2929 VDD VDD sg13_lv_pmos ad=0.34p pd=2.68u as=0 ps=0 w=1u l=1u
X2260 VSS.t447 VDD VSS.t448 VSS.t15 sg13_lv_nmos ad=79.8f pd=0.8u as=0 ps=0 w=0.42u l=1u
X2261 VSS.t1685 VDD VSS.t1684 VSS.t1683 sg13_lv_nmos ad=0.1428p pd=1.52u as=0 ps=0 w=0.42u l=1u
X2262 VSS.t414 VDD VSS.t415 VSS.t15 sg13_lv_nmos ad=79.8f pd=0.8u as=0 ps=0 w=0.42u l=1u
X2263 a_21477_14495# sg13cmos5l_buf_8_2.X VSS.t15 VSS.t194 sg13_lv_nmos ad=0.2516p pd=2.16u as=3.8707p ps=25.555u w=0.74u l=0.13u
X2264 VDD VSS.t1467 VDD VDD sg13_lv_pmos ad=0.19p pd=1.38u as=0 ps=0 w=1u l=1u
X2265 VSS.t2781 VDD VSS.t2780 VSS.t61 sg13_lv_nmos ad=0.1428p pd=1.52u as=0 ps=0 w=0.42u l=1u
X2266 VSS.t2052 VDD VSS.t2054 VSS.t2053 sg13_lv_nmos ad=79.8f pd=0.8u as=0 ps=0 w=0.42u l=1u
X2267 VSS.t2264 VDD VSS.t2266 VSS.t2265 sg13_lv_nmos ad=79.8f pd=0.8u as=0 ps=0 w=0.42u l=1u
X2268 VDD VSS.t3119 VDD VDD sg13_lv_pmos ad=0.34p pd=2.68u as=0 ps=0 w=1u l=1u
X2269 VDD VSS.t2501 VDD VDD sg13_lv_pmos ad=0.19p pd=1.38u as=0 ps=0 w=1u l=1u
X2270 VDD VSS.t935 VDD VDD sg13_lv_pmos ad=0.34p pd=2.68u as=0 ps=0 w=1u l=1u
X2271 VSS.t1197 VDD VSS.t1198 VSS.t70 sg13_lv_nmos ad=79.8f pd=0.8u as=0 ps=0 w=0.42u l=1u
X2272 VSS.t1234 VDD VSS.t1233 VSS.t70 sg13_lv_nmos ad=0.1428p pd=1.52u as=0 ps=0 w=0.42u l=1u
X2273 VDD VSS.t1941 VDD VDD sg13_lv_pmos ad=0.34p pd=2.68u as=0 ps=0 w=1u l=1u
X2274 a_22149_16033# a_22149_16033# VSS.t30 VSS.t202 sg13_lv_nmos ad=0.111p pd=1.34u as=7.70437p ps=50.66u w=0.3u l=0.13u
X2275 VSS.t1265 VDD VSS.t1266 VSS.t70 sg13_lv_nmos ad=79.8f pd=0.8u as=0 ps=0 w=0.42u l=1u
X2276 VDD VSS.t1624 VDD VDD sg13_lv_pmos ad=0.34p pd=2.68u as=0 ps=0 w=1u l=1u
X2277 VSS.t1515 VDD VSS.t1514 VSS.t1513 sg13_lv_nmos ad=0.1428p pd=1.52u as=0 ps=0 w=0.42u l=1u
X2278 VSS.t2424 VDD VSS.t2423 VSS.t2422 sg13_lv_nmos ad=0.1428p pd=1.52u as=0 ps=0 w=0.42u l=1u
X2279 VDD VSS.t1020 VDD VDD sg13_lv_pmos ad=0.34p pd=2.68u as=0 ps=0 w=1u l=1u
X2280 VSS.t971 VDD VSS.t970 VSS.t969 sg13_lv_nmos ad=0.1428p pd=1.52u as=0 ps=0 w=0.42u l=1u
X2281 VSS.t1530 VDD VSS.t1532 VSS.t1531 sg13_lv_nmos ad=79.8f pd=0.8u as=0 ps=0 w=0.42u l=1u
X2282 VSS.t2745 VDD VSS.t2746 VSS.t61 sg13_lv_nmos ad=79.8f pd=0.8u as=0 ps=0 w=0.42u l=1u
X2283 VSS.t429 VDD VSS.t428 VSS.t15 sg13_lv_nmos ad=0.1428p pd=1.52u as=0 ps=0 w=0.42u l=1u
X2284 VDD VSS.t835 VDD VDD sg13_lv_pmos ad=0.34p pd=2.68u as=0 ps=0 w=1u l=1u
X2285 VSS.t1403 VDD VSS.t1270 VSS.t70 sg13_lv_nmos ad=79.8f pd=0.8u as=0 ps=0 w=0.42u l=1u
X2286 VDD VSS.t1204 VDD VDD sg13_lv_pmos ad=0.34p pd=2.68u as=0 ps=0 w=1u l=1u
X2287 VSS.t591 VDD VSS.t591 VSS.t590 sg13_lv_nmos ad=0.1428p pd=1.52u as=0 ps=0 w=0.42u l=1u
X2288 VDD VSS.t574 VDD VDD sg13_lv_pmos ad=0.34p pd=2.68u as=0 ps=0 w=1u l=1u
X2289 VDD VSS.t2914 VDD VDD sg13_lv_pmos ad=0.34p pd=2.68u as=0 ps=0 w=1u l=1u
X2290 VDD VSS.t20 VDD VDD sg13_lv_pmos ad=0.34p pd=2.68u as=0 ps=0 w=1u l=1u
X2291 VSS.t1847 VDD VSS.t1846 VSS.t1845 sg13_lv_nmos ad=0.1428p pd=1.52u as=0 ps=0 w=0.42u l=1u
X2292 VSS.t545 VDD VSS.t544 VSS.t543 sg13_lv_nmos ad=0.1428p pd=1.52u as=0 ps=0 w=0.42u l=1u
X2293 VSS.t2935 VDD VSS.t2934 VSS.t2933 sg13_lv_nmos ad=0.1428p pd=1.52u as=0 ps=0 w=0.42u l=1u
X2294 VSS.t102 VDD VSS.t102 VSS.t604 sg13_lv_nmos ad=0.1428p pd=1.52u as=0 ps=0 w=0.42u l=1u
X2295 VSS.t1031 VDD VSS.t1033 VSS.t1032 sg13_lv_nmos ad=79.8f pd=0.8u as=0 ps=0 w=0.42u l=1u
X2296 VDD VSS.t1212 VDD VDD sg13_lv_pmos ad=0.19p pd=1.38u as=0 ps=0 w=1u l=1u
X2297 VDD VSS.t1316 VDD VDD sg13_lv_pmos ad=0.34p pd=2.68u as=0 ps=0 w=1u l=1u
X2298 VDD VSS.t2716 VDD VDD sg13_lv_pmos ad=0.19p pd=1.38u as=0 ps=0 w=1u l=1u
X2299 VSS.t2389 VDD VSS.t2388 VSS.t2387 sg13_lv_nmos ad=0.1428p pd=1.52u as=0 ps=0 w=0.42u l=1u
X2300 VSS.t2002 VDD VSS.t2004 VSS.t2003 sg13_lv_nmos ad=79.8f pd=0.8u as=0 ps=0 w=0.42u l=1u
X2301 VSS.t172 sg13cmos5l_or3_1_2.B a_21251_13690# VSS.t3263 sg13_lv_nmos ad=0.1045p pd=0.93u as=0.198p ps=1.27u w=0.55u l=0.13u
X2302 VSS.t1288 VDD VSS.t1289 VSS.t70 sg13_lv_nmos ad=79.8f pd=0.8u as=0 ps=0 w=0.42u l=1u
X2303 a_2724_15234# sg13cmos5l_and2_1_0.X a_2630_15234# VSS.t268 sg13_lv_nmos ad=60.89999f pd=0.71u as=0.1428p ps=1.52u w=0.42u l=0.13u
X2304 VSS.t512 VDD VSS.t512 VSS.t513 sg13_lv_nmos ad=79.8f pd=0.8u as=0 ps=0 w=0.42u l=1u
X2305 VDD VSS.t593 VDD VDD sg13_lv_pmos ad=0.19p pd=1.38u as=0 ps=0 w=1u l=1u
X2306 VDD VSS.t898 VDD VDD sg13_lv_pmos ad=0.19p pd=1.38u as=0 ps=0 w=1u l=1u
X2307 VDD VSS.t1474 VDD VDD sg13_lv_pmos ad=0.34p pd=2.68u as=0 ps=0 w=1u l=1u
X2308 VDD VSS.t2687 VDD VDD sg13_lv_pmos ad=0.34p pd=2.68u as=0 ps=0 w=1u l=1u
X2309 VSS.t2704 VDD VSS.t2703 VSS.t61 sg13_lv_nmos ad=0.1428p pd=1.52u as=0 ps=0 w=0.42u l=1u
X2310 VDD VSS.t367 VDD VDD sg13_lv_pmos ad=0.19p pd=1.38u as=0 ps=0 w=1u l=1u
X2311 VDD VSS.t1609 VDD VDD sg13_lv_pmos ad=0.34p pd=2.68u as=0 ps=0 w=1u l=1u
X2312 VSS.t2454 VDD VSS.t2456 VSS.t2455 sg13_lv_nmos ad=79.8f pd=0.8u as=0 ps=0 w=0.42u l=1u
X2313 VSS.t1500 VDD VSS.t1499 VSS.t1498 sg13_lv_nmos ad=0.1428p pd=1.52u as=0 ps=0 w=0.42u l=1u
X2314 VSS.t816 VDD VSS.t815 VSS.t814 sg13_lv_nmos ad=0.1428p pd=1.52u as=0 ps=0 w=0.42u l=1u
X2315 VSS.t2409 VDD VSS.t2408 VSS.t2407 sg13_lv_nmos ad=0.1428p pd=1.52u as=0 ps=0 w=0.42u l=1u
X2316 VDD VSS.t2029 VDD VDD sg13_lv_pmos ad=0.19p pd=1.38u as=0 ps=0 w=1u l=1u
X2317 VDD VSS.t729 VDD VDD sg13_lv_pmos ad=0.19p pd=1.38u as=0 ps=0 w=1u l=1u
X2318 VSS.t15 a_9861_15213# a_9963_15356# VSS.t90 sg13_lv_nmos ad=4.11262p pd=27.15u as=0.2516p ps=2.16u w=0.74u l=0.13u
X2319 VSS.t575 VDD VSS.t574 VSS.t573 sg13_lv_nmos ad=0.1428p pd=1.52u as=0 ps=0 w=0.42u l=1u
X2320 VSS.t1046 VDD VSS.t1048 VSS.t1047 sg13_lv_nmos ad=79.8f pd=0.8u as=0 ps=0 w=0.42u l=1u
X2321 VDD VSS.t1527 VDD VDD sg13_lv_pmos ad=0.19p pd=1.38u as=0 ps=0 w=1u l=1u
X2322 VDD VSS.t1981 VDD VDD sg13_lv_pmos ad=0.34p pd=2.68u as=0 ps=0 w=1u l=1u
X2323 VDD VSS.t1195 VDD VDD sg13_lv_pmos ad=0.34p pd=2.68u as=0 ps=0 w=1u l=1u
X2324 VDD VSS.t2760 VDD VDD sg13_lv_pmos ad=0.34p pd=2.68u as=0 ps=0 w=1u l=1u
X2325 a_2059_14832# sg13cmos5l_buf_1_10.X a_1965_14832# VSS.t0 sg13_lv_nmos ad=0.1216p pd=1.02u as=0.2176p ps=1.96u w=0.64u l=0.13u
X2326 VSS.t1475 VDD VSS.t1477 VSS.t1476 sg13_lv_nmos ad=79.8f pd=0.8u as=0 ps=0 w=0.42u l=1u
X2327 VSS.t2697 VDD VSS.t2696 VSS.t61 sg13_lv_nmos ad=0.1428p pd=1.52u as=0 ps=0 w=0.42u l=1u
X2328 VSS.t71 reset_n_i a_1192_9948# VSS.t70 sg13_lv_nmos ad=0.14875p pd=1.16u as=0.187p ps=1.78u w=0.55u l=0.13u
X2329 VDD VSS.t1187 VDD VDD sg13_lv_pmos ad=0.34p pd=2.68u as=0 ps=0 w=1u l=1u
X2330 VSS.t2037 VDD VSS.t2039 VSS.t2038 sg13_lv_nmos ad=79.8f pd=0.8u as=0 ps=0 w=0.42u l=1u
X2331 VDD VSS.t1994 VDD VDD sg13_lv_pmos ad=0.19p pd=1.38u as=0 ps=0 w=1u l=1u
X2332 VDD VSS.t865 VDD VDD sg13_lv_pmos ad=0.34p pd=2.68u as=0 ps=0 w=1u l=1u
X2333 VDD VSS.t1053 VDD VDD sg13_lv_pmos ad=0.19p pd=1.38u as=0 ps=0 w=1u l=1u
X2334 VDD VSS.t1223 VDD VDD sg13_lv_pmos ad=0.19p pd=1.38u as=0 ps=0 w=1u l=1u
X2335 VSS.t2754 VDD VSS.t2753 VSS.t61 sg13_lv_nmos ad=0.1428p pd=1.52u as=0 ps=0 w=0.42u l=1u
X2336 VSS.t2249 VDD VSS.t2251 VSS.t2250 sg13_lv_nmos ad=79.8f pd=0.8u as=0 ps=0 w=0.42u l=1u
X2337 VDD VSS.t303 VDD VDD sg13_lv_pmos ad=0.34p pd=2.68u as=0 ps=0 w=1u l=1u
X2338 VDD VSS.t2348 VDD VDD sg13_lv_pmos ad=0.34p pd=2.68u as=0 ps=0 w=1u l=1u
X2339 VDD sg13cmos5l_or3_1_1.B a_16168_15996# VDD sg13_lv_pmos ad=0.2114p pd=1.54u as=0.2856p ps=2.36u w=0.84u l=0.13u
X2340 VDD VSS.t1494 VDD VDD sg13_lv_pmos ad=0.34p pd=2.68u as=0 ps=0 w=1u l=1u
X2341 VDD VSS.t1667 VDD VDD sg13_lv_pmos ad=0.19p pd=1.38u as=0 ps=0 w=1u l=1u
X2342 VDD sg13cmos5l_dfrbpq_1_3.Q sg13cmos5l_or3_1_1.C VDD sg13_lv_pmos ad=0.2128p pd=1.5u as=0.2128p ps=1.5u w=1.12u l=0.13u
X2343 VSS.t1540 VDD VSS.t1539 VSS.t1538 sg13_lv_nmos ad=0.1428p pd=1.52u as=0 ps=0 w=0.42u l=1u
X2344 VSS.t1957 VDD VSS.t1956 VSS.t1955 sg13_lv_nmos ad=0.1428p pd=1.52u as=0 ps=0 w=0.42u l=1u
X2345 VDD VSS.t2659 VDD VDD sg13_lv_pmos ad=0.34p pd=2.68u as=0 ps=0 w=1u l=1u
X2346 VSS.t971 VDD VSS.t970 VSS.t969 sg13_lv_nmos ad=0.1428p pd=1.52u as=0 ps=0 w=0.42u l=1u
X2347 VDD VSS.t928 VDD VDD sg13_lv_pmos ad=0.19p pd=1.38u as=0 ps=0 w=1u l=1u
X2348 VSS.t1016 VDD VSS.t1015 VSS.t1014 sg13_lv_nmos ad=0.1428p pd=1.52u as=0 ps=0 w=0.42u l=1u
X2349 VDD VSS.t2356 VDD VDD sg13_lv_pmos ad=0.19p pd=1.38u as=0 ps=0 w=1u l=1u
X2350 VDD VSS.t2049 VDD VDD sg13_lv_pmos ad=0.19p pd=1.38u as=0 ps=0 w=1u l=1u
X2351 a_7160_15242# sg13cmos5l_xnor2_1_2.A a_7058_15242# VSS.t3208 sg13_lv_nmos ad=0.1406p pd=1.12u as=0.1406p ps=1.12u w=0.74u l=0.13u
X2352 VSS.t1296 VDD VSS.t1297 VSS.t70 sg13_lv_nmos ad=79.8f pd=0.8u as=0 ps=0 w=0.42u l=1u
X2353 VSS.t1695 VDD VSS.t1694 VSS.t1693 sg13_lv_nmos ad=0.1428p pd=1.52u as=0 ps=0 w=0.42u l=1u
X2354 VSS.t41 a_25774_15423# sg13cmos5l_dfrbpq_1_7.D VSS.t65 sg13_lv_nmos ad=0.1426p pd=1.16u as=0.2516p ps=2.16u w=0.74u l=0.13u
X2355 VSS.t2735 VDD VSS.t2737 VSS.t61 sg13_lv_nmos ad=79.8f pd=0.8u as=0 ps=0 w=0.42u l=1u
X2356 VDD VSS.t2668 VDD VDD sg13_lv_pmos ad=0.19p pd=1.38u as=0 ps=0 w=1u l=1u
X2357 VSS.t2995 VDD VSS.t2994 VSS.t2993 sg13_lv_nmos ad=0.1428p pd=1.52u as=0 ps=0 w=0.42u l=1u
X2358 VDD VSS.t446 VDD VDD sg13_lv_pmos ad=0.34p pd=2.68u as=0 ps=0 w=1u l=1u
X2359 VSS.t2374 VDD VSS.t2376 VSS.t2375 sg13_lv_nmos ad=79.8f pd=0.8u as=0 ps=0 w=0.42u l=1u
X2360 VSS.t423 VDD VSS.t422 VSS.t15 sg13_lv_nmos ad=0.1428p pd=1.52u as=0 ps=0 w=0.42u l=1u
X2361 VSS.t1460 VDD VSS.t1462 VSS.t1461 sg13_lv_nmos ad=79.8f pd=0.8u as=0 ps=0 w=0.42u l=1u
X2362 a_21166_16263# a_21281_16262# VSS.t222 VSS.t221 sg13_lv_nmos ad=0.1428p pd=1.52u as=0.1426p ps=1.16u w=0.42u l=0.5u
X2363 VSS.t1031 VDD VSS.t1033 VSS.t1032 sg13_lv_nmos ad=79.8f pd=0.8u as=0 ps=0 w=0.42u l=1u
X2364 VDD VSS.t1278 VDD VDD sg13_lv_pmos ad=0.34p pd=2.68u as=0 ps=0 w=1u l=1u
X2365 VSS.t1218 VDD VSS.t1219 VSS.t70 sg13_lv_nmos ad=79.8f pd=0.8u as=0 ps=0 w=0.42u l=1u
X2366 VDD VSS.t532 VDD VDD sg13_lv_pmos ad=0.19p pd=1.38u as=0 ps=0 w=1u l=1u
X2367 VDD VSS.t828 VDD VDD sg13_lv_pmos ad=0.19p pd=1.38u as=0 ps=0 w=1u l=1u
X2368 VDD VSS.t1472 VDD VDD sg13_lv_pmos ad=0.19p pd=1.38u as=0 ps=0 w=1u l=1u
X2369 VDD VSS.t2381 VDD VDD sg13_lv_pmos ad=0.19p pd=1.38u as=0 ps=0 w=1u l=1u
X2370 VSS.t67 a_22426_15202# a_22145_15424# VSS.t65 sg13_lv_nmos ad=79.8f pd=0.8u as=0.1428p ps=1.52u w=0.42u l=0.5u
X2371 VDD VSS.t621 VDD VDD sg13_lv_pmos ad=0.19p pd=1.38u as=0 ps=0 w=1u l=1u
X2372 VSS.t2269 VDD VSS.t2271 VSS.t2270 sg13_lv_nmos ad=79.8f pd=0.8u as=0 ps=0 w=0.42u l=1u
X2373 VSS.t1315 VDD VSS.t1316 VSS.t70 sg13_lv_nmos ad=79.8f pd=0.8u as=0 ps=0 w=0.42u l=1u
X2374 VDD VSS.t1306 VDD VDD sg13_lv_pmos ad=0.34p pd=2.68u as=0 ps=0 w=1u l=1u
X2375 sg13cmos5l_or3_1_1.B a_14261_15238# VDD VDD sg13_lv_pmos ad=0.2128p pd=1.5u as=0.2128p ps=1.5u w=1.12u l=0.13u
X2376 a_17806_15423# a_17921_15424# VSS.t64 VSS.t159 sg13_lv_nmos ad=0.1428p pd=1.52u as=0.1426p ps=1.16u w=0.42u l=0.5u
X2377 VDD VSS.t596 VDD VDD sg13_lv_pmos ad=0.19p pd=1.38u as=0 ps=0 w=1u l=1u
X2378 VDD VSS.t943 VDD VDD sg13_lv_pmos ad=0.19p pd=1.38u as=0 ps=0 w=1u l=1u
X2379 VSS.t2734 VDD VSS.t2735 VSS.t61 sg13_lv_nmos ad=79.8f pd=0.8u as=0 ps=0 w=0.42u l=1u
X2380 VDD VSS.t2506 VDD VDD sg13_lv_pmos ad=0.19p pd=1.38u as=0 ps=0 w=1u l=1u
X2381 VSS.t1987 VDD VSS.t1989 VSS.t1988 sg13_lv_nmos ad=79.8f pd=0.8u as=0 ps=0 w=0.42u l=1u
X2382 VSS.t67 a_22576_14726# a_22225_14845# VSS.t56 sg13_lv_nmos ad=79.8f pd=0.8u as=0.1428p ps=1.52u w=0.42u l=0.13u
X2383 VDD VSS.t2678 VDD VDD sg13_lv_pmos ad=0.34p pd=2.68u as=0 ps=0 w=1u l=1u
X2384 VSS.t1490 VDD VSS.t1489 VSS.t1488 sg13_lv_nmos ad=0.1428p pd=1.52u as=0 ps=0 w=0.42u l=1u
X2385 a_27472_14726# sg13cmos5l_dfrbpq_1_7.RESET_B VDD VDD sg13_lv_pmos ad=79.8f pd=0.8u as=2.42015p ps=15.68u w=0.42u l=0.13u
X2386 a_8218_13690# sg13cmos5l_dlygate4sd3_1_1.A VDD VDD sg13_lv_pmos ad=0.1428p pd=1.52u as=0.1523p ps=1.38u w=0.42u l=0.13u
X2387 VSS.t207 sg13cmos5l_buf_8_2.A a_19323_13726# VSS.t258 sg13_lv_nmos ad=0.1406p pd=1.12u as=0.1406p ps=1.12u w=0.74u l=0.13u
X2388 a_26148_14040# a_26122_13945# VSS.t729 VSS.t3279 sg13_lv_nmos ad=0.2516p pd=2.16u as=0.1626p ps=1.415u w=0.74u l=0.13u
X2389 VDD VSS.t1230 VDD VDD sg13_lv_pmos ad=0.34p pd=2.68u as=0 ps=0 w=1u l=1u
X2390 VDD VSS.t2735 VDD VDD sg13_lv_pmos ad=0.34p pd=2.68u as=0 ps=0 w=1u l=1u
X2391 VDD VSS.t2006 VDD VDD sg13_lv_pmos ad=0.34p pd=2.68u as=0 ps=0 w=1u l=1u
X2392 VSS.t1046 VDD VSS.t1048 VSS.t1047 sg13_lv_nmos ad=79.8f pd=0.8u as=0 ps=0 w=0.42u l=1u
X2393 VDD VSS.t1287 VDD VDD sg13_lv_pmos ad=0.34p pd=2.68u as=0 ps=0 w=1u l=1u
X2394 a_17746_13722# sg13cmos5l_dfrbpq_1_2.RESET_B VSS.t81 VSS.t80 sg13_lv_nmos ad=37.8f pd=0.6u as=79.8f ps=0.8u w=0.42u l=0.13u
X2395 VSS.t1485 VDD VSS.t1484 VSS.t1483 sg13_lv_nmos ad=0.1428p pd=1.52u as=0 ps=0 w=0.42u l=1u
X2396 VSS.t2394 VDD VSS.t2393 VSS.t2392 sg13_lv_nmos ad=0.1428p pd=1.52u as=0 ps=0 w=0.42u l=1u
X2397 VDD VSS.t1689 VDD VDD sg13_lv_pmos ad=0.34p pd=2.68u as=0 ps=0 w=1u l=1u
X2398 VSS.t2727 VDD VSS.t2728 VSS.t61 sg13_lv_nmos ad=79.8f pd=0.8u as=0 ps=0 w=0.42u l=1u
X2399 VDD VSS.t1966 VDD VDD sg13_lv_pmos ad=0.34p pd=2.68u as=0 ps=0 w=1u l=1u
X2400 VDD VSS.t416 VDD VDD sg13_lv_pmos ad=0.34p pd=2.68u as=0 ps=0 w=1u l=1u
X2401 VSS.t550 VDD VSS.t552 VSS.t551 sg13_lv_nmos ad=79.8f pd=0.8u as=0 ps=0 w=0.42u l=1u
X2402 VSS.t906 VDD VSS.t905 VSS.t904 sg13_lv_nmos ad=0.1428p pd=1.52u as=0 ps=0 w=0.42u l=1u
X2403 VDD VSS.t2919 VDD VDD sg13_lv_pmos ad=0.34p pd=2.68u as=0 ps=0 w=1u l=1u
X2404 VSS.t2309 VDD VSS.t2311 VSS.t2310 sg13_lv_nmos ad=79.8f pd=0.8u as=0 ps=0 w=0.42u l=1u
X2405 a_2916_15552# a_2890_15457# VDD VDD sg13_lv_pmos ad=0.34p pd=2.68u as=0.36237p ps=2.605u w=1u l=0.13u
X2406 VDD VSS.t3092 VDD VDD sg13_lv_pmos ad=0.19p pd=1.38u as=0 ps=0 w=1u l=1u
X2407 VDD VSS.t2301 VDD VDD sg13_lv_pmos ad=0.19p pd=1.38u as=0 ps=0 w=1u l=1u
X2408 VDD a_9861_15213# a_9963_15356# VDD sg13_lv_pmos ad=2.8961p pd=18.25u as=0.3864p ps=2.93u w=1.12u l=0.13u
X2409 VDD VSS.t399 VDD VDD sg13_lv_pmos ad=0.19p pd=1.38u as=0 ps=0 w=1u l=1u
X2410 a_4078_14751# a_4193_14750# VDD VDD sg13_lv_pmos ad=0.34p pd=2.68u as=0.2254p ps=1.53u w=1u l=0.5u
X2411 a_22521_14607# a_21579_14495# a_22319_14845# VDD sg13_lv_pmos ad=93.45f pd=0.865u as=0.2048p ps=1.63u w=0.42u l=0.13u
X2412 VSS.t2745 VDD VSS.t2743 VSS.t61 sg13_lv_nmos ad=0.1428p pd=1.52u as=0 ps=0 w=0.42u l=1u
X2413 VDD VSS.t2693 VDD VDD sg13_lv_pmos ad=0.34p pd=2.68u as=0 ps=0 w=1u l=1u
X2414 VDD VSS.t910 VDD VDD sg13_lv_pmos ad=0.34p pd=2.68u as=0 ps=0 w=1u l=1u
X2415 VDD VSS.t2333 VDD VDD sg13_lv_pmos ad=0.34p pd=2.68u as=0 ps=0 w=1u l=1u
X2416 VSS.t781 VDD VSS.t780 VSS.t779 sg13_lv_nmos ad=0.1428p pd=1.52u as=0 ps=0 w=0.42u l=1u
X2417 VDD VSS.t1479 VDD VDD sg13_lv_pmos ad=0.34p pd=2.68u as=0 ps=0 w=1u l=1u
X2418 a_14261_15238# sg13cmos5l_nand4_1_0.Y VDD VDD sg13_lv_pmos ad=0.1596p pd=1.22u as=0.2856p ps=2.36u w=0.84u l=0.13u
X2419 VSS.t2117 VDD VSS.t2119 VSS.t2118 sg13_lv_nmos ad=79.8f pd=0.8u as=0 ps=0 w=0.42u l=1u
X2420 VDD VSS.t645 VDD VDD sg13_lv_pmos ad=0.19p pd=1.38u as=0 ps=0 w=1u l=1u
X2421 VDD VSS.t833 VDD VDD sg13_lv_pmos ad=0.19p pd=1.38u as=0 ps=0 w=1u l=1u
X2422 VSS.t639 VDD VSS.t639 VSS.t766 sg13_lv_nmos ad=0.1428p pd=1.52u as=0 ps=0 w=0.42u l=1u
X2423 VSS.t2686 VDD VSS.t2685 VSS.t61 sg13_lv_nmos ad=0.1428p pd=1.52u as=0 ps=0 w=0.42u l=1u
X2424 VDD VSS.t367 VDD VDD sg13_lv_pmos ad=0.34p pd=2.68u as=0 ps=0 w=1u l=1u
X2425 VSS.t1016 VDD VSS.t1015 VSS.t1014 sg13_lv_nmos ad=0.1428p pd=1.52u as=0 ps=0 w=0.42u l=1u
X2426 VDD VSS.t1669 VDD VDD sg13_lv_pmos ad=0.34p pd=2.68u as=0 ps=0 w=1u l=1u
X2427 VDD VSS.t785 VDD VDD sg13_lv_pmos ad=0.34p pd=2.68u as=0 ps=0 w=1u l=1u
X2428 VDD VSS.t455 VDD VDD sg13_lv_pmos ad=0.34p pd=2.68u as=0 ps=0 w=1u l=1u
X2429 VDD VSS.t1532 VDD VDD sg13_lv_pmos ad=0.19p pd=1.38u as=0 ps=0 w=1u l=1u
X2430 a_18021_14495# sg13cmos5l_buf_8_2.X VSS.t15 VSS.t193 sg13_lv_nmos ad=0.2516p pd=2.16u as=3.8707p ps=25.555u w=0.74u l=0.13u
X2431 VSS.t1176 VDD VSS.t1177 VSS.t70 sg13_lv_nmos ad=79.8f pd=0.8u as=0 ps=0 w=0.42u l=1u
X2432 VSS.t1214 VDD VSS.t1213 VSS.t70 sg13_lv_nmos ad=0.1428p pd=1.52u as=0 ps=0 w=0.42u l=1u
X2433 VDD VSS.t1198 VDD VDD sg13_lv_pmos ad=0.34p pd=2.68u as=0 ps=0 w=1u l=1u
X2434 VSS.t2980 VDD VSS.t2979 VSS.t2978 sg13_lv_nmos ad=0.1428p pd=1.52u as=0 ps=0 w=0.42u l=1u
X2435 VDD VSS.t2763 VDD VDD sg13_lv_pmos ad=0.34p pd=2.68u as=0 ps=0 w=1u l=1u
X2436 VDD VSS.t1305 VDD VDD sg13_lv_pmos ad=0.34p pd=2.68u as=0 ps=0 w=1u l=1u
X2437 VSS.t821 VDD VSS.t820 VSS.t819 sg13_lv_nmos ad=0.1428p pd=1.52u as=0 ps=0 w=0.42u l=1u
X2438 VSS.t136 a_12524_15960# counter_value_o[2] VSS.t3223 sg13_lv_nmos ad=0.14875p pd=1.16u as=0.2886p ps=2.26u w=0.74u l=0.13u
X2439 a_17165_16020# sg13cmos5l_inv_1_0.Y a_17063_16020# VDD sg13_lv_pmos ad=0.1575p pd=1.315u as=0.19p ps=1.38u w=1u l=0.13u
X2440 VSS.t1181 VDD VSS.t1182 VSS.t70 sg13_lv_nmos ad=79.8f pd=0.8u as=0 ps=0 w=0.42u l=1u
X2441 VDD VSS.t2710 VDD VDD sg13_lv_pmos ad=0.19p pd=1.38u as=0 ps=0 w=1u l=1u
X2442 VSS.t2254 VDD VSS.t2256 VSS.t2255 sg13_lv_nmos ad=79.8f pd=0.8u as=0 ps=0 w=0.42u l=1u
X2443 VDD clock_i a_15579_14854# VDD sg13_lv_pmos ad=0.2128p pd=1.5u as=0.3808p ps=2.92u w=1.12u l=0.13u
X2444 VSS.t936 VDD VSS.t935 VSS.t934 sg13_lv_nmos ad=0.1428p pd=1.52u as=0 ps=0 w=0.42u l=1u
X2445 VSS.t2379 VDD VSS.t2378 VSS.t2377 sg13_lv_nmos ad=0.1428p pd=1.52u as=0 ps=0 w=0.42u l=1u
X2446 VSS.t587 VDD VSS.t587 VSS.t705 sg13_lv_nmos ad=79.8f pd=0.8u as=0 ps=0 w=0.42u l=1u
X2447 VDD VSS.t800 VDD VDD sg13_lv_pmos ad=0.34p pd=2.68u as=0 ps=0 w=1u l=1u
X2448 VDD VSS.t1464 VDD VDD sg13_lv_pmos ad=0.34p pd=2.68u as=0 ps=0 w=1u l=1u
X2449 VSS.t2725 VDD VSS.t2726 VSS.t61 sg13_lv_nmos ad=79.8f pd=0.8u as=0 ps=0 w=0.42u l=1u
X2450 VDD VSS.t624 VDD VDD sg13_lv_pmos ad=0.34p pd=2.68u as=0 ps=0 w=1u l=1u
X2451 VDD VSS.t988 VDD VDD sg13_lv_pmos ad=0.19p pd=1.38u as=0 ps=0 w=1u l=1u
X2452 VSS.t1232 VDD VSS.t1231 VSS.t70 sg13_lv_nmos ad=0.1428p pd=1.52u as=0 ps=0 w=0.42u l=1u
X2453 VSS.t2102 VDD VSS.t2104 VSS.t2103 sg13_lv_nmos ad=79.8f pd=0.8u as=0 ps=0 w=0.42u l=1u
X2454 VDD VSS.t287 VDD VDD sg13_lv_pmos ad=0.19p pd=1.38u as=0 ps=0 w=1u l=1u
X2455 VSS.t303 VDD VSS.t303 VSS.t307 sg13_lv_nmos ad=0.1428p pd=1.52u as=0 ps=0 w=0.42u l=1u
X2456 sg13cmos5l_and2_1_0.X a_1965_14832# VDD VDD sg13_lv_pmos ad=0.3808p pd=2.92u as=0.1918p ps=1.5u w=1.12u l=0.13u
X2457 VSS.t570 VDD VSS.t572 VSS.t571 sg13_lv_nmos ad=79.8f pd=0.8u as=0 ps=0 w=0.42u l=1u
X2458 VSS.t1545 VDD VSS.t1544 VSS.t1543 sg13_lv_nmos ad=0.1428p pd=1.52u as=0 ps=0 w=0.42u l=1u
X2459 VDD VSS.t157 VDD VDD sg13_lv_pmos ad=0.34p pd=2.68u as=0 ps=0 w=1u l=1u
X2460 VSS.t2698 VDD VSS.t2697 VSS.t61 sg13_lv_nmos ad=0.1428p pd=1.52u as=0 ps=0 w=0.42u l=1u
X2461 VDD VSS.t2663 VDD VDD sg13_lv_pmos ad=0.34p pd=2.68u as=0 ps=0 w=1u l=1u
X2462 VSS.t545 VDD VSS.t544 VSS.t543 sg13_lv_nmos ad=0.1428p pd=1.52u as=0 ps=0 w=0.42u l=1u
X2463 VDD sg13cmos5l_dfrbpq_1_3.RESET_B a_17318_14922# VDD sg13_lv_pmos ad=0.36237p pd=2.605u as=79.8f ps=0.8u w=0.42u l=0.13u
X2464 VDD VSS.t1369 VDD VDD sg13_lv_pmos ad=0.34p pd=2.68u as=0 ps=0 w=1u l=1u
X2465 VDD VSS.t2726 VDD VDD sg13_lv_pmos ad=0.34p pd=2.68u as=0 ps=0 w=1u l=1u
X2466 VDD VSS.t1991 VDD VDD sg13_lv_pmos ad=0.34p pd=2.68u as=0 ps=0 w=1u l=1u
X2467 VDD VSS.t2361 VDD VDD sg13_lv_pmos ad=0.19p pd=1.38u as=0 ps=0 w=1u l=1u
X2468 VDD VSS.t2019 VDD VDD sg13_lv_pmos ad=0.19p pd=1.38u as=0 ps=0 w=1u l=1u
X2469 VSS.t512 VDD VSS.t512 VSS.t513 sg13_lv_nmos ad=79.8f pd=0.8u as=0 ps=0 w=0.42u l=1u
X2470 VSS.t836 VDD VSS.t835 VSS.t834 sg13_lv_nmos ad=0.1428p pd=1.52u as=0 ps=0 w=0.42u l=1u
X2471 VSS.t906 VDD VSS.t905 VSS.t904 sg13_lv_nmos ad=0.1428p pd=1.52u as=0 ps=0 w=0.42u l=1u
X2472 VSS.t1267 VDD VSS.t1268 VSS.t70 sg13_lv_nmos ad=79.8f pd=0.8u as=0 ps=0 w=0.42u l=1u
X2473 VSS.t1190 VDD VSS.t1191 VSS.t70 sg13_lv_nmos ad=79.8f pd=0.8u as=0 ps=0 w=0.42u l=1u
X2474 VDD VSS.t443 VDD VDD sg13_lv_pmos ad=0.34p pd=2.68u as=0 ps=0 w=1u l=1u
X2475 VDD VSS.t863 VDD VDD sg13_lv_pmos ad=0.19p pd=1.38u as=0 ps=0 w=1u l=1u
X2476 VDD VSS.t1674 VDD VDD sg13_lv_pmos ad=0.34p pd=2.68u as=0 ps=0 w=1u l=1u
X2477 VSS.t3000 VDD VSS.t2999 VSS.t2998 sg13_lv_nmos ad=0.1428p pd=1.52u as=0 ps=0 w=0.42u l=1u
X2478 VSS.t2717 VDD VSS.t2719 VSS.t61 sg13_lv_nmos ad=79.8f pd=0.8u as=0 ps=0 w=0.42u l=1u
X2479 VDD VSS.t2904 VDD VDD sg13_lv_pmos ad=0.34p pd=2.68u as=0 ps=0 w=1u l=1u
X2480 a_6180_14922# sg13cmos5l_and2_1_1.X a_6086_14922# VSS.t86 sg13_lv_nmos ad=60.89999f pd=0.71u as=0.1428p ps=1.52u w=0.42u l=0.13u
X2481 VDD VSS.t1028 VDD VDD sg13_lv_pmos ad=0.19p pd=1.38u as=0 ps=0 w=1u l=1u
X2482 VSS.t2474 VDD VSS.t2473 VSS.t2472 sg13_lv_nmos ad=0.1428p pd=1.52u as=0 ps=0 w=0.42u l=1u
X2483 VSS.t2775 VDD VSS.t2776 VSS.t61 sg13_lv_nmos ad=79.8f pd=0.8u as=0 ps=0 w=0.42u l=1u
X2484 sg13cmos5l_buf_8_2.X a_19323_13726# VSS.t207 VSS.t209 sg13_lv_nmos ad=0.1406p pd=1.12u as=0.1406p ps=1.12u w=0.74u l=0.13u
X2485 VDD VSS.t1477 VDD VDD sg13_lv_pmos ad=0.19p pd=1.38u as=0 ps=0 w=1u l=1u
X2486 VDD VSS.t2386 VDD VDD sg13_lv_pmos ad=0.19p pd=1.38u as=0 ps=0 w=1u l=1u
X2487 sg13cmos5l_or3_1_2.B a_16168_15996# VSS.t218 VSS.t217 sg13_lv_nmos ad=0.2886p pd=2.26u as=0.14875p ps=1.16u w=0.74u l=0.13u
X2488 VSS.t593 VDD VSS.t596 VSS.t595 sg13_lv_nmos ad=79.8f pd=0.8u as=0 ps=0 w=0.42u l=1u
X2489 VSS.t575 VDD VSS.t574 VSS.t573 sg13_lv_nmos ad=0.1428p pd=1.52u as=0 ps=0 w=0.42u l=1u
X2490 VSS.t781 VDD VSS.t780 VSS.t779 sg13_lv_nmos ad=0.1428p pd=1.52u as=0 ps=0 w=0.42u l=1u
X2491 VDD VSS.t955 VDD VDD sg13_lv_pmos ad=0.34p pd=2.68u as=0 ps=0 w=1u l=1u
X2492 VSS.t335 VDD VSS.t337 VSS.t336 sg13_lv_nmos ad=79.8f pd=0.8u as=0 ps=0 w=0.42u l=1u
X2493 VDD a_6789_14495# a_6891_14495# VDD sg13_lv_pmos ad=2.42015p pd=15.68u as=0.3864p ps=2.93u w=1.12u l=0.13u
X2494 VSS.t1246 VDD VSS.t1245 VSS.t70 sg13_lv_nmos ad=0.1428p pd=1.52u as=0 ps=0 w=0.42u l=1u
X2495 VSS.t1992 VDD VSS.t1994 VSS.t1993 sg13_lv_nmos ad=79.8f pd=0.8u as=0 ps=0 w=0.42u l=1u
X2496 VSS.t2716 VDD VSS.t2717 VSS.t61 sg13_lv_nmos ad=79.8f pd=0.8u as=0 ps=0 w=0.42u l=1u
X2497 VSS.t1495 VDD VSS.t1494 VSS.t1493 sg13_lv_nmos ad=0.1428p pd=1.52u as=0 ps=0 w=0.42u l=1u
X2498 VDD a_21166_16263# sg13cmos5l_dfrbpq_1_6.D VDD sg13_lv_pmos ad=0.2254p pd=1.53u as=0.4256p ps=3u w=1.12u l=0.13u
X2499 VSS.t1665 VDD VSS.t1667 VSS.t1666 sg13_lv_nmos ad=79.8f pd=0.8u as=0 ps=0 w=0.42u l=1u
X2500 VDD VSS.t445 VDD VDD sg13_lv_pmos ad=0.19p pd=1.38u as=0 ps=0 w=1u l=1u
X2501 VSS.t2057 VDD VSS.t2056 VSS.t2055 sg13_lv_nmos ad=0.1428p pd=1.52u as=0 ps=0 w=0.42u l=1u
X2502 VSS.t512 VDD VSS.t512 VSS.t515 sg13_lv_nmos ad=79.8f pd=0.8u as=0 ps=0 w=0.42u l=1u
X2503 VDD VSS.t2717 VDD VDD sg13_lv_pmos ad=0.34p pd=2.68u as=0 ps=0 w=1u l=1u
X2504 VDD VSS.t2011 VDD VDD sg13_lv_pmos ad=0.34p pd=2.68u as=0 ps=0 w=1u l=1u
X2505 VDD VSS.t218 VDD VDD sg13_lv_pmos ad=0.19p pd=1.38u as=0 ps=0 w=1u l=1u
X2506 VSS.t593 VDD VSS.t593 VSS.t718 sg13_lv_nmos ad=79.8f pd=0.8u as=0 ps=0 w=0.42u l=1u
X2507 VSS.t1250 VDD VSS.t1249 VSS.t70 sg13_lv_nmos ad=0.1428p pd=1.52u as=0 ps=0 w=0.42u l=1u
X2508 VDD VSS.t1018 VDD VDD sg13_lv_pmos ad=0.19p pd=1.38u as=0 ps=0 w=1u l=1u
X2509 VSS.t1172 VDD VSS.t1171 VSS.t70 sg13_lv_nmos ad=0.1428p pd=1.52u as=0 ps=0 w=0.42u l=1u
X2510 VSS.t1280 VDD VSS.t1282 VSS.t70 sg13_lv_nmos ad=79.8f pd=0.8u as=0 ps=0 w=0.42u l=1u
X2511 VSS.t2239 VDD VSS.t2241 VSS.t2240 sg13_lv_nmos ad=79.8f pd=0.8u as=0 ps=0 w=0.42u l=1u
X2512 VSS.t441 VDD VSS.t440 VSS.t15 sg13_lv_nmos ad=0.1428p pd=1.52u as=0 ps=0 w=0.42u l=1u
X2513 a_27898_15202# sg13cmos5l_dfrbpq_1_5.Q VDD VDD sg13_lv_pmos ad=0.1428p pd=1.52u as=0.1523p ps=1.38u w=0.42u l=0.13u
X2514 VDD VSS.t1694 VDD VDD sg13_lv_pmos ad=0.34p pd=2.68u as=0 ps=0 w=1u l=1u
X2515 VDD VSS.t1971 VDD VDD sg13_lv_pmos ad=0.34p pd=2.68u as=0 ps=0 w=1u l=1u
X2516 VDD VSS.t1189 VDD VDD sg13_lv_pmos ad=0.34p pd=2.68u as=0 ps=0 w=1u l=1u
X2517 VSS.t2314 VDD VSS.t2316 VSS.t2315 sg13_lv_nmos ad=79.8f pd=0.8u as=0 ps=0 w=0.42u l=1u
X2518 VSS.t821 VDD VSS.t820 VSS.t819 sg13_lv_nmos ad=0.1428p pd=1.52u as=0 ps=0 w=0.42u l=1u
X2519 VDD VSS.t3097 VDD VDD sg13_lv_pmos ad=0.19p pd=1.38u as=0 ps=0 w=1u l=1u
X2520 VDD VSS.t733 VDD VDD sg13_lv_pmos ad=0.19p pd=1.38u as=0 ps=0 w=1u l=1u
X2521 VSS.t1051 VDD VSS.t1053 VSS.t1052 sg13_lv_nmos ad=79.8f pd=0.8u as=0 ps=0 w=0.42u l=1u
X2522 VSS.t936 VDD VSS.t935 VSS.t934 sg13_lv_nmos ad=0.1428p pd=1.52u as=0 ps=0 w=0.42u l=1u
X2523 VSS.t128 sg13cmos5l_dfrbpq_1_2.Q a_16552_15996# VSS.t3272 sg13_lv_nmos ad=0.14875p pd=1.16u as=0.187p ps=1.78u w=0.55u l=0.13u
X2524 VSS.t273 VDD VSS.t273 VSS.t372 sg13_lv_nmos ad=79.8f pd=0.8u as=0 ps=0 w=0.42u l=1u
X2525 VSS.t521 VDD VSS.t521 VSS.t523 sg13_lv_nmos ad=79.8f pd=0.8u as=0 ps=0 w=0.42u l=1u
X2526 VSS.t2748 VDD VSS.t2747 VSS.t61 sg13_lv_nmos ad=0.1428p pd=1.52u as=0 ps=0 w=0.42u l=1u
X2527 a_21348_14909# a_21579_14495# a_21034_14452# VSS.t58 sg13_lv_nmos ad=0.2373p pd=1.97u as=79.8f ps=0.8u w=0.42u l=0.13u
X2528 VDD VSS.t2677 VDD VDD sg13_lv_pmos ad=0.34p pd=2.68u as=0 ps=0 w=1u l=1u
X2529 VSS.t282 VDD VSS.t282 VSS.t285 sg13_lv_nmos ad=79.8f pd=0.8u as=0 ps=0 w=0.42u l=1u
X2530 VDD VSS.t1033 VDD VDD sg13_lv_pmos ad=0.19p pd=1.38u as=0 ps=0 w=1u l=1u
X2531 VDD a_27898_15202# a_27617_15424# VDD sg13_lv_pmos ad=0.1523p pd=1.38u as=0.34p ps=2.68u w=1u l=0.5u
X2532 VDD VSS.t425 VDD VDD sg13_lv_pmos ad=0.34p pd=2.68u as=0 ps=0 w=1u l=1u
X2533 VSS.t2087 VDD VSS.t2089 VSS.t2088 sg13_lv_nmos ad=79.8f pd=0.8u as=0 ps=0 w=0.42u l=1u
X2534 VDD VSS.t1253 VDD VDD sg13_lv_pmos ad=0.19p pd=1.38u as=0 ps=0 w=1u l=1u
X2535 VSS.t1530 VDD VSS.t1529 VSS.t1528 sg13_lv_nmos ad=0.1428p pd=1.52u as=0 ps=0 w=0.42u l=1u
X2536 VDD VSS.t2758 VDD VDD sg13_lv_pmos ad=0.19p pd=1.38u as=0 ps=0 w=1u l=1u
X2537 VSS.t2459 VDD VSS.t2458 VSS.t2457 sg13_lv_nmos ad=0.1428p pd=1.52u as=0 ps=0 w=0.42u l=1u
X2538 VDD VSS.t1489 VDD VDD sg13_lv_pmos ad=0.34p pd=2.68u as=0 ps=0 w=1u l=1u
X2539 VSS.t2689 VDD VSS.t2687 VSS.t61 sg13_lv_nmos ad=0.1428p pd=1.52u as=0 ps=0 w=0.42u l=1u
X2540 VDD VSS.t2653 VDD VDD sg13_lv_pmos ad=0.34p pd=2.68u as=0 ps=0 w=1u l=1u
X2541 VDD VSS.t2398 VDD VDD sg13_lv_pmos ad=0.34p pd=2.68u as=0 ps=0 w=1u l=1u
X2542 VSS.t836 VDD VSS.t835 VSS.t834 sg13_lv_nmos ad=0.1428p pd=1.52u as=0 ps=0 w=0.42u l=1u
X2543 VSS.t1264 VDD VSS.t1263 VSS.t70 sg13_lv_nmos ad=0.1428p pd=1.52u as=0 ps=0 w=0.42u l=1u
X2544 VDD VSS.t606 VDD VDD sg13_lv_pmos ad=0.19p pd=1.38u as=0 ps=0 w=1u l=1u
X2545 VDD VSS.t793 VDD VDD sg13_lv_pmos ad=0.19p pd=1.38u as=0 ps=0 w=1u l=1u
X2546 VSS.t740 VDD VSS.t110 VSS.t739 sg13_lv_nmos ad=0.1428p pd=1.52u as=0 ps=0 w=0.42u l=1u
X2547 VDD VSS.t2346 VDD VDD sg13_lv_pmos ad=0.19p pd=1.38u as=0 ps=0 w=1u l=1u
X2548 VDD VSS.t2004 VDD VDD sg13_lv_pmos ad=0.19p pd=1.38u as=0 ps=0 w=1u l=1u
X2549 VSS.t2007 VDD VSS.t2006 VSS.t2005 sg13_lv_nmos ad=0.1428p pd=1.52u as=0 ps=0 w=0.42u l=1u
X2550 VSS.t1294 VDD VSS.t1295 VSS.t70 sg13_lv_nmos ad=79.8f pd=0.8u as=0 ps=0 w=0.42u l=1u
X2551 a_26148_14040# a_26122_13945# VDD VDD sg13_lv_pmos ad=0.34p pd=2.68u as=0.36237p ps=2.605u w=1u l=0.13u
X2552 VDD VSS.t1201 VDD VDD sg13_lv_pmos ad=0.34p pd=2.68u as=0 ps=0 w=1u l=1u
X2553 VSS.t2985 VDD VSS.t2984 VSS.t2983 sg13_lv_nmos ad=0.1428p pd=1.52u as=0 ps=0 w=0.42u l=1u
X2554 VSS.t253 VDD VSS.t253 VSS.t475 sg13_lv_nmos ad=79.8f pd=0.8u as=0 ps=0 w=0.42u l=1u
X2555 VSS.t1021 VDD VSS.t1020 VSS.t1019 sg13_lv_nmos ad=0.1428p pd=1.52u as=0 ps=0 w=0.42u l=1u
X2556 VDD VSS.t1199 VDD VDD sg13_lv_pmos ad=0.34p pd=2.68u as=0 ps=0 w=1u l=1u
X2557 VDD VSS.t434 VDD VDD sg13_lv_pmos ad=0.34p pd=2.68u as=0 ps=0 w=1u l=1u
X2558 VSS.t1427 VDD VSS.t1300 VSS.t70 sg13_lv_nmos ad=79.8f pd=0.8u as=0 ps=0 w=0.42u l=1u
X2559 VSS.t636 VDD VSS.t639 VSS.t765 sg13_lv_nmos ad=79.8f pd=0.8u as=0 ps=0 w=0.42u l=1u
X2560 VDD VSS.t885 VDD VDD sg13_lv_pmos ad=0.34p pd=2.68u as=0 ps=0 w=1u l=1u
X2561 VDD VSS.t1462 VDD VDD sg13_lv_pmos ad=0.19p pd=1.38u as=0 ps=0 w=1u l=1u
X2562 VSS.t2766 VDD VSS.t2767 VSS.t61 sg13_lv_nmos ad=79.8f pd=0.8u as=0 ps=0 w=0.42u l=1u
X2563 VSS.t2259 VDD VSS.t2261 VSS.t2260 sg13_lv_nmos ad=79.8f pd=0.8u as=0 ps=0 w=0.42u l=1u
X2564 VSS.t2739 VDD VSS.t2737 VSS.t61 sg13_lv_nmos ad=0.1428p pd=1.52u as=0 ps=0 w=0.42u l=1u
X2565 VDD VSS.t1469 VDD VDD sg13_lv_pmos ad=0.34p pd=2.68u as=0 ps=0 w=1u l=1u
X2566 VDD VSS.t1642 VDD VDD sg13_lv_pmos ad=0.19p pd=1.38u as=0 ps=0 w=1u l=1u
X2567 VSS.t1480 VDD VSS.t1479 VSS.t1478 sg13_lv_nmos ad=0.1428p pd=1.52u as=0 ps=0 w=0.42u l=1u
X2568 VSS.t1550 VDD VSS.t1549 VSS.t1548 sg13_lv_nmos ad=0.1428p pd=1.52u as=0 ps=0 w=0.42u l=1u
X2569 sg13cmos5l_or3_1_1.C sg13cmos5l_o21ai_1_2.B1 a_24062_15242# VSS.t65 sg13_lv_nmos ad=0.2516p pd=2.16u as=0.1406p ps=1.12u w=0.74u l=0.13u
X2570 VDD VSS.t2646 VDD VDD sg13_lv_pmos ad=0.34p pd=2.68u as=0 ps=0 w=1u l=1u
X2571 VDD VSS.t948 VDD VDD sg13_lv_pmos ad=0.19p pd=1.38u as=0 ps=0 w=1u l=1u
X2572 VSS.t73 sg13cmos5l_and2_1_2.B a_8779_14832# VSS.t113 sg13_lv_nmos ad=0.1331p pd=1.12u as=0.1216p ps=1.02u w=0.64u l=0.13u
X2573 a_27407_13799# a_26565_13701# a_27313_13799# VSS.t3287 sg13_lv_nmos ad=0.12665p pd=1.145u as=0.1428p ps=1.52u w=0.42u l=0.13u
X2574 VDD VSS.t1224 VDD VDD sg13_lv_pmos ad=0.34p pd=2.68u as=0 ps=0 w=1u l=1u
X2575 VDD VSS.t1996 VDD VDD sg13_lv_pmos ad=0.34p pd=2.68u as=0 ps=0 w=1u l=1u
X2576 VDD VSS.t2366 VDD VDD sg13_lv_pmos ad=0.19p pd=1.38u as=0 ps=0 w=1u l=1u
X2577 VDD VSS.t2024 VDD VDD sg13_lv_pmos ad=0.19p pd=1.38u as=0 ps=0 w=1u l=1u
X2578 a_6660_14909# a_6372_14488# a_6598_14909# VSS.t238 sg13_lv_nmos ad=0.1428p pd=1.52u as=37.8f ps=0.6u w=0.42u l=0.13u
X2579 a_25203_13320# sg13cmos5l_a21oi_1_3.A2 VSS.t157 VSS.t156 sg13_lv_nmos ad=0.1406p pd=1.12u as=0.2516p ps=2.16u w=0.74u l=0.13u
X2580 VSS.t1670 VDD VSS.t1669 VSS.t1668 sg13_lv_nmos ad=0.1428p pd=1.52u as=0 ps=0 w=0.42u l=1u
X2581 VDD VSS.t875 VDD VDD sg13_lv_pmos ad=0.34p pd=2.68u as=0 ps=0 w=1u l=1u
X2582 VSS.t47 clock_i a_15579_14854# VSS.t3250 sg13_lv_nmos ad=0.1406p pd=1.12u as=0.1406p ps=1.12u w=0.74u l=0.13u
X2583 VDD VSS.t1290 VDD VDD sg13_lv_pmos ad=0.34p pd=2.68u as=0 ps=0 w=1u l=1u
X2584 a_17892_14909# a_18123_14495# a_17578_14452# VSS.t164 sg13_lv_nmos ad=0.2373p pd=1.97u as=79.8f ps=0.8u w=0.42u l=0.13u
X2585 a_17961_14531# a_17604_14488# VDD VDD sg13_lv_pmos ad=63f pd=0.72u as=0.1563p ps=1.22u w=0.42u l=0.13u
X2586 VDD VSS.t512 VDD VDD sg13_lv_pmos ad=0.34p pd=2.68u as=0 ps=0 w=1u l=1u
X2587 VDD VSS.t624 VDD VDD sg13_lv_pmos ad=0.19p pd=1.38u as=0 ps=0 w=1u l=1u
X2588 VSS.t1051 VDD VSS.t1053 VSS.t1052 sg13_lv_nmos ad=79.8f pd=0.8u as=0 ps=0 w=0.42u l=1u
X2589 VSS.t2479 VDD VSS.t2478 VSS.t2477 sg13_lv_nmos ad=0.1428p pd=1.52u as=0 ps=0 w=0.42u l=1u
X2590 VDD a_32492_15960# counter_value_o[6] VDD sg13_lv_pmos ad=0.2114p pd=1.54u as=0.42p ps=2.99u w=1.12u l=0.13u
X2591 VSS.t618 VDD VSS.t618 VSS.t752 sg13_lv_nmos ad=0.1428p pd=1.52u as=0 ps=0 w=0.42u l=1u
X2592 VDD VSS.t1254 VDD VDD sg13_lv_pmos ad=0.19p pd=1.38u as=0 ps=0 w=1u l=1u
X2593 VDD VSS.t2051 VDD VDD sg13_lv_pmos ad=0.34p pd=2.68u as=0 ps=0 w=1u l=1u
X2594 a_17126_15238# a_16856_15238# VSS.t64 VSS.t83 sg13_lv_nmos ad=0.1428p pd=1.52u as=79.8f ps=0.8u w=0.42u l=0.5u
X2595 VSS.t911 VDD VSS.t910 VSS.t909 sg13_lv_nmos ad=0.1428p pd=1.52u as=0 ps=0 w=0.42u l=1u
X2596 VDD VSS.t3177 VDD VDD sg13_lv_pmos ad=0.19p pd=1.38u as=0 ps=0 w=1u l=1u
X2597 VSS.t2244 VDD VSS.t2246 VSS.t2245 sg13_lv_nmos ad=79.8f pd=0.8u as=0 ps=0 w=0.42u l=1u
X2598 VSS.t1234 VDD VSS.t1235 VSS.t70 sg13_lv_nmos ad=79.8f pd=0.8u as=0 ps=0 w=0.42u l=1u
X2599 VDD VSS.t2669 VDD VDD sg13_lv_pmos ad=0.34p pd=2.68u as=0 ps=0 w=1u l=1u
X2600 VSS.t2719 VDD VSS.t2720 VSS.t61 sg13_lv_nmos ad=79.8f pd=0.8u as=0 ps=0 w=0.42u l=1u
X2601 VSS.t1465 VDD VSS.t1464 VSS.t1463 sg13_lv_nmos ad=0.1428p pd=1.52u as=0 ps=0 w=0.42u l=1u
X2602 VSS.t3212 a_21466_15202# a_21185_15424# VSS.t3211 sg13_lv_nmos ad=79.8f pd=0.8u as=0.1428p ps=1.52u w=0.42u l=0.5u
X2603 VDD VSS.t915 VDD VDD sg13_lv_pmos ad=0.34p pd=2.68u as=0 ps=0 w=1u l=1u
X2604 VDD VSS.t1474 VDD VDD sg13_lv_pmos ad=0.34p pd=2.68u as=0 ps=0 w=1u l=1u
X2605 VDD VSS.t2383 VDD VDD sg13_lv_pmos ad=0.34p pd=2.68u as=0 ps=0 w=1u l=1u
X2606 VSS.t786 VDD VSS.t785 VSS.t784 sg13_lv_nmos ad=0.1428p pd=1.52u as=0 ps=0 w=0.42u l=1u
X2607 VDD VSS.t1216 VDD VDD sg13_lv_pmos ad=0.34p pd=2.68u as=0 ps=0 w=1u l=1u
X2608 VDD VSS.t2720 VDD VDD sg13_lv_pmos ad=0.34p pd=2.68u as=0 ps=0 w=1u l=1u
X2609 VSS.t2274 VDD VSS.t2273 VSS.t2272 sg13_lv_nmos ad=0.1428p pd=1.52u as=0 ps=0 w=0.42u l=1u
X2610 VSS.t128 a_18106_15960# a_17825_16262# VSS.t3202 sg13_lv_nmos ad=79.8f pd=0.8u as=0.1428p ps=1.52u w=0.42u l=0.5u
X2611 a_32492_15960# sg13cmos5l_dfrbpq_1_7.Q VDD VDD sg13_lv_pmos ad=0.2856p pd=2.36u as=0.2114p ps=1.54u w=0.84u l=0.13u
X2612 VDD VSS.t838 VDD VDD sg13_lv_pmos ad=0.19p pd=1.38u as=0 ps=0 w=1u l=1u
X2613 VSS.t2657 VDD VSS.t2658 VSS.t61 sg13_lv_nmos ad=79.8f pd=0.8u as=0 ps=0 w=0.42u l=1u
X2614 VDD VSS.t2508 VDD VDD sg13_lv_pmos ad=0.34p pd=2.68u as=0 ps=0 w=1u l=1u
X2615 VSS.t570 VDD VSS.t572 VSS.t571 sg13_lv_nmos ad=79.8f pd=0.8u as=0 ps=0 w=0.42u l=1u
X2616 VSS.t1021 VDD VSS.t1020 VSS.t1019 sg13_lv_nmos ad=0.1428p pd=1.52u as=0 ps=0 w=0.42u l=1u
X2617 VSS.t1212 VDD VSS.t1211 VSS.t70 sg13_lv_nmos ad=0.1428p pd=1.52u as=0 ps=0 w=0.42u l=1u
X2618 VSS.t253 VDD VSS.t253 VSS.t404 sg13_lv_nmos ad=79.8f pd=0.8u as=0 ps=0 w=0.42u l=1u
X2619 VSS.t1243 VDD VSS.t1244 VSS.t70 sg13_lv_nmos ad=79.8f pd=0.8u as=0 ps=0 w=0.42u l=1u
X2620 VDD VSS.t1192 VDD VDD sg13_lv_pmos ad=0.34p pd=2.68u as=0 ps=0 w=1u l=1u
X2621 VDD VSS.t2036 VDD VDD sg13_lv_pmos ad=0.34p pd=2.68u as=0 ps=0 w=1u l=1u
X2622 VSS.t1217 VDD VSS.t1216 VSS.t70 sg13_lv_nmos ad=0.1428p pd=1.52u as=0 ps=0 w=0.42u l=1u
X2623 a_2540_15960# sg13cmos5l_dlygate4sd3_1_3.A VDD VDD sg13_lv_pmos ad=0.2856p pd=2.36u as=0.2114p ps=1.54u w=0.84u l=0.13u
X2624 VSS.t801 VDD VSS.t800 VSS.t799 sg13_lv_nmos ad=0.1428p pd=1.52u as=0 ps=0 w=0.42u l=1u
X2625 VSS.t986 VDD VSS.t988 VSS.t987 sg13_lv_nmos ad=79.8f pd=0.8u as=0 ps=0 w=0.42u l=1u
X2626 VSS.t2729 VDD VSS.t2729 VSS.t61 sg13_lv_nmos ad=0.1428p pd=1.52u as=0 ps=0 w=0.42u l=1u
X2627 VDD VSS.t2679 VDD VDD sg13_lv_pmos ad=0.34p pd=2.68u as=0 ps=0 w=1u l=1u
X2628 VDD VSS.t1984 VDD VDD sg13_lv_pmos ad=0.19p pd=1.38u as=0 ps=0 w=1u l=1u
X2629 VSS.t1169 VDD VSS.t1170 VSS.t70 sg13_lv_nmos ad=79.8f pd=0.8u as=0 ps=0 w=0.42u l=1u
X2630 VDD VSS.t1454 VDD VDD sg13_lv_pmos ad=0.34p pd=2.68u as=0 ps=0 w=1u l=1u
X2631 VDD VSS.t539 VDD VDD sg13_lv_pmos ad=0.34p pd=2.68u as=0 ps=0 w=1u l=1u
X2632 VSS.t2092 VDD VSS.t2094 VSS.t2093 sg13_lv_nmos ad=79.8f pd=0.8u as=0 ps=0 w=0.42u l=1u
X2633 VSS.t1535 VDD VSS.t1534 VSS.t1533 sg13_lv_nmos ad=0.1428p pd=1.52u as=0 ps=0 w=0.42u l=1u
X2634 VSS.t3180 VDD VSS.t3182 VSS.t3181 sg13_lv_nmos ad=79.8f pd=0.8u as=0 ps=0 w=0.42u l=1u
X2635 VDD VSS.t587 VDD VDD sg13_lv_pmos ad=0.34p pd=2.68u as=0 ps=0 w=1u l=1u
X2636 VDD VSS.t993 VDD VDD sg13_lv_pmos ad=0.19p pd=1.38u as=0 ps=0 w=1u l=1u
X2637 VDD VSS.t1494 VDD VDD sg13_lv_pmos ad=0.34p pd=2.68u as=0 ps=0 w=1u l=1u
X2638 VSS.t2692 VDD VSS.t2691 VSS.t61 sg13_lv_nmos ad=0.1428p pd=1.52u as=0 ps=0 w=0.42u l=1u
X2639 VDD VSS.t2403 VDD VDD sg13_lv_pmos ad=0.34p pd=2.68u as=0 ps=0 w=1u l=1u
X2640 VDD VSS.t1667 VDD VDD sg13_lv_pmos ad=0.19p pd=1.38u as=0 ps=0 w=1u l=1u
X2641 VSS.t417 VDD VSS.t416 VSS.t15 sg13_lv_nmos ad=0.1428p pd=1.52u as=0 ps=0 w=0.42u l=1u
X2642 VDD VSS.t805 VDD VDD sg13_lv_pmos ad=0.34p pd=2.68u as=0 ps=0 w=1u l=1u
X2643 VSS.t303 VDD VSS.t298 VSS.t302 sg13_lv_nmos ad=0.1428p pd=1.52u as=0 ps=0 w=0.42u l=1u
X2644 sg13cmos5l_xor2_1_0.X a_2490_14447# VSS.t38 VSS.t37 sg13_lv_nmos ad=0.1628p pd=1.18u as=0.3108p ps=2.32u w=0.74u l=0.13u
X2645 VSS.t575 VDD VSS.t577 VSS.t576 sg13_lv_nmos ad=79.8f pd=0.8u as=0 ps=0 w=0.42u l=1u
X2646 sg13cmos5l_dfrbpq_1_2.Q a_17994_14020# VSS.t81 VSS.t3190 sg13_lv_nmos ad=0.2516p pd=2.16u as=0.1406p ps=1.12u w=0.74u l=0.13u
X2647 VDD VSS.t2351 VDD VDD sg13_lv_pmos ad=0.19p pd=1.38u as=0 ps=0 w=1u l=1u
X2648 VDD VSS.t2009 VDD VDD sg13_lv_pmos ad=0.19p pd=1.38u as=0 ps=0 w=1u l=1u
X2649 VSS.t2012 VDD VSS.t2011 VSS.t2010 sg13_lv_nmos ad=0.1428p pd=1.52u as=0 ps=0 w=0.42u l=1u
X2650 VDD VSS.t920 VDD VDD sg13_lv_pmos ad=0.34p pd=2.68u as=0 ps=0 w=1u l=1u
X2651 VSS.t1188 VDD VSS.t1189 VSS.t70 sg13_lv_nmos ad=79.8f pd=0.8u as=0 ps=0 w=0.42u l=1u
X2652 VSS.t1225 VDD VSS.t1224 VSS.t70 sg13_lv_nmos ad=0.1428p pd=1.52u as=0 ps=0 w=0.42u l=1u
X2653 VDD VSS.t1317 VDD VDD sg13_lv_pmos ad=0.34p pd=2.68u as=0 ps=0 w=1u l=1u
X2654 VDD VSS.t512 VDD VDD sg13_lv_pmos ad=0.34p pd=2.68u as=0 ps=0 w=1u l=1u
X2655 a_9444_15552# a_9963_15356# a_10703_15311# VSS.t108 sg13_lv_nmos ad=0.3473p pd=2.71u as=0.12665p ps=1.145u w=0.74u l=0.13u
X2656 a_7888_14726# sg13cmos5l_dfrbpq_1_1.RESET_B VDD VDD sg13_lv_pmos ad=79.8f pd=0.8u as=2.42015p ps=15.68u w=0.42u l=0.13u
X2657 VSS.t648 VDD VSS.t645 VSS.t647 sg13_lv_nmos ad=0.1428p pd=1.52u as=0 ps=0 w=0.42u l=1u
X2658 VSS.t512 VDD VSS.t512 VSS.t515 sg13_lv_nmos ad=79.8f pd=0.8u as=0 ps=0 w=0.42u l=1u
X2659 VDD a_27215_14845# a_27472_14726# VDD sg13_lv_pmos ad=2.42015p pd=15.68u as=79.8f ps=0.8u w=0.42u l=0.13u
X2660 VSS.t911 VDD VSS.t910 VSS.t909 sg13_lv_nmos ad=0.1428p pd=1.52u as=0 ps=0 w=0.42u l=1u
X2661 VSS.t1193 VDD VSS.t1194 VSS.t70 sg13_lv_nmos ad=79.8f pd=0.8u as=0 ps=0 w=0.42u l=1u
X2662 VDD VSS.t2641 VDD VDD sg13_lv_pmos ad=0.19p pd=1.38u as=0 ps=0 w=1u l=1u
X2663 VDD VSS.t446 VDD VDD sg13_lv_pmos ad=0.34p pd=2.68u as=0 ps=0 w=1u l=1u
X2664 VSS.t1525 VDD VSS.t1524 VSS.t1523 sg13_lv_nmos ad=0.1428p pd=1.52u as=0 ps=0 w=0.42u l=1u
X2665 VSS.t3050 VDD VSS.t3049 VSS.t3048 sg13_lv_nmos ad=0.1428p pd=1.52u as=0 ps=0 w=0.42u l=1u
X2666 VSS.t2259 VDD VSS.t2258 VSS.t2257 sg13_lv_nmos ad=0.1428p pd=1.52u as=0 ps=0 w=0.42u l=1u
X2667 VDD a_7631_14845# a_8298_14484# VDD sg13_lv_pmos ad=0.2128p pd=1.5u as=0.3864p ps=2.93u w=1.12u l=0.13u
X2668 VSS.t956 VDD VSS.t955 VSS.t954 sg13_lv_nmos ad=0.1428p pd=1.52u as=0 ps=0 w=0.42u l=1u
X2669 VDD VSS.t820 VDD VDD sg13_lv_pmos ad=0.34p pd=2.68u as=0 ps=0 w=1u l=1u
X2670 VSS.t1261 VDD VSS.t1262 VSS.t70 sg13_lv_nmos ad=79.8f pd=0.8u as=0 ps=0 w=0.42u l=1u
X2671 VDD VSS.t3162 VDD VDD sg13_lv_pmos ad=0.19p pd=1.38u as=0 ps=0 w=1u l=1u
X2672 VDD VSS.t1647 VDD VDD sg13_lv_pmos ad=0.19p pd=1.38u as=0 ps=0 w=1u l=1u
X2673 VDD VSS.t3114 VDD VDD sg13_lv_pmos ad=0.34p pd=2.68u as=0 ps=0 w=1u l=1u
X2674 VSS.t2710 VDD VSS.t2711 VSS.t61 sg13_lv_nmos ad=79.8f pd=0.8u as=0 ps=0 w=0.42u l=1u
X2675 VSS.t786 VDD VSS.t785 VSS.t784 sg13_lv_nmos ad=0.1428p pd=1.52u as=0 ps=0 w=0.42u l=1u
X2676 VSS.t353 VDD VSS.t355 VSS.t354 sg13_lv_nmos ad=79.8f pd=0.8u as=0 ps=0 w=0.42u l=1u
X2677 VSS.t2047 VDD VSS.t2046 VSS.t2045 sg13_lv_nmos ad=0.1428p pd=1.52u as=0 ps=0 w=0.42u l=1u
X2678 a_19054_15423# a_19169_15424# VSS.t43 VSS.t42 sg13_lv_nmos ad=0.1428p pd=1.52u as=0.1426p ps=1.16u w=0.42u l=0.5u
X2679 VSS.t521 VDD VSS.t521 VSS.t523 sg13_lv_nmos ad=79.8f pd=0.8u as=0 ps=0 w=0.42u l=1u
X2680 VSS.t1016 VDD VSS.t1018 VSS.t1017 sg13_lv_nmos ad=79.8f pd=0.8u as=0 ps=0 w=0.42u l=1u
X2681 VDD VSS.t1207 VDD VDD sg13_lv_pmos ad=0.19p pd=1.38u as=0 ps=0 w=1u l=1u
X2682 VDD VSS.t1207 VDD VDD sg13_lv_pmos ad=0.34p pd=2.68u as=0 ps=0 w=1u l=1u
X2683 VDD VSS.t2711 VDD VDD sg13_lv_pmos ad=0.34p pd=2.68u as=0 ps=0 w=1u l=1u
X2684 VDD VSS.t2749 VDD VDD sg13_lv_pmos ad=0.19p pd=1.38u as=0 ps=0 w=1u l=1u
X2685 VSS.t1279 VDD VSS.t1280 VSS.t70 sg13_lv_nmos ad=79.8f pd=0.8u as=0 ps=0 w=0.42u l=1u
X2686 VSS.t1202 VDD VSS.t1203 VSS.t70 sg13_lv_nmos ad=79.8f pd=0.8u as=0 ps=0 w=0.42u l=1u
X2687 VDD VSS.t2336 VDD VDD sg13_lv_pmos ad=0.19p pd=1.38u as=0 ps=0 w=1u l=1u
X2688 VDD VSS.t883 VDD VDD sg13_lv_pmos ad=0.19p pd=1.38u as=0 ps=0 w=1u l=1u
X2689 VSS.t2648 VDD VSS.t2649 VSS.t61 sg13_lv_nmos ad=79.8f pd=0.8u as=0 ps=0 w=0.42u l=1u
X2690 VDD sg13cmos5l_nand4_1_0.Y a_14261_15238# VDD sg13_lv_pmos ad=0.203p pd=1.5u as=0.1596p ps=1.22u w=0.84u l=0.13u
X2691 VDD VSS.t593 VDD VDD sg13_lv_pmos ad=0.34p pd=2.68u as=0 ps=0 w=1u l=1u
X2692 sg13cmos5l_dfrbpq_1_1.RESET_B a_5886_15486# VDD VDD sg13_lv_pmos ad=0.3927p pd=2.99u as=2.8961p ps=18.25u w=1.155u l=0.13u
X2693 VSS.t435 VDD VSS.t434 VSS.t15 sg13_lv_nmos ad=0.1428p pd=1.52u as=0 ps=0 w=0.42u l=1u
X2694 VSS.t383 VDD VSS.t383 VSS.t386 sg13_lv_nmos ad=79.8f pd=0.8u as=0 ps=0 w=0.42u l=1u
X2695 VSS.t15 sg13cmos5l_dlygate4sd3_1_0.X a_5707_14832# VSS.t262 sg13_lv_nmos ad=0.1331p pd=1.12u as=0.1216p ps=1.02u w=0.64u l=0.13u
X2696 VSS.t801 VDD VSS.t800 VSS.t799 sg13_lv_nmos ad=0.1428p pd=1.52u as=0 ps=0 w=0.42u l=1u
X2697 VSS.t2760 VDD VSS.t2761 VSS.t61 sg13_lv_nmos ad=79.8f pd=0.8u as=0 ps=0 w=0.42u l=1u
X2698 VDD a_25390_16263# sg13cmos5l_a21oi_1_2.A1 VDD sg13_lv_pmos ad=0.2254p pd=1.53u as=0.4256p ps=3u w=1.12u l=0.13u
X2699 VSS.t986 VDD VSS.t988 VSS.t987 sg13_lv_nmos ad=79.8f pd=0.8u as=0 ps=0 w=0.42u l=1u
X2700 VDD VSS.t975 VDD VDD sg13_lv_pmos ad=0.34p pd=2.68u as=0 ps=0 w=1u l=1u
X2701 VDD VSS.t2021 VDD VDD sg13_lv_pmos ad=0.34p pd=2.68u as=0 ps=0 w=1u l=1u
X2702 VDD VSS.t282 VDD VDD sg13_lv_pmos ad=0.34p pd=2.68u as=0 ps=0 w=1u l=1u
X2703 VSS.t560 VDD VSS.t559 VSS.t558 sg13_lv_nmos ad=0.1428p pd=1.52u as=0 ps=0 w=0.42u l=1u
X2704 VDD VSS.t3147 VDD VDD sg13_lv_pmos ad=0.19p pd=1.38u as=0 ps=0 w=1u l=1u
X2705 VSS.t66 a_25094_15238# a_25206_15302# VSS.t65 sg13_lv_nmos ad=0.1426p pd=1.16u as=0.1428p ps=1.52u w=0.42u l=0.5u
X2706 VDD VSS.t399 VDD VDD sg13_lv_pmos ad=0.19p pd=1.38u as=0 ps=0 w=1u l=1u
X2707 a_9861_14521# a_9861_14521# VSS.t15 VSS.t244 sg13_lv_nmos ad=0.111p pd=1.34u as=4.11262p ps=27.15u w=0.3u l=0.13u
X2708 VDD VSS.t539 VDD VDD sg13_lv_pmos ad=0.34p pd=2.68u as=0 ps=0 w=1u l=1u
X2709 VDD VSS.t2672 VDD VDD sg13_lv_pmos ad=0.34p pd=2.68u as=0 ps=0 w=1u l=1u
X2710 a_10703_15311# a_9861_15213# a_10609_15311# VSS.t153 sg13_lv_nmos ad=0.12665p pd=1.145u as=0.1428p ps=1.52u w=0.42u l=0.13u
X2711 VDD VSS.t8 VDD VDD sg13_lv_pmos ad=0.34p pd=2.68u as=0 ps=0 w=1u l=1u
X2712 VSS.t1470 VDD VSS.t1469 VSS.t1468 sg13_lv_nmos ad=0.1428p pd=1.52u as=0 ps=0 w=0.42u l=1u
X2713 VSS.t273 VDD VSS.t273 VSS.t374 sg13_lv_nmos ad=79.8f pd=0.8u as=0 ps=0 w=0.42u l=1u
X2714 VSS.t1640 VDD VSS.t1642 VSS.t1641 sg13_lv_nmos ad=79.8f pd=0.8u as=0 ps=0 w=0.42u l=1u
X2715 VSS.t3165 VDD VSS.t3167 VSS.t3166 sg13_lv_nmos ad=79.8f pd=0.8u as=0 ps=0 w=0.42u l=1u
X2716 sg13cmos5l_buf_8_2.X a_19323_13726# VDD VDD sg13_lv_pmos ad=0.2128p pd=1.5u as=0.2128p ps=1.5u w=1.12u l=0.13u
X2717 VDD VSS.t1178 VDD VDD sg13_lv_pmos ad=0.34p pd=2.68u as=0 ps=0 w=1u l=1u
X2718 VDD VSS.t1479 VDD VDD sg13_lv_pmos ad=0.34p pd=2.68u as=0 ps=0 w=1u l=1u
X2719 VDD VSS.t2388 VDD VDD sg13_lv_pmos ad=0.34p pd=2.68u as=0 ps=0 w=1u l=1u
X2720 VSS.t444 VDD VSS.t443 VSS.t15 sg13_lv_nmos ad=0.1428p pd=1.52u as=0 ps=0 w=0.42u l=1u
X2721 VDD VSS.t850 VDD VDD sg13_lv_pmos ad=0.34p pd=2.68u as=0 ps=0 w=1u l=1u
X2722 VDD VSS.t1038 VDD VDD sg13_lv_pmos ad=0.19p pd=1.38u as=0 ps=0 w=1u l=1u
X2723 VSS.t2279 VDD VSS.t2278 VSS.t2277 sg13_lv_nmos ad=0.1428p pd=1.52u as=0 ps=0 w=0.42u l=1u
X2724 VDD VSS.t1986 VDD VDD sg13_lv_pmos ad=0.34p pd=2.68u as=0 ps=0 w=1u l=1u
X2725 VSS.t287 VDD VSS.t287 VSS.t288 sg13_lv_nmos ad=79.8f pd=0.8u as=0 ps=0 w=0.42u l=1u
X2726 a_15579_14854# clock_i VDD VDD sg13_lv_pmos ad=0.2128p pd=1.5u as=0.2128p ps=1.5u w=1.12u l=0.13u
X2727 VSS.t2449 VDD VSS.t2451 VSS.t2450 sg13_lv_nmos ad=79.8f pd=0.8u as=0 ps=0 w=0.42u l=1u
X2728 VDD VSS.t2513 VDD VDD sg13_lv_pmos ad=0.34p pd=2.68u as=0 ps=0 w=1u l=1u
X2729 VSS.t1997 VDD VSS.t1996 VSS.t1995 sg13_lv_nmos ad=0.1428p pd=1.52u as=0 ps=0 w=0.42u l=1u
X2730 VSS.t345 VDD VSS.t222 VSS.t346 sg13_lv_nmos ad=79.8f pd=0.8u as=0 ps=0 w=0.42u l=1u
X2731 VSS.t15 a_18021_14495# a_18123_14495# VSS.t14 sg13_lv_nmos ad=4.11262p pd=27.15u as=0.2516p ps=2.16u w=0.74u l=0.13u
X2732 VDD VSS.t642 VDD VDD sg13_lv_pmos ad=0.19p pd=1.38u as=0 ps=0 w=1u l=1u
X2733 VSS.t1947 VDD VSS.t1949 VSS.t1948 sg13_lv_nmos ad=79.8f pd=0.8u as=0 ps=0 w=0.42u l=1u
X2734 VDD VSS.t1669 VDD VDD sg13_lv_pmos ad=0.34p pd=2.68u as=0 ps=0 w=1u l=1u
X2735 VSS.t3035 VDD VSS.t3037 VSS.t3036 sg13_lv_nmos ad=79.8f pd=0.8u as=0 ps=0 w=0.42u l=1u
X2736 VDD sg13cmos5l_dfrbpq_1_6.RESET_B a_21034_14452# VDD sg13_lv_pmos ad=0.1563p pd=1.22u as=0.147p ps=1.54u w=0.42u l=0.13u
X2737 VDD sg13cmos5l_dlygate4sd3_1_8.X sg13cmos5l_nand4_1_0.Y VDD sg13_lv_pmos ad=0.3808p pd=2.92u as=0.2128p ps=1.5u w=1.12u l=0.13u
X2738 a_6680_15242# sg13cmos5l_dlygate4sd3_1_1.A a_6578_15242# VSS.t3230 sg13_lv_nmos ad=0.1406p pd=1.12u as=0.1406p ps=1.12u w=0.74u l=0.13u
X2739 VDD VSS.t609 VDD VDD sg13_lv_pmos ad=0.19p pd=1.38u as=0 ps=0 w=1u l=1u
X2740 VSS.t956 VDD VSS.t955 VSS.t954 sg13_lv_nmos ad=0.1428p pd=1.52u as=0 ps=0 w=0.42u l=1u
X2741 VSS.t1297 VDD VSS.t1298 VSS.t70 sg13_lv_nmos ad=79.8f pd=0.8u as=0 ps=0 w=0.42u l=1u
X2742 VSS.t1730 VDD VSS.t1732 VSS.t1731 sg13_lv_nmos ad=79.8f pd=0.8u as=0 ps=0 w=0.42u l=1u
X2743 VDD VSS.t2632 VDD VDD sg13_lv_pmos ad=0.19p pd=1.38u as=0 ps=0 w=1u l=1u
X2744 VSS.t2244 VDD VSS.t2243 VSS.t2242 sg13_lv_nmos ad=0.1428p pd=1.52u as=0 ps=0 w=0.42u l=1u
X2745 sg13cmos5l_dfrbpq_1_2.RESET_B a_15870_15486# VDD VDD sg13_lv_pmos ad=0.3927p pd=2.99u as=2.8961p ps=18.25u w=1.155u l=0.13u
X2746 VSS.t6 a_7631_14845# a_8298_14484# VSS.t140 sg13_lv_nmos ad=0.1406p pd=1.12u as=0.2516p ps=2.16u w=0.74u l=0.13u
X2747 VSS.t2733 VDD VSS.t2731 VSS.t61 sg13_lv_nmos ad=0.1428p pd=1.52u as=0 ps=0 w=0.42u l=1u
X2748 VDD VSS.t437 VDD VDD sg13_lv_pmos ad=0.34p pd=2.68u as=0 ps=0 w=1u l=1u
X2749 a_26638_15423# a_26753_15424# VSS.t41 VSS.t145 sg13_lv_nmos ad=0.1428p pd=1.52u as=0.1426p ps=1.16u w=0.42u l=0.5u
X2750 a_16068_14040# a_16587_13844# a_17327_13799# VSS.t180 sg13_lv_nmos ad=0.3473p pd=2.71u as=0.12665p ps=1.145u w=0.74u l=0.13u
X2751 VDD VSS.t3099 VDD VDD sg13_lv_pmos ad=0.34p pd=2.68u as=0 ps=0 w=1u l=1u
X2752 VSS.t2097 VDD VSS.t2099 VSS.t2098 sg13_lv_nmos ad=79.8f pd=0.8u as=0 ps=0 w=0.42u l=1u
X2753 VDD VSS.t320 VDD VDD sg13_lv_pmos ad=0.34p pd=2.68u as=0 ps=0 w=1u l=1u
X2754 VSS.t1016 VDD VSS.t1018 VSS.t1017 sg13_lv_nmos ad=79.8f pd=0.8u as=0 ps=0 w=0.42u l=1u
X2755 VDD VSS.t1269 VDD VDD sg13_lv_pmos ad=0.34p pd=2.68u as=0 ps=0 w=1u l=1u
X2756 VSS.t1660 VDD VSS.t1662 VSS.t1661 sg13_lv_nmos ad=79.8f pd=0.8u as=0 ps=0 w=0.42u l=1u
X2757 VDD VSS.t813 VDD VDD sg13_lv_pmos ad=0.19p pd=1.38u as=0 ps=0 w=1u l=1u
X2758 VDD VSS.t1005 VDD VDD sg13_lv_pmos ad=0.34p pd=2.68u as=0 ps=0 w=1u l=1u
X2759 VDD VSS.t1464 VDD VDD sg13_lv_pmos ad=0.34p pd=2.68u as=0 ps=0 w=1u l=1u
X2760 VSS.t1306 VDD VSS.t1306 VSS.t70 sg13_lv_nmos ad=79.8f pd=0.8u as=0 ps=0 w=0.42u l=1u
X2761 VDD VSS.t1727 VDD VDD sg13_lv_pmos ad=0.19p pd=1.38u as=0 ps=0 w=1u l=1u
X2762 VDD VSS.t621 VDD VDD sg13_lv_pmos ad=0.34p pd=2.68u as=0 ps=0 w=1u l=1u
X2763 VSS.t876 VDD VSS.t875 VSS.t874 sg13_lv_nmos ad=0.1428p pd=1.52u as=0 ps=0 w=0.42u l=1u
X2764 VSS.t1600 VDD VSS.t1599 VSS.t1598 sg13_lv_nmos ad=0.1428p pd=1.52u as=0 ps=0 w=0.42u l=1u
X2765 VDD VSS.t2498 VDD VDD sg13_lv_pmos ad=0.34p pd=2.68u as=0 ps=0 w=1u l=1u
X2766 VDD VSS.t2321 VDD VDD sg13_lv_pmos ad=0.19p pd=1.38u as=0 ps=0 w=1u l=1u
X2767 VSS.t1214 VDD VSS.t1215 VSS.t70 sg13_lv_nmos ad=79.8f pd=0.8u as=0 ps=0 w=0.42u l=1u
X2768 VDD VSS.t303 VDD VDD sg13_lv_pmos ad=0.34p pd=2.68u as=0 ps=0 w=1u l=1u
X2769 VDD a_6286_13911# sg13cmos5l_dlygate4sd3_1_0.X VDD sg13_lv_pmos ad=0.2254p pd=1.53u as=0.4256p ps=3u w=1.12u l=0.13u
X2770 a_26505_14113# a_26148_14040# VDD VDD sg13_lv_pmos ad=63f pd=0.72u as=0.1563p ps=1.22u w=0.42u l=0.13u
X2771 VSS.t1310 VDD VSS.t1312 VSS.t70 sg13_lv_nmos ad=79.8f pd=0.8u as=0 ps=0 w=0.42u l=1u
X2772 VDD VSS.t2074 VDD VDD sg13_lv_pmos ad=0.19p pd=1.38u as=0 ps=0 w=1u l=1u
X2773 VDD VSS.t537 VDD VDD sg13_lv_pmos ad=0.19p pd=1.38u as=0 ps=0 w=1u l=1u
X2774 VSS.t57 sg13cmos5l_o21ai_1_2.Y a_24824_15238# VSS.t65 sg13_lv_nmos ad=79.8f pd=0.8u as=0.1428p ps=1.52u w=0.42u l=0.13u
X2775 VDD VSS.t1849 VDD VDD sg13_lv_pmos ad=0.19p pd=1.38u as=0 ps=0 w=1u l=1u
X2776 VSS.t1892 VDD VSS.t1894 VSS.t1893 sg13_lv_nmos ad=79.8f pd=0.8u as=0 ps=0 w=0.42u l=1u
X2777 VSS.t64 sg13cmos5l_inv_1_0.Y a_16596_15280# VSS.t3254 sg13_lv_nmos ad=0.2272p pd=1.99u as=78.39999f ps=0.885u w=0.64u l=0.13u
X2778 VSS.t2434 VDD VSS.t2436 VSS.t2435 sg13_lv_nmos ad=79.8f pd=0.8u as=0 ps=0 w=0.42u l=1u
X2779 VDD VSS.t512 VDD VDD sg13_lv_pmos ad=0.34p pd=2.68u as=0 ps=0 w=1u l=1u
X2780 VDD VSS.t2376 VDD VDD sg13_lv_pmos ad=0.19p pd=1.38u as=0 ps=0 w=1u l=1u
X2781 a_15782_13722# sg13cmos5l_dfrbpq_1_2.D VDD VDD sg13_lv_pmos ad=79.8f pd=0.8u as=0.1428p ps=1.52u w=0.42u l=0.13u
X2782 VSS.t2713 VDD VSS.t2714 VSS.t61 sg13_lv_nmos ad=79.8f pd=0.8u as=0 ps=0 w=0.42u l=1u
X2783 a_4474_14448# sg13cmos5l_dlygate4sd3_1_3.A VDD VDD sg13_lv_pmos ad=0.1428p pd=1.52u as=0.1523p ps=1.38u w=0.42u l=0.13u
X2784 VDD VSS.t968 VDD VDD sg13_lv_pmos ad=0.19p pd=1.38u as=0 ps=0 w=1u l=1u
X2785 VSS.t1455 VDD VSS.t1454 VSS.t1453 sg13_lv_nmos ad=0.1428p pd=1.52u as=0 ps=0 w=0.42u l=1u
X2786 VSS.t1982 VDD VSS.t1984 VSS.t1983 sg13_lv_nmos ad=79.8f pd=0.8u as=0 ps=0 w=0.42u l=1u
X2787 VSS.t836 VDD VSS.t838 VSS.t837 sg13_lv_nmos ad=79.8f pd=0.8u as=0 ps=0 w=0.42u l=1u
X2788 VDD VSS.t1210 VDD VDD sg13_lv_pmos ad=0.34p pd=2.68u as=0 ps=0 w=1u l=1u
X2789 VDD VSS.t2714 VDD VDD sg13_lv_pmos ad=0.34p pd=2.68u as=0 ps=0 w=1u l=1u
X2790 a_27500_15960# sg13cmos5l_dfrbpq_1_6.Q VDD VDD sg13_lv_pmos ad=0.2856p pd=2.36u as=0.2114p ps=1.54u w=0.84u l=0.13u
X2791 VSS.t2264 VDD VSS.t2263 VSS.t2262 sg13_lv_nmos ad=0.1428p pd=1.52u as=0 ps=0 w=0.42u l=1u
X2792 VDD VSS.t445 VDD VDD sg13_lv_pmos ad=0.19p pd=1.38u as=0 ps=0 w=1u l=1u
X2793 VDD VSS.t895 VDD VDD sg13_lv_pmos ad=0.34p pd=2.68u as=0 ps=0 w=1u l=1u
X2794 VSS.t2651 VDD VSS.t2652 VSS.t61 sg13_lv_nmos ad=79.8f pd=0.8u as=0 ps=0 w=0.42u l=1u
X2795 VSS.t2112 VDD VSS.t2111 VSS.t2110 sg13_lv_nmos ad=0.1428p pd=1.52u as=0 ps=0 w=0.42u l=1u
X2796 VSS.t1932 VDD VSS.t1934 VSS.t1933 sg13_lv_nmos ad=79.8f pd=0.8u as=0 ps=0 w=0.42u l=1u
X2797 VDD VSS.t521 VDD VDD sg13_lv_pmos ad=0.34p pd=2.68u as=0 ps=0 w=1u l=1u
X2798 VDD VSS.t636 VDD VDD sg13_lv_pmos ad=0.19p pd=1.38u as=0 ps=0 w=1u l=1u
X2799 VSS.t3020 VDD VSS.t3022 VSS.t3021 sg13_lv_nmos ad=79.8f pd=0.8u as=0 ps=0 w=0.42u l=1u
X2800 VDD sg13cmos5l_dfrbpq_1_6.RESET_B a_20774_14922# VDD sg13_lv_pmos ad=0.36237p pd=2.605u as=79.8f ps=0.8u w=0.42u l=0.13u
X2801 VSS.t630 VDD VSS.t630 VSS.t760 sg13_lv_nmos ad=0.1428p pd=1.52u as=0 ps=0 w=0.42u l=1u
X2802 VDD VSS.t2962 VDD VDD sg13_lv_pmos ad=0.19p pd=1.38u as=0 ps=0 w=1u l=1u
X2803 a_2516_14484# sg13cmos5l_buf_1_0.X VDD VDD sg13_lv_pmos ad=0.3808p pd=2.92u as=0.2128p ps=1.5u w=1.12u l=0.13u
X2804 VSS.t2454 VDD VSS.t2453 VSS.t2452 sg13_lv_nmos ad=0.1428p pd=1.52u as=0 ps=0 w=0.42u l=1u
X2805 VSS.t1715 VDD VSS.t1717 VSS.t1716 sg13_lv_nmos ad=79.8f pd=0.8u as=0 ps=0 w=0.42u l=1u
X2806 VSS.t575 VDD VSS.t577 VSS.t576 sg13_lv_nmos ad=79.8f pd=0.8u as=0 ps=0 w=0.42u l=1u
X2807 VDD VSS.t2368 VDD VDD sg13_lv_pmos ad=0.34p pd=2.68u as=0 ps=0 w=1u l=1u
X2808 a_26313_14531# a_25956_14488# VDD VDD sg13_lv_pmos ad=63f pd=0.72u as=0.1563p ps=1.22u w=0.42u l=0.13u
X2809 VSS.t1246 VDD VSS.t1247 VSS.t70 sg13_lv_nmos ad=79.8f pd=0.8u as=0 ps=0 w=0.42u l=1u
X2810 VDD VSS.t2026 VDD VDD sg13_lv_pmos ad=0.34p pd=2.68u as=0 ps=0 w=1u l=1u
X2811 VDD VSS.t3152 VDD VDD sg13_lv_pmos ad=0.19p pd=1.38u as=0 ps=0 w=1u l=1u
X2812 VDD VSS.t2674 VDD VDD sg13_lv_pmos ad=0.34p pd=2.68u as=0 ps=0 w=1u l=1u
X2813 VSS.t15 a_9737_14822# a_9658_14725# VSS.t25 sg13_lv_nmos ad=4.11262p pd=27.15u as=0.27427p ps=2.28u w=0.795u l=0.13u
X2814 VDD VSS.t1296 VDD VDD sg13_lv_pmos ad=0.34p pd=2.68u as=0 ps=0 w=1u l=1u
X2815 VSS.t1179 VDD VSS.t1178 VSS.t70 sg13_lv_nmos ad=0.1428p pd=1.52u as=0 ps=0 w=0.42u l=1u
X2816 VSS.t1585 VDD VSS.t1587 VSS.t1586 sg13_lv_nmos ad=79.8f pd=0.8u as=0 ps=0 w=0.42u l=1u
X2817 VSS.t1645 VDD VSS.t1647 VSS.t1646 sg13_lv_nmos ad=79.8f pd=0.8u as=0 ps=0 w=0.42u l=1u
X2818 VSS.t3170 VDD VSS.t3172 VSS.t3171 sg13_lv_nmos ad=79.8f pd=0.8u as=0 ps=0 w=0.42u l=1u
X2819 VSS.t2082 VDD VSS.t2084 VSS.t2083 sg13_lv_nmos ad=79.8f pd=0.8u as=0 ps=0 w=0.42u l=1u
X2820 VSS.t806 VDD VSS.t805 VSS.t804 sg13_lv_nmos ad=0.1428p pd=1.52u as=0 ps=0 w=0.42u l=1u
X2821 VSS.t2780 VDD VSS.t2779 VSS.t61 sg13_lv_nmos ad=0.1428p pd=1.52u as=0 ps=0 w=0.42u l=1u
X2822 VDD VSS.t425 VDD VDD sg13_lv_pmos ad=0.34p pd=2.68u as=0 ps=0 w=1u l=1u
X2823 VSS.t876 VDD VSS.t875 VSS.t874 sg13_lv_nmos ad=0.1428p pd=1.52u as=0 ps=0 w=0.42u l=1u
X2824 VSS.t1172 VDD VSS.t1173 VSS.t70 sg13_lv_nmos ad=79.8f pd=0.8u as=0 ps=0 w=0.42u l=1u
X2825 a_21549_14020# sg13cmos5l_or3_1_2.B a_21460_14020# VDD sg13_lv_pmos ad=0.19p pd=1.38u as=0.1575p ps=1.315u w=1u l=0.13u
X2826 VDD VSS.t1712 VDD VDD sg13_lv_pmos ad=0.19p pd=1.38u as=0 ps=0 w=1u l=1u
X2827 VSS.t2249 VDD VSS.t2248 VSS.t2247 sg13_lv_nmos ad=0.1428p pd=1.52u as=0 ps=0 w=0.42u l=1u
X2828 VSS.t693 VDD VSS.t695 VSS.t694 sg13_lv_nmos ad=79.8f pd=0.8u as=0 ps=0 w=0.42u l=1u
X2829 VDD VSS.t256 VDD VDD sg13_lv_pmos ad=0.34p pd=2.68u as=0 ps=0 w=1u l=1u
X2830 VDD VSS.t615 VDD VDD sg13_lv_pmos ad=0.34p pd=2.68u as=0 ps=0 w=1u l=1u
X2831 VDD VSS.t998 VDD VDD sg13_lv_pmos ad=0.19p pd=1.38u as=0 ps=0 w=1u l=1u
X2832 VDD VSS.t1664 VDD VDD sg13_lv_pmos ad=0.34p pd=2.68u as=0 ps=0 w=1u l=1u
X2833 VSS.t2643 VDD VSS.t2644 VSS.t61 sg13_lv_nmos ad=79.8f pd=0.8u as=0 ps=0 w=0.42u l=1u
X2834 VSS.t2722 VDD VSS.t2721 VSS.t61 sg13_lv_nmos ad=0.1428p pd=1.52u as=0 ps=0 w=0.42u l=1u
X2835 VDD VSS.t2483 VDD VDD sg13_lv_pmos ad=0.34p pd=2.68u as=0 ps=0 w=1u l=1u
X2836 VSS.t1952 VDD VSS.t1954 VSS.t1953 sg13_lv_nmos ad=79.8f pd=0.8u as=0 ps=0 w=0.42u l=1u
X2837 VDD VSS.t282 VDD VDD sg13_lv_pmos ad=0.19p pd=1.38u as=0 ps=0 w=1u l=1u
X2838 VDD a_21251_13690# sg13cmos5l_or3_1_2.X VDD sg13_lv_pmos ad=0.3822p pd=1.84u as=0.3808p ps=2.92u w=1.12u l=0.13u
X2839 VDD VSS.t537 VDD VDD sg13_lv_pmos ad=0.19p pd=1.38u as=0 ps=0 w=1u l=1u
X2840 VSS.t142 VDD VSS.t532 VSS.t667 sg13_lv_nmos ad=0.1428p pd=1.52u as=0 ps=0 w=0.42u l=1u
X2841 VSS.t1228 VDD VSS.t1227 VSS.t70 sg13_lv_nmos ad=0.1428p pd=1.52u as=0 ps=0 w=0.42u l=1u
X2842 sg13cmos5l_xnor2_1_2.B sg13cmos5l_buf_1_0.X a_6202_15238# VSS.t3289 sg13_lv_nmos ad=0.2516p pd=2.16u as=0.1406p ps=1.12u w=0.74u l=0.13u
X2843 sg13cmos5l_xnor2_1_0.Y a_7680_15549# a_7829_15238# VSS.t3294 sg13_lv_nmos ad=0.2516p pd=2.16u as=0.1406p ps=1.12u w=0.74u l=0.13u
X2844 VDD VSS.t1320 VDD VDD sg13_lv_pmos ad=0.34p pd=2.68u as=0 ps=0 w=1u l=1u
X2845 VSS.t2965 VDD VSS.t2967 VSS.t2966 sg13_lv_nmos ad=79.8f pd=0.8u as=0 ps=0 w=0.42u l=1u
X2846 VDD VSS.t512 VDD VDD sg13_lv_pmos ad=0.34p pd=2.68u as=0 ps=0 w=1u l=1u
X2847 VDD VSS.t434 VDD VDD sg13_lv_pmos ad=0.34p pd=2.68u as=0 ps=0 w=1u l=1u
X2848 sg13cmos5l_a21oi_1_3.B1 sg13cmos5l_buf_1_10.X VDD VDD sg13_lv_pmos ad=0.3808p pd=2.92u as=0.3808p ps=2.92u w=1.12u l=0.13u
X2849 VDD VSS.t2707 VDD VDD sg13_lv_pmos ad=0.19p pd=1.38u as=0 ps=0 w=1u l=1u
X2850 VSS.t612 VDD VSS.t612 VSS.t613 sg13_lv_nmos ad=79.8f pd=0.8u as=0 ps=0 w=0.42u l=1u
X2851 VDD VSS.t1013 VDD VDD sg13_lv_pmos ad=0.19p pd=1.38u as=0 ps=0 w=1u l=1u
X2852 VDD VSS.t3104 VDD VDD sg13_lv_pmos ad=0.34p pd=2.68u as=0 ps=0 w=1u l=1u
X2853 VSS.t2374 VDD VSS.t2373 VSS.t2372 sg13_lv_nmos ad=0.1428p pd=1.52u as=0 ps=0 w=0.42u l=1u
X2854 VSS.t2067 VDD VSS.t2069 VSS.t2068 sg13_lv_nmos ad=79.8f pd=0.8u as=0 ps=0 w=0.42u l=1u
X2855 VDD VSS.t585 VDD VDD sg13_lv_pmos ad=0.34p pd=2.68u as=0 ps=0 w=1u l=1u
X2856 VSS.t836 VDD VSS.t838 VSS.t837 sg13_lv_nmos ad=79.8f pd=0.8u as=0 ps=0 w=0.42u l=1u
X2857 VDD VSS.t1469 VDD VDD sg13_lv_pmos ad=0.34p pd=2.68u as=0 ps=0 w=1u l=1u
X2858 VDD VSS.t2378 VDD VDD sg13_lv_pmos ad=0.34p pd=2.68u as=0 ps=0 w=1u l=1u
X2859 VSS.t560 VDD VSS.t559 VSS.t558 sg13_lv_nmos ad=0.1428p pd=1.52u as=0 ps=0 w=0.42u l=1u
X2860 VDD VSS.t1642 VDD VDD sg13_lv_pmos ad=0.19p pd=1.38u as=0 ps=0 w=1u l=1u
X2861 VDD VSS.t1697 VDD VDD sg13_lv_pmos ad=0.19p pd=1.38u as=0 ps=0 w=1u l=1u
X2862 VDD VSS.t1889 VDD VDD sg13_lv_pmos ad=0.19p pd=1.38u as=0 ps=0 w=1u l=1u
X2863 a_27034_15202# sg13cmos5l_dfrbpq_1_7.Q VSS.t28 VSS.t15 sg13_lv_nmos ad=0.1428p pd=1.52u as=79.8f ps=0.8u w=0.42u l=0.13u
X2864 VSS.t1987 VDD VSS.t1986 VSS.t1985 sg13_lv_nmos ad=0.1428p pd=1.52u as=0 ps=0 w=0.42u l=1u
X2865 VDD VSS.t1329 VDD VDD sg13_lv_pmos ad=0.34p pd=2.68u as=0 ps=0 w=1u l=1u
X2866 VSS.t535 VDD VSS.t537 VSS.t536 sg13_lv_nmos ad=79.8f pd=0.8u as=0 ps=0 w=0.42u l=1u
X2867 VDD VSS.t521 VDD VDD sg13_lv_pmos ad=0.34p pd=2.68u as=0 ps=0 w=1u l=1u
X2868 VSS.t2097 VDD VSS.t2096 VSS.t2095 sg13_lv_nmos ad=0.1428p pd=1.52u as=0 ps=0 w=0.42u l=1u
X2869 VSS.t211 VDD VSS.t216 VSS.t711 sg13_lv_nmos ad=79.8f pd=0.8u as=0 ps=0 w=0.42u l=1u
X2870 VSS.t976 VDD VSS.t975 VSS.t974 sg13_lv_nmos ad=0.1428p pd=1.52u as=0 ps=0 w=0.42u l=1u
X2871 VSS.t1897 VDD VSS.t1899 VSS.t1898 sg13_lv_nmos ad=79.8f pd=0.8u as=0 ps=0 w=0.42u l=1u
X2872 VSS.t1272 VDD VSS.t1273 VSS.t70 sg13_lv_nmos ad=79.8f pd=0.8u as=0 ps=0 w=0.42u l=1u
X2873 VSS.t2754 VDD VSS.t2755 VSS.t61 sg13_lv_nmos ad=79.8f pd=0.8u as=0 ps=0 w=0.42u l=1u
X2874 VSS.t2439 VDD VSS.t2441 VSS.t2440 sg13_lv_nmos ad=79.8f pd=0.8u as=0 ps=0 w=0.42u l=1u
X2875 VDD VSS.t3137 VDD VDD sg13_lv_pmos ad=0.19p pd=1.38u as=0 ps=0 w=1u l=1u
X2876 a_20705_15260# sg13cmos5l_dlygate4sd3_1_9.X sg13cmos5l_a21oi_1_1.Y VSS.t42 sg13_lv_nmos ad=0.1406p pd=1.12u as=0.1406p ps=1.12u w=0.74u l=0.13u
X2877 VSS.t806 VDD VSS.t805 VSS.t804 sg13_lv_nmos ad=0.1428p pd=1.52u as=0 ps=0 w=0.42u l=1u
X2878 VSS.t2309 VDD VSS.t2308 VSS.t2307 sg13_lv_nmos ad=0.1428p pd=1.52u as=0 ps=0 w=0.42u l=1u
X2879 VSS.t1570 VDD VSS.t1572 VSS.t1571 sg13_lv_nmos ad=79.8f pd=0.8u as=0 ps=0 w=0.42u l=1u
X2880 VSS.t1036 VDD VSS.t1038 VSS.t1037 sg13_lv_nmos ad=79.8f pd=0.8u as=0 ps=0 w=0.42u l=1u
X2881 VDD VSS.t606 VDD VDD sg13_lv_pmos ad=0.34p pd=2.68u as=0 ps=0 w=1u l=1u
X2882 VDD VSS.t3007 VDD VDD sg13_lv_pmos ad=0.19p pd=1.38u as=0 ps=0 w=1u l=1u
X2883 VDD VSS.t1874 VDD VDD sg13_lv_pmos ad=0.19p pd=1.38u as=0 ps=0 w=1u l=1u
X2884 VDD VSS.t344 VDD VDD sg13_lv_pmos ad=0.34p pd=2.68u as=0 ps=0 w=1u l=1u
X2885 VDD sg13cmos5l_dfrbpq_1_3.RESET_B a_17578_14452# VDD sg13_lv_pmos ad=0.1563p pd=1.22u as=0.147p ps=1.54u w=0.42u l=0.13u
X2886 a_26122_13945# a_26565_13701# a_25862_13722# VSS.t3285 sg13_lv_nmos ad=79.8f pd=0.8u as=0.1296p ps=1.52u w=0.42u l=0.13u
X2887 VSS.t1725 VDD VSS.t1727 VSS.t1726 sg13_lv_nmos ad=79.8f pd=0.8u as=0 ps=0 w=0.42u l=1u
X2888 VDD VSS.t1649 VDD VDD sg13_lv_pmos ad=0.34p pd=2.68u as=0 ps=0 w=1u l=1u
X2889 VSS.t2634 VDD VSS.t2635 VSS.t61 sg13_lv_nmos ad=79.8f pd=0.8u as=0 ps=0 w=0.42u l=1u
X2890 VSS.t2117 VDD VSS.t2116 VSS.t2115 sg13_lv_nmos ad=0.1428p pd=1.52u as=0 ps=0 w=0.42u l=1u
X2891 VSS.t1937 VDD VSS.t1939 VSS.t1938 sg13_lv_nmos ad=79.8f pd=0.8u as=0 ps=0 w=0.42u l=1u
X2892 VSS.t447 VDD VSS.t446 VSS.t15 sg13_lv_nmos ad=0.1428p pd=1.52u as=0 ps=0 w=0.42u l=1u
X2893 VSS.t3025 VDD VSS.t3027 VSS.t3026 sg13_lv_nmos ad=79.8f pd=0.8u as=0 ps=0 w=0.42u l=1u
X2894 VDD VSS.t2790 VDD VDD sg13_lv_pmos ad=0.19p pd=1.38u as=0 ps=0 w=1u l=1u
X2895 VSS.t6 sg13cmos5l_xnor2_1_0.Y a_8312_15238# VSS.t3183 sg13_lv_nmos ad=79.8f pd=0.8u as=0.1428p ps=1.52u w=0.42u l=0.13u
X2896 VDD sg13cmos5l_buf_8_2.A a_19323_13726# VDD sg13_lv_pmos ad=0.2128p pd=1.5u as=0.2128p ps=1.5u w=1.12u l=0.13u
X2897 sg13cmos5l_a21oi_1_3.A2 a_24169_14508# VDD VDD sg13_lv_pmos ad=0.3808p pd=2.92u as=0.3822p ps=1.84u w=1.12u l=0.13u
X2898 VSS.t1255 VDD VSS.t1254 VSS.t70 sg13_lv_nmos ad=0.1428p pd=1.52u as=0 ps=0 w=0.42u l=1u
X2899 VSS.t1720 VDD VSS.t1722 VSS.t1721 sg13_lv_nmos ad=79.8f pd=0.8u as=0 ps=0 w=0.42u l=1u
X2900 VDD VSS.t2241 VDD VDD sg13_lv_pmos ad=0.19p pd=1.38u as=0 ps=0 w=1u l=1u
X2901 VDD VSS.t2338 VDD VDD sg13_lv_pmos ad=0.34p pd=2.68u as=0 ps=0 w=1u l=1u
X2902 VDD VSS.t2031 VDD VDD sg13_lv_pmos ad=0.34p pd=2.68u as=0 ps=0 w=1u l=1u
X2903 VDD VSS.t3157 VDD VDD sg13_lv_pmos ad=0.19p pd=1.38u as=0 ps=0 w=1u l=1u
X2904 VSS.t1847 VDD VSS.t1849 VSS.t1848 sg13_lv_nmos ad=79.8f pd=0.8u as=0 ps=0 w=0.42u l=1u
X2905 VSS.t27 a_22030_15423# sg13cmos5l_or3_1_2.A VSS.t150 sg13_lv_nmos ad=0.1426p pd=1.16u as=0.2516p ps=2.16u w=0.74u l=0.13u
X2906 VSS.t1297 VDD VSS.t1296 VSS.t70 sg13_lv_nmos ad=0.1428p pd=1.52u as=0 ps=0 w=0.42u l=1u
X2907 VDD VSS.t579 VDD VDD sg13_lv_pmos ad=0.34p pd=2.68u as=0 ps=0 w=1u l=1u
X2908 VSS.t92 a_16485_13701# a_16587_13844# VSS.t91 sg13_lv_nmos ad=15.38618p pd=0.10091m as=0.2516p ps=2.16u w=0.74u l=0.13u
X2909 VSS.t170 VDD VSS.t528 VSS.t664 sg13_lv_nmos ad=0.1428p pd=1.52u as=0 ps=0 w=0.42u l=1u
X2910 VDD VSS.t1979 VDD VDD sg13_lv_pmos ad=0.19p pd=1.38u as=0 ps=0 w=1u l=1u
X2911 VSS.t1006 VDD VSS.t1005 VSS.t1004 sg13_lv_nmos ad=0.1428p pd=1.52u as=0 ps=0 w=0.42u l=1u
X2912 VSS.t311 VDD VSS.t136 VSS.t310 sg13_lv_nmos ad=0.1428p pd=1.52u as=0 ps=0 w=0.42u l=1u
X2913 VSS.t192 a_12010_15202# sg13cmos5l_dfrbpq_1_2.CLK VSS.t191 sg13_lv_nmos ad=0.1406p pd=1.12u as=0.1406p ps=1.12u w=0.74u l=0.13u
X2914 VSS.t1912 VDD VSS.t1911 VSS.t1910 sg13_lv_nmos ad=0.1428p pd=1.52u as=0 ps=0 w=0.42u l=1u
X2915 VDD VSS.t870 VDD VDD sg13_lv_pmos ad=0.34p pd=2.68u as=0 ps=0 w=1u l=1u
X2916 VDD VSS.t1454 VDD VDD sg13_lv_pmos ad=0.34p pd=2.68u as=0 ps=0 w=1u l=1u
X2917 VSS.t2763 VDD VSS.t2761 VSS.t61 sg13_lv_nmos ad=0.1428p pd=1.52u as=0 ps=0 w=0.42u l=1u
X2918 VDD VSS.t848 VDD VDD sg13_lv_pmos ad=0.19p pd=1.38u as=0 ps=0 w=1u l=1u
X2919 a_11122_15234# sg13cmos5l_tiehi_1.L_HI VSS.t53 VSS.t223 sg13_lv_nmos ad=37.8f pd=0.6u as=79.8f ps=0.8u w=0.42u l=0.13u
X2920 VSS.t2254 VDD VSS.t2253 VSS.t2252 sg13_lv_nmos ad=0.1428p pd=1.52u as=0 ps=0 w=0.42u l=1u
X2921 sg13cmos5l_or3_1_2.C sg13cmos5l_dfrbpq_1_3.Q a_20218_15238# VSS.t42 sg13_lv_nmos ad=0.2516p pd=2.16u as=0.1406p ps=1.12u w=0.74u l=0.13u
X2922 VSS.t1710 VDD VSS.t1712 VSS.t1711 sg13_lv_nmos ad=79.8f pd=0.8u as=0 ps=0 w=0.42u l=1u
X2923 VSS.t1515 VDD VSS.t1517 VSS.t1516 sg13_lv_nmos ad=79.8f pd=0.8u as=0 ps=0 w=0.42u l=1u
X2924 VSS.t2424 VDD VSS.t2426 VSS.t2425 sg13_lv_nmos ad=79.8f pd=0.8u as=0 ps=0 w=0.42u l=1u
X2925 VSS.t2725 VDD VSS.t2723 VSS.t61 sg13_lv_nmos ad=0.1428p pd=1.52u as=0 ps=0 w=0.42u l=1u
X2926 a_16175_15238# sg13cmos5l_inv_1_0.Y VSS.t47 VSS.t3255 sg13_lv_nmos ad=0.2516p pd=2.16u as=0.1898p ps=1.36u w=0.74u l=0.13u
X2927 VSS.t976 VDD VSS.t975 VSS.t974 sg13_lv_nmos ad=0.1428p pd=1.52u as=0 ps=0 w=0.42u l=1u
X2928 VDD VSS.t2952 VDD VDD sg13_lv_pmos ad=0.19p pd=1.38u as=0 ps=0 w=1u l=1u
X2929 VSS.t414 VDD VSS.t413 VSS.t15 sg13_lv_nmos ad=0.1428p pd=1.52u as=0 ps=0 w=0.42u l=1u
X2930 VDD VSS.t933 VDD VDD sg13_lv_pmos ad=0.19p pd=1.38u as=0 ps=0 w=1u l=1u
X2931 VSS.t881 VDD VSS.t883 VSS.t882 sg13_lv_nmos ad=79.8f pd=0.8u as=0 ps=0 w=0.42u l=1u
X2932 VDD VSS.t2406 VDD VDD sg13_lv_pmos ad=0.19p pd=1.38u as=0 ps=0 w=1u l=1u
X2933 VSS.t2067 VDD VSS.t2066 VSS.t2065 sg13_lv_nmos ad=0.1428p pd=1.52u as=0 ps=0 w=0.42u l=1u
X2934 VDD VSS.t2064 VDD VDD sg13_lv_pmos ad=0.19p pd=1.38u as=0 ps=0 w=1u l=1u
X2935 VSS.t397 VDD VSS.t399 VSS.t398 sg13_lv_nmos ad=79.8f pd=0.8u as=0 ps=0 w=0.42u l=1u
X2936 VSS.t1882 VDD VSS.t1884 VSS.t1883 sg13_lv_nmos ad=79.8f pd=0.8u as=0 ps=0 w=0.42u l=1u
X2937 VSS.t172 a_21251_13690# sg13cmos5l_or3_1_2.X VSS.t171 sg13_lv_nmos ad=0.13395p pd=1.12u as=0.2516p ps=2.16u w=0.74u l=0.13u
X2938 VDD VSS.t449 VDD VDD sg13_lv_pmos ad=0.34p pd=2.68u as=0 ps=0 w=1u l=1u
X2939 VDD VSS.t542 VDD VDD sg13_lv_pmos ad=0.19p pd=1.38u as=0 ps=0 w=1u l=1u
X2940 VDD a_4175_15311# a_4842_15532# VDD sg13_lv_pmos ad=0.2128p pd=1.5u as=0.3864p ps=2.93u w=1.12u l=0.13u
X2941 VDD a_10222_14751# sg13cmos5l_dlygate4sd3_1_8.X VDD sg13_lv_pmos ad=0.2254p pd=1.53u as=0.4256p ps=3u w=1.12u l=0.13u
X2942 VDD VSS.t1281 VDD VDD sg13_lv_pmos ad=0.34p pd=2.68u as=0 ps=0 w=1u l=1u
X2943 VDD VSS.t1512 VDD VDD sg13_lv_pmos ad=0.19p pd=1.38u as=0 ps=0 w=1u l=1u
X2944 VSS.t1036 VDD VSS.t1038 VSS.t1037 sg13_lv_nmos ad=79.8f pd=0.8u as=0 ps=0 w=0.42u l=1u
X2945 VSS.t187 a_12010_15202# sg13cmos5l_dfrbpq_1_2.CLK VSS.t186 sg13_lv_nmos ad=0.1406p pd=1.12u as=0.1406p ps=1.12u w=0.74u l=0.13u
X2946 VSS.t2669 VDD VSS.t2670 VSS.t61 sg13_lv_nmos ad=79.8f pd=0.8u as=0 ps=0 w=0.42u l=1u
X2947 VDD VSS.t633 VDD VDD sg13_lv_pmos ad=0.34p pd=2.68u as=0 ps=0 w=1u l=1u
X2948 VDD VSS.t1647 VDD VDD sg13_lv_pmos ad=0.19p pd=1.38u as=0 ps=0 w=1u l=1u
X2949 sg13cmos5l_dfrbpq_1_5.Q a_28074_14020# VDD VDD sg13_lv_pmos ad=0.3808p pd=2.92u as=0.2128p ps=1.5u w=1.12u l=0.13u
X2950 VDD VSS.t1702 VDD VDD sg13_lv_pmos ad=0.19p pd=1.38u as=0 ps=0 w=1u l=1u
X2951 VDD VSS.t2992 VDD VDD sg13_lv_pmos ad=0.19p pd=1.38u as=0 ps=0 w=1u l=1u
X2952 VDD VSS.t3169 VDD VDD sg13_lv_pmos ad=0.34p pd=2.68u as=0 ps=0 w=1u l=1u
X2953 VDD VSS.t1859 VDD VDD sg13_lv_pmos ad=0.19p pd=1.38u as=0 ps=0 w=1u l=1u
X2954 VSS.t2444 VDD VSS.t2446 VSS.t2445 sg13_lv_nmos ad=79.8f pd=0.8u as=0 ps=0 w=0.42u l=1u
X2955 VDD VSS.t2782 VDD VDD sg13_lv_pmos ad=0.19p pd=1.38u as=0 ps=0 w=1u l=1u
X2956 VSS.t2102 VDD VSS.t2101 VSS.t2100 sg13_lv_nmos ad=0.1428p pd=1.52u as=0 ps=0 w=0.42u l=1u
X2957 VDD VSS.t903 VDD VDD sg13_lv_pmos ad=0.19p pd=1.38u as=0 ps=0 w=1u l=1u
X2958 VSS.t1665 VDD VSS.t1664 VSS.t1663 sg13_lv_nmos ad=0.1428p pd=1.52u as=0 ps=0 w=0.42u l=1u
X2959 VDD VSS.t2391 VDD VDD sg13_lv_pmos ad=0.19p pd=1.38u as=0 ps=0 w=1u l=1u
X2960 VDD VSS.t34 VDD VDD sg13_lv_pmos ad=0.19p pd=1.38u as=0 ps=0 w=1u l=1u
X2961 VDD VSS.t521 VDD VDD sg13_lv_pmos ad=0.34p pd=2.68u as=0 ps=0 w=1u l=1u
X2962 VSS.t633 VDD VSS.t636 VSS.t763 sg13_lv_nmos ad=79.8f pd=0.8u as=0 ps=0 w=0.42u l=1u
X2963 VDD VSS.t2016 VDD VDD sg13_lv_pmos ad=0.34p pd=2.68u as=0 ps=0 w=1u l=1u
X2964 VSS.t1006 VDD VSS.t1005 VSS.t1004 sg13_lv_nmos ad=0.1428p pd=1.52u as=0 ps=0 w=0.42u l=1u
X2965 VDD VSS.t840 VDD VDD sg13_lv_pmos ad=0.34p pd=2.68u as=0 ps=0 w=1u l=1u
X2966 VDD VSS.t3142 VDD VDD sg13_lv_pmos ad=0.19p pd=1.38u as=0 ps=0 w=1u l=1u
X2967 VSS.t2409 VDD VSS.t2411 VSS.t2410 sg13_lv_nmos ad=79.8f pd=0.8u as=0 ps=0 w=0.42u l=1u
X2968 VDD VSS.t579 VDD VDD sg13_lv_pmos ad=0.34p pd=2.68u as=0 ps=0 w=1u l=1u
X2969 VDD VSS.t38 VDD VDD sg13_lv_pmos ad=0.19p pd=1.38u as=0 ps=0 w=1u l=1u
X2970 VDD VSS.t778 VDD VDD sg13_lv_pmos ad=0.19p pd=1.38u as=0 ps=0 w=1u l=1u
X2971 VSS.t1575 VDD VSS.t1577 VSS.t1576 sg13_lv_nmos ad=79.8f pd=0.8u as=0 ps=0 w=0.42u l=1u
X2972 sg13cmos5l_buf_8_2.X a_19323_13726# VDD VDD sg13_lv_pmos ad=0.2128p pd=1.5u as=0.2128p ps=1.5u w=1.12u l=0.13u
X2973 VSS.t1897 VDD VSS.t1896 VSS.t1895 sg13_lv_nmos ad=0.1428p pd=1.52u as=0 ps=0 w=0.42u l=1u
X2974 VDD VSS.t383 VDD VDD sg13_lv_pmos ad=0.19p pd=1.38u as=0 ps=0 w=1u l=1u
X2975 VSS.t1207 VDD VSS.t1207 VSS.t70 sg13_lv_nmos ad=0.1428p pd=1.52u as=0 ps=0 w=0.42u l=1u
X2976 VDD VSS.t1851 VDD VDD sg13_lv_pmos ad=0.34p pd=2.68u as=0 ps=0 w=1u l=1u
X2977 sg13cmos5l_dlygate4sd3_1_0.A a_6540_13238# VDD VDD sg13_lv_pmos ad=0.2408p pd=1.55u as=0.3808p ps=2.92u w=1.12u l=0.13u
X2978 VDD VSS.t147 VDD VDD sg13_lv_pmos ad=0.19p pd=1.38u as=0 ps=0 w=1u l=1u
X2979 a_8685_14832# sg13cmos5l_buf_1_10.X VDD VDD sg13_lv_pmos ad=0.1596p pd=1.22u as=0.2856p ps=2.36u w=0.84u l=0.13u
X2980 a_21060_14488# a_21579_14495# a_22319_14845# VSS.t56 sg13_lv_nmos ad=0.3473p pd=2.71u as=0.12665p ps=1.145u w=0.74u l=0.13u
X2981 VDD VSS.t1299 VDD VDD sg13_lv_pmos ad=0.34p pd=2.68u as=0 ps=0 w=1u l=1u
X2982 VSS.t2239 VDD VSS.t2238 VSS.t2237 sg13_lv_nmos ad=0.1428p pd=1.52u as=0 ps=0 w=0.42u l=1u
X2983 VSS.t630 VDD VSS.t627 VSS.t629 sg13_lv_nmos ad=0.1428p pd=1.52u as=0 ps=0 w=0.42u l=1u
X2984 VDD VSS.t1654 VDD VDD sg13_lv_pmos ad=0.34p pd=2.68u as=0 ps=0 w=1u l=1u
X2985 VSS.t1695 VDD VSS.t1697 VSS.t1696 sg13_lv_nmos ad=79.8f pd=0.8u as=0 ps=0 w=0.42u l=1u
X2986 VSS.t2636 VDD VSS.t2638 VSS.t61 sg13_lv_nmos ad=79.8f pd=0.8u as=0 ps=0 w=0.42u l=1u
X2987 VSS.t2716 VDD VSS.t2715 VSS.t61 sg13_lv_nmos ad=0.1428p pd=1.52u as=0 ps=0 w=0.42u l=1u
X2988 VSS.t881 VDD VSS.t883 VSS.t882 sg13_lv_nmos ad=79.8f pd=0.8u as=0 ps=0 w=0.42u l=1u
X2989 VSS.t3030 VDD VSS.t3032 VSS.t3031 sg13_lv_nmos ad=79.8f pd=0.8u as=0 ps=0 w=0.42u l=1u
X2990 VDD VSS.t2937 VDD VDD sg13_lv_pmos ad=0.19p pd=1.38u as=0 ps=0 w=1u l=1u
X2991 a_21166_16263# a_21281_16262# VDD VDD sg13_lv_pmos ad=0.34p pd=2.68u as=0.2254p ps=1.53u w=1u l=0.5u
X2992 VDD a_5687_15315# a_5687_15549# VDD sg13_lv_pmos ad=2.8961p pd=18.25u as=0.2442p ps=2.06u w=0.66u l=0.13u
X2993 VDD VSS.t2343 VDD VDD sg13_lv_pmos ad=0.34p pd=2.68u as=0 ps=0 w=1u l=1u
X2994 VDD VSS.t2001 VDD VDD sg13_lv_pmos ad=0.34p pd=2.68u as=0 ps=0 w=1u l=1u
X2995 VDD a_22508_15960# counter_value_o[4] VDD sg13_lv_pmos ad=0.2114p pd=1.54u as=0.42p ps=2.99u w=1.12u l=0.13u
X2996 VDD VSS.t606 VDD VDD sg13_lv_pmos ad=0.19p pd=1.38u as=0 ps=0 w=1u l=1u
X2997 VSS.t535 VDD VSS.t537 VSS.t536 sg13_lv_nmos ad=79.8f pd=0.8u as=0 ps=0 w=0.42u l=1u
X2998 VDD VSS.t542 VDD VDD sg13_lv_pmos ad=0.19p pd=1.38u as=0 ps=0 w=1u l=1u
X2999 VDD VSS.t1329 VDD VDD sg13_lv_pmos ad=0.19p pd=1.38u as=0 ps=0 w=1u l=1u
X3000 VDD VSS.t1227 VDD VDD sg13_lv_pmos ad=0.19p pd=1.38u as=0 ps=0 w=1u l=1u
X3001 VSS.t1191 VDD VSS.t1190 VSS.t70 sg13_lv_nmos ad=0.1428p pd=1.52u as=0 ps=0 w=0.42u l=1u
X3002 VDD VSS.t3127 VDD VDD sg13_lv_pmos ad=0.19p pd=1.38u as=0 ps=0 w=1u l=1u
X3003 VDD VSS.t2701 VDD VDD sg13_lv_pmos ad=0.19p pd=1.38u as=0 ps=0 w=1u l=1u
X3004 VDD VSS.t1919 VDD VDD sg13_lv_pmos ad=0.19p pd=1.38u as=0 ps=0 w=1u l=1u
X3005 VSS.t2364 VDD VSS.t2363 VSS.t2362 sg13_lv_nmos ad=0.1428p pd=1.52u as=0 ps=0 w=0.42u l=1u
X3006 a_27664_13942# sg13cmos5l_dfrbpq_1_5.RESET_B VDD VDD sg13_lv_pmos ad=79.8f pd=0.8u as=2.42015p ps=15.68u w=0.42u l=0.13u
X3007 VSS.t1184 VDD VSS.t1185 VSS.t70 sg13_lv_nmos ad=79.8f pd=0.8u as=0 ps=0 w=0.42u l=1u
X3008 sg13cmos5l_nand4_1_0.Y sg13cmos5l_xor2_1_0.B VDD VDD sg13_lv_pmos ad=0.2128p pd=1.5u as=0.3808p ps=2.92u w=1.12u l=0.13u
X3009 VSS.t444 VDD VSS.t445 VSS.t15 sg13_lv_nmos ad=79.8f pd=0.8u as=0 ps=0 w=0.42u l=1u
X3010 VDD VSS.t437 VDD VDD sg13_lv_pmos ad=0.34p pd=2.68u as=0 ps=0 w=1u l=1u
X3011 a_15782_13722# a_16587_13844# a_16042_13945# VDD sg13_lv_pmos ad=0.1428p pd=1.52u as=79.8f ps=0.8u w=0.42u l=0.13u
X3012 VSS.t2766 VDD VSS.t2765 VSS.t61 sg13_lv_nmos ad=0.1428p pd=1.52u as=0 ps=0 w=0.42u l=1u
X3013 VDD VSS.t2044 VDD VDD sg13_lv_pmos ad=0.19p pd=1.38u as=0 ps=0 w=1u l=1u
X3014 VDD VSS.t3154 VDD VDD sg13_lv_pmos ad=0.34p pd=2.68u as=0 ps=0 w=1u l=1u
X3015 VDD VSS.t292 VDD VDD sg13_lv_pmos ad=0.19p pd=1.38u as=0 ps=0 w=1u l=1u
X3016 VDD VSS.t1687 VDD VDD sg13_lv_pmos ad=0.19p pd=1.38u as=0 ps=0 w=1u l=1u
X3017 VSS.t2429 VDD VSS.t2431 VSS.t2430 sg13_lv_nmos ad=79.8f pd=0.8u as=0 ps=0 w=0.42u l=1u
X3018 a_10222_14751# a_10337_14750# VDD VDD sg13_lv_pmos ad=0.34p pd=2.68u as=0.2254p ps=1.53u w=1u l=0.5u
X3019 VDD VSS.t1727 VDD VDD sg13_lv_pmos ad=0.19p pd=1.38u as=0 ps=0 w=1u l=1u
X3020 VSS.t1927 VDD VSS.t1929 VSS.t1928 sg13_lv_nmos ad=79.8f pd=0.8u as=0 ps=0 w=0.42u l=1u
X3021 VDD VSS.t2957 VDD VDD sg13_lv_pmos ad=0.19p pd=1.38u as=0 ps=0 w=1u l=1u
X3022 VDD VSS.t1557 VDD VDD sg13_lv_pmos ad=0.19p pd=1.38u as=0 ps=0 w=1u l=1u
X3023 VDD a_26565_13701# a_26667_13844# VDD sg13_lv_pmos ad=2.42015p pd=15.68u as=0.3864p ps=2.93u w=1.12u l=0.13u
X3024 VDD VSS.t521 VDD VDD sg13_lv_pmos ad=0.34p pd=2.68u as=0 ps=0 w=1u l=1u
X3025 VSS.t15 a_21477_14495# a_21579_14495# VSS.t116 sg13_lv_nmos ad=4.11262p pd=27.15u as=0.2516p ps=2.16u w=0.74u l=0.13u
X3026 VDD VSS.t334 VDD VDD sg13_lv_pmos ad=0.34p pd=2.68u as=0 ps=0 w=1u l=1u
X3027 VSS.t1282 VDD VSS.t1281 VSS.t70 sg13_lv_nmos ad=0.1428p pd=1.52u as=0 ps=0 w=0.42u l=1u
X3028 VDD VSS.t1321 VDD VDD sg13_lv_pmos ad=0.19p pd=1.38u as=0 ps=0 w=1u l=1u
X3029 VSS.t2645 VDD VSS.t2645 VSS.t61 sg13_lv_nmos ad=0.1428p pd=1.52u as=0 ps=0 w=0.42u l=1u
X3030 VDD VSS.t216 VDD VDD sg13_lv_pmos ad=0.34p pd=2.68u as=0 ps=0 w=1u l=1u
X3031 VDD VSS.t2696 VDD VDD sg13_lv_pmos ad=0.19p pd=1.38u as=0 ps=0 w=1u l=1u
X3032 VDD VSS.t2371 VDD VDD sg13_lv_pmos ad=0.19p pd=1.38u as=0 ps=0 w=1u l=1u
X3033 VSS.t426 VDD VSS.t425 VSS.t15 sg13_lv_nmos ad=0.1428p pd=1.52u as=0 ps=0 w=0.42u l=1u
X3034 a_4474_14448# sg13cmos5l_dlygate4sd3_1_3.A VSS.t15 VSS.t3204 sg13_lv_nmos ad=0.1428p pd=1.52u as=79.8f ps=0.8u w=0.42u l=0.13u
X3035 VSS.t273 VDD VSS.t378 VSS.t377 sg13_lv_nmos ad=79.8f pd=0.8u as=0 ps=0 w=0.42u l=1u
X3036 VSS.t596 VDD VSS.t599 VSS.t598 sg13_lv_nmos ad=79.8f pd=0.8u as=0 ps=0 w=0.42u l=1u
X3037 VSS.t2671 VDD VSS.t2672 VSS.t61 sg13_lv_nmos ad=79.8f pd=0.8u as=0 ps=0 w=0.42u l=1u
X3038 VSS.t2707 VDD VSS.t2708 VSS.t61 sg13_lv_nmos ad=79.8f pd=0.8u as=0 ps=0 w=0.42u l=1u
X3039 VSS.t1318 VDD VSS.t1319 VSS.t70 sg13_lv_nmos ad=79.8f pd=0.8u as=0 ps=0 w=0.42u l=1u
X3040 VDD VSS.t1707 VDD VDD sg13_lv_pmos ad=0.19p pd=1.38u as=0 ps=0 w=1u l=1u
X3041 VDD VSS.t2997 VDD VDD sg13_lv_pmos ad=0.19p pd=1.38u as=0 ps=0 w=1u l=1u
X3042 VDD VSS.t1864 VDD VDD sg13_lv_pmos ad=0.19p pd=1.38u as=0 ps=0 w=1u l=1u
X3043 VSS.t1867 VDD VSS.t1866 VSS.t1865 sg13_lv_nmos ad=0.1428p pd=1.52u as=0 ps=0 w=0.42u l=1u
X3044 VSS.t298 VDD VSS.t298 VSS.t300 sg13_lv_nmos ad=0.1428p pd=1.52u as=0 ps=0 w=0.42u l=1u
X3045 VDD VSS.t192 VDD VDD sg13_lv_pmos ad=0.19p pd=1.38u as=0 ps=0 w=1u l=1u
X3046 VDD VSS.t530 VDD VDD sg13_lv_pmos ad=0.34p pd=2.68u as=0 ps=0 w=1u l=1u
X3047 VDD VSS.t2708 VDD VDD sg13_lv_pmos ad=0.34p pd=2.68u as=0 ps=0 w=1u l=1u
X3048 a_27215_14845# a_26373_14495# a_25956_14488# VDD sg13_lv_pmos ad=0.2048p pd=1.63u as=0.34p ps=2.68u w=1u l=0.13u
X3049 VSS.t3015 VDD VSS.t3017 VSS.t3016 sg13_lv_nmos ad=79.8f pd=0.8u as=0 ps=0 w=0.42u l=1u
X3050 VDD VSS.t2784 VDD VDD sg13_lv_pmos ad=0.19p pd=1.38u as=0 ps=0 w=1u l=1u
X3051 VSS.t2072 VDD VSS.t2071 VSS.t2070 sg13_lv_nmos ad=0.1428p pd=1.52u as=0 ps=0 w=0.42u l=1u
X3052 VSS.t596 VDD VSS.t596 VSS.t720 sg13_lv_nmos ad=79.8f pd=0.8u as=0 ps=0 w=0.42u l=1u
X3053 VDD VSS.t421 VDD VDD sg13_lv_pmos ad=0.19p pd=1.38u as=0 ps=0 w=1u l=1u
X3054 VDD VSS.t1040 VDD VDD sg13_lv_pmos ad=0.34p pd=2.68u as=0 ps=0 w=1u l=1u
X3055 VDD VSS.t633 VDD VDD sg13_lv_pmos ad=0.19p pd=1.38u as=0 ps=0 w=1u l=1u
X3056 VSS.t1327 VDD VSS.t1327 VSS.t70 sg13_lv_nmos ad=79.8f pd=0.8u as=0 ps=0 w=0.42u l=1u
X3057 VSS.t2414 VDD VSS.t2416 VSS.t2415 sg13_lv_nmos ad=79.8f pd=0.8u as=0 ps=0 w=0.42u l=1u
X3058 VDD VSS.t1502 VDD VDD sg13_lv_pmos ad=0.19p pd=1.38u as=0 ps=0 w=1u l=1u
X3059 VDD VSS.t2969 VDD VDD sg13_lv_pmos ad=0.34p pd=2.68u as=0 ps=0 w=1u l=1u
X3060 VDD VSS.t609 VDD VDD sg13_lv_pmos ad=0.34p pd=2.68u as=0 ps=0 w=1u l=1u
X3061 VSS.t1580 VDD VSS.t1582 VSS.t1581 sg13_lv_nmos ad=79.8f pd=0.8u as=0 ps=0 w=0.42u l=1u
X3062 VDD VSS.t2081 VDD VDD sg13_lv_pmos ad=0.34p pd=2.68u as=0 ps=0 w=1u l=1u
X3063 VSS.t846 VDD VSS.t848 VSS.t847 sg13_lv_nmos ad=79.8f pd=0.8u as=0 ps=0 w=0.42u l=1u
X3064 VSS.t1902 VDD VSS.t1901 VSS.t1900 sg13_lv_nmos ad=0.1428p pd=1.52u as=0 ps=0 w=0.42u l=1u
X3065 a_4078_14751# a_4193_14750# VSS.t265 VSS.t3227 sg13_lv_nmos ad=0.1428p pd=1.52u as=0.1426p ps=1.16u w=0.42u l=0.5u
X3066 VSS.t2757 VDD VSS.t2755 VSS.t61 sg13_lv_nmos ad=0.1428p pd=1.52u as=0 ps=0 w=0.42u l=1u
X3067 VDD VSS.t2665 VDD VDD sg13_lv_pmos ad=0.19p pd=1.38u as=0 ps=0 w=1u l=1u
X3068 a_21286_14909# sg13cmos5l_dfrbpq_1_6.RESET_B VSS.t22 VSS.t68 sg13_lv_nmos ad=37.8f pd=0.6u as=0.1701p ps=1.65u w=0.42u l=0.13u
X3069 VDD VSS.t1244 VDD VDD sg13_lv_pmos ad=0.19p pd=1.38u as=0 ps=0 w=1u l=1u
X3070 VDD VSS.t2029 VDD VDD sg13_lv_pmos ad=0.19p pd=1.38u as=0 ps=0 w=1u l=1u
X3071 VSS.t2444 VDD VSS.t2443 VSS.t2442 sg13_lv_nmos ad=0.1428p pd=1.52u as=0 ps=0 w=0.42u l=1u
X3072 VDD VSS.t1981 VDD VDD sg13_lv_pmos ad=0.34p pd=2.68u as=0 ps=0 w=1u l=1u
X3073 VSS.t1700 VDD VSS.t1702 VSS.t1701 sg13_lv_nmos ad=79.8f pd=0.8u as=0 ps=0 w=0.42u l=1u
X3074 VDD VSS.t1712 VDD VDD sg13_lv_pmos ad=0.19p pd=1.38u as=0 ps=0 w=1u l=1u
X3075 VSS.t2092 VDD VSS.t2091 VSS.t2090 sg13_lv_nmos ad=0.1428p pd=1.52u as=0 ps=0 w=0.42u l=1u
X3076 VSS.t1912 VDD VSS.t1914 VSS.t1913 sg13_lv_nmos ad=79.8f pd=0.8u as=0 ps=0 w=0.42u l=1u
X3077 a_16955_14484# sg13cmos5l_a21oi_1_0.A2 VDD VDD sg13_lv_pmos ad=0.3808p pd=2.92u as=0.2128p ps=1.5u w=1.12u l=0.13u
X3078 VDD VSS.t2942 VDD VDD sg13_lv_pmos ad=0.19p pd=1.38u as=0 ps=0 w=1u l=1u
X3079 VSS.t3000 VDD VSS.t3002 VSS.t3001 sg13_lv_nmos ad=79.8f pd=0.8u as=0 ps=0 w=0.42u l=1u
X3080 VDD VSS.t1664 VDD VDD sg13_lv_pmos ad=0.34p pd=2.68u as=0 ps=0 w=1u l=1u
X3081 VSS.t2509 VDD VSS.t2511 VSS.t2510 sg13_lv_nmos ad=79.8f pd=0.8u as=0 ps=0 w=0.42u l=1u
X3082 a_2942_14484# sg13cmos5l_xor2_1_0.B a_2490_14447# VDD sg13_lv_pmos ad=0.1225p pd=1.245u as=0.34p ps=2.68u w=1u l=0.13u
X3083 VSS.t64 a_15579_14854# sg13cmos5l_buf_8_2.A VSS.t3241 sg13_lv_nmos ad=0.2516p pd=2.16u as=0.1406p ps=1.12u w=0.74u l=0.13u
X3084 VDD VSS.t815 VDD VDD sg13_lv_pmos ad=0.34p pd=2.68u as=0 ps=0 w=1u l=1u
X3085 VDD VSS.t1542 VDD VDD sg13_lv_pmos ad=0.19p pd=1.38u as=0 ps=0 w=1u l=1u
X3086 VDD VSS.t1719 VDD VDD sg13_lv_pmos ad=0.34p pd=2.68u as=0 ps=0 w=1u l=1u
X3087 VDD VSS.t612 VDD VDD sg13_lv_pmos ad=0.34p pd=2.68u as=0 ps=0 w=1u l=1u
X3088 a_5613_14832# sg13cmos5l_buf_1_10.X VDD VDD sg13_lv_pmos ad=0.1596p pd=1.22u as=0.2856p ps=2.36u w=0.84u l=0.13u
X3089 VSS.t1309 VDD VSS.t1308 VSS.t70 sg13_lv_nmos ad=0.1428p pd=1.52u as=0 ps=0 w=0.42u l=1u
X3090 VDD VSS.t2348 VDD VDD sg13_lv_pmos ad=0.34p pd=2.68u as=0 ps=0 w=1u l=1u
X3091 a_18665_15180# a_18789_15277# VDD VDD sg13_lv_pmos ad=0.2442p pd=2.06u as=2.8961p ps=18.25u w=0.66u l=0.13u
X3092 VDD sg13cmos5l_buf_1_0.X sg13cmos5l_xnor2_1_2.B VDD sg13_lv_pmos ad=0.3808p pd=2.92u as=0.2128p ps=1.5u w=1.12u l=0.13u
X3093 VSS.t11 VDD VSS.t38 VSS.t401 sg13_lv_nmos ad=79.8f pd=0.8u as=0 ps=0 w=0.42u l=1u
X3094 VDD VSS.t648 VDD VDD sg13_lv_pmos ad=0.34p pd=2.68u as=0 ps=0 w=1u l=1u
X3095 VSS.t1430 VDD VSS.t1303 VSS.t70 sg13_lv_nmos ad=79.8f pd=0.8u as=0 ps=0 w=0.42u l=1u
X3096 VDD VSS.t1924 VDD VDD sg13_lv_pmos ad=0.19p pd=1.38u as=0 ps=0 w=1u l=1u
X3097 VSS.t331 VDD VSS.t330 VSS.t329 sg13_lv_nmos ad=0.1428p pd=1.52u as=0 ps=0 w=0.42u l=1u
X3098 a_5886_15486# a_5687_15549# VSS.t15 VSS.t48 sg13_lv_nmos ad=0.27427p pd=2.28u as=4.11262p ps=27.15u w=0.795u l=0.13u
X3099 VDD VSS.t454 VDD VDD sg13_lv_pmos ad=0.19p pd=1.38u as=0 ps=0 w=1u l=1u
X3100 VDD VSS.t868 VDD VDD sg13_lv_pmos ad=0.19p pd=1.38u as=0 ps=0 w=1u l=1u
X3101 VDD VSS.t2243 VDD VDD sg13_lv_pmos ad=0.34p pd=2.68u as=0 ps=0 w=1u l=1u
X3102 VSS.t2768 VDD VSS.t2768 VSS.t61 sg13_lv_nmos ad=0.1428p pd=1.52u as=0 ps=0 w=0.42u l=1u
X3103 VSS.t22 a_21070_15423# sg13cmos5l_dlygate4sd3_1_9.X VSS.t243 sg13_lv_nmos ad=0.1426p pd=1.16u as=0.2516p ps=2.16u w=0.74u l=0.13u
X3104 VDD VSS.t1286 VDD VDD sg13_lv_pmos ad=0.19p pd=1.38u as=0 ps=0 w=1u l=1u
X3105 VDD VSS.t1235 VDD VDD sg13_lv_pmos ad=0.19p pd=1.38u as=0 ps=0 w=1u l=1u
X3106 VDD VSS.t2740 VDD VDD sg13_lv_pmos ad=0.19p pd=1.38u as=0 ps=0 w=1u l=1u
X3107 VDD VSS.t2049 VDD VDD sg13_lv_pmos ad=0.19p pd=1.38u as=0 ps=0 w=1u l=1u
X3108 VDD VSS.t3159 VDD VDD sg13_lv_pmos ad=0.34p pd=2.68u as=0 ps=0 w=1u l=1u
X3109 VSS.t2429 VDD VSS.t2428 VSS.t2427 sg13_lv_nmos ad=0.1428p pd=1.52u as=0 ps=0 w=0.42u l=1u
X3110 VSS.t1852 VDD VSS.t1851 VSS.t1850 sg13_lv_nmos ad=0.1428p pd=1.52u as=0 ps=0 w=0.42u l=1u
X3111 VDD a_7822_13911# sg13cmos5l_xnor2_1_2.A VDD sg13_lv_pmos ad=0.2254p pd=1.53u as=0.4256p ps=3u w=1.12u l=0.13u
X3112 VSS.t587 VDD VSS.t256 VSS.t707 sg13_lv_nmos ad=79.8f pd=0.8u as=0 ps=0 w=0.42u l=1u
X3113 VSS.t612 VDD VSS.t615 VSS.t749 sg13_lv_nmos ad=79.8f pd=0.8u as=0 ps=0 w=0.42u l=1u
X3114 VDD VSS.t1692 VDD VDD sg13_lv_pmos ad=0.19p pd=1.38u as=0 ps=0 w=1u l=1u
X3115 VSS.t2710 VDD VSS.t2709 VSS.t61 sg13_lv_nmos ad=0.1428p pd=1.52u as=0 ps=0 w=0.42u l=1u
X3116 VSS.t22 sg13cmos5l_or3_1_2.X a_20705_15260# VSS.t42 sg13_lv_nmos ad=0.2516p pd=2.16u as=0.1406p ps=1.12u w=0.74u l=0.13u
X3117 VDD VSS.t1697 VDD VDD sg13_lv_pmos ad=0.19p pd=1.38u as=0 ps=0 w=1u l=1u
X3118 VSS.t901 VDD VSS.t903 VSS.t902 sg13_lv_nmos ad=79.8f pd=0.8u as=0 ps=0 w=0.42u l=1u
X3119 VSS.t1655 VDD VSS.t1654 VSS.t1653 sg13_lv_nmos ad=0.1428p pd=1.52u as=0 ps=0 w=0.42u l=1u
X3120 VSS.t3180 VDD VSS.t3179 VSS.t3178 sg13_lv_nmos ad=0.1428p pd=1.52u as=0 ps=0 w=0.42u l=1u
X3121 VSS.t2494 VDD VSS.t2496 VSS.t2495 sg13_lv_nmos ad=79.8f pd=0.8u as=0 ps=0 w=0.42u l=1u
X3122 VDD VSS.t2381 VDD VDD sg13_lv_pmos ad=0.19p pd=1.38u as=0 ps=0 w=1u l=1u
X3123 a_22508_15960# sg13cmos5l_dfrbpq_1_3.Q VSS.t88 VSS.t203 sg13_lv_nmos ad=0.187p pd=1.78u as=0.14875p ps=1.16u w=0.55u l=0.13u
X3124 a_7631_14845# a_6789_14495# a_7537_14845# VSS.t240 sg13_lv_nmos ad=0.12665p pd=1.145u as=0.1428p ps=1.52u w=0.42u l=0.13u
X3125 VSS.t841 VDD VSS.t840 VSS.t839 sg13_lv_nmos ad=0.1428p pd=1.52u as=0 ps=0 w=0.42u l=1u
X3126 VSS.t2648 VDD VSS.t2647 VSS.t61 sg13_lv_nmos ad=0.1428p pd=1.52u as=0 ps=0 w=0.42u l=1u
X3127 VSS.t776 VDD VSS.t778 VSS.t777 sg13_lv_nmos ad=79.8f pd=0.8u as=0 ps=0 w=0.42u l=1u
X3128 VSS.t2748 VDD VSS.t2749 VSS.t61 sg13_lv_nmos ad=79.8f pd=0.8u as=0 ps=0 w=0.42u l=1u
X3129 VDD VSS.t2699 VDD VDD sg13_lv_pmos ad=0.19p pd=1.38u as=0 ps=0 w=1u l=1u
X3130 VSS.t2399 VDD VSS.t2401 VSS.t2400 sg13_lv_nmos ad=79.8f pd=0.8u as=0 ps=0 w=0.42u l=1u
X3131 VSS.t1962 VDD VSS.t1961 VSS.t1960 sg13_lv_nmos ad=0.1428p pd=1.52u as=0 ps=0 w=0.42u l=1u
X3132 VDD VSS.t1487 VDD VDD sg13_lv_pmos ad=0.19p pd=1.38u as=0 ps=0 w=1u l=1u
X3133 VDD VSS.t2954 VDD VDD sg13_lv_pmos ad=0.34p pd=2.68u as=0 ps=0 w=1u l=1u
X3134 VDD VSS.t636 VDD VDD sg13_lv_pmos ad=0.34p pd=2.68u as=0 ps=0 w=1u l=1u
X3135 VSS.t846 VDD VSS.t848 VSS.t847 sg13_lv_nmos ad=79.8f pd=0.8u as=0 ps=0 w=0.42u l=1u
X3136 VSS.t1244 VDD VSS.t1243 VSS.t70 sg13_lv_nmos ad=0.1428p pd=1.52u as=0 ps=0 w=0.42u l=1u
X3137 a_21562_15960# sg13cmos5l_a21oi_1_1.Y VDD VDD sg13_lv_pmos ad=0.1428p pd=1.52u as=0.1523p ps=1.38u w=0.42u l=0.13u
X3138 VSS.t1565 VDD VSS.t1567 VSS.t1566 sg13_lv_nmos ad=79.8f pd=0.8u as=0 ps=0 w=0.42u l=1u
X3139 VDD VSS.t2066 VDD VDD sg13_lv_pmos ad=0.34p pd=2.68u as=0 ps=0 w=1u l=1u
X3140 VSS.t24 sg13cmos5l_or3_1_1.X a_25025_16344# VSS.t269 sg13_lv_nmos ad=0.2516p pd=2.16u as=0.1406p ps=1.12u w=0.74u l=0.13u
X3141 VDD VSS.t367 VDD VDD sg13_lv_pmos ad=0.19p pd=1.38u as=0 ps=0 w=1u l=1u
X3142 a_17604_14488# a_18123_14495# a_18863_14845# VSS.t16 sg13_lv_nmos ad=0.3473p pd=2.71u as=0.12665p ps=1.145u w=0.74u l=0.13u
X3143 VDD VSS.t2436 VDD VDD sg13_lv_pmos ad=0.19p pd=1.38u as=0 ps=0 w=1u l=1u
X3144 VDD VSS.t1869 VDD VDD sg13_lv_pmos ad=0.19p pd=1.38u as=0 ps=0 w=1u l=1u
X3145 VSS.t1249 VDD VSS.t1248 VSS.t70 sg13_lv_nmos ad=0.1428p pd=1.52u as=0 ps=0 w=0.42u l=1u
X3146 VDD VSS.t1677 VDD VDD sg13_lv_pmos ad=0.19p pd=1.38u as=0 ps=0 w=1u l=1u
X3147 VSS.t2042 VDD VSS.t2044 VSS.t2043 sg13_lv_nmos ad=79.8f pd=0.8u as=0 ps=0 w=0.42u l=1u
X3148 VSS.t871 VDD VSS.t870 VSS.t869 sg13_lv_nmos ad=0.1428p pd=1.52u as=0 ps=0 w=0.42u l=1u
X3149 VDD VSS.t1966 VDD VDD sg13_lv_pmos ad=0.34p pd=2.68u as=0 ps=0 w=1u l=1u
X3150 VSS.t1170 VDD VSS.t1169 VSS.t70 sg13_lv_nmos ad=0.1428p pd=1.52u as=0 ps=0 w=0.42u l=1u
X3151 VSS.t1211 VDD VSS.t1212 VSS.t70 sg13_lv_nmos ad=79.8f pd=0.8u as=0 ps=0 w=0.42u l=1u
X3152 VSS.t2077 VDD VSS.t2076 VSS.t2075 sg13_lv_nmos ad=0.1428p pd=1.52u as=0 ps=0 w=0.42u l=1u
X3153 VSS.t3165 VDD VSS.t3164 VSS.t3163 sg13_lv_nmos ad=0.1428p pd=1.52u as=0 ps=0 w=0.42u l=1u
X3154 VDD VSS.t1048 VDD VDD sg13_lv_pmos ad=0.19p pd=1.38u as=0 ps=0 w=1u l=1u
X3155 sg13cmos5l_buf_1_10.X a_1192_9948# VDD VDD sg13_lv_pmos ad=0.42p pd=2.99u as=0.2114p ps=1.54u w=1.12u l=0.13u
X3156 VSS.t633 VDD VSS.t633 VSS.t634 sg13_lv_nmos ad=79.8f pd=0.8u as=0 ps=0 w=0.42u l=1u
X3157 VSS.t645 VDD VSS.t648 VSS.t771 sg13_lv_nmos ad=79.8f pd=0.8u as=0 ps=0 w=0.42u l=1u
X3158 VDD VSS.t1649 VDD VDD sg13_lv_pmos ad=0.34p pd=2.68u as=0 ps=0 w=1u l=1u
X3159 VSS.t1175 VDD VSS.t1174 VSS.t70 sg13_lv_nmos ad=0.1428p pd=1.52u as=0 ps=0 w=0.42u l=1u
X3160 VDD VSS.t1704 VDD VDD sg13_lv_pmos ad=0.34p pd=2.68u as=0 ps=0 w=1u l=1u
X3161 VSS.t1555 VDD VSS.t1557 VSS.t1556 sg13_lv_nmos ad=79.8f pd=0.8u as=0 ps=0 w=0.42u l=1u
X3162 VSS.t2449 VDD VSS.t2448 VSS.t2447 sg13_lv_nmos ad=0.1428p pd=1.52u as=0 ps=0 w=0.42u l=1u
X3163 a_27417_14607# a_26475_14495# a_27215_14845# VDD sg13_lv_pmos ad=93.45f pd=0.865u as=0.2048p ps=1.63u w=0.42u l=0.13u
X3164 VDD VSS.t701 VDD VDD sg13_lv_pmos ad=0.34p pd=2.68u as=0 ps=0 w=1u l=1u
X3165 VSS.t931 VDD VSS.t933 VSS.t932 sg13_lv_nmos ad=79.8f pd=0.8u as=0 ps=0 w=0.42u l=1u
X3166 VDD VSS.t2333 VDD VDD sg13_lv_pmos ad=0.34p pd=2.68u as=0 ps=0 w=1u l=1u
X3167 VSS.t698 VDD VSS.t697 VSS.t696 sg13_lv_nmos ad=0.1428p pd=1.52u as=0 ps=0 w=0.42u l=1u
X3168 VDD VSS.t798 VDD VDD sg13_lv_pmos ad=0.19p pd=1.38u as=0 ps=0 w=1u l=1u
X3169 VDD VSS.t1507 VDD VDD sg13_lv_pmos ad=0.19p pd=1.38u as=0 ps=0 w=1u l=1u
X3170 VSS.t2630 VDD VSS.t2631 VSS.t61 sg13_lv_nmos ad=79.8f pd=0.8u as=0 ps=0 w=0.42u l=1u
X3171 VSS.t298 VDD VSS.t298 VSS.t299 sg13_lv_nmos ad=79.8f pd=0.8u as=0 ps=0 w=0.42u l=1u
X3172 VSS.t1550 VDD VSS.t1552 VSS.t1551 sg13_lv_nmos ad=79.8f pd=0.8u as=0 ps=0 w=0.42u l=1u
X3173 VDD VSS.t2086 VDD VDD sg13_lv_pmos ad=0.34p pd=2.68u as=0 ps=0 w=1u l=1u
X3174 VSS.t1907 VDD VSS.t1906 VSS.t1905 sg13_lv_nmos ad=0.1428p pd=1.52u as=0 ps=0 w=0.42u l=1u
X3175 VDD a_12010_15202# sg13cmos5l_dfrbpq_1_2.CLK VDD sg13_lv_pmos ad=0.2128p pd=1.5u as=0.2128p ps=1.5u w=1.12u l=0.13u
X3176 VDD VSS.t1311 VDD VDD sg13_lv_pmos ad=0.34p pd=2.68u as=0 ps=0 w=1u l=1u
X3177 VSS.t1194 VDD VSS.t1193 VSS.t70 sg13_lv_nmos ad=0.1428p pd=1.52u as=0 ps=0 w=0.42u l=1u
X3178 VSS.t2760 VDD VSS.t2759 VSS.t61 sg13_lv_nmos ad=0.1428p pd=1.52u as=0 ps=0 w=0.42u l=1u
X3179 VDD VSS.t2631 VDD VDD sg13_lv_pmos ad=0.34p pd=2.68u as=0 ps=0 w=1u l=1u
X3180 VSS.t521 VDD VSS.t521 VSS.t525 sg13_lv_nmos ad=79.8f pd=0.8u as=0 ps=0 w=0.42u l=1u
X3181 VDD VSS.t1226 VDD VDD sg13_lv_pmos ad=0.19p pd=1.38u as=0 ps=0 w=1u l=1u
X3182 VDD VSS.t2731 VDD VDD sg13_lv_pmos ad=0.19p pd=1.38u as=0 ps=0 w=1u l=1u
X3183 VSS.t2414 VDD VSS.t2413 VSS.t2412 sg13_lv_nmos ad=0.1428p pd=1.52u as=0 ps=0 w=0.42u l=1u
X3184 VSS.t901 VDD VSS.t903 VSS.t902 sg13_lv_nmos ad=79.8f pd=0.8u as=0 ps=0 w=0.42u l=1u
X3185 VSS.t1262 VDD VSS.t1261 VSS.t70 sg13_lv_nmos ad=0.1428p pd=1.52u as=0 ps=0 w=0.42u l=1u
X3186 VSS.t453 VDD VSS.t452 VSS.t15 sg13_lv_nmos ad=0.1428p pd=1.52u as=0 ps=0 w=0.42u l=1u
X3187 VSS.t1705 VDD VSS.t1707 VSS.t1706 sg13_lv_nmos ad=79.8f pd=0.8u as=0 ps=0 w=0.42u l=1u
X3188 VDD sg13cmos5l_dfrbpq_1_3.Q sg13cmos5l_or3_1_2.C VDD sg13_lv_pmos ad=0.3808p pd=2.92u as=0.2128p ps=1.5u w=1.12u l=0.13u
X3189 VDD sg13cmos5l_inv_1_0.Y a_16314_15532# VDD sg13_lv_pmos ad=0.2891p pd=1.695u as=0.1428p ps=1.375u w=1.12u l=0.13u
X3190 VDD VSS.t1015 VDD VDD sg13_lv_pmos ad=0.34p pd=2.68u as=0 ps=0 w=1u l=1u
X3191 VSS.t2479 VDD VSS.t2481 VSS.t2480 sg13_lv_nmos ad=79.8f pd=0.8u as=0 ps=0 w=0.42u l=1u
X3192 VSS.t841 VDD VSS.t840 VSS.t839 sg13_lv_nmos ad=0.1428p pd=1.52u as=0 ps=0 w=0.42u l=1u
X3193 VDD VSS.t1547 VDD VDD sg13_lv_pmos ad=0.19p pd=1.38u as=0 ps=0 w=1u l=1u
X3194 VSS.t2758 VDD VSS.t2757 VSS.t61 sg13_lv_nmos ad=0.1428p pd=1.52u as=0 ps=0 w=0.42u l=1u
X3195 VDD VSS.t1881 VDD VDD sg13_lv_pmos ad=0.34p pd=2.68u as=0 ps=0 w=1u l=1u
X3196 a_24841_13726# sg13cmos5l_or3_1_1.B VSS.t157 VSS.t3214 sg13_lv_nmos ad=0.198p pd=1.27u as=0.1045p ps=0.93u w=0.55u l=0.13u
X3197 VSS.t776 VDD VSS.t778 VSS.t777 sg13_lv_nmos ad=79.8f pd=0.8u as=0 ps=0 w=0.42u l=1u
X3198 VDD VSS.t1239 VDD VDD sg13_lv_pmos ad=0.19p pd=1.38u as=0 ps=0 w=1u l=1u
X3199 VSS.t1203 VDD VSS.t1202 VSS.t70 sg13_lv_nmos ad=0.1428p pd=1.52u as=0 ps=0 w=0.42u l=1u
X3200 sg13cmos5l_or3_1_1.C sg13cmos5l_dfrbpq_1_6.Q VDD VDD sg13_lv_pmos ad=0.2128p pd=1.5u as=0.2128p ps=1.5u w=1.12u l=0.13u
X3201 a_23378_15242# sg13cmos5l_dfrbpq_1_2.Q VSS.t3275 VSS.t65 sg13_lv_nmos ad=0.1406p pd=1.12u as=0.2886p ps=2.26u w=0.74u l=0.13u
X3202 VDD a_19120_14726# a_19065_14607# VDD sg13_lv_pmos ad=2.42015p pd=15.68u as=93.45f ps=0.865u w=0.42u l=0.13u
X3203 VDD VSS.t953 VDD VDD sg13_lv_pmos ad=0.19p pd=1.38u as=0 ps=0 w=1u l=1u
X3204 VSS.t2640 VDD VSS.t2639 VSS.t61 sg13_lv_nmos ad=0.1428p pd=1.52u as=0 ps=0 w=0.42u l=1u
X3205 VDD VSS.t2690 VDD VDD sg13_lv_pmos ad=0.19p pd=1.38u as=0 ps=0 w=1u l=1u
X3206 VDD sg13cmos5l_dfrbpq_1_0.RESET_B a_2630_15234# VDD sg13_lv_pmos ad=0.36237p pd=2.605u as=79.8f ps=0.8u w=0.42u l=0.13u
X3207 VSS.t3035 VDD VSS.t3034 VSS.t3033 sg13_lv_nmos ad=0.1428p pd=1.52u as=0 ps=0 w=0.42u l=1u
X3208 VDD VSS.t449 VDD VDD sg13_lv_pmos ad=0.34p pd=2.68u as=0 ps=0 w=1u l=1u
X3209 VSS.t1500 VDD VSS.t1502 VSS.t1501 sg13_lv_nmos ad=79.8f pd=0.8u as=0 ps=0 w=0.42u l=1u
X3210 VDD VSS.t352 VDD VDD sg13_lv_pmos ad=0.34p pd=2.68u as=0 ps=0 w=1u l=1u
X3211 VSS.t1730 VDD VSS.t1729 VSS.t1728 sg13_lv_nmos ad=0.1428p pd=1.52u as=0 ps=0 w=0.42u l=1u
X3212 VDD VSS.t1512 VDD VDD sg13_lv_pmos ad=0.19p pd=1.38u as=0 ps=0 w=1u l=1u
X3213 VDD VSS.t2421 VDD VDD sg13_lv_pmos ad=0.19p pd=1.38u as=0 ps=0 w=1u l=1u
X3214 VSS.t1892 VDD VSS.t1891 VSS.t1890 sg13_lv_nmos ad=0.1428p pd=1.52u as=0 ps=0 w=0.42u l=1u
X3215 VSS.t216 VDD VSS.t216 VSS.t712 sg13_lv_nmos ad=0.1428p pd=1.52u as=0 ps=0 w=0.42u l=1u
X3216 VDD VSS.t1238 VDD VDD sg13_lv_pmos ad=0.19p pd=1.38u as=0 ps=0 w=1u l=1u
X3217 VDD VSS.t2743 VDD VDD sg13_lv_pmos ad=0.19p pd=1.38u as=0 ps=0 w=1u l=1u
X3218 VDD VSS.t2019 VDD VDD sg13_lv_pmos ad=0.19p pd=1.38u as=0 ps=0 w=1u l=1u
X3219 VDD a_12010_15202# sg13cmos5l_dfrbpq_1_2.CLK VDD sg13_lv_pmos ad=0.2128p pd=1.5u as=0.2128p ps=1.5u w=1.12u l=0.13u
X3220 VSS.t871 VDD VSS.t870 VSS.t869 sg13_lv_nmos ad=0.1428p pd=1.52u as=0 ps=0 w=0.42u l=1u
X3221 VSS.t1408 VDD VSS.t1274 VSS.t70 sg13_lv_nmos ad=0.1428p pd=1.52u as=0 ps=0 w=0.42u l=1u
X3222 VDD VSS.t2373 VDD VDD sg13_lv_pmos ad=0.34p pd=2.68u as=0 ps=0 w=1u l=1u
X3223 VSS.t2434 VDD VSS.t2433 VSS.t2432 sg13_lv_nmos ad=0.1428p pd=1.52u as=0 ps=0 w=0.42u l=1u
X3224 VSS.t601 VDD VSS.t603 VSS.t602 sg13_lv_nmos ad=79.8f pd=0.8u as=0 ps=0 w=0.42u l=1u
X3225 VDD VSS.t1519 VDD VDD sg13_lv_pmos ad=0.34p pd=2.68u as=0 ps=0 w=1u l=1u
X3226 VDD VSS.t3129 VDD VDD sg13_lv_pmos ad=0.34p pd=2.68u as=0 ps=0 w=1u l=1u
X3227 VDD VSS.t1854 VDD VDD sg13_lv_pmos ad=0.19p pd=1.38u as=0 ps=0 w=1u l=1u
X3228 VSS.t358 VDD VSS.t104 VSS.t359 sg13_lv_nmos ad=79.8f pd=0.8u as=0 ps=0 w=0.42u l=1u
X3229 VDD VSS.t1702 VDD VDD sg13_lv_pmos ad=0.19p pd=1.38u as=0 ps=0 w=1u l=1u
X3230 VSS.t1982 VDD VSS.t1981 VSS.t1980 sg13_lv_nmos ad=0.1428p pd=1.52u as=0 ps=0 w=0.42u l=1u
X3231 a_21060_14488# a_21034_14452# VSS.t22 VSS.t21 sg13_lv_nmos ad=0.2516p pd=2.16u as=0.1626p ps=1.415u w=0.74u l=0.13u
X3232 sg13cmos5l_buf_8_2.A a_15579_14854# VDD VDD sg13_lv_pmos ad=0.2128p pd=1.5u as=0.2128p ps=1.5u w=1.12u l=0.13u
X3233 sg13cmos5l_dfrbpq_1_2.CLK a_12010_15202# VSS.t182 VSS.t181 sg13_lv_nmos ad=0.1406p pd=1.12u as=0.2516p ps=2.16u w=0.74u l=0.13u
X3234 VSS.t1041 VDD VSS.t1040 VSS.t1039 sg13_lv_nmos ad=0.1428p pd=1.52u as=0 ps=0 w=0.42u l=1u
X3235 VDD VSS.t2386 VDD VDD sg13_lv_pmos ad=0.19p pd=1.38u as=0 ps=0 w=1u l=1u
X3236 VSS.t931 VDD VSS.t933 VSS.t932 sg13_lv_nmos ad=79.8f pd=0.8u as=0 ps=0 w=0.42u l=1u
X3237 VDD VSS.t1220 VDD VDD sg13_lv_pmos ad=0.34p pd=2.68u as=0 ps=0 w=1u l=1u
X3238 VDD VSS.t552 VDD VDD sg13_lv_pmos ad=0.19p pd=1.38u as=0 ps=0 w=1u l=1u
X3239 VDD VSS.t905 VDD VDD sg13_lv_pmos ad=0.34p pd=2.68u as=0 ps=0 w=1u l=1u
X3240 a_6682_13690# sg13cmos5l_dlygate4sd3_1_0.A VSS.t170 VSS.t3185 sg13_lv_nmos ad=0.1428p pd=1.52u as=79.8f ps=0.8u w=0.42u l=0.13u
X3241 VSS.t1540 VDD VSS.t1542 VSS.t1541 sg13_lv_nmos ad=79.8f pd=0.8u as=0 ps=0 w=0.42u l=1u
X3242 VSS.t1720 VDD VSS.t1719 VSS.t1718 sg13_lv_nmos ad=0.1428p pd=1.52u as=0 ps=0 w=0.42u l=1u
X3243 VSS.t2651 VDD VSS.t2650 VSS.t61 sg13_lv_nmos ad=0.1428p pd=1.52u as=0 ps=0 w=0.42u l=1u
X3244 VSS.t2751 VDD VSS.t2752 VSS.t61 sg13_lv_nmos ad=79.8f pd=0.8u as=0 ps=0 w=0.42u l=1u
X3245 VDD VSS.t2702 VDD VDD sg13_lv_pmos ad=0.19p pd=1.38u as=0 ps=0 w=1u l=1u
X3246 VSS.t1932 VDD VSS.t1931 VSS.t1930 sg13_lv_nmos ad=0.1428p pd=1.52u as=0 ps=0 w=0.42u l=1u
X3247 VSS.t438 VDD VSS.t437 VSS.t15 sg13_lv_nmos ad=0.1428p pd=1.52u as=0 ps=0 w=0.42u l=1u
X3248 VDD VSS.t1492 VDD VDD sg13_lv_pmos ad=0.19p pd=1.38u as=0 ps=0 w=1u l=1u
X3249 VDD VSS.t2959 VDD VDD sg13_lv_pmos ad=0.34p pd=2.68u as=0 ps=0 w=1u l=1u
X3250 VDD VSS.t273 VDD VDD sg13_lv_pmos ad=0.34p pd=2.68u as=0 ps=0 w=1u l=1u
X3251 VDD VSS.t424 VDD VDD sg13_lv_pmos ad=0.19p pd=1.38u as=0 ps=0 w=1u l=1u
X3252 VDD VSS.t1256 VDD VDD sg13_lv_pmos ad=0.19p pd=1.38u as=0 ps=0 w=1u l=1u
X3253 VSS.t1329 VDD VSS.t1330 VSS.t70 sg13_lv_nmos ad=79.8f pd=0.8u as=0 ps=0 w=0.42u l=1u
X3254 VSS.t1715 VDD VSS.t1714 VSS.t1713 sg13_lv_nmos ad=0.1428p pd=1.52u as=0 ps=0 w=0.42u l=1u
X3255 VDD VSS.t2441 VDD VDD sg13_lv_pmos ad=0.19p pd=1.38u as=0 ps=0 w=1u l=1u
X3256 VSS.t2464 VDD VSS.t2466 VSS.t2465 sg13_lv_nmos ad=79.8f pd=0.8u as=0 ps=0 w=0.42u l=1u
X3257 VDD VSS.t780 VDD VDD sg13_lv_pmos ad=0.34p pd=2.68u as=0 ps=0 w=1u l=1u
X3258 VSS.t736 VDD VSS.t738 VSS.t737 sg13_lv_nmos ad=79.8f pd=0.8u as=0 ps=0 w=0.42u l=1u
X3259 VDD VSS.t1322 VDD VDD sg13_lv_pmos ad=0.34p pd=2.68u as=0 ps=0 w=1u l=1u
X3260 VDD VSS.t2972 VDD VDD sg13_lv_pmos ad=0.19p pd=1.38u as=0 ps=0 w=1u l=1u
X3261 VSS.t2047 VDD VSS.t2049 VSS.t2048 sg13_lv_nmos ad=79.8f pd=0.8u as=0 ps=0 w=0.42u l=1u
X3262 VDD VSS.t1971 VDD VDD sg13_lv_pmos ad=0.34p pd=2.68u as=0 ps=0 w=1u l=1u
X3263 VSS.t110 a_27664_13942# a_27313_13799# VSS.t109 sg13_lv_nmos ad=79.8f pd=0.8u as=0.1428p ps=1.52u w=0.42u l=0.13u
X3264 VSS.t1690 VDD VSS.t1692 VSS.t1691 sg13_lv_nmos ad=79.8f pd=0.8u as=0 ps=0 w=0.42u l=1u
X3265 VSS.t182 VDD VSS.t470 VSS.t469 sg13_lv_nmos ad=0.1428p pd=1.52u as=0 ps=0 w=0.42u l=1u
X3266 VDD VSS.t276 VDD VDD sg13_lv_pmos ad=0.34p pd=2.68u as=0 ps=0 w=1u l=1u
X3267 VDD VSS.t1198 VDD VDD sg13_lv_pmos ad=0.19p pd=1.38u as=0 ps=0 w=1u l=1u
X3268 VSS.t2674 VDD VSS.t2673 VSS.t61 sg13_lv_nmos ad=0.1428p pd=1.52u as=0 ps=0 w=0.42u l=1u
X3269 VDD VSS.t433 VDD VDD sg13_lv_pmos ad=0.19p pd=1.38u as=0 ps=0 w=1u l=1u
X3270 sg13cmos5l_buf_8_2.A a_15579_14854# VDD VDD sg13_lv_pmos ad=0.2128p pd=1.5u as=0.2128p ps=1.5u w=1.12u l=0.13u
X3271 a_6714_12972# sg13cmos5l_xnor2_1_2.B sg13cmos5l_dlygate4sd3_1_0.A VDD sg13_lv_pmos ad=0.1428p pd=1.375u as=0.2408p ps=1.55u w=1.12u l=0.13u
X3272 VDD VSS.t1654 VDD VDD sg13_lv_pmos ad=0.34p pd=2.68u as=0 ps=0 w=1u l=1u
X3273 a_25094_15238# a_24824_15238# VDD VDD sg13_lv_pmos ad=0.34p pd=2.68u as=0.1523p ps=1.38u w=1u l=0.5u
X3274 VDD VSS.t1266 VDD VDD sg13_lv_pmos ad=0.19p pd=1.38u as=0 ps=0 w=1u l=1u
X3275 VDD VSS.t1709 VDD VDD sg13_lv_pmos ad=0.34p pd=2.68u as=0 ps=0 w=1u l=1u
X3276 VSS.t1560 VDD VSS.t1562 VSS.t1561 sg13_lv_nmos ad=79.8f pd=0.8u as=0 ps=0 w=0.42u l=1u
X3277 VSS.t3085 VDD VSS.t3087 VSS.t3086 sg13_lv_nmos ad=79.8f pd=0.8u as=0 ps=0 w=0.42u l=1u
X3278 VSS.t2294 VDD VSS.t2296 VSS.t2295 sg13_lv_nmos ad=79.8f pd=0.8u as=0 ps=0 w=0.42u l=1u
X3279 VDD VSS.t1866 VDD VDD sg13_lv_pmos ad=0.34p pd=2.68u as=0 ps=0 w=1u l=1u
X3280 a_6575_13342# sg13cmos5l_xnor2_1_2.A VSS.t170 VSS.t3209 sg13_lv_nmos ad=0.2516p pd=2.16u as=0.1898p ps=1.36u w=0.74u l=0.13u
X3281 a_26244_14909# a_26475_14495# a_25930_14452# VSS.t137 sg13_lv_nmos ad=0.2373p pd=1.97u as=79.8f ps=0.8u w=0.42u l=0.13u
X3282 VDD VSS.t2786 VDD VDD sg13_lv_pmos ad=0.34p pd=2.68u as=0 ps=0 w=1u l=1u
X3283 VSS.t866 VDD VSS.t868 VSS.t867 sg13_lv_nmos ad=79.8f pd=0.8u as=0 ps=0 w=0.42u l=1u
X3284 a_25670_14922# sg13cmos5l_dfrbpq_1_7.D VDD VDD sg13_lv_pmos ad=79.8f pd=0.8u as=0.1428p ps=1.52u w=0.42u l=0.13u
X3285 VSS.t1312 VDD VSS.t1311 VSS.t70 sg13_lv_nmos ad=0.1428p pd=1.52u as=0 ps=0 w=0.42u l=1u
X3286 VDD VSS.t2398 VDD VDD sg13_lv_pmos ad=0.34p pd=2.68u as=0 ps=0 w=1u l=1u
X3287 VDD VSS.t53 VDD VDD sg13_lv_pmos ad=0.34p pd=2.68u as=0 ps=0 w=1u l=1u
X3288 VDD VSS.t591 VDD VDD sg13_lv_pmos ad=0.34p pd=2.68u as=0 ps=0 w=1u l=1u
X3289 VDD VSS.t935 VDD VDD sg13_lv_pmos ad=0.34p pd=2.68u as=0 ps=0 w=1u l=1u
X3290 VDD VSS.t2633 VDD VDD sg13_lv_pmos ad=0.34p pd=2.68u as=0 ps=0 w=1u l=1u
X3291 VSS.t1877 VDD VSS.t1876 VSS.t1875 sg13_lv_nmos ad=0.1428p pd=1.52u as=0 ps=0 w=0.42u l=1u
X3292 VDD VSS.t1229 VDD VDD sg13_lv_pmos ad=0.19p pd=1.38u as=0 ps=0 w=1u l=1u
X3293 VDD VSS.t2734 VDD VDD sg13_lv_pmos ad=0.19p pd=1.38u as=0 ps=0 w=1u l=1u
X3294 VDD VSS.t2004 VDD VDD sg13_lv_pmos ad=0.19p pd=1.38u as=0 ps=0 w=1u l=1u
X3295 a_24169_14508# sg13cmos5l_or3_1_2.B VSS.t174 VSS.t56 sg13_lv_nmos ad=0.198p pd=1.27u as=0.1045p ps=0.93u w=0.55u l=0.13u
X3296 VSS.t157 VDD VSS.t157 VSS.t726 sg13_lv_nmos ad=0.1428p pd=1.52u as=0 ps=0 w=0.42u l=1u
X3297 VSS.t2419 VDD VSS.t2418 VSS.t2417 sg13_lv_nmos ad=0.1428p pd=1.52u as=0 ps=0 w=0.42u l=1u
X3298 VDD VSS.t873 VDD VDD sg13_lv_pmos ad=0.19p pd=1.38u as=0 ps=0 w=1u l=1u
X3299 VDD VSS.t1504 VDD VDD sg13_lv_pmos ad=0.34p pd=2.68u as=0 ps=0 w=1u l=1u
X3300 VDD VSS.t2358 VDD VDD sg13_lv_pmos ad=0.34p pd=2.68u as=0 ps=0 w=1u l=1u
X3301 VDD VSS.t544 VDD VDD sg13_lv_pmos ad=0.34p pd=2.68u as=0 ps=0 w=1u l=1u
X3302 VSS.t1675 VDD VSS.t1677 VSS.t1676 sg13_lv_nmos ad=79.8f pd=0.8u as=0 ps=0 w=0.42u l=1u
X3303 VSS.t1585 VDD VSS.t1584 VSS.t1583 sg13_lv_nmos ad=0.1428p pd=1.52u as=0 ps=0 w=0.42u l=1u
X3304 a_18106_15960# sg13cmos5l_dlygate4sd3_1_5.A VSS.t128 VSS.t3271 sg13_lv_nmos ad=0.1428p pd=1.52u as=79.8f ps=0.8u w=0.42u l=0.13u
X3305 VDD VSS.t512 VDD VDD sg13_lv_pmos ad=0.19p pd=1.38u as=0 ps=0 w=1u l=1u
X3306 a_6996_13320# sg13cmos5l_xnor2_1_2.B a_6540_13238# VSS.t3220 sg13_lv_nmos ad=78.39999f pd=0.885u as=0.2176p ps=1.96u w=0.64u l=0.13u
X3307 VDD VSS.t835 VDD VDD sg13_lv_pmos ad=0.34p pd=2.68u as=0 ps=0 w=1u l=1u
X3308 VSS.t1041 VDD VSS.t1040 VSS.t1039 sg13_lv_nmos ad=0.1428p pd=1.52u as=0 ps=0 w=0.42u l=1u
X3309 VDD VSS.t1687 VDD VDD sg13_lv_pmos ad=0.19p pd=1.38u as=0 ps=0 w=1u l=1u
X3310 VDD VSS.t624 VDD VDD sg13_lv_pmos ad=0.34p pd=2.68u as=0 ps=0 w=1u l=1u
X3311 VSS.t615 VDD VSS.t618 VSS.t751 sg13_lv_nmos ad=79.8f pd=0.8u as=0 ps=0 w=0.42u l=1u
X3312 sg13cmos5l_buf_1_0.X a_1192_3900# VSS.t62 VSS.t61 sg13_lv_nmos ad=0.2886p pd=2.26u as=0.14875p ps=1.16u w=0.74u l=0.13u
X3313 VSS.t2484 VDD VSS.t2486 VSS.t2485 sg13_lv_nmos ad=79.8f pd=0.8u as=0 ps=0 w=0.42u l=1u
X3314 VDD VSS.t3019 VDD VDD sg13_lv_pmos ad=0.34p pd=2.68u as=0 ps=0 w=1u l=1u
X3315 VDD VSS.t1886 VDD VDD sg13_lv_pmos ad=0.34p pd=2.68u as=0 ps=0 w=1u l=1u
X3316 VDD VSS.t552 VDD VDD sg13_lv_pmos ad=0.19p pd=1.38u as=0 ps=0 w=1u l=1u
X3317 VDD VSS.t2059 VDD VDD sg13_lv_pmos ad=0.19p pd=1.38u as=0 ps=0 w=1u l=1u
X3318 VSS.t1705 VDD VSS.t1704 VSS.t1703 sg13_lv_nmos ad=0.1428p pd=1.52u as=0 ps=0 w=0.42u l=1u
X3319 VDD VSS.t1557 VDD VDD sg13_lv_pmos ad=0.19p pd=1.38u as=0 ps=0 w=1u l=1u
X3320 VSS.t2643 VDD VSS.t2642 VSS.t61 sg13_lv_nmos ad=0.1428p pd=1.52u as=0 ps=0 w=0.42u l=1u
X3321 VDD VSS.t2693 VDD VDD sg13_lv_pmos ad=0.19p pd=1.38u as=0 ps=0 w=1u l=1u
X3322 VSS.t73 a_8582_15238# a_8694_15302# VSS.t231 sg13_lv_nmos ad=0.1426p pd=1.16u as=0.1428p ps=1.52u w=0.42u l=0.5u
X3323 VDD VSS.t888 VDD VDD sg13_lv_pmos ad=0.19p pd=1.38u as=0 ps=0 w=1u l=1u
X3324 VSS.t3005 VDD VSS.t3004 VSS.t3003 sg13_lv_nmos ad=0.1428p pd=1.52u as=0 ps=0 w=0.42u l=1u
X3325 VSS.t1505 VDD VSS.t1507 VSS.t1506 sg13_lv_nmos ad=79.8f pd=0.8u as=0 ps=0 w=0.42u l=1u
X3326 VSS.t624 VDD VSS.t627 VSS.t757 sg13_lv_nmos ad=79.8f pd=0.8u as=0 ps=0 w=0.42u l=1u
X3327 VSS.t781 VDD VSS.t783 VSS.t782 sg13_lv_nmos ad=79.8f pd=0.8u as=0 ps=0 w=0.42u l=1u
X3328 VDD VSS.t2024 VDD VDD sg13_lv_pmos ad=0.19p pd=1.38u as=0 ps=0 w=1u l=1u
X3329 VDD VSS.t825 VDD VDD sg13_lv_pmos ad=0.34p pd=2.68u as=0 ps=0 w=1u l=1u
X3330 VSS.t1247 VDD VSS.t1246 VSS.t70 sg13_lv_nmos ad=0.1428p pd=1.52u as=0 ps=0 w=0.42u l=1u
X3331 VDD VSS.t639 VDD VDD sg13_lv_pmos ad=0.34p pd=2.68u as=0 ps=0 w=1u l=1u
X3332 VDD VSS.t3134 VDD VDD sg13_lv_pmos ad=0.34p pd=2.68u as=0 ps=0 w=1u l=1u
X3333 VSS.t2641 VDD VSS.t2640 VSS.t61 sg13_lv_nmos ad=0.1428p pd=1.52u as=0 ps=0 w=0.42u l=1u
X3334 a_9158_15234# a_9963_15356# a_9418_15457# VDD sg13_lv_pmos ad=0.1428p pd=1.52u as=79.8f ps=0.8u w=0.42u l=0.13u
X3335 VSS.t15 sg13cmos5l_dfrbpq_1_1.RESET_B a_6180_14922# VSS.t200 sg13_lv_nmos ad=0.1626p pd=1.415u as=60.89999f ps=0.71u w=0.42u l=0.13u
X3336 sg13cmos5l_o21ai_1_2.Y sg13cmos5l_o21ai_1_2.A2 a_23736_14464# VDD sg13_lv_pmos ad=0.2128p pd=1.5u as=0.2128p ps=1.5u w=1.12u l=0.15u
X3337 VDD VSS.t1707 VDD VDD sg13_lv_pmos ad=0.19p pd=1.38u as=0 ps=0 w=1u l=1u
X3338 VDD a_17327_13799# a_17994_14020# VDD sg13_lv_pmos ad=0.2128p pd=1.5u as=0.3864p ps=2.93u w=1.12u l=0.13u
X3339 VSS.t521 VDD VSS.t521 VSS.t525 sg13_lv_nmos ad=79.8f pd=0.8u as=0 ps=0 w=0.42u l=1u
X3340 VDD VSS.t2051 VDD VDD sg13_lv_pmos ad=0.34p pd=2.68u as=0 ps=0 w=1u l=1u
X3341 VSS.t1173 VDD VSS.t1172 VSS.t70 sg13_lv_nmos ad=0.1428p pd=1.52u as=0 ps=0 w=0.42u l=1u
X3342 VSS.t1356 VDD VSS.t1206 VSS.t70 sg13_lv_nmos ad=79.8f pd=0.8u as=0 ps=0 w=0.42u l=1u
X3343 a_23858_15242# sg13cmos5l_dfrbpq_1_2.Q VSS.t3191 VSS.t65 sg13_lv_nmos ad=0.1406p pd=1.12u as=0.2516p ps=2.16u w=0.74u l=0.13u
X3344 VSS.t2439 VDD VSS.t2438 VSS.t2437 sg13_lv_nmos ad=0.1428p pd=1.52u as=0 ps=0 w=0.42u l=1u
X3345 VSS.t2279 VDD VSS.t2281 VSS.t2280 sg13_lv_nmos ad=79.8f pd=0.8u as=0 ps=0 w=0.42u l=1u
X3346 VDD VSS.t147 VDD VDD sg13_lv_pmos ad=0.34p pd=2.68u as=0 ps=0 w=1u l=1u
X3347 a_7643_15280# sg13cmos5l_dlygate4sd3_1_8.X VSS.t124 VSS.t3216 sg13_lv_nmos ad=78.39999f pd=0.885u as=0.2272p ps=1.99u w=0.64u l=0.13u
X3348 VSS.t796 VDD VSS.t798 VSS.t797 sg13_lv_nmos ad=79.8f pd=0.8u as=0 ps=0 w=0.42u l=1u
X3349 VSS.t1545 VDD VSS.t1547 VSS.t1546 sg13_lv_nmos ad=79.8f pd=0.8u as=0 ps=0 w=0.42u l=1u
X3350 VSS.t1725 VDD VSS.t1724 VSS.t1723 sg13_lv_nmos ad=0.1428p pd=1.52u as=0 ps=0 w=0.42u l=1u
X3351 VSS.t3070 VDD VSS.t3072 VSS.t3071 sg13_lv_nmos ad=79.8f pd=0.8u as=0 ps=0 w=0.42u l=1u
X3352 VDD VSS.t421 VDD VDD sg13_lv_pmos ad=0.19p pd=1.38u as=0 ps=0 w=1u l=1u
X3353 VDD VSS.t1053 VDD VDD sg13_lv_pmos ad=0.19p pd=1.38u as=0 ps=0 w=1u l=1u
X3354 VSS.t866 VDD VSS.t868 VSS.t867 sg13_lv_nmos ad=79.8f pd=0.8u as=0 ps=0 w=0.42u l=1u
X3355 VDD VSS.t855 VDD VDD sg13_lv_pmos ad=0.34p pd=2.68u as=0 ps=0 w=1u l=1u
X3356 VDD VSS.t2684 VDD VDD sg13_lv_pmos ad=0.19p pd=1.38u as=0 ps=0 w=1u l=1u
X3357 VSS.t1937 VDD VSS.t1936 VSS.t1935 sg13_lv_nmos ad=0.1428p pd=1.52u as=0 ps=0 w=0.42u l=1u
X3358 VSS.t32 a_27898_15202# a_27617_15424# VSS.t15 sg13_lv_nmos ad=79.8f pd=0.8u as=0.1428p ps=1.52u w=0.42u l=0.5u
X3359 VDD VSS.t2964 VDD VDD sg13_lv_pmos ad=0.34p pd=2.68u as=0 ps=0 w=1u l=1u
X3360 VSS.t3025 VDD VSS.t3024 VSS.t3023 sg13_lv_nmos ad=0.1428p pd=1.52u as=0 ps=0 w=0.42u l=1u
X3361 VSS.t47 sg13cmos5l_inv_1_0.A sg13cmos5l_inv_1_0.Y VSS.t3283 sg13_lv_nmos ad=0.2516p pd=2.16u as=0.2516p ps=2.16u w=0.74u l=0.13u
X3362 VSS.t34 VDD VSS.t34 VSS.t388 sg13_lv_nmos ad=79.8f pd=0.8u as=0 ps=0 w=0.42u l=1u
X3363 VDD VSS.t587 VDD VDD sg13_lv_pmos ad=0.19p pd=1.38u as=0 ps=0 w=1u l=1u
X3364 VDD VSS.t2383 VDD VDD sg13_lv_pmos ad=0.34p pd=2.68u as=0 ps=0 w=1u l=1u
X3365 VSS.t702 VDD VSS.t701 VSS.t700 sg13_lv_nmos ad=0.1428p pd=1.52u as=0 ps=0 w=0.42u l=1u
X3366 VDD VSS.t1502 VDD VDD sg13_lv_pmos ad=0.19p pd=1.38u as=0 ps=0 w=1u l=1u
X3367 VDD VSS.t2411 VDD VDD sg13_lv_pmos ad=0.19p pd=1.38u as=0 ps=0 w=1u l=1u
X3368 VSS.t2469 VDD VSS.t2471 VSS.t2470 sg13_lv_nmos ad=79.8f pd=0.8u as=0 ps=0 w=0.42u l=1u
X3369 VDD a_17806_15423# sg13cmos5l_inv_1_0.A VDD sg13_lv_pmos ad=0.2254p pd=1.53u as=0.4256p ps=3u w=1.12u l=0.13u
X3370 VSS.t298 VDD VSS.t298 VSS.t301 sg13_lv_nmos ad=79.8f pd=0.8u as=0 ps=0 w=0.42u l=1u
X3371 VSS.t565 VDD VSS.t564 VSS.t563 sg13_lv_nmos ad=0.1428p pd=1.52u as=0 ps=0 w=0.42u l=1u
X3372 a_25956_14488# a_26475_14495# a_27215_14845# VSS.t15 sg13_lv_nmos ad=0.3473p pd=2.71u as=0.12665p ps=1.145u w=0.74u l=0.13u
X3373 VDD VSS.t544 VDD VDD sg13_lv_pmos ad=0.34p pd=2.68u as=0 ps=0 w=1u l=1u
X3374 VDD VSS.t918 VDD VDD sg13_lv_pmos ad=0.19p pd=1.38u as=0 ps=0 w=1u l=1u
X3375 VDD VSS.t1219 VDD VDD sg13_lv_pmos ad=0.19p pd=1.38u as=0 ps=0 w=1u l=1u
X3376 VSS.t1182 VDD VSS.t1181 VSS.t70 sg13_lv_nmos ad=0.1428p pd=1.52u as=0 ps=0 w=0.42u l=1u
X3377 VSS.t1291 VDD VSS.t1292 VSS.t70 sg13_lv_nmos ad=79.8f pd=0.8u as=0 ps=0 w=0.42u l=1u
X3378 VDD VSS.t1325 VDD VDD sg13_lv_pmos ad=0.34p pd=2.68u as=0 ps=0 w=1u l=1u
X3379 VSS.t1635 VDD VSS.t1637 VSS.t1636 sg13_lv_nmos ad=79.8f pd=0.8u as=0 ps=0 w=0.42u l=1u
X3380 VSS.t2017 VDD VSS.t2019 VSS.t2018 sg13_lv_nmos ad=79.8f pd=0.8u as=0 ps=0 w=0.42u l=1u
X3381 sg13cmos5l_nand3_1_0.Y sg13cmos5l_dlygate4sd3_1_3.A VDD VDD sg13_lv_pmos ad=0.2128p pd=1.5u as=0.3808p ps=2.92u w=1.12u l=0.13u
X3382 VSS.t1222 VDD VSS.t1223 VSS.t70 sg13_lv_nmos ad=79.8f pd=0.8u as=0 ps=0 w=0.42u l=1u
X3383 VDD VSS.t1316 VDD VDD sg13_lv_pmos ad=0.19p pd=1.38u as=0 ps=0 w=1u l=1u
X3384 VSS.t1520 VDD VSS.t1519 VSS.t1518 sg13_lv_nmos ad=0.1428p pd=1.52u as=0 ps=0 w=0.42u l=1u
X3385 VDD VSS.t2696 VDD VDD sg13_lv_pmos ad=0.34p pd=2.68u as=0 ps=0 w=1u l=1u
X3386 VDD VSS.t512 VDD VDD sg13_lv_pmos ad=0.19p pd=1.38u as=0 ps=0 w=1u l=1u
X3387 a_15876_13722# sg13cmos5l_dfrbpq_1_2.D a_15782_13722# VSS.t3266 sg13_lv_nmos ad=60.89999f pd=0.71u as=0.1428p ps=1.52u w=0.42u l=0.13u
X3388 VSS.t645 VDD VSS.t645 VSS.t646 sg13_lv_nmos ad=79.8f pd=0.8u as=0 ps=0 w=0.42u l=1u
X3389 VSS.t1187 VDD VSS.t1186 VSS.t70 sg13_lv_nmos ad=0.1428p pd=1.52u as=0 ps=0 w=0.42u l=1u
X3390 VDD VSS.t2036 VDD VDD sg13_lv_pmos ad=0.34p pd=2.68u as=0 ps=0 w=1u l=1u
X3391 VSS.t951 VDD VSS.t953 VSS.t952 sg13_lv_nmos ad=79.8f pd=0.8u as=0 ps=0 w=0.42u l=1u
X3392 VDD VSS.t1679 VDD VDD sg13_lv_pmos ad=0.34p pd=2.68u as=0 ps=0 w=1u l=1u
X3393 VDD VSS.t1871 VDD VDD sg13_lv_pmos ad=0.34p pd=2.68u as=0 ps=0 w=1u l=1u
X3394 VSS.t15 VDD VSS.t15 VSS.t464 sg13_lv_nmos ad=79.8f pd=0.8u as=0 ps=0 w=0.42u l=1u
X3395 VSS.t3055 VDD VSS.t3057 VSS.t3056 sg13_lv_nmos ad=79.8f pd=0.8u as=0 ps=0 w=0.42u l=1u
X3396 VSS.t2264 VDD VSS.t2266 VSS.t2265 sg13_lv_nmos ad=79.8f pd=0.8u as=0 ps=0 w=0.42u l=1u
X3397 VDD VSS.t1542 VDD VDD sg13_lv_pmos ad=0.19p pd=1.38u as=0 ps=0 w=1u l=1u
X3398 VDD VSS.t1719 VDD VDD sg13_lv_pmos ad=0.34p pd=2.68u as=0 ps=0 w=1u l=1u
X3399 VDD VSS.t2788 VDD VDD sg13_lv_pmos ad=0.34p pd=2.68u as=0 ps=0 w=1u l=1u
X3400 VSS.t2339 VDD VSS.t2341 VSS.t2340 sg13_lv_nmos ad=79.8f pd=0.8u as=0 ps=0 w=0.42u l=1u
X3401 VSS.t781 VDD VSS.t783 VSS.t782 sg13_lv_nmos ad=79.8f pd=0.8u as=0 ps=0 w=0.42u l=1u
X3402 VDD VSS.t2403 VDD VDD sg13_lv_pmos ad=0.34p pd=2.68u as=0 ps=0 w=1u l=1u
X3403 VDD VSS.t2061 VDD VDD sg13_lv_pmos ad=0.34p pd=2.68u as=0 ps=0 w=1u l=1u
X3404 VSS.t1490 VDD VSS.t1492 VSS.t1491 sg13_lv_nmos ad=79.8f pd=0.8u as=0 ps=0 w=0.42u l=1u
X3405 a_9732_15247# a_9444_15552# a_9670_15247# VSS.t89 sg13_lv_nmos ad=0.1428p pd=1.52u as=37.8f ps=0.6u w=0.42u l=0.13u
X3406 sg13cmos5l_buf_8_2.A a_15579_14854# VSS.t47 VSS.t3238 sg13_lv_nmos ad=0.1406p pd=1.12u as=0.1406p ps=1.12u w=0.74u l=0.13u
X3407 VSS.t1273 VDD VSS.t1272 VSS.t70 sg13_lv_nmos ad=0.1428p pd=1.52u as=0 ps=0 w=0.42u l=1u
X3408 VDD VSS.t1232 VDD VDD sg13_lv_pmos ad=0.19p pd=1.38u as=0 ps=0 w=1u l=1u
X3409 VDD VSS.t2737 VDD VDD sg13_lv_pmos ad=0.19p pd=1.38u as=0 ps=0 w=1u l=1u
X3410 VDD VSS.t2009 VDD VDD sg13_lv_pmos ad=0.19p pd=1.38u as=0 ps=0 w=1u l=1u
X3411 a_17604_14488# a_17578_14452# VSS.t64 VSS.t143 sg13_lv_nmos ad=0.2516p pd=2.16u as=0.1626p ps=1.415u w=0.74u l=0.13u
X3412 VDD VSS.t454 VDD VDD sg13_lv_pmos ad=0.19p pd=1.38u as=0 ps=0 w=1u l=1u
X3413 VSS.t2424 VDD VSS.t2423 VSS.t2422 sg13_lv_nmos ad=0.1428p pd=1.52u as=0 ps=0 w=0.42u l=1u
X3414 VDD VSS.t357 VDD VDD sg13_lv_pmos ad=0.34p pd=2.68u as=0 ps=0 w=1u l=1u
X3415 VDD VSS.t1509 VDD VDD sg13_lv_pmos ad=0.34p pd=2.68u as=0 ps=0 w=1u l=1u
X3416 VSS.t2632 VDD VSS.t2632 VSS.t61 sg13_lv_nmos ad=0.1428p pd=1.52u as=0 ps=0 w=0.42u l=1u
X3417 VDD VSS.t2363 VDD VDD sg13_lv_pmos ad=0.34p pd=2.68u as=0 ps=0 w=1u l=1u
X3418 a_16140_15424# sg13cmos5l_or3_1_2.B VDD VDD sg13_lv_pmos ad=0.1596p pd=1.22u as=0.2891p ps=1.695u w=0.84u l=0.13u
X3419 VDD VSS.t325 VDD VDD sg13_lv_pmos ad=0.34p pd=2.68u as=0 ps=0 w=1u l=1u
X3420 VSS.t627 VDD VSS.t624 VSS.t626 sg13_lv_nmos ad=0.1428p pd=1.52u as=0 ps=0 w=0.42u l=1u
X3421 VSS.t1972 VDD VSS.t1971 VSS.t1970 sg13_lv_nmos ad=0.1428p pd=1.52u as=0 ps=0 w=0.42u l=1u
X3422 a_22319_14845# a_21477_14495# a_22225_14845# VSS.t56 sg13_lv_nmos ad=0.12665p pd=1.145u as=0.1428p ps=1.52u w=0.42u l=0.13u
X3423 VSS.t1411 VDD VSS.t1276 VSS.t70 sg13_lv_nmos ad=0.1428p pd=1.52u as=0 ps=0 w=0.42u l=1u
X3424 VSS.t1555 VDD VSS.t1554 VSS.t1553 sg13_lv_nmos ad=0.1428p pd=1.52u as=0 ps=0 w=0.42u l=1u
X3425 VDD VSS.t1692 VDD VDD sg13_lv_pmos ad=0.19p pd=1.38u as=0 ps=0 w=1u l=1u
X3426 VSS.t378 VDD VSS.t378 VSS.t379 sg13_lv_nmos ad=0.1428p pd=1.52u as=0 ps=0 w=0.42u l=1u
X3427 a_25774_15423# a_25889_15424# VSS.t41 VSS.t119 sg13_lv_nmos ad=0.1428p pd=1.52u as=0.1426p ps=1.16u w=0.42u l=0.5u
X3428 a_19282_14922# sg13cmos5l_dfrbpq_1_3.RESET_B VSS.t43 VSS.t16 sg13_lv_nmos ad=37.8f pd=0.6u as=79.8f ps=0.8u w=0.42u l=0.13u
X3429 VSS.t601 VDD VSS.t601 VSS.t600 sg13_lv_nmos ad=0.1428p pd=1.52u as=0 ps=0 w=0.42u l=1u
X3430 VSS.t2489 VDD VSS.t2491 VSS.t2490 sg13_lv_nmos ad=79.8f pd=0.8u as=0 ps=0 w=0.42u l=1u
X3431 a_8582_15238# a_8312_15238# VDD VDD sg13_lv_pmos ad=0.34p pd=2.68u as=0.1523p ps=1.38u w=1u l=0.5u
X3432 VSS.t796 VDD VSS.t798 VSS.t797 sg13_lv_nmos ad=79.8f pd=0.8u as=0 ps=0 w=0.42u l=1u
X3433 VSS.t1309 VDD VSS.t1310 VSS.t70 sg13_lv_nmos ad=79.8f pd=0.8u as=0 ps=0 w=0.42u l=1u
X3434 VDD VSS.t1522 VDD VDD sg13_lv_pmos ad=0.19p pd=1.38u as=0 ps=0 w=1u l=1u
X3435 VDD VSS.t2989 VDD VDD sg13_lv_pmos ad=0.34p pd=2.68u as=0 ps=0 w=1u l=1u
X3436 VDD VSS.t1856 VDD VDD sg13_lv_pmos ad=0.34p pd=2.68u as=0 ps=0 w=1u l=1u
X3437 VDD a_4078_14751# sg13cmos5l_xor2_1_0.B VDD sg13_lv_pmos ad=0.2254p pd=1.53u as=0.4256p ps=3u w=1.12u l=0.13u
X3438 VSS.t1710 VDD VSS.t1709 VSS.t1708 sg13_lv_nmos ad=0.1428p pd=1.52u as=0 ps=0 w=0.42u l=1u
X3439 VSS.t460 VDD VSS.t462 VSS.t461 sg13_lv_nmos ad=79.8f pd=0.8u as=0 ps=0 w=0.42u l=1u
X3440 VDD VSS.t2780 VDD VDD sg13_lv_pmos ad=0.34p pd=2.68u as=0 ps=0 w=1u l=1u
X3441 VDD VSS.t2676 VDD VDD sg13_lv_pmos ad=0.19p pd=1.38u as=0 ps=0 w=1u l=1u
X3442 VSS.t1922 VDD VSS.t1921 VSS.t1920 sg13_lv_nmos ad=0.1428p pd=1.52u as=0 ps=0 w=0.42u l=1u
X3443 VDD VSS.t2949 VDD VDD sg13_lv_pmos ad=0.34p pd=2.68u as=0 ps=0 w=1u l=1u
X3444 VSS.t3010 VDD VSS.t3009 VSS.t3008 sg13_lv_nmos ad=0.1428p pd=1.52u as=0 ps=0 w=0.42u l=1u
X3445 VDD a_18586_15455# sg13cmos5l_dfrbpq_1_3.RESET_B VDD sg13_lv_pmos ad=2.8961p pd=18.25u as=0.3927p ps=2.99u w=1.155u l=0.13u
X3446 VSS.t518 VDD VSS.t518 VSS.t519 sg13_lv_nmos ad=0.1428p pd=1.52u as=0 ps=0 w=0.42u l=1u
X3447 VDD VSS.t910 VDD VDD sg13_lv_pmos ad=0.34p pd=2.68u as=0 ps=0 w=1u l=1u
X3448 sg13cmos5l_o21ai_1_3.Y sg13cmos5l_or3_1_1.A a_24310_15230# VSS.t65 sg13_lv_nmos ad=0.2516p pd=2.16u as=0.1406p ps=1.12u w=0.74u l=0.15u
X3449 VSS.t599 VDD VSS.t596 VSS.t721 sg13_lv_nmos ad=0.1428p pd=1.52u as=0 ps=0 w=0.42u l=1u
X3450 VDD VSS.t1177 VDD VDD sg13_lv_pmos ad=0.19p pd=1.38u as=0 ps=0 w=1u l=1u
X3451 VSS.t441 VDD VSS.t442 VSS.t15 sg13_lv_nmos ad=79.8f pd=0.8u as=0 ps=0 w=0.42u l=1u
X3452 VDD VSS.t833 VDD VDD sg13_lv_pmos ad=0.19p pd=1.38u as=0 ps=0 w=1u l=1u
X3453 VDD VSS.t1025 VDD VDD sg13_lv_pmos ad=0.34p pd=2.68u as=0 ps=0 w=1u l=1u
X3454 VSS.t1287 VDD VSS.t1286 VSS.t70 sg13_lv_nmos ad=0.1428p pd=1.52u as=0 ps=0 w=0.42u l=1u
X3455 VDD VSS.t1487 VDD VDD sg13_lv_pmos ad=0.19p pd=1.38u as=0 ps=0 w=1u l=1u
X3456 VSS.t2454 VDD VSS.t2456 VSS.t2455 sg13_lv_nmos ad=79.8f pd=0.8u as=0 ps=0 w=0.42u l=1u
X3457 VSS.t282 VDD VSS.t282 VSS.t281 sg13_lv_nmos ad=0.1428p pd=1.52u as=0 ps=0 w=0.42u l=1u
X3458 VDD sg13cmos5l_dfrbpq_1_5.RESET_B a_26122_13945# VDD sg13_lv_pmos ad=0.1563p pd=1.22u as=0.147p ps=1.54u w=0.42u l=0.13u
X3459 VSS.t530 sg13cmos5l_xnor2_1_2.A a_6996_13320# VSS.t3210 sg13_lv_nmos ad=0.2272p pd=1.99u as=78.39999f ps=0.885u w=0.64u l=0.13u
X3460 VDD VSS.t2396 VDD VDD sg13_lv_pmos ad=0.19p pd=1.38u as=0 ps=0 w=1u l=1u
X3461 VDD VSS.t2728 VDD VDD sg13_lv_pmos ad=0.19p pd=1.38u as=0 ps=0 w=1u l=1u
X3462 VSS.t2284 VDD VSS.t2286 VSS.t2285 sg13_lv_nmos ad=79.8f pd=0.8u as=0 ps=0 w=0.42u l=1u
X3463 VSS.t2409 VDD VSS.t2408 VSS.t2407 sg13_lv_nmos ad=0.1428p pd=1.52u as=0 ps=0 w=0.42u l=1u
X3464 VSS.t1620 VDD VSS.t1622 VSS.t1621 sg13_lv_nmos ad=79.8f pd=0.8u as=0 ps=0 w=0.42u l=1u
X3465 VSS.t2743 VDD VSS.t2743 VSS.t61 sg13_lv_nmos ad=79.8f pd=0.8u as=0 ps=0 w=0.42u l=1u
X3466 VSS.t157 sg13cmos5l_or3_1_1.C a_24841_13726# VSS.t173 sg13_lv_nmos ad=0.1045p pd=0.93u as=0.187p ps=1.78u w=0.55u l=0.13u
X3467 VDD VSS.t110 VDD VDD sg13_lv_pmos ad=0.34p pd=2.68u as=0 ps=0 w=1u l=1u
X3468 VDD VSS.t785 VDD VDD sg13_lv_pmos ad=0.34p pd=2.68u as=0 ps=0 w=1u l=1u
X3469 VSS.t1575 VDD VSS.t1574 VSS.t1573 sg13_lv_nmos ad=0.1428p pd=1.52u as=0 ps=0 w=0.42u l=1u
X3470 VSS.t1505 VDD VSS.t1504 VSS.t1503 sg13_lv_nmos ad=0.1428p pd=1.52u as=0 ps=0 w=0.42u l=1u
X3471 VDD VSS.t1677 VDD VDD sg13_lv_pmos ad=0.19p pd=1.38u as=0 ps=0 w=1u l=1u
X3472 a_37484_15960# sg13cmos5l_dfrbpq_1_5.Q VDD VDD sg13_lv_pmos ad=0.2856p pd=2.36u as=0.2114p ps=1.54u w=0.84u l=0.13u
X3473 VSS.t951 VDD VSS.t953 VSS.t952 sg13_lv_nmos ad=79.8f pd=0.8u as=0 ps=0 w=0.42u l=1u
X3474 VDD VSS.t1231 VDD VDD sg13_lv_pmos ad=0.34p pd=2.68u as=0 ps=0 w=1u l=1u
X3475 VSS.t1323 VDD VSS.t1324 VSS.t70 sg13_lv_nmos ad=79.8f pd=0.8u as=0 ps=0 w=0.42u l=1u
X3476 VDD VSS.t572 VDD VDD sg13_lv_pmos ad=0.19p pd=1.38u as=0 ps=0 w=1u l=1u
X3477 VDD VSS.t1239 VDD VDD sg13_lv_pmos ad=0.34p pd=2.68u as=0 ps=0 w=1u l=1u
X3478 VDD VSS.t2743 VDD VDD sg13_lv_pmos ad=0.34p pd=2.68u as=0 ps=0 w=1u l=1u
X3479 VDD VSS.t2021 VDD VDD sg13_lv_pmos ad=0.34p pd=2.68u as=0 ps=0 w=1u l=1u
X3480 VSS.t587 VDD VSS.t587 VSS.t586 sg13_lv_nmos ad=0.1428p pd=1.52u as=0 ps=0 w=0.42u l=1u
X3481 VSS.t4 a_14261_15238# sg13cmos5l_or3_1_1.B VSS.t250 sg13_lv_nmos ad=0.2516p pd=2.16u as=0.1406p ps=1.12u w=0.74u l=0.13u
X3482 VSS.t187 VDD VSS.t187 VSS.t472 sg13_lv_nmos ad=0.1428p pd=1.52u as=0 ps=0 w=0.42u l=1u
X3483 VSS.t2249 VDD VSS.t2251 VSS.t2250 sg13_lv_nmos ad=79.8f pd=0.8u as=0 ps=0 w=0.42u l=1u
X3484 VSS.t1942 VDD VSS.t1941 VSS.t1940 sg13_lv_nmos ad=0.1428p pd=1.52u as=0 ps=0 w=0.42u l=1u
X3485 VDD VSS.t639 VDD VDD sg13_lv_pmos ad=0.19p pd=1.38u as=0 ps=0 w=1u l=1u
X3486 VDD VSS.t1704 VDD VDD sg13_lv_pmos ad=0.34p pd=2.68u as=0 ps=0 w=1u l=1u
X3487 VDD VSS.t1268 VDD VDD sg13_lv_pmos ad=0.19p pd=1.38u as=0 ps=0 w=1u l=1u
X3488 VDD VSS.t2934 VDD VDD sg13_lv_pmos ad=0.34p pd=2.68u as=0 ps=0 w=1u l=1u
X3489 VSS.t2504 VDD VSS.t2503 VSS.t2502 sg13_lv_nmos ad=0.1428p pd=1.52u as=0 ps=0 w=0.42u l=1u
X3490 VSS.t2324 VDD VSS.t2326 VSS.t2325 sg13_lv_nmos ad=79.8f pd=0.8u as=0 ps=0 w=0.42u l=1u
X3491 VDD sg13cmos5l_a21oi_1_2.A1 a_24923_15996# VDD sg13_lv_pmos ad=0.2128p pd=1.5u as=0.2128p ps=1.5u w=1.12u l=0.13u
X3492 VDD VSS.t800 VDD VDD sg13_lv_pmos ad=0.34p pd=2.68u as=0 ps=0 w=1u l=1u
X3493 VDD VSS.t988 VDD VDD sg13_lv_pmos ad=0.19p pd=1.38u as=0 ps=0 w=1u l=1u
X3494 VDD VSS.t1569 VDD VDD sg13_lv_pmos ad=0.34p pd=2.68u as=0 ps=0 w=1u l=1u
X3495 VDD VSS.t2388 VDD VDD sg13_lv_pmos ad=0.34p pd=2.68u as=0 ps=0 w=1u l=1u
X3496 VDD VSS.t1507 VDD VDD sg13_lv_pmos ad=0.19p pd=1.38u as=0 ps=0 w=1u l=1u
X3497 VDD VSS.t2416 VDD VDD sg13_lv_pmos ad=0.19p pd=1.38u as=0 ps=0 w=1u l=1u
X3498 VSS.t871 VDD VSS.t873 VSS.t872 sg13_lv_nmos ad=79.8f pd=0.8u as=0 ps=0 w=0.42u l=1u
X3499 VSS.t1605 VDD VSS.t1607 VSS.t1606 sg13_lv_nmos ad=79.8f pd=0.8u as=0 ps=0 w=0.42u l=1u
X3500 VDD VSS.t2703 VDD VDD sg13_lv_pmos ad=0.34p pd=2.68u as=0 ps=0 w=1u l=1u
X3501 VSS.t2022 VDD VSS.t2024 VSS.t2023 sg13_lv_nmos ad=79.8f pd=0.8u as=0 ps=0 w=0.42u l=1u
X3502 a_6372_14488# a_6346_14452# VDD VDD sg13_lv_pmos ad=0.34p pd=2.68u as=0.36237p ps=2.605u w=1u l=0.13u
X3503 VDD VSS.t303 VDD VDD sg13_lv_pmos ad=0.19p pd=1.38u as=0 ps=0 w=1u l=1u
X3504 VDD sg13cmos5l_dfrbpq_1_7.RESET_B a_25930_14452# VDD sg13_lv_pmos ad=0.1563p pd=1.22u as=0.147p ps=1.54u w=0.42u l=0.13u
X3505 VSS.t1433 VDD VSS.t1303 VSS.t70 sg13_lv_nmos ad=0.1428p pd=1.52u as=0 ps=0 w=0.42u l=1u
X3506 a_4432_15454# sg13cmos5l_dfrbpq_1_0.RESET_B VDD VDD sg13_lv_pmos ad=79.8f pd=0.8u as=2.8961p ps=18.25u w=0.42u l=0.13u
X3507 VDD VSS.t2443 VDD VDD sg13_lv_pmos ad=0.34p pd=2.68u as=0 ps=0 w=1u l=1u
X3508 VSS.t2474 VDD VSS.t2476 VSS.t2475 sg13_lv_nmos ad=79.8f pd=0.8u as=0 ps=0 w=0.42u l=1u
X3509 VSS.t698 VDD VSS.t699 VSS.t696 sg13_lv_nmos ad=79.8f pd=0.8u as=0 ps=0 w=0.42u l=1u
X3510 VDD VSS.t1684 VDD VDD sg13_lv_pmos ad=0.34p pd=2.68u as=0 ps=0 w=1u l=1u
X3511 VDD VSS.t2974 VDD VDD sg13_lv_pmos ad=0.34p pd=2.68u as=0 ps=0 w=1u l=1u
X3512 VSS.t2052 VDD VSS.t2051 VSS.t2050 sg13_lv_nmos ad=0.1428p pd=1.52u as=0 ps=0 w=0.42u l=1u
X3513 VDD VSS.t618 VDD VDD sg13_lv_pmos ad=0.34p pd=2.68u as=0 ps=0 w=1u l=1u
X3514 VSS.t1226 VDD VSS.t1225 VSS.t70 sg13_lv_nmos ad=0.1428p pd=1.52u as=0 ps=0 w=0.42u l=1u
X3515 VSS.t1535 VDD VSS.t1537 VSS.t1536 sg13_lv_nmos ad=79.8f pd=0.8u as=0 ps=0 w=0.42u l=1u
X3516 VSS.t3060 VDD VSS.t3062 VSS.t3061 sg13_lv_nmos ad=79.8f pd=0.8u as=0 ps=0 w=0.42u l=1u
X3517 VSS.t2269 VDD VSS.t2271 VSS.t2270 sg13_lv_nmos ad=79.8f pd=0.8u as=0 ps=0 w=0.42u l=1u
X3518 a_22576_14726# a_22319_14845# a_22738_14922# VSS.t56 sg13_lv_nmos ad=0.1428p pd=1.52u as=37.8f ps=0.6u w=0.42u l=0.13u
X3519 VDD VSS.t1547 VDD VDD sg13_lv_pmos ad=0.19p pd=1.38u as=0 ps=0 w=1u l=1u
X3520 VSS.t886 VDD VSS.t888 VSS.t887 sg13_lv_nmos ad=79.8f pd=0.8u as=0 ps=0 w=0.42u l=1u
X3521 VDD VSS.t1249 VDD VDD sg13_lv_pmos ad=0.34p pd=2.68u as=0 ps=0 w=1u l=1u
X3522 VDD VSS.t2772 VDD VDD sg13_lv_pmos ad=0.34p pd=2.68u as=0 ps=0 w=1u l=1u
X3523 VDD VSS.t955 VDD VDD sg13_lv_pmos ad=0.34p pd=2.68u as=0 ps=0 w=1u l=1u
X3524 VSS.t2344 VDD VSS.t2346 VSS.t2345 sg13_lv_nmos ad=79.8f pd=0.8u as=0 ps=0 w=0.42u l=1u
X3525 VSS.t826 VDD VSS.t825 VSS.t824 sg13_lv_nmos ad=0.1428p pd=1.52u as=0 ps=0 w=0.42u l=1u
X3526 VDD VSS.t2719 VDD VDD sg13_lv_pmos ad=0.19p pd=1.38u as=0 ps=0 w=1u l=1u
X3527 VSS.t2394 VDD VSS.t2393 VSS.t2392 sg13_lv_nmos ad=0.1428p pd=1.52u as=0 ps=0 w=0.42u l=1u
X3528 VDD VSS.t1514 VDD VDD sg13_lv_pmos ad=0.34p pd=2.68u as=0 ps=0 w=1u l=1u
X3529 VDD VSS.t521 VDD VDD sg13_lv_pmos ad=0.19p pd=1.38u as=0 ps=0 w=1u l=1u
X3530 VDD VSS.t627 VDD VDD sg13_lv_pmos ad=0.34p pd=2.68u as=0 ps=0 w=1u l=1u
X3531 VDD VSS.t1018 VDD VDD sg13_lv_pmos ad=0.19p pd=1.38u as=0 ps=0 w=1u l=1u
X3532 VDD VSS.t2074 VDD VDD sg13_lv_pmos ad=0.19p pd=1.38u as=0 ps=0 w=1u l=1u
X3533 VSS.t1560 VDD VSS.t1559 VSS.t1558 sg13_lv_nmos ad=0.1428p pd=1.52u as=0 ps=0 w=0.42u l=1u
X3534 VDD VSS.t1519 VDD VDD sg13_lv_pmos ad=0.34p pd=2.68u as=0 ps=0 w=1u l=1u
X3535 VSS.t2707 VDD VSS.t2705 VSS.t61 sg13_lv_nmos ad=0.1428p pd=1.52u as=0 ps=0 w=0.42u l=1u
X3536 VDD VSS.t2428 VDD VDD sg13_lv_pmos ad=0.34p pd=2.68u as=0 ps=0 w=1u l=1u
X3537 VSS.t2309 VDD VSS.t2311 VSS.t2310 sg13_lv_nmos ad=79.8f pd=0.8u as=0 ps=0 w=0.42u l=1u
X3538 VSS.t426 VDD VSS.t427 VSS.t15 sg13_lv_nmos ad=79.8f pd=0.8u as=0 ps=0 w=0.42u l=1u
X3539 VDD VSS.t572 VDD VDD sg13_lv_pmos ad=0.19p pd=1.38u as=0 ps=0 w=1u l=1u
X3540 VSS.t565 VDD VSS.t564 VSS.t563 sg13_lv_nmos ad=0.1428p pd=1.52u as=0 ps=0 w=0.42u l=1u
X3541 VSS.t2459 VDD VSS.t2461 VSS.t2460 sg13_lv_nmos ad=79.8f pd=0.8u as=0 ps=0 w=0.42u l=1u
X3542 VSS.t1203 VDD VSS.t1204 VSS.t70 sg13_lv_nmos ad=79.8f pd=0.8u as=0 ps=0 w=0.42u l=1u
X3543 VSS.t1240 VDD VSS.t1239 VSS.t70 sg13_lv_nmos ad=0.1428p pd=1.52u as=0 ps=0 w=0.42u l=1u
X3544 VDD VSS.t2994 VDD VDD sg13_lv_pmos ad=0.34p pd=2.68u as=0 ps=0 w=1u l=1u
X3545 VDD VSS.t1861 VDD VDD sg13_lv_pmos ad=0.34p pd=2.68u as=0 ps=0 w=1u l=1u
X3546 VSS.t2037 VDD VSS.t2036 VSS.t2035 sg13_lv_nmos ad=0.1428p pd=1.52u as=0 ps=0 w=0.42u l=1u
X3547 sg13cmos5l_dfrbpq_1_2.CLK a_12010_15202# VDD VDD sg13_lv_pmos ad=0.2128p pd=1.5u as=0.3864p ps=2.93u w=1.12u l=0.13u
X3548 VSS.t856 VDD VSS.t855 VSS.t854 sg13_lv_nmos ad=0.1428p pd=1.52u as=0 ps=0 w=0.42u l=1u
X3549 VDD VSS.t2376 VDD VDD sg13_lv_pmos ad=0.19p pd=1.38u as=0 ps=0 w=1u l=1u
X3550 VDD VSS.t2034 VDD VDD sg13_lv_pmos ad=0.19p pd=1.38u as=0 ps=0 w=1u l=1u
X3551 VSS.t1680 VDD VSS.t1679 VSS.t1678 sg13_lv_nmos ad=0.1428p pd=1.52u as=0 ps=0 w=0.42u l=1u
X3552 VDD VSS.t908 VDD VDD sg13_lv_pmos ad=0.19p pd=1.38u as=0 ps=0 w=1u l=1u
X3553 VSS.t1927 VDD VSS.t1926 VSS.t1925 sg13_lv_nmos ad=0.1428p pd=1.52u as=0 ps=0 w=0.42u l=1u
X3554 VDD VSS.t1295 VDD VDD sg13_lv_pmos ad=0.19p pd=1.38u as=0 ps=0 w=1u l=1u
X3555 VSS.t3015 VDD VSS.t3014 VSS.t3013 sg13_lv_nmos ad=0.1428p pd=1.52u as=0 ps=0 w=0.42u l=1u
X3556 a_9861_15213# sg13cmos5l_dfrbpq_1_2.CLK VSS.t15 VSS.t90 sg13_lv_nmos ad=0.2516p pd=2.16u as=3.8707p ps=25.555u w=0.74u l=0.13u
X3557 VDD VSS.t1033 VDD VDD sg13_lv_pmos ad=0.19p pd=1.38u as=0 ps=0 w=1u l=1u
X3558 VSS.t2489 VDD VSS.t2488 VSS.t2487 sg13_lv_nmos ad=0.1428p pd=1.52u as=0 ps=0 w=0.42u l=1u
X3559 VDD a_15579_14854# sg13cmos5l_buf_8_2.A VDD sg13_lv_pmos ad=0.2128p pd=1.5u as=0.2128p ps=1.5u w=1.12u l=0.13u
X3560 VSS.t624 VDD VSS.t624 VSS.t625 sg13_lv_nmos ad=79.8f pd=0.8u as=0 ps=0 w=0.42u l=1u
X3561 VDD a_22576_14726# a_22521_14607# VDD sg13_lv_pmos ad=2.42015p pd=15.68u as=93.45f ps=0.865u w=0.42u l=0.13u
X3562 VSS.t871 VDD VSS.t873 VSS.t872 sg13_lv_nmos ad=79.8f pd=0.8u as=0 ps=0 w=0.42u l=1u
X3563 VDD VSS.t1492 VDD VDD sg13_lv_pmos ad=0.19p pd=1.38u as=0 ps=0 w=1u l=1u
X3564 VSS.t2783 VDD VSS.t2784 VSS.t61 sg13_lv_nmos ad=79.8f pd=0.8u as=0 ps=0 w=0.42u l=1u
X3565 VDD VSS.t424 VDD VDD sg13_lv_pmos ad=0.19p pd=1.38u as=0 ps=0 w=1u l=1u
X3566 VSS.t916 VDD VSS.t918 VSS.t917 sg13_lv_nmos ad=79.8f pd=0.8u as=0 ps=0 w=0.42u l=1u
X3567 VDD VSS.t2401 VDD VDD sg13_lv_pmos ad=0.19p pd=1.38u as=0 ps=0 w=1u l=1u
X3568 VDD sg13cmos5l_a21oi_1_0.Y a_16856_15238# VDD sg13_lv_pmos ad=0.1523p pd=1.38u as=0.1428p ps=1.52u w=0.42u l=0.13u
X3569 VSS.t2289 VDD VSS.t2291 VSS.t2290 sg13_lv_nmos ad=79.8f pd=0.8u as=0 ps=0 w=0.42u l=1u
X3570 VSS.t479 VDD VSS.t479 VSS.t16 sg13_lv_nmos ad=0.1428p pd=1.52u as=0 ps=0 w=0.42u l=1u
X3571 VDD VSS.t783 VDD VDD sg13_lv_pmos ad=0.19p pd=1.38u as=0 ps=0 w=1u l=1u
X3572 VSS.t2007 VDD VSS.t2009 VSS.t2008 sg13_lv_nmos ad=79.8f pd=0.8u as=0 ps=0 w=0.42u l=1u
X3573 VDD VSS.t455 VDD VDD sg13_lv_pmos ad=0.34p pd=2.68u as=0 ps=0 w=1u l=1u
X3574 VSS.t2746 VDD VSS.t2747 VSS.t61 sg13_lv_nmos ad=79.8f pd=0.8u as=0 ps=0 w=0.42u l=1u
X3575 sg13cmos5l_a21oi_1_3.A1 a_25206_15302# VDD VDD sg13_lv_pmos ad=0.4256p pd=3u as=0.2254p ps=1.53u w=1.12u l=0.13u
X3576 a_6086_14922# sg13cmos5l_and2_1_1.X VDD VDD sg13_lv_pmos ad=79.8f pd=0.8u as=0.1428p ps=1.52u w=0.42u l=0.13u
X3577 a_21034_14452# a_21477_14495# a_21417_14531# VDD sg13_lv_pmos ad=79.8f pd=0.8u as=63f ps=0.72u w=0.42u l=0.13u
X3578 VSS.t532 VDD VSS.t532 VSS.t666 sg13_lv_nmos ad=79.8f pd=0.8u as=0 ps=0 w=0.42u l=1u
X3579 VSS.t1510 VDD VSS.t1509 VSS.t1508 sg13_lv_nmos ad=0.1428p pd=1.52u as=0 ps=0 w=0.42u l=1u
X3580 VDD sg13cmos5l_dfrbpq_1_7.RESET_B a_25670_14922# VDD sg13_lv_pmos ad=0.36237p pd=2.605u as=79.8f ps=0.8u w=0.42u l=0.13u
X3581 VSS.t1185 VDD VSS.t1184 VSS.t70 sg13_lv_nmos ad=0.1428p pd=1.52u as=0 ps=0 w=0.42u l=1u
X3582 VSS.t512 VDD VSS.t518 VSS.t517 sg13_lv_nmos ad=79.8f pd=0.8u as=0 ps=0 w=0.42u l=1u
X3583 VDD VSS.t1242 VDD VDD sg13_lv_pmos ad=0.34p pd=2.68u as=0 ps=0 w=1u l=1u
X3584 VDD VSS.t2747 VDD VDD sg13_lv_pmos ad=0.34p pd=2.68u as=0 ps=0 w=1u l=1u
X3585 VDD VSS.t2026 VDD VDD sg13_lv_pmos ad=0.34p pd=2.68u as=0 ps=0 w=1u l=1u
X3586 VSS.t211 a_19323_13726# sg13cmos5l_buf_8_2.X VSS.t213 sg13_lv_nmos ad=0.1406p pd=1.12u as=0.1406p ps=1.12u w=0.74u l=0.13u
X3587 VSS.t886 VDD VSS.t888 VSS.t887 sg13_lv_nmos ad=79.8f pd=0.8u as=0 ps=0 w=0.42u l=1u
X3588 VDD VSS.t433 VDD VDD sg13_lv_pmos ad=0.19p pd=1.38u as=0 ps=0 w=1u l=1u
X3589 VSS.t648 VDD VSS.t648 VSS.t649 sg13_lv_nmos ad=79.8f pd=0.8u as=0 ps=0 w=0.42u l=1u
X3590 VSS.t1520 VDD VSS.t1522 VSS.t1521 sg13_lv_nmos ad=79.8f pd=0.8u as=0 ps=0 w=0.42u l=1u
X3591 VSS.t1700 VDD VSS.t1699 VSS.t1698 sg13_lv_nmos ad=0.1428p pd=1.52u as=0 ps=0 w=0.42u l=1u
X3592 VSS.t3045 VDD VSS.t3047 VSS.t3046 sg13_lv_nmos ad=79.8f pd=0.8u as=0 ps=0 w=0.42u l=1u
X3593 VSS.t2254 VDD VSS.t2256 VSS.t2255 sg13_lv_nmos ad=79.8f pd=0.8u as=0 ps=0 w=0.42u l=1u
X3594 VDD VSS.t273 VDD VDD sg13_lv_pmos ad=0.19p pd=1.38u as=0 ps=0 w=1u l=1u
X3595 a_19065_14607# a_18123_14495# a_18863_14845# VDD sg13_lv_pmos ad=93.45f pd=0.865u as=0.2048p ps=1.63u w=0.42u l=0.13u
X3596 VDD VSS.t1709 VDD VDD sg13_lv_pmos ad=0.34p pd=2.68u as=0 ps=0 w=1u l=1u
X3597 VSS.t2509 VDD VSS.t2508 VSS.t2507 sg13_lv_nmos ad=0.1428p pd=1.52u as=0 ps=0 w=0.42u l=1u
X3598 VSS.t2329 VDD VSS.t2331 VSS.t2330 sg13_lv_nmos ad=79.8f pd=0.8u as=0 ps=0 w=0.42u l=1u
X3599 VSS.t128 sg13cmos5l_dlygate4sd3_1_4.X a_16969_16020# VSS.t3269 sg13_lv_nmos ad=0.13395p pd=1.12u as=0.198p ps=1.27u w=0.55u l=0.13u
X3600 a_2916_15552# a_2890_15457# VSS.t36 VSS.t35 sg13_lv_nmos ad=0.2516p pd=2.16u as=0.1626p ps=1.415u w=0.74u l=0.13u
X3601 VDD VSS.t253 VDD VDD sg13_lv_pmos ad=0.34p pd=2.68u as=0 ps=0 w=1u l=1u
X3602 sg13cmos5l_o21ai_1_2.A2 sg13cmos5l_dfrbpq_1_6.Q VDD VDD sg13_lv_pmos ad=0.3808p pd=2.92u as=0.2128p ps=1.5u w=1.12u l=0.13u
X3603 VSS.t826 VDD VSS.t825 VSS.t824 sg13_lv_nmos ad=0.1428p pd=1.52u as=0 ps=0 w=0.42u l=1u
X3604 VSS.t1258 VDD VSS.t1256 VSS.t70 sg13_lv_nmos ad=0.1428p pd=1.52u as=0 ps=0 w=0.42u l=1u
X3605 VDD VSS.t3112 VDD VDD sg13_lv_pmos ad=0.19p pd=1.38u as=0 ps=0 w=1u l=1u
X3606 VDD VSS.t1539 VDD VDD sg13_lv_pmos ad=0.34p pd=2.68u as=0 ps=0 w=1u l=1u
X3607 VDD VSS.t1230 VDD VDD sg13_lv_pmos ad=0.19p pd=1.38u as=0 ps=0 w=1u l=1u
X3608 VDD VSS.t938 VDD VDD sg13_lv_pmos ad=0.19p pd=1.38u as=0 ps=0 w=1u l=1u
X3609 VSS.t1610 VDD VSS.t1612 VSS.t1611 sg13_lv_nmos ad=79.8f pd=0.8u as=0 ps=0 w=0.42u l=1u
X3610 VDD VSS.t2685 VDD VDD sg13_lv_pmos ad=0.34p pd=2.68u as=0 ps=0 w=1u l=1u
X3611 VSS.t182 VDD VSS.t184 VSS.t471 sg13_lv_nmos ad=79.8f pd=0.8u as=0 ps=0 w=0.42u l=1u
X3612 VDD VSS.t521 VDD VDD sg13_lv_pmos ad=0.19p pd=1.38u as=0 ps=0 w=1u l=1u
X3613 VSS.t518 VDD VSS.t518 VSS.t519 sg13_lv_nmos ad=0.1428p pd=1.52u as=0 ps=0 w=0.42u l=1u
X3614 VDD VSS.t1499 VDD VDD sg13_lv_pmos ad=0.34p pd=2.68u as=0 ps=0 w=1u l=1u
X3615 VSS.t1199 VDD VSS.t1198 VSS.t70 sg13_lv_nmos ad=0.1428p pd=1.52u as=0 ps=0 w=0.42u l=1u
X3616 VDD VSS.t1262 VDD VDD sg13_lv_pmos ad=0.19p pd=1.38u as=0 ps=0 w=1u l=1u
X3617 VDD VSS.t2767 VDD VDD sg13_lv_pmos ad=0.19p pd=1.38u as=0 ps=0 w=1u l=1u
X3618 VSS.t363 VDD VSS.t363 VSS.t364 sg13_lv_nmos ad=0.1428p pd=1.52u as=0 ps=0 w=0.42u l=1u
X3619 VDD VSS.t875 VDD VDD sg13_lv_pmos ad=0.34p pd=2.68u as=0 ps=0 w=1u l=1u
X3620 VDD VSS.t1504 VDD VDD sg13_lv_pmos ad=0.34p pd=2.68u as=0 ps=0 w=1u l=1u
X3621 VSS.t2474 VDD VSS.t2473 VSS.t2472 sg13_lv_nmos ad=0.1428p pd=1.52u as=0 ps=0 w=0.42u l=1u
X3622 a_2646_14842# sg13cmos5l_xor2_1_0.B sg13cmos5l_xor2_1_0.X VSS.t125 sg13_lv_nmos ad=88.8f pd=0.98u as=0.1628p ps=1.18u w=0.74u l=0.13u
X3623 VDD VSS.t2413 VDD VDD sg13_lv_pmos ad=0.34p pd=2.68u as=0 ps=0 w=1u l=1u
X3624 VSS.t420 VDD VSS.t421 VSS.t15 sg13_lv_nmos ad=79.8f pd=0.8u as=0 ps=0 w=0.42u l=1u
X3625 VSS.t856 VDD VSS.t855 VSS.t854 sg13_lv_nmos ad=0.1428p pd=1.52u as=0 ps=0 w=0.42u l=1u
X3626 VSS.t1400 VDD VSS.t1266 VSS.t70 sg13_lv_nmos ad=0.1428p pd=1.52u as=0 ps=0 w=0.42u l=1u
X3627 VSS.t2304 VDD VSS.t2303 VSS.t2302 sg13_lv_nmos ad=0.1428p pd=1.52u as=0 ps=0 w=0.42u l=1u
X3628 VDD VSS.t2979 VDD VDD sg13_lv_pmos ad=0.34p pd=2.68u as=0 ps=0 w=1u l=1u
X3629 VDD VSS.t1846 VDD VDD sg13_lv_pmos ad=0.34p pd=2.68u as=0 ps=0 w=1u l=1u
X3630 VSS.t2022 VDD VSS.t2021 VSS.t2020 sg13_lv_nmos ad=0.1428p pd=1.52u as=0 ps=0 w=0.42u l=1u
X3631 VSS.t383 VDD VSS.t381 VSS.t382 sg13_lv_nmos ad=0.1428p pd=1.52u as=0 ps=0 w=0.42u l=1u
X3632 a_23638_14862# sg13cmos5l_o21ai_1_2.A2 VSS.t3191 VSS.t56 sg13_lv_nmos ad=0.1406p pd=1.12u as=0.1406p ps=1.12u w=0.74u l=0.15u
X3633 VSS.t585 VDD VSS.t584 VSS.t583 sg13_lv_nmos ad=0.1428p pd=1.52u as=0 ps=0 w=0.42u l=1u
X3634 a_3273_15625# a_2916_15552# VDD VDD sg13_lv_pmos ad=63f pd=0.72u as=0.1563p ps=1.22u w=0.42u l=0.13u
X3635 VSS.t1026 VDD VSS.t1025 VSS.t1024 sg13_lv_nmos ad=0.1428p pd=1.52u as=0 ps=0 w=0.42u l=1u
X3636 VDD VSS.t2378 VDD VDD sg13_lv_pmos ad=0.34p pd=2.68u as=0 ps=0 w=1u l=1u
X3637 VSS.t916 VDD VSS.t918 VSS.t917 sg13_lv_nmos ad=79.8f pd=0.8u as=0 ps=0 w=0.42u l=1u
X3638 VDD VSS.t1211 VDD VDD sg13_lv_pmos ad=0.34p pd=2.68u as=0 ps=0 w=1u l=1u
X3639 VSS.t1285 VDD VSS.t1284 VSS.t70 sg13_lv_nmos ad=0.1428p pd=1.52u as=0 ps=0 w=0.42u l=1u
X3640 VDD VSS.t1889 VDD VDD sg13_lv_pmos ad=0.19p pd=1.38u as=0 ps=0 w=1u l=1u
X3641 VDD VSS.t2726 VDD VDD sg13_lv_pmos ad=0.19p pd=1.38u as=0 ps=0 w=1u l=1u
X3642 a_17578_14452# a_18021_14495# a_17961_14531# VDD sg13_lv_pmos ad=79.8f pd=0.8u as=63f ps=0.72u w=0.42u l=0.13u
X3643 VSS.t1570 VDD VSS.t1569 VSS.t1568 sg13_lv_nmos ad=0.1428p pd=1.52u as=0 ps=0 w=0.42u l=1u
X3644 a_9861_15213# sg13cmos5l_dfrbpq_1_2.CLK VDD VDD sg13_lv_pmos ad=0.4088p pd=2.97u as=2.77542p ps=17.49u w=1.12u l=0.13u
X3645 VSS.t2274 VDD VSS.t2276 VSS.t2275 sg13_lv_nmos ad=79.8f pd=0.8u as=0 ps=0 w=0.42u l=1u
X3646 VSS.t724 VDD VSS.t601 VSS.t723 sg13_lv_nmos ad=0.1428p pd=1.52u as=0 ps=0 w=0.42u l=1u
X3647 VSS.t1290 VDD VSS.t1289 VSS.t70 sg13_lv_nmos ad=0.1428p pd=1.52u as=0 ps=0 w=0.42u l=1u
X3648 VDD VSS.t1484 VDD VDD sg13_lv_pmos ad=0.34p pd=2.68u as=0 ps=0 w=1u l=1u
X3649 VDD VSS.t838 VDD VDD sg13_lv_pmos ad=0.19p pd=1.38u as=0 ps=0 w=1u l=1u
X3650 VSS.t2122 VDD VSS.t2124 VSS.t2123 sg13_lv_nmos ad=79.8f pd=0.8u as=0 ps=0 w=0.42u l=1u
X3651 VDD a_26554_16237# sg13cmos5l_dfrbpq_1_5.RESET_B VDD sg13_lv_pmos ad=2.8961p pd=18.25u as=0.3927p ps=2.99u w=1.155u l=0.13u
X3652 VSS.t1321 VDD VSS.t1322 VSS.t70 sg13_lv_nmos ad=79.8f pd=0.8u as=0 ps=0 w=0.42u l=1u
X3653 VSS.t1565 VDD VSS.t1564 VSS.t1563 sg13_lv_nmos ad=0.1428p pd=1.52u as=0 ps=0 w=0.42u l=1u
X3654 VSS.t2314 VDD VSS.t2316 VSS.t2315 sg13_lv_nmos ad=79.8f pd=0.8u as=0 ps=0 w=0.42u l=1u
X3655 VDD VSS.t1233 VDD VDD sg13_lv_pmos ad=0.34p pd=2.68u as=0 ps=0 w=1u l=1u
X3656 VDD VSS.t2737 VDD VDD sg13_lv_pmos ad=0.34p pd=2.68u as=0 ps=0 w=1u l=1u
X3657 VSS.t2042 VDD VSS.t2041 VSS.t2040 sg13_lv_nmos ad=0.1428p pd=1.52u as=0 ps=0 w=0.42u l=1u
X3658 VDD VSS.t2039 VDD VDD sg13_lv_pmos ad=0.19p pd=1.38u as=0 ps=0 w=1u l=1u
X3659 VSS.t147 a_7532_15960# counter_value_o[1] VSS.t146 sg13_lv_nmos ad=0.14875p pd=1.16u as=0.2886p ps=2.26u w=0.74u l=0.13u
X3660 VSS.t1685 VDD VSS.t1684 VSS.t1683 sg13_lv_nmos ad=0.1428p pd=1.52u as=0 ps=0 w=0.42u l=1u
X3661 VDD VSS.t577 VDD VDD sg13_lv_pmos ad=0.19p pd=1.38u as=0 ps=0 w=1u l=1u
X3662 VDD VSS.t1189 VDD VDD sg13_lv_pmos ad=0.19p pd=1.38u as=0 ps=0 w=1u l=1u
X3663 VDD VSS.t1045 VDD VDD sg13_lv_pmos ad=0.34p pd=2.68u as=0 ps=0 w=1u l=1u
X3664 VSS.t2494 VDD VSS.t2493 VSS.t2492 sg13_lv_nmos ad=0.1428p pd=1.52u as=0 ps=0 w=0.42u l=1u
X3665 VSS.t292 VDD VSS.t287 VSS.t291 sg13_lv_nmos ad=0.1428p pd=1.52u as=0 ps=0 w=0.42u l=1u
X3666 VSS.t453 VDD VSS.t454 VSS.t15 sg13_lv_nmos ad=79.8f pd=0.8u as=0 ps=0 w=0.42u l=1u
X3667 VDD VSS.t1524 VDD VDD sg13_lv_pmos ad=0.34p pd=2.68u as=0 ps=0 w=1u l=1u
X3668 VDD VSS.t1874 VDD VDD sg13_lv_pmos ad=0.19p pd=1.38u as=0 ps=0 w=1u l=1u
X3669 VSS.t2899 VDD VSS.t2786 VSS.t61 sg13_lv_nmos ad=79.8f pd=0.8u as=0 ps=0 w=0.42u l=1u
X3670 VDD VSS.t2717 VDD VDD sg13_lv_pmos ad=0.19p pd=1.38u as=0 ps=0 w=1u l=1u
X3671 VSS.t1992 VDD VSS.t1991 VSS.t1990 sg13_lv_nmos ad=0.1428p pd=1.52u as=0 ps=0 w=0.42u l=1u
X3672 VDD VSS.t645 VDD VDD sg13_lv_pmos ad=0.34p pd=2.68u as=0 ps=0 w=1u l=1u
X3673 VDD VSS.t805 VDD VDD sg13_lv_pmos ad=0.34p pd=2.68u as=0 ps=0 w=1u l=1u
X3674 VSS.t1595 VDD VSS.t1597 VSS.t1596 sg13_lv_nmos ad=79.8f pd=0.8u as=0 ps=0 w=0.42u l=1u
X3675 VSS.t2728 VDD VSS.t2729 VSS.t61 sg13_lv_nmos ad=79.8f pd=0.8u as=0 ps=0 w=0.42u l=1u
X3676 VSS.t1303 VDD VSS.t1302 VSS.t70 sg13_lv_nmos ad=0.1428p pd=1.52u as=0 ps=0 w=0.42u l=1u
X3677 VDD VSS.t2466 VDD VDD sg13_lv_pmos ad=0.19p pd=1.38u as=0 ps=0 w=1u l=1u
X3678 VDD a_19054_15423# sg13cmos5l_dlygate4sd3_1_4.X VDD sg13_lv_pmos ad=0.2254p pd=1.53u as=0.4256p ps=3u w=1.12u l=0.13u
X3679 VSS.t411 VDD VSS.t412 VSS.t15 sg13_lv_nmos ad=79.8f pd=0.8u as=0 ps=0 w=0.42u l=1u
X3680 VDD VSS.t920 VDD VDD sg13_lv_pmos ad=0.34p pd=2.68u as=0 ps=0 w=1u l=1u
X3681 VSS.t1515 VDD VSS.t1514 VSS.t1513 sg13_lv_nmos ad=0.1428p pd=1.52u as=0 ps=0 w=0.42u l=1u
X3682 VDD VSS.t2241 VDD VDD sg13_lv_pmos ad=0.19p pd=1.38u as=0 ps=0 w=1u l=1u
X3683 VSS.t2072 VDD VSS.t2074 VSS.t2073 sg13_lv_nmos ad=79.8f pd=0.8u as=0 ps=0 w=0.42u l=1u
X3684 VDD VSS.t1245 VDD VDD sg13_lv_pmos ad=0.34p pd=2.68u as=0 ps=0 w=1u l=1u
X3685 VDD VSS.t2031 VDD VDD sg13_lv_pmos ad=0.34p pd=2.68u as=0 ps=0 w=1u l=1u
X3686 VDD VSS.t2729 VDD VDD sg13_lv_pmos ad=0.34p pd=2.68u as=0 ps=0 w=1u l=1u
X3687 VSS.t2289 VDD VSS.t2288 VSS.t2287 sg13_lv_nmos ad=0.1428p pd=1.52u as=0 ps=0 w=0.42u l=1u
X3688 VSS.t15 a_5687_15315# a_5687_15315# VSS.t3194 sg13_lv_nmos ad=4.11262p pd=27.15u as=0.111p ps=1.34u w=0.3u l=0.13u
X3689 VDD VSS.t858 VDD VDD sg13_lv_pmos ad=0.19p pd=1.38u as=0 ps=0 w=1u l=1u
X3690 VSS.t3050 VDD VSS.t3052 VSS.t3051 sg13_lv_nmos ad=79.8f pd=0.8u as=0 ps=0 w=0.42u l=1u
X3691 VSS.t2665 VDD VSS.t2667 VSS.t61 sg13_lv_nmos ad=79.8f pd=0.8u as=0 ps=0 w=0.42u l=1u
X3692 VSS.t2259 VDD VSS.t2261 VSS.t2260 sg13_lv_nmos ad=79.8f pd=0.8u as=0 ps=0 w=0.42u l=1u
X3693 a_21251_13690# sg13cmos5l_or3_1_2.C VSS.t172 VSS.t3232 sg13_lv_nmos ad=0.187p pd=1.78u as=0.1045p ps=0.93u w=0.55u l=0.13u
X3694 VDD VSS.t1280 VDD VDD sg13_lv_pmos ad=0.19p pd=1.38u as=0 ps=0 w=1u l=1u
X3695 VDD VSS.t820 VDD VDD sg13_lv_pmos ad=0.34p pd=2.68u as=0 ps=0 w=1u l=1u
X3696 VSS.t1026 VDD VSS.t1025 VSS.t1024 sg13_lv_nmos ad=0.1428p pd=1.52u as=0 ps=0 w=0.42u l=1u
X3697 VDD VSS.t1679 VDD VDD sg13_lv_pmos ad=0.34p pd=2.68u as=0 ps=0 w=1u l=1u
X3698 VSS.t609 VDD VSS.t609 VSS.t610 sg13_lv_nmos ad=79.8f pd=0.8u as=0 ps=0 w=0.42u l=1u
X3699 VSS.t1229 VDD VSS.t1230 VSS.t70 sg13_lv_nmos ad=79.8f pd=0.8u as=0 ps=0 w=0.42u l=1u
X3700 VSS.t303 VDD VSS.t303 VSS.t306 sg13_lv_nmos ad=79.8f pd=0.8u as=0 ps=0 w=0.42u l=1u
X3701 VDD VSS.t1544 VDD VDD sg13_lv_pmos ad=0.34p pd=2.68u as=0 ps=0 w=1u l=1u
X3702 VSS.t1902 VDD VSS.t1904 VSS.t1903 sg13_lv_nmos ad=79.8f pd=0.8u as=0 ps=0 w=0.42u l=1u
X3703 VDD VSS.t2687 VDD VDD sg13_lv_pmos ad=0.34p pd=2.68u as=0 ps=0 w=1u l=1u
X3704 VSS.t1317 VDD VSS.t1316 VSS.t70 sg13_lv_nmos ad=0.1428p pd=1.52u as=0 ps=0 w=0.42u l=1u
X3705 VDD VSS.t559 VDD VDD sg13_lv_pmos ad=0.34p pd=2.68u as=0 ps=0 w=1u l=1u
X3706 VSS.t831 VDD VSS.t833 VSS.t832 sg13_lv_nmos ad=79.8f pd=0.8u as=0 ps=0 w=0.42u l=1u
X3707 a_9158_15234# sg13cmos5l_and2_1_2.X VDD VDD sg13_lv_pmos ad=79.8f pd=0.8u as=0.1428p ps=1.52u w=0.42u l=0.13u
X3708 VSS.t11 sg13cmos5l_xor2_1_0.X a_2059_14832# VSS.t10 sg13_lv_nmos ad=0.1331p pd=1.12u as=0.1216p ps=1.02u w=0.64u l=0.13u
X3709 VDD VSS.t890 VDD VDD sg13_lv_pmos ad=0.34p pd=2.68u as=0 ps=0 w=1u l=1u
X3710 VDD VSS.t1265 VDD VDD sg13_lv_pmos ad=0.19p pd=1.38u as=0 ps=0 w=1u l=1u
X3711 VSS.t1500 VDD VSS.t1499 VSS.t1498 sg13_lv_nmos ad=0.1428p pd=1.52u as=0 ps=0 w=0.42u l=1u
X3712 VSS.t2107 VDD VSS.t2109 VSS.t2108 sg13_lv_nmos ad=79.8f pd=0.8u as=0 ps=0 w=0.42u l=1u
X3713 VDD VSS.t2064 VDD VDD sg13_lv_pmos ad=0.19p pd=1.38u as=0 ps=0 w=1u l=1u
X3714 VDD VSS.t1509 VDD VDD sg13_lv_pmos ad=0.34p pd=2.68u as=0 ps=0 w=1u l=1u
X3715 VSS.t2479 VDD VSS.t2478 VSS.t2477 sg13_lv_nmos ad=0.1428p pd=1.52u as=0 ps=0 w=0.42u l=1u
X3716 VSS.t207 VDD VSS.t207 VSS.t709 sg13_lv_nmos ad=79.8f pd=0.8u as=0 ps=0 w=0.42u l=1u
X3717 VSS.t2701 VDD VSS.t2699 VSS.t61 sg13_lv_nmos ad=0.1428p pd=1.52u as=0 ps=0 w=0.42u l=1u
X3718 VDD VSS.t2418 VDD VDD sg13_lv_pmos ad=0.34p pd=2.68u as=0 ps=0 w=1u l=1u
X3719 VDD VSS.t630 VDD VDD sg13_lv_pmos ad=0.34p pd=2.68u as=0 ps=0 w=1u l=1u
X3720 VDD VSS.t2984 VDD VDD sg13_lv_pmos ad=0.34p pd=2.68u as=0 ps=0 w=1u l=1u
X3721 a_10222_14751# a_10337_14750# VSS.t53 VSS.t178 sg13_lv_nmos ad=0.1428p pd=1.52u as=0.1426p ps=1.16u w=0.42u l=0.5u
X3722 VSS.t2244 VDD VSS.t2246 VSS.t2245 sg13_lv_nmos ad=79.8f pd=0.8u as=0 ps=0 w=0.42u l=1u
X3723 VSS.t2027 VDD VSS.t2026 VSS.t2025 sg13_lv_nmos ad=0.1428p pd=1.52u as=0 ps=0 w=0.42u l=1u
X3724 VDD VSS.t577 VDD VDD sg13_lv_pmos ad=0.19p pd=1.38u as=0 ps=0 w=1u l=1u
X3725 VDD VSS.t975 VDD VDD sg13_lv_pmos ad=0.34p pd=2.68u as=0 ps=0 w=1u l=1u
X3726 VSS.t1977 VDD VSS.t1979 VSS.t1978 sg13_lv_nmos ad=79.8f pd=0.8u as=0 ps=0 w=0.42u l=1u
X3727 VDD VSS.t1522 VDD VDD sg13_lv_pmos ad=0.19p pd=1.38u as=0 ps=0 w=1u l=1u
X3728 VSS.t2319 VDD VSS.t2321 VSS.t2320 sg13_lv_nmos ad=79.8f pd=0.8u as=0 ps=0 w=0.42u l=1u
X3729 VSS.t512 VDD VSS.t518 VSS.t517 sg13_lv_nmos ad=79.8f pd=0.8u as=0 ps=0 w=0.42u l=1u
X3730 VDD VSS.t2119 VDD VDD sg13_lv_pmos ad=0.19p pd=1.38u as=0 ps=0 w=1u l=1u
X3731 VDD VSS.t273 VDD VDD sg13_lv_pmos ad=0.34p pd=2.68u as=0 ps=0 w=1u l=1u
X3732 a_25037_14020# sg13cmos5l_or3_1_1.B a_24935_14020# VDD sg13_lv_pmos ad=0.1575p pd=1.315u as=0.19p ps=1.38u w=1u l=0.13u
X3733 VDD VSS.t1859 VDD VDD sg13_lv_pmos ad=0.19p pd=1.38u as=0 ps=0 w=1u l=1u
X3734 VSS.t2892 VDD VSS.t2778 VSS.t61 sg13_lv_nmos ad=79.8f pd=0.8u as=0 ps=0 w=0.42u l=1u
X3735 VDD VSS.t2649 VDD VDD sg13_lv_pmos ad=0.19p pd=1.38u as=0 ps=0 w=1u l=1u
X3736 VDD VSS.t339 VDD VDD sg13_lv_pmos ad=0.34p pd=2.68u as=0 ps=0 w=1u l=1u
X3737 VDD VSS.t1298 VDD VDD sg13_lv_pmos ad=0.19p pd=1.38u as=0 ps=0 w=1u l=1u
X3738 VSS.t1540 VDD VSS.t1539 VSS.t1538 sg13_lv_nmos ad=0.1428p pd=1.52u as=0 ps=0 w=0.42u l=1u
X3739 VSS.t3065 VDD VSS.t3064 VSS.t3063 sg13_lv_nmos ad=0.1428p pd=1.52u as=0 ps=0 w=0.42u l=1u
X3740 VSS.t2274 VDD VSS.t2273 VSS.t2272 sg13_lv_nmos ad=0.1428p pd=1.52u as=0 ps=0 w=0.42u l=1u
X3741 a_7262_15242# sg13cmos5l_buf_1_0.X a_7160_15242# VSS.t3291 sg13_lv_nmos ad=0.1406p pd=1.12u as=0.1406p ps=1.12u w=0.74u l=0.13u
X3742 VDD a_26638_15423# sg13cmos5l_o21ai_1_2.B1 VDD sg13_lv_pmos ad=0.2254p pd=1.53u as=0.4256p ps=3u w=1.12u l=0.13u
X3743 VDD a_6682_13690# a_6401_13912# VDD sg13_lv_pmos ad=0.1523p pd=1.38u as=0.34p ps=2.68u w=1u l=0.5u
X3744 VSS.t2751 VDD VSS.t2749 VSS.t61 sg13_lv_nmos ad=0.1428p pd=1.52u as=0 ps=0 w=0.42u l=1u
X3745 VSS.t627 VDD VSS.t627 VSS.t628 sg13_lv_nmos ad=79.8f pd=0.8u as=0 ps=0 w=0.42u l=1u
X3746 VDD VSS.t1038 VDD VDD sg13_lv_pmos ad=0.19p pd=1.38u as=0 ps=0 w=1u l=1u
X3747 VDD sg13cmos5l_inv_1_0.A sg13cmos5l_inv_1_0.Y VDD sg13_lv_pmos ad=0.3808p pd=2.92u as=0.3808p ps=2.92u w=1.12u l=0.13u
X3748 VSS.t378 VDD VSS.t381 VSS.t380 sg13_lv_nmos ad=79.8f pd=0.8u as=0 ps=0 w=0.42u l=1u
X3749 VSS.t438 VDD VSS.t439 VSS.t15 sg13_lv_nmos ad=79.8f pd=0.8u as=0 ps=0 w=0.42u l=1u
X3750 VDD VSS.t695 VDD VDD sg13_lv_pmos ad=0.19p pd=1.38u as=0 ps=0 w=1u l=1u
X3751 VDD VSS.t1662 VDD VDD sg13_lv_pmos ad=0.19p pd=1.38u as=0 ps=0 w=1u l=1u
X3752 VSS.t584 VDD VSS.t585 VSS.t689 sg13_lv_nmos ad=0.1428p pd=1.52u as=0 ps=0 w=0.42u l=1u
X3753 VDD VSS.t2016 VDD VDD sg13_lv_pmos ad=0.34p pd=2.68u as=0 ps=0 w=1u l=1u
X3754 VDD VSS.t532 VDD VDD sg13_lv_pmos ad=0.34p pd=2.68u as=0 ps=0 w=1u l=1u
X3755 VDD VSS.t1306 VDD VDD sg13_lv_pmos ad=0.19p pd=1.38u as=0 ps=0 w=1u l=1u
X3756 VDD a_14261_15238# sg13cmos5l_or3_1_1.B VDD sg13_lv_pmos ad=0.3808p pd=2.92u as=0.2128p ps=1.5u w=1.12u l=0.13u
X3757 a_22738_14922# sg13cmos5l_dfrbpq_1_6.RESET_B VSS.t67 VSS.t56 sg13_lv_nmos ad=37.8f pd=0.6u as=79.8f ps=0.8u w=0.42u l=0.13u
X3758 VSS.t636 VDD VSS.t636 VSS.t637 sg13_lv_nmos ad=79.8f pd=0.8u as=0 ps=0 w=0.42u l=1u
X3759 VDD a_4175_15311# a_4432_15454# VDD sg13_lv_pmos ad=2.8961p pd=18.25u as=79.8f ps=0.8u w=0.42u l=0.13u
X3760 VSS.t1178 VDD VSS.t1337 VSS.t70 sg13_lv_nmos ad=0.1428p pd=1.52u as=0 ps=0 w=0.42u l=1u
X3761 VSS.t1287 VDD VSS.t1288 VSS.t70 sg13_lv_nmos ad=79.8f pd=0.8u as=0 ps=0 w=0.42u l=1u
X3762 VDD VSS.t2281 VDD VDD sg13_lv_pmos ad=0.19p pd=1.38u as=0 ps=0 w=1u l=1u
X3763 VSS.t2464 VDD VSS.t2463 VSS.t2462 sg13_lv_nmos ad=0.1428p pd=1.52u as=0 ps=0 w=0.42u l=1u
X3764 a_26565_13701# sg13cmos5l_buf_8_2.X VDD VDD sg13_lv_pmos ad=0.4088p pd=2.97u as=2.3367p ps=15.135u w=1.12u l=0.13u
X3765 VSS.t936 VDD VSS.t938 VSS.t937 sg13_lv_nmos ad=79.8f pd=0.8u as=0 ps=0 w=0.42u l=1u
X3766 VDD VSS.t1529 VDD VDD sg13_lv_pmos ad=0.34p pd=2.68u as=0 ps=0 w=1u l=1u
X3767 sg13cmos5l_buf_8_2.X a_19323_13726# VSS.t207 VSS.t206 sg13_lv_nmos ad=0.1406p pd=1.12u as=0.1406p ps=1.12u w=0.74u l=0.13u
X3768 VDD VSS.t1005 VDD VDD sg13_lv_pmos ad=0.34p pd=2.68u as=0 ps=0 w=1u l=1u
X3769 VSS.t2768 VDD VSS.t2770 VSS.t61 sg13_lv_nmos ad=79.8f pd=0.8u as=0 ps=0 w=0.42u l=1u
X3770 VDD VSS.t282 VDD VDD sg13_lv_pmos ad=0.34p pd=2.68u as=0 ps=0 w=1u l=1u
X3771 sg13cmos5l_or3_1_1.B a_14261_15238# VSS.t4 VSS.t247 sg13_lv_nmos ad=0.1406p pd=1.12u as=0.3293p ps=1.63u w=0.74u l=0.13u
X3772 VSS.t1887 VDD VSS.t1889 VSS.t1888 sg13_lv_nmos ad=79.8f pd=0.8u as=0 ps=0 w=0.42u l=1u
X3773 VSS.t420 VDD VSS.t419 VSS.t15 sg13_lv_nmos ad=0.1428p pd=1.52u as=0 ps=0 w=0.42u l=1u
X3774 VSS.t831 VDD VSS.t833 VSS.t832 sg13_lv_nmos ad=79.8f pd=0.8u as=0 ps=0 w=0.42u l=1u
X3775 VDD VSS.t1569 VDD VDD sg13_lv_pmos ad=0.34p pd=2.68u as=0 ps=0 w=1u l=1u
X3776 VDD VSS.t559 VDD VDD sg13_lv_pmos ad=0.34p pd=2.68u as=0 ps=0 w=1u l=1u
X3777 VSS.t1600 VDD VSS.t1602 VSS.t1601 sg13_lv_nmos ad=79.8f pd=0.8u as=0 ps=0 w=0.42u l=1u
X3778 VSS.t2731 VDD VSS.t2731 VSS.t61 sg13_lv_nmos ad=79.8f pd=0.8u as=0 ps=0 w=0.42u l=1u
X3779 VSS.t1485 VDD VSS.t1484 VSS.t1483 sg13_lv_nmos ad=0.1428p pd=1.52u as=0 ps=0 w=0.42u l=1u
X3780 a_12524_15960# sg13cmos5l_dlygate4sd3_1_8.A VDD VDD sg13_lv_pmos ad=0.2856p pd=2.36u as=0.2114p ps=1.54u w=0.84u l=0.13u
X3781 VDD VSS.t1256 VDD VDD sg13_lv_pmos ad=0.19p pd=1.38u as=0 ps=0 w=1u l=1u
X3782 VSS.t2077 VDD VSS.t2079 VSS.t2078 sg13_lv_nmos ad=79.8f pd=0.8u as=0 ps=0 w=0.42u l=1u
X3783 a_17529_14037# a_16587_13844# a_17327_13799# VDD sg13_lv_pmos ad=93.45f pd=0.865u as=0.2048p ps=1.63u w=0.42u l=0.13u
X3784 VDD VSS.t1227 VDD VDD sg13_lv_pmos ad=0.34p pd=2.68u as=0 ps=0 w=1u l=1u
X3785 VDD VSS.t2731 VDD VDD sg13_lv_pmos ad=0.34p pd=2.68u as=0 ps=0 w=1u l=1u
X3786 VSS.t2294 VDD VSS.t2293 VSS.t2292 sg13_lv_nmos ad=0.1428p pd=1.52u as=0 ps=0 w=0.42u l=1u
X3787 VDD VSS.t2001 VDD VDD sg13_lv_pmos ad=0.34p pd=2.68u as=0 ps=0 w=1u l=1u
X3788 VSS.t367 VDD VSS.t363 VSS.t366 sg13_lv_nmos ad=0.1428p pd=1.52u as=0 ps=0 w=0.42u l=1u
X3789 VDD VSS.t216 VDD VDD sg13_lv_pmos ad=0.19p pd=1.38u as=0 ps=0 w=1u l=1u
X3790 VSS.t2749 VDD VSS.t2748 VSS.t61 sg13_lv_nmos ad=0.1428p pd=1.52u as=0 ps=0 w=0.42u l=1u
X3791 VSS.t98 a_10703_15311# a_11370_15532# VSS.t149 sg13_lv_nmos ad=0.1406p pd=1.12u as=0.2516p ps=2.16u w=0.74u l=0.13u
X3792 a_18789_15277# a_18789_15277# VSS.t15 VSS.t42 sg13_lv_nmos ad=0.111p pd=1.34u as=4.11262p ps=27.15u w=0.3u l=0.13u
X3793 VSS.t618 VDD VSS.t615 VSS.t617 sg13_lv_nmos ad=0.1428p pd=1.52u as=0 ps=0 w=0.42u l=1u
X3794 VDD VSS.t1919 VDD VDD sg13_lv_pmos ad=0.19p pd=1.38u as=0 ps=0 w=1u l=1u
X3795 VSS.t1962 VDD VSS.t1964 VSS.t1963 sg13_lv_nmos ad=79.8f pd=0.8u as=0 ps=0 w=0.42u l=1u
X3796 VSS.t423 VDD VSS.t424 VSS.t15 sg13_lv_nmos ad=79.8f pd=0.8u as=0 ps=0 w=0.42u l=1u
X3797 VSS.t1403 VDD VSS.t1268 VSS.t70 sg13_lv_nmos ad=0.1428p pd=1.52u as=0 ps=0 w=0.42u l=1u
X3798 VDD VSS.t1684 VDD VDD sg13_lv_pmos ad=0.34p pd=2.68u as=0 ps=0 w=1u l=1u
X3799 a_6346_14452# a_6789_14495# a_6086_14922# VSS.t54 sg13_lv_nmos ad=79.8f pd=0.8u as=0.1296p ps=1.52u w=0.42u l=0.13u
X3800 VDD VSS.t2266 VDD VDD sg13_lv_pmos ad=0.19p pd=1.38u as=0 ps=0 w=1u l=1u
X3801 VSS.t2484 VDD VSS.t2483 VSS.t2482 sg13_lv_nmos ad=0.1428p pd=1.52u as=0 ps=0 w=0.42u l=1u
X3802 VSS.t2304 VDD VSS.t2306 VSS.t2305 sg13_lv_nmos ad=79.8f pd=0.8u as=0 ps=0 w=0.42u l=1u
X3803 VDD VSS.t2104 VDD VDD sg13_lv_pmos ad=0.19p pd=1.38u as=0 ps=0 w=1u l=1u
X3804 VDD VSS.t2056 VDD VDD sg13_lv_pmos ad=0.34p pd=2.68u as=0 ps=0 w=1u l=1u
X3805 VSS.t1872 VDD VSS.t1874 VSS.t1873 sg13_lv_nmos ad=79.8f pd=0.8u as=0 ps=0 w=0.42u l=1u
X3806 VDD VSS.t3182 VDD VDD sg13_lv_pmos ad=0.19p pd=1.38u as=0 ps=0 w=1u l=1u
X3807 VDD VSS.t2691 VDD VDD sg13_lv_pmos ad=0.34p pd=2.68u as=0 ps=0 w=1u l=1u
X3808 VSS.t2742 VDD VSS.t2741 VSS.t61 sg13_lv_nmos ad=0.1428p pd=1.52u as=0 ps=0 w=0.42u l=1u
X3809 VSS.t512 VDD VSS.t512 VSS.t511 sg13_lv_nmos ad=0.1428p pd=1.52u as=0 ps=0 w=0.42u l=1u
X3810 VDD VSS.t895 VDD VDD sg13_lv_pmos ad=0.34p pd=2.68u as=0 ps=0 w=1u l=1u
X3811 VSS.t715 VDD VSS.t172 VSS.t714 sg13_lv_nmos ad=0.1428p pd=1.52u as=0 ps=0 w=0.42u l=1u
X3812 VSS.t2112 VDD VSS.t2114 VSS.t2113 sg13_lv_nmos ad=79.8f pd=0.8u as=0 ps=0 w=0.42u l=1u
X3813 VSS.t432 VDD VSS.t433 VSS.t15 sg13_lv_nmos ad=79.8f pd=0.8u as=0 ps=0 w=0.42u l=1u
X3814 VDD VSS.t1514 VDD VDD sg13_lv_pmos ad=0.34p pd=2.68u as=0 ps=0 w=1u l=1u
X3815 VDD VSS.t2423 VDD VDD sg13_lv_pmos ad=0.34p pd=2.68u as=0 ps=0 w=1u l=1u
X3816 VDD a_17126_15238# a_17238_15302# VDD sg13_lv_pmos ad=0.2254p pd=1.53u as=0.34p ps=2.68u w=1u l=0.5u
X3817 sg13cmos5l_dlygate4sd3_1_3.A a_4842_15532# VDD VDD sg13_lv_pmos ad=0.3808p pd=2.92u as=0.2128p ps=1.5u w=1.12u l=0.13u
X3818 VSS.t1615 VDD VSS.t1614 VSS.t1613 sg13_lv_nmos ad=0.1428p pd=1.52u as=0 ps=0 w=0.42u l=1u
X3819 VDD VSS.t2371 VDD VDD sg13_lv_pmos ad=0.19p pd=1.38u as=0 ps=0 w=1u l=1u
X3820 VSS.t2032 VDD VSS.t2031 VSS.t2030 sg13_lv_nmos ad=0.1428p pd=1.52u as=0 ps=0 w=0.42u l=1u
X3821 VSS.t2740 VDD VSS.t2739 VSS.t61 sg13_lv_nmos ad=0.1428p pd=1.52u as=0 ps=0 w=0.42u l=1u
X3822 VSS.t906 VDD VSS.t908 VSS.t907 sg13_lv_nmos ad=79.8f pd=0.8u as=0 ps=0 w=0.42u l=1u
X3823 VSS.t936 VDD VSS.t938 VSS.t937 sg13_lv_nmos ad=79.8f pd=0.8u as=0 ps=0 w=0.42u l=1u
X3824 VDD VSS.t1222 VDD VDD sg13_lv_pmos ad=0.34p pd=2.68u as=0 ps=0 w=1u l=1u
X3825 VDD VSS.t36 VDD VDD sg13_lv_pmos ad=0.34p pd=2.68u as=0 ps=0 w=1u l=1u
X3826 a_7631_14845# a_6789_14495# a_6372_14488# VDD sg13_lv_pmos ad=0.2048p pd=1.63u as=0.34p ps=2.68u w=1u l=0.13u
X3827 VDD VSS.t2089 VDD VDD sg13_lv_pmos ad=0.19p pd=1.38u as=0 ps=0 w=1u l=1u
X3828 sg13cmos5l_buf_8_2.X a_19323_13726# VSS.t211 VSS.t214 sg13_lv_nmos ad=0.1406p pd=1.12u as=0.1406p ps=1.12u w=0.74u l=0.13u
X3829 VDD VSS.t1864 VDD VDD sg13_lv_pmos ad=0.19p pd=1.38u as=0 ps=0 w=1u l=1u
X3830 VDD VSS.t2652 VDD VDD sg13_lv_pmos ad=0.19p pd=1.38u as=0 ps=0 w=1u l=1u
X3831 VDD VSS.t2711 VDD VDD sg13_lv_pmos ad=0.19p pd=1.38u as=0 ps=0 w=1u l=1u
X3832 VSS.t1907 VDD VSS.t1909 VSS.t1908 sg13_lv_nmos ad=79.8f pd=0.8u as=0 ps=0 w=0.42u l=1u
X3833 VSS.t1545 VDD VSS.t1544 VSS.t1543 sg13_lv_nmos ad=0.1428p pd=1.52u as=0 ps=0 w=0.42u l=1u
X3834 VSS.t3070 VDD VSS.t3069 VSS.t3068 sg13_lv_nmos ad=0.1428p pd=1.52u as=0 ps=0 w=0.42u l=1u
X3835 VSS.t2279 VDD VSS.t2278 VSS.t2277 sg13_lv_nmos ad=0.1428p pd=1.52u as=0 ps=0 w=0.42u l=1u
X3836 VSS.t2449 VDD VSS.t2451 VSS.t2450 sg13_lv_nmos ad=79.8f pd=0.8u as=0 ps=0 w=0.42u l=1u
X3837 VDD VSS.t47 VDD VDD sg13_lv_pmos ad=0.34p pd=2.68u as=0 ps=0 w=1u l=1u
X3838 VDD VSS.t1260 VDD VDD sg13_lv_pmos ad=0.19p pd=1.38u as=0 ps=0 w=1u l=1u
X3839 VSS.t2354 VDD VSS.t2353 VSS.t2352 sg13_lv_nmos ad=0.1428p pd=1.52u as=0 ps=0 w=0.42u l=1u
X3840 VSS.t2722 VDD VSS.t2723 VSS.t61 sg13_lv_nmos ad=79.8f pd=0.8u as=0 ps=0 w=0.42u l=1u
X3841 VDD VSS.t2456 VDD VDD sg13_lv_pmos ad=0.19p pd=1.38u as=0 ps=0 w=1u l=1u
X3842 VSS.t222 a_21166_16263# sg13cmos5l_dfrbpq_1_6.D VSS.t3252 sg13_lv_nmos ad=0.1426p pd=1.16u as=0.2516p ps=2.16u w=0.74u l=0.13u
X3843 VSS.t1209 VDD VSS.t1210 VSS.t70 sg13_lv_nmos ad=79.8f pd=0.8u as=0 ps=0 w=0.42u l=1u
X3844 counter_value_o[3] a_16552_15996# VDD VDD sg13_lv_pmos ad=0.42p pd=2.99u as=0.2114p ps=1.54u w=1.12u l=0.13u
X3845 a_25786_15960# sg13cmos5l_o21ai_1_3.Y VSS.t24 VSS.t31 sg13_lv_nmos ad=0.1428p pd=1.52u as=79.8f ps=0.8u w=0.42u l=0.13u
X3846 VDD VSS.t612 VDD VDD sg13_lv_pmos ad=0.19p pd=1.38u as=0 ps=0 w=1u l=1u
X3847 VSS.t2062 VDD VSS.t2064 VSS.t2063 sg13_lv_nmos ad=79.8f pd=0.8u as=0 ps=0 w=0.42u l=1u
X3848 VDD sg13cmos5l_o21ai_1_2.B1 sg13cmos5l_o21ai_1_2.Y VDD sg13_lv_pmos ad=0.3808p pd=2.92u as=0.2128p ps=1.5u w=1.12u l=0.15u
X3849 VDD VSS.t1219 VDD VDD sg13_lv_pmos ad=0.34p pd=2.68u as=0 ps=0 w=1u l=1u
X3850 VDD VSS.t2723 VDD VDD sg13_lv_pmos ad=0.34p pd=2.68u as=0 ps=0 w=1u l=1u
X3851 VSS.t2017 VDD VSS.t2016 VSS.t2015 sg13_lv_nmos ad=0.1428p pd=1.52u as=0 ps=0 w=0.42u l=1u
X3852 VSS.t2659 VDD VSS.t2661 VSS.t61 sg13_lv_nmos ad=79.8f pd=0.8u as=0 ps=0 w=0.42u l=1u
X3853 VDD a_18202_15202# a_17921_15424# VDD sg13_lv_pmos ad=0.1523p pd=1.38u as=0.34p ps=2.68u w=1u l=0.5u
X3854 VSS.t1296 VDD VSS.t1295 VSS.t70 sg13_lv_nmos ad=0.1428p pd=1.52u as=0 ps=0 w=0.42u l=1u
X3855 VDD VSS.t2081 VDD VDD sg13_lv_pmos ad=0.34p pd=2.68u as=0 ps=0 w=1u l=1u
X3856 VSS.t326 VDD VSS.t328 VSS.t327 sg13_lv_nmos ad=79.8f pd=0.8u as=0 ps=0 w=0.42u l=1u
X3857 VDD VSS.t1274 VDD VDD sg13_lv_pmos ad=0.34p pd=2.68u as=0 ps=0 w=1u l=1u
X3858 VDD VSS.t2779 VDD VDD sg13_lv_pmos ad=0.34p pd=2.68u as=0 ps=0 w=1u l=1u
X3859 VSS.t2469 VDD VSS.t2468 VSS.t2467 sg13_lv_nmos ad=0.1428p pd=1.52u as=0 ps=0 w=0.42u l=1u
X3860 VDD VSS.t1534 VDD VDD sg13_lv_pmos ad=0.34p pd=2.68u as=0 ps=0 w=1u l=1u
X3861 VDD VSS.t2251 VDD VDD sg13_lv_pmos ad=0.19p pd=1.38u as=0 ps=0 w=1u l=1u
X3862 VSS.t2772 VDD VSS.t2773 VSS.t61 sg13_lv_nmos ad=79.8f pd=0.8u as=0 ps=0 w=0.42u l=1u
X3863 VDD VSS.t2041 VDD VDD sg13_lv_pmos ad=0.34p pd=2.68u as=0 ps=0 w=1u l=1u
X3864 VSS.t1857 VDD VSS.t1859 VSS.t1858 sg13_lv_nmos ad=79.8f pd=0.8u as=0 ps=0 w=0.42u l=1u
X3865 VDD VSS.t803 VDD VDD sg13_lv_pmos ad=0.19p pd=1.38u as=0 ps=0 w=1u l=1u
X3866 VDD VSS.t1539 VDD VDD sg13_lv_pmos ad=0.34p pd=2.68u as=0 ps=0 w=1u l=1u
X3867 VDD VSS.t3167 VDD VDD sg13_lv_pmos ad=0.19p pd=1.38u as=0 ps=0 w=1u l=1u
X3868 VDD VSS.t2682 VDD VDD sg13_lv_pmos ad=0.34p pd=2.68u as=0 ps=0 w=1u l=1u
X3869 VSS.t891 VDD VSS.t890 VSS.t889 sg13_lv_nmos ad=0.1428p pd=1.52u as=0 ps=0 w=0.42u l=1u
X3870 a_26148_14040# a_26667_13844# a_27407_13799# VSS.t163 sg13_lv_nmos ad=0.3473p pd=2.71u as=0.12665p ps=1.145u w=0.74u l=0.13u
X3871 VSS.t2788 VDD VSS.t2787 VSS.t61 sg13_lv_nmos ad=0.1428p pd=1.52u as=0 ps=0 w=0.42u l=1u
X3872 VDD VSS.t1499 VDD VDD sg13_lv_pmos ad=0.34p pd=2.68u as=0 ps=0 w=1u l=1u
X3873 VDD VSS.t2408 VDD VDD sg13_lv_pmos ad=0.34p pd=2.68u as=0 ps=0 w=1u l=1u
X3874 VSS.t2299 VDD VSS.t2298 VSS.t2297 sg13_lv_nmos ad=0.1428p pd=1.52u as=0 ps=0 w=0.42u l=1u
X3875 VSS.t906 VDD VSS.t908 VSS.t907 sg13_lv_nmos ad=79.8f pd=0.8u as=0 ps=0 w=0.42u l=1u
X3876 VDD VSS.t512 VDD VDD sg13_lv_pmos ad=0.19p pd=1.38u as=0 ps=0 w=1u l=1u
X3877 VDD VSS.t1924 VDD VDD sg13_lv_pmos ad=0.19p pd=1.38u as=0 ps=0 w=1u l=1u
X3878 VSS.t2731 VDD VSS.t2729 VSS.t61 sg13_lv_nmos ad=0.1428p pd=1.52u as=0 ps=0 w=0.42u l=1u
X3879 VSS.t1967 VDD VSS.t1969 VSS.t1968 sg13_lv_nmos ad=79.8f pd=0.8u as=0 ps=0 w=0.42u l=1u
X3880 VDD VSS.t818 VDD VDD sg13_lv_pmos ad=0.19p pd=1.38u as=0 ps=0 w=1u l=1u
X3881 VSS.t1241 VDD VSS.t1242 VSS.t70 sg13_lv_nmos ad=79.8f pd=0.8u as=0 ps=0 w=0.42u l=1u
X3882 VDD VSS.t2243 VDD VDD sg13_lv_pmos ad=0.34p pd=2.68u as=0 ps=0 w=1u l=1u
X3883 VDD VSS.t131 VDD VDD sg13_lv_pmos ad=0.34p pd=2.68u as=0 ps=0 w=1u l=1u
X3884 VSS.t1206 VDD VSS.t1205 VSS.t70 sg13_lv_nmos ad=0.1428p pd=1.52u as=0 ps=0 w=0.42u l=1u
X3885 VDD VSS.t2644 VDD VDD sg13_lv_pmos ad=0.19p pd=1.38u as=0 ps=0 w=1u l=1u
X3886 VDD VSS.t396 VDD VDD sg13_lv_pmos ad=0.34p pd=2.68u as=0 ps=0 w=1u l=1u
X3887 VSS.t1530 VDD VSS.t1529 VSS.t1528 sg13_lv_nmos ad=0.1428p pd=1.52u as=0 ps=0 w=0.42u l=1u
X3888 VSS.t3055 VDD VSS.t3054 VSS.t3053 sg13_lv_nmos ad=0.1428p pd=1.52u as=0 ps=0 w=0.42u l=1u
X3889 VSS.t2264 VDD VSS.t2263 VSS.t2262 sg13_lv_nmos ad=0.1428p pd=1.52u as=0 ps=0 w=0.42u l=1u
X3890 VSS.t1877 VDD VSS.t1879 VSS.t1878 sg13_lv_nmos ad=79.8f pd=0.8u as=0 ps=0 w=0.42u l=1u
X3891 VSS.t8 a_27407_13799# a_28074_14020# VSS.t45 sg13_lv_nmos ad=0.1406p pd=1.12u as=0.2516p ps=2.16u w=0.74u l=0.13u
X3892 VSS.t1167 VDD VSS.t1168 VSS.t70 sg13_lv_nmos ad=79.8f pd=0.8u as=0 ps=0 w=0.42u l=1u
X3893 VSS.t363 VDD VSS.t363 VSS.t365 sg13_lv_nmos ad=79.8f pd=0.8u as=0 ps=0 w=0.42u l=1u
X3894 VSS.t124 sg13cmos5l_dlygate4sd3_1_8.X a_7829_15238# VSS.t3217 sg13_lv_nmos ad=0.1898p pd=1.36u as=0.2516p ps=2.16u w=0.74u l=0.13u
X3895 VDD VSS.t1250 VDD VDD sg13_lv_pmos ad=0.19p pd=1.38u as=0 ps=0 w=1u l=1u
X3896 VDD VSS.t2755 VDD VDD sg13_lv_pmos ad=0.19p pd=1.38u as=0 ps=0 w=1u l=1u
X3897 VDD VSS.t642 VDD VDD sg13_lv_pmos ad=0.34p pd=2.68u as=0 ps=0 w=1u l=1u
X3898 VDD VSS.t1484 VDD VDD sg13_lv_pmos ad=0.34p pd=2.68u as=0 ps=0 w=1u l=1u
X3899 VSS.t2674 VDD VSS.t2675 VSS.t61 sg13_lv_nmos ad=79.8f pd=0.8u as=0 ps=0 w=0.42u l=1u
X3900 VDD VSS.t2393 VDD VDD sg13_lv_pmos ad=0.34p pd=2.68u as=0 ps=0 w=1u l=1u
X3901 VSS.t2454 VDD VSS.t2453 VSS.t2452 sg13_lv_nmos ad=0.1428p pd=1.52u as=0 ps=0 w=0.42u l=1u
X3902 VDD VSS.t418 VDD VDD sg13_lv_pmos ad=0.19p pd=1.38u as=0 ps=0 w=1u l=1u
X3903 VSS.t2284 VDD VSS.t2283 VSS.t2282 sg13_lv_nmos ad=0.1428p pd=1.52u as=0 ps=0 w=0.42u l=1u
X3904 VSS.t921 VDD VSS.t920 VSS.t919 sg13_lv_nmos ad=0.1428p pd=1.52u as=0 ps=0 w=0.42u l=1u
X3905 VDD VSS.t1904 VDD VDD sg13_lv_pmos ad=0.19p pd=1.38u as=0 ps=0 w=1u l=1u
X3906 VSS.t1620 VDD VSS.t1619 VSS.t1618 sg13_lv_nmos ad=0.1428p pd=1.52u as=0 ps=0 w=0.42u l=1u
X3907 VSS.t2002 VDD VSS.t2001 VSS.t2000 sg13_lv_nmos ad=0.1428p pd=1.52u as=0 ps=0 w=0.42u l=1u
X3908 VDD VSS.t973 VDD VDD sg13_lv_pmos ad=0.19p pd=1.38u as=0 ps=0 w=1u l=1u
X3909 VSS.t1223 VDD VSS.t1222 VSS.t70 sg13_lv_nmos ad=0.1428p pd=1.52u as=0 ps=0 w=0.42u l=1u
X3910 VSS.t2743 VDD VSS.t2742 VSS.t61 sg13_lv_nmos ad=0.1428p pd=1.52u as=0 ps=0 w=0.42u l=1u
X3911 VDD VSS.t2311 VDD VDD sg13_lv_pmos ad=0.19p pd=1.38u as=0 ps=0 w=1u l=1u
X3912 VSS.t555 VDD VSS.t557 VSS.t556 sg13_lv_nmos ad=79.8f pd=0.8u as=0 ps=0 w=0.42u l=1u
X3913 VDD VSS.t383 VDD VDD sg13_lv_pmos ad=0.34p pd=2.68u as=0 ps=0 w=1u l=1u
X3914 VDD VSS.t1266 VDD VDD sg13_lv_pmos ad=0.34p pd=2.68u as=0 ps=0 w=1u l=1u
X3915 VDD VSS.t2066 VDD VDD sg13_lv_pmos ad=0.34p pd=2.68u as=0 ps=0 w=1u l=1u
X3916 VDD VSS.t2436 VDD VDD sg13_lv_pmos ad=0.19p pd=1.38u as=0 ps=0 w=1u l=1u
X3917 VDD VSS.t2094 VDD VDD sg13_lv_pmos ad=0.19p pd=1.38u as=0 ps=0 w=1u l=1u
X3918 VSS.t1917 VDD VSS.t1919 VSS.t1918 sg13_lv_nmos ad=79.8f pd=0.8u as=0 ps=0 w=0.42u l=1u
X3919 VDD VSS.t298 VDD VDD sg13_lv_pmos ad=0.34p pd=2.68u as=0 ps=0 w=1u l=1u
X3920 sg13cmos5l_and2_1_2.X a_8685_14832# VSS.t73 VSS.t241 sg13_lv_nmos ad=0.2516p pd=2.16u as=0.1331p ps=1.12u w=0.74u l=0.13u
X3921 VDD VSS.t1869 VDD VDD sg13_lv_pmos ad=0.19p pd=1.38u as=0 ps=0 w=1u l=1u
X3922 VDD VSS.t2714 VDD VDD sg13_lv_pmos ad=0.19p pd=1.38u as=0 ps=0 w=1u l=1u
X3923 VSS.t639 VDD VSS.t639 VSS.t640 sg13_lv_nmos ad=79.8f pd=0.8u as=0 ps=0 w=0.42u l=1u
X3924 VSS.t1550 VDD VSS.t1549 VSS.t1548 sg13_lv_nmos ad=0.1428p pd=1.52u as=0 ps=0 w=0.42u l=1u
X3925 VSS.t2763 VDD VSS.t2764 VSS.t61 sg13_lv_nmos ad=79.8f pd=0.8u as=0 ps=0 w=0.42u l=1u
X3926 VDD VSS.t2635 VDD VDD sg13_lv_pmos ad=0.19p pd=1.38u as=0 ps=0 w=1u l=1u
X3927 VSS.t2249 VDD VSS.t2248 VSS.t2247 sg13_lv_nmos ad=0.1428p pd=1.52u as=0 ps=0 w=0.42u l=1u
X3928 sg13cmos5l_a21oi_1_3.Y sg13cmos5l_a21oi_1_3.A1 a_25203_13320# VSS.t12 sg13_lv_nmos ad=0.1406p pd=1.12u as=0.1406p ps=1.12u w=0.74u l=0.13u
X3929 VSS.t891 VDD VSS.t890 VSS.t889 sg13_lv_nmos ad=0.1428p pd=1.52u as=0 ps=0 w=0.42u l=1u
X3930 VSS.t1259 VDD VSS.t1260 VSS.t70 sg13_lv_nmos ad=79.8f pd=0.8u as=0 ps=0 w=0.42u l=1u
X3931 VSS.t34 VDD VSS.t34 VSS.t390 sg13_lv_nmos ad=79.8f pd=0.8u as=0 ps=0 w=0.42u l=1u
X3932 VSS.t450 VDD VSS.t451 VSS.t15 sg13_lv_nmos ad=79.8f pd=0.8u as=0 ps=0 w=0.42u l=1u
X3933 VDD VSS.t256 VDD VDD sg13_lv_pmos ad=0.19p pd=1.38u as=0 ps=0 w=1u l=1u
X3934 VDD VSS.t848 VDD VDD sg13_lv_pmos ad=0.19p pd=1.38u as=0 ps=0 w=1u l=1u
X3935 VDD VSS.t1524 VDD VDD sg13_lv_pmos ad=0.34p pd=2.68u as=0 ps=0 w=1u l=1u
X3936 a_18202_15202# sg13cmos5l_dfrbpq_1_2.Q VDD VDD sg13_lv_pmos ad=0.1428p pd=1.52u as=0.1523p ps=1.38u w=0.42u l=0.13u
X3937 sg13cmos5l_buf_8_2.A a_15579_14854# VSS.t47 VSS.t3234 sg13_lv_nmos ad=0.1406p pd=1.12u as=0.1406p ps=1.12u w=0.74u l=0.13u
X3938 VSS.t587 VDD VSS.t81 VSS.t704 sg13_lv_nmos ad=0.1428p pd=1.52u as=0 ps=0 w=0.42u l=1u
X3939 VSS.t2324 VDD VSS.t2323 VSS.t2322 sg13_lv_nmos ad=0.1428p pd=1.52u as=0 ps=0 w=0.42u l=1u
X3940 VSS.t2685 VDD VSS.t2686 VSS.t61 sg13_lv_nmos ad=79.8f pd=0.8u as=0 ps=0 w=0.42u l=1u
X3941 VDD VSS.t287 VDD VDD sg13_lv_pmos ad=0.34p pd=2.68u as=0 ps=0 w=1u l=1u
X3942 VSS.t218 sg13cmos5l_or3_1_1.B a_16168_15996# VSS.t3213 sg13_lv_nmos ad=0.14875p pd=1.16u as=0.187p ps=1.78u w=0.55u l=0.13u
X3943 a_23736_14464# sg13cmos5l_or3_1_2.B VDD VDD sg13_lv_pmos ad=0.2128p pd=1.5u as=0.3808p ps=2.92u w=1.12u l=0.15u
X3944 VDD VSS.t609 VDD VDD sg13_lv_pmos ad=0.34p pd=2.68u as=0 ps=0 w=1u l=1u
X3945 VDD VSS.t1732 VDD VDD sg13_lv_pmos ad=0.19p pd=1.38u as=0 ps=0 w=1u l=1u
X3946 VDD VSS.t3022 VDD VDD sg13_lv_pmos ad=0.19p pd=1.38u as=0 ps=0 w=1u l=1u
X3947 VSS.t2761 VDD VSS.t2761 VSS.t61 sg13_lv_nmos ad=79.8f pd=0.8u as=0 ps=0 w=0.42u l=1u
X3948 VDD VSS.t512 VDD VDD sg13_lv_pmos ad=0.19p pd=1.38u as=0 ps=0 w=1u l=1u
X3949 VDD VSS.t940 VDD VDD sg13_lv_pmos ad=0.34p pd=2.68u as=0 ps=0 w=1u l=1u
X3950 a_24935_14020# sg13cmos5l_or3_1_1.C a_24841_13726# VDD sg13_lv_pmos ad=0.19p pd=1.38u as=0.34p ps=2.68u w=1u l=0.13u
X3951 VSS.t512 VDD VSS.t512 VSS.t511 sg13_lv_nmos ad=0.1428p pd=1.52u as=0 ps=0 w=0.42u l=1u
X3952 VSS.t2663 VDD VSS.t2664 VSS.t61 sg13_lv_nmos ad=79.8f pd=0.8u as=0 ps=0 w=0.42u l=1u
X3953 VDD VSS.t2086 VDD VDD sg13_lv_pmos ad=0.34p pd=2.68u as=0 ps=0 w=1u l=1u
X3954 VDD VSS.t1256 VDD VDD sg13_lv_pmos ad=0.34p pd=2.68u as=0 ps=0 w=1u l=1u
X3955 VDD VSS.t2761 VDD VDD sg13_lv_pmos ad=0.34p pd=2.68u as=0 ps=0 w=1u l=1u
X3956 VSS.t3040 VDD VSS.t3042 VSS.t3041 sg13_lv_nmos ad=79.8f pd=0.8u as=0 ps=0 w=0.42u l=1u
X3957 VDD VSS.t350 VDD VDD sg13_lv_pmos ad=0.19p pd=1.38u as=0 ps=0 w=1u l=1u
X3958 a_2890_15457# a_3333_15213# a_2630_15234# VSS.t3297 sg13_lv_nmos ad=79.8f pd=0.8u as=0.1296p ps=1.52u w=0.42u l=0.13u
X3959 VDD VSS.t436 VDD VDD sg13_lv_pmos ad=0.19p pd=1.38u as=0 ps=0 w=1u l=1u
X3960 a_22030_15423# a_22145_15424# VSS.t27 VSS.t26 sg13_lv_nmos ad=0.1428p pd=1.52u as=0.1426p ps=1.16u w=0.42u l=0.5u
X3961 VDD VSS.t318 VDD VDD sg13_lv_pmos ad=0.19p pd=1.38u as=0 ps=0 w=1u l=1u
X3962 VSS.t648 VDD VSS.t773 VSS.t772 sg13_lv_nmos ad=0.1428p pd=1.52u as=0 ps=0 w=0.42u l=1u
X3963 VDD VSS.t2256 VDD VDD sg13_lv_pmos ad=0.19p pd=1.38u as=0 ps=0 w=1u l=1u
X3964 VDD VSS.t1003 VDD VDD sg13_lv_pmos ad=0.19p pd=1.38u as=0 ps=0 w=1u l=1u
X3965 VDD VSS.t2046 VDD VDD sg13_lv_pmos ad=0.34p pd=2.68u as=0 ps=0 w=1u l=1u
X3966 VSS.t432 VDD VSS.t431 VSS.t15 sg13_lv_nmos ad=0.1428p pd=1.52u as=0 ps=0 w=0.42u l=1u
X3967 VSS.t593 VDD VSS.t593 VSS.t594 sg13_lv_nmos ad=0.1428p pd=1.52u as=0 ps=0 w=0.42u l=1u
X3968 VSS.t1862 VDD VSS.t1864 VSS.t1863 sg13_lv_nmos ad=79.8f pd=0.8u as=0 ps=0 w=0.42u l=1u
X3969 VSS.t609 VDD VSS.t612 VSS.t747 sg13_lv_nmos ad=79.8f pd=0.8u as=0 ps=0 w=0.42u l=1u
X3970 VDD VSS.t1544 VDD VDD sg13_lv_pmos ad=0.34p pd=2.68u as=0 ps=0 w=1u l=1u
X3971 VDD VSS.t3172 VDD VDD sg13_lv_pmos ad=0.19p pd=1.38u as=0 ps=0 w=1u l=1u
X3972 VSS.t2661 VDD VSS.t2662 VSS.t61 sg13_lv_nmos ad=79.8f pd=0.8u as=0 ps=0 w=0.42u l=1u
X3973 VSS.t348 VDD VSS.t88 VSS.t347 sg13_lv_nmos ad=0.1428p pd=1.52u as=0 ps=0 w=0.42u l=1u
X3974 a_21477_14495# sg13cmos5l_buf_8_2.X VDD VDD sg13_lv_pmos ad=0.4088p pd=2.97u as=2.3367p ps=15.135u w=1.12u l=0.13u
X3975 VDD VSS.t479 VDD VDD sg13_lv_pmos ad=0.34p pd=2.68u as=0 ps=0 w=1u l=1u
X3976 VDD VSS.t1881 VDD VDD sg13_lv_pmos ad=0.34p pd=2.68u as=0 ps=0 w=1u l=1u
X3977 VDD VSS.t2721 VDD VDD sg13_lv_pmos ad=0.34p pd=2.68u as=0 ps=0 w=1u l=1u
X3978 VSS.t921 VDD VSS.t920 VSS.t919 sg13_lv_nmos ad=0.1428p pd=1.52u as=0 ps=0 w=0.42u l=1u
X3979 VSS.t2772 VDD VSS.t2771 VSS.t61 sg13_lv_nmos ad=0.1428p pd=1.52u as=0 ps=0 w=0.42u l=1u
X3980 VDD VSS.t596 VDD VDD sg13_lv_pmos ad=0.19p pd=1.38u as=0 ps=0 w=1u l=1u
X3981 VDD VSS.t903 VDD VDD sg13_lv_pmos ad=0.19p pd=1.38u as=0 ps=0 w=1u l=1u
X3982 VSS.t593 VDD VSS.t591 VSS.t717 sg13_lv_nmos ad=0.1428p pd=1.52u as=0 ps=0 w=0.42u l=1u
X3983 VSS.t2269 VDD VSS.t2268 VSS.t2267 sg13_lv_nmos ad=0.1428p pd=1.52u as=0 ps=0 w=0.42u l=1u
X3984 VSS.t1280 VDD VSS.t1280 VSS.t70 sg13_lv_nmos ad=0.1428p pd=1.52u as=0 ps=0 w=0.42u l=1u
X3985 VDD VSS.t1297 VDD VDD sg13_lv_pmos ad=0.19p pd=1.38u as=0 ps=0 w=1u l=1u
X3986 VSS.t1605 VDD VSS.t1604 VSS.t1603 sg13_lv_nmos ad=0.1428p pd=1.52u as=0 ps=0 w=0.42u l=1u
X3987 VSS.t2653 VDD VSS.t2655 VSS.t61 sg13_lv_nmos ad=79.8f pd=0.8u as=0 ps=0 w=0.42u l=1u
X3988 VSS.t2734 VDD VSS.t2733 VSS.t61 sg13_lv_nmos ad=0.1428p pd=1.52u as=0 ps=0 w=0.42u l=1u
X3989 VDD VSS.t2473 VDD VDD sg13_lv_pmos ad=0.34p pd=2.68u as=0 ps=0 w=1u l=1u
X3990 VSS.t1972 VDD VSS.t1974 VSS.t1973 sg13_lv_nmos ad=79.8f pd=0.8u as=0 ps=0 w=0.42u l=1u
X3991 VDD VSS.t2670 VDD VDD sg13_lv_pmos ad=0.19p pd=1.38u as=0 ps=0 w=1u l=1u
X3992 VSS.t2309 VDD VSS.t2308 VSS.t2307 sg13_lv_nmos ad=0.1428p pd=1.52u as=0 ps=0 w=0.42u l=1u
X3993 a_6682_13690# sg13cmos5l_dlygate4sd3_1_0.A VDD VDD sg13_lv_pmos ad=0.1428p pd=1.52u as=0.1523p ps=1.38u w=0.42u l=0.13u
X3994 VDD VSS.t627 VDD VDD sg13_lv_pmos ad=0.34p pd=2.68u as=0 ps=0 w=1u l=1u
X3995 VDD VSS.t840 VDD VDD sg13_lv_pmos ad=0.34p pd=2.68u as=0 ps=0 w=1u l=1u
X3996 VDD VSS.t2967 VDD VDD sg13_lv_pmos ad=0.19p pd=1.38u as=0 ps=0 w=1u l=1u
X3997 VSS.t1324 VDD VSS.t1323 VSS.t70 sg13_lv_nmos ad=0.1428p pd=1.52u as=0 ps=0 w=0.42u l=1u
X3998 VDD VSS.t2421 VDD VDD sg13_lv_pmos ad=0.19p pd=1.38u as=0 ps=0 w=1u l=1u
X3999 VDD VSS.t2079 VDD VDD sg13_lv_pmos ad=0.19p pd=1.38u as=0 ps=0 w=1u l=1u
X4000 VSS.t2082 VDD VSS.t2081 VSS.t2080 sg13_lv_nmos ad=0.1428p pd=1.52u as=0 ps=0 w=0.42u l=1u
X4001 VDD VSS.t778 VDD VDD sg13_lv_pmos ad=0.19p pd=1.38u as=0 ps=0 w=1u l=1u
X4002 VDD VSS.t253 VDD VDD sg13_lv_pmos ad=0.34p pd=2.68u as=0 ps=0 w=1u l=1u
X4003 VSS.t102 VDD VSS.t102 VSS.t727 sg13_lv_nmos ad=0.1428p pd=1.52u as=0 ps=0 w=0.42u l=1u
X4004 VDD VSS.t1854 VDD VDD sg13_lv_pmos ad=0.19p pd=1.38u as=0 ps=0 w=1u l=1u
X4005 VDD VSS.t2373 VDD VDD sg13_lv_pmos ad=0.34p pd=2.68u as=0 ps=0 w=1u l=1u
X4006 VSS.t1535 VDD VSS.t1534 VSS.t1533 sg13_lv_nmos ad=0.1428p pd=1.52u as=0 ps=0 w=0.42u l=1u
X4007 VSS.t273 VDD VSS.t367 VSS.t371 sg13_lv_nmos ad=0.1428p pd=1.52u as=0 ps=0 w=0.42u l=1u
X4008 VDD VSS.t562 VDD VDD sg13_lv_pmos ad=0.19p pd=1.38u as=0 ps=0 w=1u l=1u
X4009 VDD VSS.t406 VDD VDD sg13_lv_pmos ad=0.34p pd=2.68u as=0 ps=0 w=1u l=1u
X4010 VSS.t467 VDD VSS.t98 VSS.t468 sg13_lv_nmos ad=79.8f pd=0.8u as=0 ps=0 w=0.42u l=1u
X4011 VDD VSS.t893 VDD VDD sg13_lv_pmos ad=0.19p pd=1.38u as=0 ps=0 w=1u l=1u
X4012 VDD VSS.t1949 VDD VDD sg13_lv_pmos ad=0.19p pd=1.38u as=0 ps=0 w=1u l=1u
X4013 VDD VSS.t1190 VDD VDD sg13_lv_pmos ad=0.34p pd=2.68u as=0 ps=0 w=1u l=1u
X4014 VDD a_7631_14845# a_7888_14726# VDD sg13_lv_pmos ad=2.42015p pd=15.68u as=79.8f ps=0.8u w=0.42u l=0.13u
X4015 VSS.t627 VDD VSS.t630 VSS.t759 sg13_lv_nmos ad=79.8f pd=0.8u as=0 ps=0 w=0.42u l=1u
X4016 VSS.t2783 VDD VSS.t2782 VSS.t61 sg13_lv_nmos ad=0.1428p pd=1.52u as=0 ps=0 w=0.42u l=1u
X4017 VSS.t2676 VDD VSS.t2677 VSS.t61 sg13_lv_nmos ad=79.8f pd=0.8u as=0 ps=0 w=0.42u l=1u
X4018 VDD VSS.t1662 VDD VDD sg13_lv_pmos ad=0.19p pd=1.38u as=0 ps=0 w=1u l=1u
X4019 sg13cmos5l_dlygate4sd3_1_1.A a_8298_14484# VDD VDD sg13_lv_pmos ad=0.3808p pd=2.92u as=0.2128p ps=1.5u w=1.12u l=0.13u
X4020 VDD VSS.t1717 VDD VDD sg13_lv_pmos ad=0.19p pd=1.38u as=0 ps=0 w=1u l=1u
X4021 VDD VSS.t2316 VDD VDD sg13_lv_pmos ad=0.19p pd=1.38u as=0 ps=0 w=1u l=1u
X4022 a_17710_16263# a_17825_16262# VSS.t128 VSS.t234 sg13_lv_nmos ad=0.1428p pd=1.52u as=0.1426p ps=1.16u w=0.42u l=0.5u
X4023 VDD VSS.t2441 VDD VDD sg13_lv_pmos ad=0.19p pd=1.38u as=0 ps=0 w=1u l=1u
X4024 VDD VSS.t2099 VDD VDD sg13_lv_pmos ad=0.19p pd=1.38u as=0 ps=0 w=1u l=1u
X4025 VSS.t1922 VDD VSS.t1924 VSS.t1923 sg13_lv_nmos ad=79.8f pd=0.8u as=0 ps=0 w=0.42u l=1u
X4026 VSS.t801 VDD VSS.t803 VSS.t802 sg13_lv_nmos ad=79.8f pd=0.8u as=0 ps=0 w=0.42u l=1u
X4027 VDD VSS.t2638 VDD VDD sg13_lv_pmos ad=0.19p pd=1.38u as=0 ps=0 w=1u l=1u
X4028 VSS.t2254 VDD VSS.t2253 VSS.t2252 sg13_lv_nmos ad=0.1428p pd=1.52u as=0 ps=0 w=0.42u l=1u
X4029 VSS.t24 a_25390_16263# sg13cmos5l_a21oi_1_2.A1 VSS.t198 sg13_lv_nmos ad=0.1426p pd=1.16u as=0.2516p ps=2.16u w=0.74u l=0.13u
X4030 a_24310_15230# sg13cmos5l_or3_1_1.C VSS.t174 VSS.t65 sg13_lv_nmos ad=0.1406p pd=1.12u as=0.1406p ps=1.12u w=0.74u l=0.15u
X4031 VDD VSS.t860 VDD VDD sg13_lv_pmos ad=0.34p pd=2.68u as=0 ps=0 w=1u l=1u
X4032 VSS.t3045 VDD VSS.t3044 VSS.t3043 sg13_lv_nmos ad=0.1428p pd=1.52u as=0 ps=0 w=0.42u l=1u
X4033 VSS.t2424 VDD VSS.t2426 VSS.t2425 sg13_lv_nmos ad=79.8f pd=0.8u as=0 ps=0 w=0.42u l=1u
X4034 sg13cmos5l_dlygate4sd3_1_8.A a_11370_15532# VSS.t98 VSS.t97 sg13_lv_nmos ad=0.2516p pd=2.16u as=0.1406p ps=1.12u w=0.74u l=0.13u
X4035 VDD VSS.t1529 VDD VDD sg13_lv_pmos ad=0.34p pd=2.68u as=0 ps=0 w=1u l=1u
X4036 VSS.t2652 VDD VSS.t2653 VSS.t61 sg13_lv_nmos ad=79.8f pd=0.8u as=0 ps=0 w=0.42u l=1u
X4037 sg13cmos5l_or3_1_1.B a_14261_15238# VDD VDD sg13_lv_pmos ad=0.2128p pd=1.5u as=0.203p ps=1.5u w=1.12u l=0.13u
X4038 VSS.t36 sg13cmos5l_buf_1_0.X a_2646_14842# VSS.t3293 sg13_lv_nmos ad=0.15245p pd=1.17u as=88.8f ps=0.98u w=0.74u l=0.13u
X4039 a_6660_14909# a_6891_14495# a_6346_14452# VSS.t54 sg13_lv_nmos ad=0.2373p pd=1.97u as=79.8f ps=0.8u w=0.42u l=0.13u
X4040 VDD VSS.t615 VDD VDD sg13_lv_pmos ad=0.19p pd=1.38u as=0 ps=0 w=1u l=1u
X4041 VSS.t1220 VDD VSS.t1221 VSS.t70 sg13_lv_nmos ad=79.8f pd=0.8u as=0 ps=0 w=0.42u l=1u
X4042 VSS.t2329 VDD VSS.t2328 VSS.t2327 sg13_lv_nmos ad=0.1428p pd=1.52u as=0 ps=0 w=0.42u l=1u
X4043 VSS.t197 a_26565_13701# a_26667_13844# VSS.t3286 sg13_lv_nmos ad=15.38618p pd=0.10091m as=0.2516p ps=2.16u w=0.74u l=0.13u
X4044 VSS.t612 VDD VSS.t609 VSS.t611 sg13_lv_nmos ad=0.1428p pd=1.52u as=0 ps=0 w=0.42u l=1u
X4045 VSS.t1590 VDD VSS.t1592 VSS.t1591 sg13_lv_nmos ad=79.8f pd=0.8u as=0 ps=0 w=0.42u l=1u
X4046 VDD VSS.t1866 VDD VDD sg13_lv_pmos ad=0.34p pd=2.68u as=0 ps=0 w=1u l=1u
X4047 sg13cmos5l_and2_1_1.X a_5613_14832# VSS.t15 VSS.t48 sg13_lv_nmos ad=0.2516p pd=2.16u as=0.1331p ps=1.12u w=0.74u l=0.13u
X4048 VDD VSS.t599 VDD VDD sg13_lv_pmos ad=0.19p pd=1.38u as=0 ps=0 w=1u l=1u
X4049 VDD VSS.t2711 VDD VDD sg13_lv_pmos ad=0.34p pd=2.68u as=0 ps=0 w=1u l=1u
X4050 VSS.t256 sg13cmos5l_buf_8_2.A a_19323_13726# VSS.t255 sg13_lv_nmos ad=0.1406p pd=1.12u as=0.2553p ps=2.17u w=0.74u l=0.13u
X4051 VSS.t896 VDD VSS.t895 VSS.t894 sg13_lv_nmos ad=0.1428p pd=1.52u as=0 ps=0 w=0.42u l=1u
X4052 VDD VSS.t3027 VDD VDD sg13_lv_pmos ad=0.19p pd=1.38u as=0 ps=0 w=1u l=1u
X4053 VSS.t2764 VDD VSS.t2765 VSS.t61 sg13_lv_nmos ad=79.8f pd=0.8u as=0 ps=0 w=0.42u l=1u
X4054 VDD VSS.t1894 VDD VDD sg13_lv_pmos ad=0.19p pd=1.38u as=0 ps=0 w=1u l=1u
X4055 VSS.t1225 VDD VSS.t1226 VSS.t70 sg13_lv_nmos ad=79.8f pd=0.8u as=0 ps=0 w=0.42u l=1u
X4056 VSS.t816 VDD VSS.t818 VSS.t817 sg13_lv_nmos ad=79.8f pd=0.8u as=0 ps=0 w=0.42u l=1u
X4057 a_25390_16263# a_25505_16262# VSS.t24 VSS.t39 sg13_lv_nmos ad=0.1428p pd=1.52u as=0.1426p ps=1.16u w=0.42u l=0.5u
X4058 VSS.t2645 VDD VSS.t2646 VSS.t61 sg13_lv_nmos ad=79.8f pd=0.8u as=0 ps=0 w=0.42u l=1u
X4059 VDD VSS.t2458 VDD VDD sg13_lv_pmos ad=0.34p pd=2.68u as=0 ps=0 w=1u l=1u
X4060 VSS.t1957 VDD VSS.t1959 VSS.t1958 sg13_lv_nmos ad=79.8f pd=0.8u as=0 ps=0 w=0.42u l=1u
X4061 VDD VSS.t1260 VDD VDD sg13_lv_pmos ad=0.34p pd=2.68u as=0 ps=0 w=1u l=1u
X4062 VDD VSS.t2765 VDD VDD sg13_lv_pmos ad=0.34p pd=2.68u as=0 ps=0 w=1u l=1u
X4063 VDD a_19323_13726# sg13cmos5l_buf_8_2.X VDD sg13_lv_pmos ad=0.2128p pd=1.5u as=0.2128p ps=1.5u w=1.12u l=0.13u
X4064 VDD VSS.t2261 VDD VDD sg13_lv_pmos ad=0.19p pd=1.38u as=0 ps=0 w=1u l=1u
X4065 VDD VSS.t823 VDD VDD sg13_lv_pmos ad=0.19p pd=1.38u as=0 ps=0 w=1u l=1u
X4066 VDD VSS.t2358 VDD VDD sg13_lv_pmos ad=0.34p pd=2.68u as=0 ps=0 w=1u l=1u
X4067 VDD clock_i a_15579_14854# VDD sg13_lv_pmos ad=0.2128p pd=1.5u as=0.2128p ps=1.5u w=1.12u l=0.13u
X4068 VDD VSS.t562 VDD VDD sg13_lv_pmos ad=0.19p pd=1.38u as=0 ps=0 w=1u l=1u
X4069 VSS.t2444 VDD VSS.t2446 VSS.t2445 sg13_lv_nmos ad=79.8f pd=0.8u as=0 ps=0 w=0.42u l=1u
X4070 VSS.t1867 VDD VSS.t1869 VSS.t1868 sg13_lv_nmos ad=79.8f pd=0.8u as=0 ps=0 w=0.42u l=1u
X4071 a_7822_13911# a_7937_13912# VSS.t532 VSS.t3307 sg13_lv_nmos ad=0.1428p pd=1.52u as=0.1426p ps=1.16u w=0.42u l=0.5u
X4072 VSS.t555 VDD VSS.t557 VSS.t556 sg13_lv_nmos ad=79.8f pd=0.8u as=0 ps=0 w=0.42u l=1u
X4073 VSS.t2644 VDD VSS.t2645 VSS.t61 sg13_lv_nmos ad=79.8f pd=0.8u as=0 ps=0 w=0.42u l=1u
X4074 VDD VSS.t1327 VDD VDD sg13_lv_pmos ad=0.19p pd=1.38u as=0 ps=0 w=1u l=1u
X4075 VDD VSS.t2111 VDD VDD sg13_lv_pmos ad=0.34p pd=2.68u as=0 ps=0 w=1u l=1u
X4076 VDD VSS.t1934 VDD VDD sg13_lv_pmos ad=0.19p pd=1.38u as=0 ps=0 w=1u l=1u
X4077 a_6286_13911# a_6401_13912# VSS.t170 VSS.t266 sg13_lv_nmos ad=0.1428p pd=1.52u as=0.1426p ps=1.16u w=0.42u l=0.5u
X4078 VSS.t34 VDD VSS.t34 VSS.t392 sg13_lv_nmos ad=0.1428p pd=1.52u as=0 ps=0 w=0.42u l=1u
X4079 sg13cmos5l_nand3_1_0.Y sg13cmos5l_buf_1_0.X a_6680_15242# VSS.t3290 sg13_lv_nmos ad=0.2516p pd=2.16u as=0.1406p ps=1.12u w=0.74u l=0.13u
X4080 VDD VSS.t1886 VDD VDD sg13_lv_pmos ad=0.34p pd=2.68u as=0 ps=0 w=1u l=1u
X4081 VDD VSS.t2723 VDD VDD sg13_lv_pmos ad=0.34p pd=2.68u as=0 ps=0 w=1u l=1u
X4082 VSS.t1170 VDD VSS.t1171 VSS.t70 sg13_lv_nmos ad=79.8f pd=0.8u as=0 ps=0 w=0.42u l=1u
X4083 VSS.t2775 VDD VSS.t2774 VSS.t61 sg13_lv_nmos ad=0.1428p pd=1.52u as=0 ps=0 w=0.42u l=1u
X4084 VDD VSS.t2645 VDD VDD sg13_lv_pmos ad=0.34p pd=2.68u as=0 ps=0 w=1u l=1u
X4085 VDD VSS.t2059 VDD VDD sg13_lv_pmos ad=0.19p pd=1.38u as=0 ps=0 w=1u l=1u
X4086 VDD a_2540_15960# counter_value_o[0] VDD sg13_lv_pmos ad=0.2114p pd=1.54u as=0.42p ps=2.99u w=1.12u l=0.13u
X4087 VSS.t971 VDD VSS.t973 VSS.t972 sg13_lv_nmos ad=79.8f pd=0.8u as=0 ps=0 w=0.42u l=1u
X4088 VSS.t2905 VDD VSS.t2907 VSS.t2906 sg13_lv_nmos ad=79.8f pd=0.8u as=0 ps=0 w=0.42u l=1u
X4089 sg13cmos5l_dlygate4sd3_1_1.A a_8298_14484# VSS.t6 VSS.t85 sg13_lv_nmos ad=0.2516p pd=2.16u as=0.1406p ps=1.12u w=0.74u l=0.13u
X4090 VDD VSS.t1040 VDD VDD sg13_lv_pmos ad=0.34p pd=2.68u as=0 ps=0 w=1u l=1u
X4091 VSS.t1730 VDD VSS.t1732 VSS.t1731 sg13_lv_nmos ad=79.8f pd=0.8u as=0 ps=0 w=0.42u l=1u
X4092 VSS.t429 VDD VSS.t430 VSS.t15 sg13_lv_nmos ad=79.8f pd=0.8u as=0 ps=0 w=0.42u l=1u
X4093 VDD VSS.t648 VDD VDD sg13_lv_pmos ad=0.19p pd=1.38u as=0 ps=0 w=1u l=1u
X4094 VSS.t2737 VDD VSS.t2735 VSS.t61 sg13_lv_nmos ad=0.1428p pd=1.52u as=0 ps=0 w=0.42u l=1u
X4095 VDD VSS.t2478 VDD VDD sg13_lv_pmos ad=0.34p pd=2.68u as=0 ps=0 w=1u l=1u
X4096 VSS.t1942 VDD VSS.t1944 VSS.t1943 sg13_lv_nmos ad=79.8f pd=0.8u as=0 ps=0 w=0.42u l=1u
X4097 VSS.t642 VDD VSS.t642 VSS.t768 sg13_lv_nmos ad=0.1428p pd=1.52u as=0 ps=0 w=0.42u l=1u
X4098 VSS.t253 VDD VSS.t253 VSS.t403 sg13_lv_nmos ad=0.1428p pd=1.52u as=0 ps=0 w=0.42u l=1u
X4099 VDD VSS.t697 VDD VDD sg13_lv_pmos ad=0.34p pd=2.68u as=0 ps=0 w=1u l=1u
X4100 VDD VSS.t2084 VDD VDD sg13_lv_pmos ad=0.19p pd=1.38u as=0 ps=0 w=1u l=1u
X4101 VSS.t2087 VDD VSS.t2086 VSS.t2085 sg13_lv_nmos ad=0.1428p pd=1.52u as=0 ps=0 w=0.42u l=1u
X4102 sg13cmos5l_o21ai_1_2.Y sg13cmos5l_o21ai_1_2.B1 a_23638_14862# VSS.t56 sg13_lv_nmos ad=0.2516p pd=2.16u as=0.1406p ps=1.12u w=0.74u l=0.15u
X4103 VSS.t801 VDD VSS.t803 VSS.t802 sg13_lv_nmos ad=79.8f pd=0.8u as=0 ps=0 w=0.42u l=1u
X4104 VDD VSS.t790 VDD VDD sg13_lv_pmos ad=0.34p pd=2.68u as=0 ps=0 w=1u l=1u
X4105 VDD VSS.t1572 VDD VDD sg13_lv_pmos ad=0.19p pd=1.38u as=0 ps=0 w=1u l=1u
X4106 VSS.t147 VDD VSS.t147 VSS.t295 sg13_lv_nmos ad=0.1428p pd=1.52u as=0 ps=0 w=0.42u l=1u
X4107 VSS.t560 VDD VSS.t562 VSS.t561 sg13_lv_nmos ad=79.8f pd=0.8u as=0 ps=0 w=0.42u l=1u
X4108 VDD VSS.t34 VDD VDD sg13_lv_pmos ad=0.34p pd=2.68u as=0 ps=0 w=1u l=1u
X4109 VSS.t1179 VDD VSS.t1180 VSS.t70 sg13_lv_nmos ad=79.8f pd=0.8u as=0 ps=0 w=0.42u l=1u
X4110 VSS.t2239 VDD VSS.t2238 VSS.t2237 sg13_lv_nmos ad=0.1428p pd=1.52u as=0 ps=0 w=0.42u l=1u
X4111 VSS.t1852 VDD VSS.t1854 VSS.t1853 sg13_lv_nmos ad=79.8f pd=0.8u as=0 ps=0 w=0.42u l=1u
X4112 VDD VSS.t1308 VDD VDD sg13_lv_pmos ad=0.34p pd=2.68u as=0 ps=0 w=1u l=1u
X4113 VDD VSS.t1179 VDD VDD sg13_lv_pmos ad=0.19p pd=1.38u as=0 ps=0 w=1u l=1u
X4114 VSS.t639 VDD VSS.t636 VSS.t638 sg13_lv_nmos ad=0.1428p pd=1.52u as=0 ps=0 w=0.42u l=1u
X4115 VSS.t1600 VDD VSS.t1599 VSS.t1598 sg13_lv_nmos ad=0.1428p pd=1.52u as=0 ps=0 w=0.42u l=1u
X4116 VSS.t3125 VDD VSS.t3124 VSS.t3123 sg13_lv_nmos ad=0.1428p pd=1.52u as=0 ps=0 w=0.42u l=1u
X4117 VSS.t2314 VDD VSS.t2313 VSS.t2312 sg13_lv_nmos ad=0.1428p pd=1.52u as=0 ps=0 w=0.42u l=1u
X4118 a_1965_14832# sg13cmos5l_buf_1_10.X VDD VDD sg13_lv_pmos ad=0.1596p pd=1.22u as=0.2856p ps=2.36u w=0.84u l=0.13u
X4119 VSS.t896 VDD VSS.t895 VSS.t894 sg13_lv_nmos ad=0.1428p pd=1.52u as=0 ps=0 w=0.42u l=1u
X4120 VDD VSS.t2273 VDD VDD sg13_lv_pmos ad=0.34p pd=2.68u as=0 ps=0 w=1u l=1u
X4121 a_25094_15238# a_24824_15238# VSS.t57 VSS.t65 sg13_lv_nmos ad=0.1428p pd=1.52u as=79.8f ps=0.8u w=0.42u l=0.5u
X4122 VSS.t2679 VDD VSS.t2680 VSS.t61 sg13_lv_nmos ad=79.8f pd=0.8u as=0 ps=0 w=0.42u l=1u
X4123 VSS.t941 VDD VSS.t940 VSS.t939 sg13_lv_nmos ad=0.1428p pd=1.52u as=0 ps=0 w=0.42u l=1u
X4124 VSS.t816 VDD VSS.t818 VSS.t817 sg13_lv_nmos ad=79.8f pd=0.8u as=0 ps=0 w=0.42u l=1u
X4125 VSS.t1252 VDD VSS.t1253 VSS.t70 sg13_lv_nmos ad=79.8f pd=0.8u as=0 ps=0 w=0.42u l=1u
X4126 VDD VSS.t1722 VDD VDD sg13_lv_pmos ad=0.19p pd=1.38u as=0 ps=0 w=1u l=1u
X4127 VDD VSS.t3012 VDD VDD sg13_lv_pmos ad=0.19p pd=1.38u as=0 ps=0 w=1u l=1u
X4128 VSS.t2755 VDD VSS.t2755 VSS.t61 sg13_lv_nmos ad=79.8f pd=0.8u as=0 ps=0 w=0.42u l=1u
X4129 VDD VSS.t1879 VDD VDD sg13_lv_pmos ad=0.19p pd=1.38u as=0 ps=0 w=1u l=1u
X4130 VSS.t1882 VDD VSS.t1881 VSS.t1880 sg13_lv_nmos ad=0.1428p pd=1.52u as=0 ps=0 w=0.42u l=1u
X4131 VSS.t1595 VDD VSS.t1594 VSS.t1593 sg13_lv_nmos ad=0.1428p pd=1.52u as=0 ps=0 w=0.42u l=1u
X4132 VDD sg13cmos5l_dfrbpq_1_2.RESET_B a_15782_13722# VDD sg13_lv_pmos ad=0.36237p pd=2.605u as=79.8f ps=0.8u w=0.42u l=0.13u
X4133 VSS.t157 sg13cmos5l_or3_1_1.A a_24841_13726# VSS.t3198 sg13_lv_nmos ad=0.13395p pd=1.12u as=0.198p ps=1.27u w=0.55u l=0.13u
X4134 VSS.t2728 VDD VSS.t2727 VSS.t61 sg13_lv_nmos ad=0.1428p pd=1.52u as=0 ps=0 w=0.42u l=1u
X4135 VSS.t2122 VDD VSS.t2121 VSS.t2120 sg13_lv_nmos ad=0.1428p pd=1.52u as=0 ps=0 w=0.42u l=1u
X4136 VDD VSS.t1251 VDD VDD sg13_lv_pmos ad=0.34p pd=2.68u as=0 ps=0 w=1u l=1u
X4137 VDD VSS.t2755 VDD VDD sg13_lv_pmos ad=0.34p pd=2.68u as=0 ps=0 w=1u l=1u
X4138 VDD VSS.t2411 VDD VDD sg13_lv_pmos ad=0.19p pd=1.38u as=0 ps=0 w=1u l=1u
X4139 VDD sg13cmos5l_a21oi_1_3.A2 a_25109_12972# VDD sg13_lv_pmos ad=0.2128p pd=1.5u as=0.3808p ps=2.92u w=1.12u l=0.13u
X4140 VSS.t1001 VDD VSS.t1003 VSS.t1002 sg13_lv_nmos ad=79.8f pd=0.8u as=0 ps=0 w=0.42u l=1u
X4141 VDD VSS.t2069 VDD VDD sg13_lv_pmos ad=0.19p pd=1.38u as=0 ps=0 w=1u l=1u
X4142 a_18021_14495# sg13cmos5l_buf_8_2.X VDD VDD sg13_lv_pmos ad=0.4088p pd=2.97u as=2.3367p ps=15.135u w=1.12u l=0.13u
X4143 VSS.t1270 VDD VSS.t1271 VSS.t70 sg13_lv_nmos ad=79.8f pd=0.8u as=0 ps=0 w=0.42u l=1u
X4144 VDD VSS.t2246 VDD VDD sg13_lv_pmos ad=0.19p pd=1.38u as=0 ps=0 w=1u l=1u
X4145 VDD VSS.t868 VDD VDD sg13_lv_pmos ad=0.19p pd=1.38u as=0 ps=0 w=1u l=1u
X4146 VSS.t2665 VDD VSS.t2665 VSS.t61 sg13_lv_nmos ad=0.1428p pd=1.52u as=0 ps=0 w=0.42u l=1u
X4147 VSS.t2429 VDD VSS.t2431 VSS.t2430 sg13_lv_nmos ad=79.8f pd=0.8u as=0 ps=0 w=0.42u l=1u
X4148 VDD VSS.t1534 VDD VDD sg13_lv_pmos ad=0.34p pd=2.68u as=0 ps=0 w=1u l=1u
X4149 VDD a_17710_16263# sg13cmos5l_a21oi_1_0.A1 VDD sg13_lv_pmos ad=0.2254p pd=1.53u as=0.4256p ps=3u w=1.12u l=0.13u
X4150 a_10703_15311# a_9861_15213# a_9444_15552# VDD sg13_lv_pmos ad=0.2048p pd=1.63u as=0.34p ps=2.68u w=1u l=0.13u
X4151 VDD VSS.t1517 VDD VDD sg13_lv_pmos ad=0.19p pd=1.38u as=0 ps=0 w=1u l=1u
X4152 VSS.t2635 VDD VSS.t2636 VSS.t61 sg13_lv_nmos ad=79.8f pd=0.8u as=0 ps=0 w=0.42u l=1u
X4153 VDD VSS.t323 VDD VDD sg13_lv_pmos ad=0.19p pd=1.38u as=0 ps=0 w=1u l=1u
X4154 VDD a_15671_15315# a_15671_15549# VDD sg13_lv_pmos ad=2.8961p pd=18.25u as=0.2442p ps=2.06u w=0.66u l=0.13u
X4155 VDD VSS.t32 VDD VDD sg13_lv_pmos ad=0.34p pd=2.68u as=0 ps=0 w=1u l=1u
X4156 VSS.t2334 VDD VSS.t2333 VSS.t2332 sg13_lv_nmos ad=0.1428p pd=1.52u as=0 ps=0 w=0.42u l=1u
X4157 VDD VSS.t2096 VDD VDD sg13_lv_pmos ad=0.34p pd=2.68u as=0 ps=0 w=1u l=1u
X4158 a_16068_14040# a_16042_13945# VSS.t79 VSS.t95 sg13_lv_nmos ad=0.2516p pd=2.16u as=0.1626p ps=1.415u w=0.74u l=0.13u
X4159 VDD VSS.t1243 VDD VDD sg13_lv_pmos ad=0.34p pd=2.68u as=0 ps=0 w=1u l=1u
X4160 VDD VSS.t1871 VDD VDD sg13_lv_pmos ad=0.34p pd=2.68u as=0 ps=0 w=1u l=1u
X4161 VSS.t971 VDD VSS.t973 VSS.t972 sg13_lv_nmos ad=79.8f pd=0.8u as=0 ps=0 w=0.42u l=1u
X4162 VDD VSS.t960 VDD VDD sg13_lv_pmos ad=0.34p pd=2.68u as=0 ps=0 w=1u l=1u
X4163 VDD VSS.t2636 VDD VDD sg13_lv_pmos ad=0.34p pd=2.68u as=0 ps=0 w=1u l=1u
X4164 VDD VSS.t2715 VDD VDD sg13_lv_pmos ad=0.34p pd=2.68u as=0 ps=0 w=1u l=1u
X4165 a_10960_15454# a_10703_15311# a_11122_15234# VSS.t148 sg13_lv_nmos ad=0.1428p pd=1.52u as=37.8f ps=0.6u w=0.42u l=0.13u
X4166 VDD VSS.t3032 VDD VDD sg13_lv_pmos ad=0.19p pd=1.38u as=0 ps=0 w=1u l=1u
X4167 VDD VSS.t1899 VDD VDD sg13_lv_pmos ad=0.19p pd=1.38u as=0 ps=0 w=1u l=1u
X4168 VSS.t1715 VDD VSS.t1717 VSS.t1716 sg13_lv_nmos ad=79.8f pd=0.8u as=0 ps=0 w=0.42u l=1u
X4169 VDD VSS.t448 VDD VDD sg13_lv_pmos ad=0.19p pd=1.38u as=0 ps=0 w=1u l=1u
X4170 VSS.t2107 VDD VSS.t2106 VSS.t2105 sg13_lv_nmos ad=0.1428p pd=1.52u as=0 ps=0 w=0.42u l=1u
X4171 VDD VSS.t2061 VDD VDD sg13_lv_pmos ad=0.34p pd=2.68u as=0 ps=0 w=1u l=1u
X4172 VDD VSS.t1169 VDD VDD sg13_lv_pmos ad=0.34p pd=2.68u as=0 ps=0 w=1u l=1u
X4173 VDD sg13cmos5l_or3_1_1.A sg13cmos5l_o21ai_1_3.Y VDD sg13_lv_pmos ad=0.3808p pd=2.92u as=0.2128p ps=1.5u w=1.12u l=0.15u
X4174 VDD VSS.t1023 VDD VDD sg13_lv_pmos ad=0.19p pd=1.38u as=0 ps=0 w=1u l=1u
X4175 VSS.t1416 VDD VSS.t1285 VSS.t70 sg13_lv_nmos ad=79.8f pd=0.8u as=0 ps=0 w=0.42u l=1u
X4176 VSS.t64 sg13cmos5l_dfrbpq_1_3.RESET_B a_17412_14922# VSS.t237 sg13_lv_nmos ad=0.1626p pd=1.415u as=60.89999f ps=0.71u w=0.42u l=0.13u
X4177 VSS.t1585 VDD VSS.t1587 VSS.t1586 sg13_lv_nmos ad=79.8f pd=0.8u as=0 ps=0 w=0.42u l=1u
X4178 VDD VSS.t2363 VDD VDD sg13_lv_pmos ad=0.34p pd=2.68u as=0 ps=0 w=1u l=1u
X4179 a_21251_13690# sg13cmos5l_or3_1_2.C a_21549_14020# VDD sg13_lv_pmos ad=0.34p pd=2.68u as=0.19p ps=1.38u w=1u l=0.13u
X4180 VSS.t273 a_32492_15960# counter_value_o[6] VSS.t272 sg13_lv_nmos ad=0.14875p pd=1.16u as=0.2886p ps=2.26u w=0.74u l=0.13u
X4181 VSS.t891 VDD VSS.t893 VSS.t892 sg13_lv_nmos ad=79.8f pd=0.8u as=0 ps=0 w=0.42u l=1u
X4182 VSS.t1455 VDD VSS.t1457 VSS.t1456 sg13_lv_nmos ad=79.8f pd=0.8u as=0 ps=0 w=0.42u l=1u
X4183 VSS.t2646 VDD VSS.t2647 VSS.t61 sg13_lv_nmos ad=79.8f pd=0.8u as=0 ps=0 w=0.42u l=1u
X4184 a_21070_15423# a_21185_15424# VSS.t22 VSS.t3193 sg13_lv_nmos ad=0.1428p pd=1.52u as=0.1426p ps=1.16u w=0.42u l=0.5u
X4185 VDD VSS.t396 VDD VDD sg13_lv_pmos ad=0.34p pd=2.68u as=0 ps=0 w=1u l=1u
X4186 VDD VSS.t738 VDD VDD sg13_lv_pmos ad=0.19p pd=1.38u as=0 ps=0 w=1u l=1u
X4187 VDD VSS.t1939 VDD VDD sg13_lv_pmos ad=0.19p pd=1.38u as=0 ps=0 w=1u l=1u
X4188 sg13cmos5l_and2_1_2.B a_8694_15302# VDD VDD sg13_lv_pmos ad=0.4256p pd=3u as=0.2254p ps=1.53u w=1.12u l=0.13u
X4189 VSS.t941 VDD VSS.t940 VSS.t939 sg13_lv_nmos ad=0.1428p pd=1.52u as=0 ps=0 w=0.42u l=1u
X4190 VDD VSS.t1170 VDD VDD sg13_lv_pmos ad=0.19p pd=1.38u as=0 ps=0 w=1u l=1u
X4191 VDD VSS.t2258 VDD VDD sg13_lv_pmos ad=0.34p pd=2.68u as=0 ps=0 w=1u l=1u
X4192 a_7923_15532# sg13cmos5l_dlygate4sd3_1_8.X VDD VDD sg13_lv_pmos ad=0.1428p pd=1.375u as=0.2891p ps=1.695u w=1.12u l=0.13u
X4193 VDD VSS.t1856 VDD VDD sg13_lv_pmos ad=0.34p pd=2.68u as=0 ps=0 w=1u l=1u
X4194 VSS.t2892 VDD VSS.t2776 VSS.t61 sg13_lv_nmos ad=0.1428p pd=1.52u as=0 ps=0 w=0.42u l=1u
X4195 VDD VSS.t2647 VDD VDD sg13_lv_pmos ad=0.34p pd=2.68u as=0 ps=0 w=1u l=1u
X4196 VDD VSS.t2749 VDD VDD sg13_lv_pmos ad=0.19p pd=1.38u as=0 ps=0 w=1u l=1u
X4197 VDD sg13cmos5l_o21ai_1_2.B1 a_24365_14508# VDD sg13_lv_pmos ad=0.3822p pd=1.84u as=0.1575p ps=1.315u w=1u l=0.13u
X4198 VSS.t102 sg13cmos5l_a21oi_1_3.B1 sg13cmos5l_a21oi_1_3.Y VSS.t101 sg13_lv_nmos ad=0.2516p pd=2.16u as=0.1406p ps=1.12u w=0.74u l=0.13u
X4199 VDD VSS.t3174 VDD VDD sg13_lv_pmos ad=0.34p pd=2.68u as=0 ps=0 w=1u l=1u
X4200 a_27502_15423# a_27617_15424# VDD VDD sg13_lv_pmos ad=0.34p pd=2.68u as=0.2254p ps=1.53u w=1u l=0.5u
X4201 VDD VSS.t428 VDD VDD sg13_lv_pmos ad=0.34p pd=2.68u as=0 ps=0 w=1u l=1u
X4202 VSS.t128 sg13cmos5l_or3_1_2.B a_16969_16020# VSS.t3260 sg13_lv_nmos ad=0.1045p pd=0.93u as=0.187p ps=1.78u w=0.55u l=0.13u
X4203 VDD VSS.t418 VDD VDD sg13_lv_pmos ad=0.19p pd=1.38u as=0 ps=0 w=1u l=1u
X4204 VDD VSS.t521 VDD VDD sg13_lv_pmos ad=0.19p pd=1.38u as=0 ps=0 w=1u l=1u
X4205 VDD VSS.t639 VDD VDD sg13_lv_pmos ad=0.34p pd=2.68u as=0 ps=0 w=1u l=1u
X4206 VSS.t2719 VDD VSS.t2717 VSS.t61 sg13_lv_nmos ad=0.1428p pd=1.52u as=0 ps=0 w=0.42u l=1u
X4207 VSS.t1001 VDD VSS.t1003 VSS.t1002 sg13_lv_nmos ad=79.8f pd=0.8u as=0 ps=0 w=0.42u l=1u
X4208 VDD VSS.t1261 VDD VDD sg13_lv_pmos ad=0.34p pd=2.68u as=0 ps=0 w=1u l=1u
X4209 a_32492_15960# sg13cmos5l_dfrbpq_1_7.Q VSS.t273 VSS.t3222 sg13_lv_nmos ad=0.187p pd=1.78u as=0.14875p ps=1.16u w=0.55u l=0.13u
X4210 VDD a_27034_15202# a_26753_15424# VDD sg13_lv_pmos ad=0.1523p pd=1.38u as=0.34p ps=2.68u w=1u l=0.5u
X4211 VDD VSS.t798 VDD VDD sg13_lv_pmos ad=0.19p pd=1.38u as=0 ps=0 w=1u l=1u
X4212 VDD VSS.t990 VDD VDD sg13_lv_pmos ad=0.34p pd=2.68u as=0 ps=0 w=1u l=1u
X4213 VSS.t3191 sg13cmos5l_or3_1_2.B a_23638_14862# VSS.t56 sg13_lv_nmos ad=0.1406p pd=1.12u as=0.2516p ps=2.16u w=0.74u l=0.15u
X4214 VSS.t1675 VDD VSS.t1674 VSS.t1673 sg13_lv_nmos ad=0.1428p pd=1.52u as=0 ps=0 w=0.42u l=1u
X4215 VDD VSS.t2396 VDD VDD sg13_lv_pmos ad=0.19p pd=1.38u as=0 ps=0 w=1u l=1u
X4216 VSS.t8 VDD VSS.t8 VSS.t742 sg13_lv_nmos ad=0.1428p pd=1.52u as=0 ps=0 w=0.42u l=1u
X4217 VDD VSS.t1577 VDD VDD sg13_lv_pmos ad=0.19p pd=1.38u as=0 ps=0 w=1u l=1u
X4218 VSS.t2670 VDD VSS.t2671 VSS.t61 sg13_lv_nmos ad=79.8f pd=0.8u as=0 ps=0 w=0.42u l=1u
X4219 VDD VSS.t1911 VDD VDD sg13_lv_pmos ad=0.34p pd=2.68u as=0 ps=0 w=1u l=1u
X4220 VSS.t277 VDD VSS.t279 VSS.t278 sg13_lv_nmos ad=79.8f pd=0.8u as=0 ps=0 w=0.42u l=1u
X4221 VSS.t861 VDD VSS.t860 VSS.t859 sg13_lv_nmos ad=0.1428p pd=1.52u as=0 ps=0 w=0.42u l=1u
X4222 VDD a_10960_15454# a_10905_15549# VDD sg13_lv_pmos ad=2.8961p pd=18.25u as=93.45f ps=0.865u w=0.42u l=0.13u
X4223 VDD VSS.t913 VDD VDD sg13_lv_pmos ad=0.19p pd=1.38u as=0 ps=0 w=1u l=1u
X4224 VSS.t2657 VDD VSS.t2656 VSS.t61 sg13_lv_nmos ad=0.1428p pd=1.52u as=0 ps=0 w=0.42u l=1u
X4225 VDD VSS.t2708 VDD VDD sg13_lv_pmos ad=0.19p pd=1.38u as=0 ps=0 w=1u l=1u
X4226 VSS.t1977 VDD VSS.t1976 VSS.t1975 sg13_lv_nmos ad=0.1428p pd=1.52u as=0 ps=0 w=0.42u l=1u
X4227 VSS.t311 VDD VSS.t313 VSS.t312 sg13_lv_nmos ad=79.8f pd=0.8u as=0 ps=0 w=0.42u l=1u
X4228 VSS.t406 VDD VSS.t406 VSS.t477 sg13_lv_nmos ad=79.8f pd=0.8u as=0 ps=0 w=0.42u l=1u
X4229 VDD VSS.t1202 VDD VDD sg13_lv_pmos ad=0.34p pd=2.68u as=0 ps=0 w=1u l=1u
X4230 VSS.t2319 VDD VSS.t2318 VSS.t2317 sg13_lv_nmos ad=0.1428p pd=1.52u as=0 ps=0 w=0.42u l=1u
X4231 a_2540_15960# sg13cmos5l_dlygate4sd3_1_3.A VSS.t20 VSS.t3203 sg13_lv_nmos ad=0.187p pd=1.78u as=0.14875p ps=1.16u w=0.55u l=0.13u
X4232 VSS.t639 VDD VSS.t642 VSS.t767 sg13_lv_nmos ad=79.8f pd=0.8u as=0 ps=0 w=0.42u l=1u
X4233 VDD VSS.t2278 VDD VDD sg13_lv_pmos ad=0.34p pd=2.68u as=0 ps=0 w=1u l=1u
X4234 VSS.t2509 VDD VSS.t2511 VSS.t2510 sg13_lv_nmos ad=79.8f pd=0.8u as=0 ps=0 w=0.42u l=1u
X4235 VSS.t2682 VDD VSS.t2683 VSS.t61 sg13_lv_nmos ad=79.8f pd=0.8u as=0 ps=0 w=0.42u l=1u
X4236 VDD VSS.t2451 VDD VDD sg13_lv_pmos ad=0.19p pd=1.38u as=0 ps=0 w=1u l=1u
X4237 VDD VSS.t618 VDD VDD sg13_lv_pmos ad=0.19p pd=1.38u as=0 ps=0 w=1u l=1u
X4238 VDD VSS.t788 VDD VDD sg13_lv_pmos ad=0.19p pd=1.38u as=0 ps=0 w=1u l=1u
X4239 VSS.t1223 VDD VSS.t1224 VSS.t70 sg13_lv_nmos ad=79.8f pd=0.8u as=0 ps=0 w=0.42u l=1u
X4240 VDD VSS.t3017 VDD VDD sg13_lv_pmos ad=0.19p pd=1.38u as=0 ps=0 w=1u l=1u
X4241 VDD VSS.t1884 VDD VDD sg13_lv_pmos ad=0.19p pd=1.38u as=0 ps=0 w=1u l=1u
X4242 VSS.t1887 VDD VSS.t1886 VSS.t1885 sg13_lv_nmos ad=0.1428p pd=1.52u as=0 ps=0 w=0.42u l=1u
X4243 VSS.t414 VDD VSS.t415 VSS.t15 sg13_lv_nmos ad=79.8f pd=0.8u as=0 ps=0 w=0.42u l=1u
X4244 VSS.t2057 VDD VSS.t2059 VSS.t2058 sg13_lv_nmos ad=79.8f pd=0.8u as=0 ps=0 w=0.42u l=1u
X4245 VDD VSS.t953 VDD VDD sg13_lv_pmos ad=0.19p pd=1.38u as=0 ps=0 w=1u l=1u
X4246 VDD VSS.t1732 VDD VDD sg13_lv_pmos ad=0.19p pd=1.38u as=0 ps=0 w=1u l=1u
X4247 VDD VSS.t603 VDD VDD sg13_lv_pmos ad=0.19p pd=1.38u as=0 ps=0 w=1u l=1u
X4248 VDD VSS.t1254 VDD VDD sg13_lv_pmos ad=0.34p pd=2.68u as=0 ps=0 w=1u l=1u
X4249 VDD VSS.t2759 VDD VDD sg13_lv_pmos ad=0.34p pd=2.68u as=0 ps=0 w=1u l=1u
X4250 VDD VSS.t2416 VDD VDD sg13_lv_pmos ad=0.19p pd=1.38u as=0 ps=0 w=1u l=1u
X4251 VSS.t821 VDD VSS.t823 VSS.t822 sg13_lv_nmos ad=79.8f pd=0.8u as=0 ps=0 w=0.42u l=1u
X4252 VDD a_27500_15960# counter_value_o[5] VDD sg13_lv_pmos ad=0.2114p pd=1.54u as=0.42p ps=2.99u w=1.12u l=0.13u
X4253 VSS.t891 VDD VSS.t893 VSS.t892 sg13_lv_nmos ad=79.8f pd=0.8u as=0 ps=0 w=0.42u l=1u
X4254 VSS.t2925 VDD VSS.t2924 VSS.t2923 sg13_lv_nmos ad=0.1428p pd=1.52u as=0 ps=0 w=0.42u l=1u
X4255 VDD VSS.t436 VDD VDD sg13_lv_pmos ad=0.19p pd=1.38u as=0 ps=0 w=1u l=1u
X4256 a_26436_13735# a_26667_13844# a_26122_13945# VSS.t162 sg13_lv_nmos ad=0.2373p pd=1.97u as=79.8f ps=0.8u w=0.42u l=0.13u
X4257 a_26374_13735# sg13cmos5l_dfrbpq_1_5.RESET_B VSS.t729 VSS.t3302 sg13_lv_nmos ad=37.8f pd=0.6u as=0.1701p ps=1.65u w=0.42u l=0.13u
X4258 VDD VSS.t880 VDD VDD sg13_lv_pmos ad=0.34p pd=2.68u as=0 ps=0 w=1u l=1u
X4259 VSS.t1570 VDD VSS.t1572 VSS.t1571 sg13_lv_nmos ad=79.8f pd=0.8u as=0 ps=0 w=0.42u l=1u
X4260 VSS.t1232 VDD VSS.t1233 VSS.t70 sg13_lv_nmos ad=79.8f pd=0.8u as=0 ps=0 w=0.42u l=1u
X4261 VSS.t303 VDD VSS.t303 VSS.t308 sg13_lv_nmos ad=79.8f pd=0.8u as=0 ps=0 w=0.42u l=1u
X4262 VSS.t79 sg13cmos5l_dfrbpq_1_2.RESET_B a_15876_13722# VSS.t78 sg13_lv_nmos ad=0.1626p pd=1.415u as=60.89999f ps=0.71u w=0.42u l=0.13u
X4263 VSS.t621 VDD VSS.t621 VSS.t754 sg13_lv_nmos ad=0.1428p pd=1.52u as=0 ps=0 w=0.42u l=1u
X4264 VDD VSS.t627 VDD VDD sg13_lv_pmos ad=0.19p pd=1.38u as=0 ps=0 w=1u l=1u
X4265 VSS.t2638 VDD VSS.t2639 VSS.t61 sg13_lv_nmos ad=79.8f pd=0.8u as=0 ps=0 w=0.42u l=1u
X4266 VSS.t28 a_27472_14726# a_27121_14845# VSS.t15 sg13_lv_nmos ad=79.8f pd=0.8u as=0.1428p ps=1.52u w=0.42u l=0.13u
X4267 VDD VSS.t2443 VDD VDD sg13_lv_pmos ad=0.34p pd=2.68u as=0 ps=0 w=1u l=1u
X4268 VDD VSS.t2101 VDD VDD sg13_lv_pmos ad=0.34p pd=2.68u as=0 ps=0 w=1u l=1u
X4269 VSS.t2494 VDD VSS.t2496 VSS.t2495 sg13_lv_nmos ad=79.8f pd=0.8u as=0 ps=0 w=0.42u l=1u
X4270 a_8582_15238# a_8312_15238# VSS.t6 VSS.t5 sg13_lv_nmos ad=0.1428p pd=1.52u as=79.8f ps=0.8u w=0.42u l=0.5u
X4271 sg13cmos5l_buf_8_2.X a_19323_13726# VDD VDD sg13_lv_pmos ad=0.2128p pd=1.5u as=0.2128p ps=1.5u w=1.12u l=0.13u
X4272 VSS.t560 VDD VSS.t562 VSS.t561 sg13_lv_nmos ad=79.8f pd=0.8u as=0 ps=0 w=0.42u l=1u
X4273 VSS.t1197 VDD VSS.t1196 VSS.t70 sg13_lv_nmos ad=0.1428p pd=1.52u as=0 ps=0 w=0.42u l=1u
X4274 VSS.t1237 VDD VSS.t1238 VSS.t70 sg13_lv_nmos ad=79.8f pd=0.8u as=0 ps=0 w=0.42u l=1u
X4275 VDD VSS.t2639 VDD VDD sg13_lv_pmos ad=0.34p pd=2.68u as=0 ps=0 w=1u l=1u
X4276 a_15870_15486# a_15671_15549# VSS.t15 VSS.t144 sg13_lv_nmos ad=0.27427p pd=2.28u as=4.11262p ps=27.15u w=0.795u l=0.13u
X4277 VDD VSS.t3002 VDD VDD sg13_lv_pmos ad=0.19p pd=1.38u as=0 ps=0 w=1u l=1u
X4278 VDD VSS.t521 VDD VDD sg13_lv_pmos ad=0.19p pd=1.38u as=0 ps=0 w=1u l=1u
X4279 VDD VSS.t1330 VDD VDD sg13_lv_pmos ad=0.19p pd=1.38u as=0 ps=0 w=1u l=1u
X4280 a_27472_14726# a_27215_14845# a_27634_14922# VSS.t15 sg13_lv_nmos ad=0.1428p pd=1.52u as=37.8f ps=0.6u w=0.42u l=0.13u
X4281 VSS.t1720 VDD VSS.t1722 VSS.t1721 sg13_lv_nmos ad=79.8f pd=0.8u as=0 ps=0 w=0.42u l=1u
X4282 a_12010_15202# sg13cmos5l_buf_8_2.A VSS.t192 VSS.t251 sg13_lv_nmos ad=0.1406p pd=1.12u as=0.1406p ps=1.12u w=0.74u l=0.13u
X4283 VSS.t791 VDD VSS.t790 VSS.t789 sg13_lv_nmos ad=0.1428p pd=1.52u as=0 ps=0 w=0.42u l=1u
X4284 VSS.t2691 VDD VSS.t2690 VSS.t61 sg13_lv_nmos ad=0.1428p pd=1.52u as=0 ps=0 w=0.42u l=1u
X4285 VSS.t861 VDD VSS.t860 VSS.t859 sg13_lv_nmos ad=0.1428p pd=1.52u as=0 ps=0 w=0.42u l=1u
X4286 VDD VSS.t1562 VDD VDD sg13_lv_pmos ad=0.19p pd=1.38u as=0 ps=0 w=1u l=1u
X4287 VSS.t2767 VDD VSS.t2766 VSS.t61 sg13_lv_nmos ad=0.1428p pd=1.52u as=0 ps=0 w=0.42u l=1u
X4288 VDD VSS.t1896 VDD VDD sg13_lv_pmos ad=0.34p pd=2.68u as=0 ps=0 w=1u l=1u
X4289 VSS.t2027 VDD VSS.t2029 VSS.t2028 sg13_lv_nmos ad=79.8f pd=0.8u as=0 ps=0 w=0.42u l=1u
X4290 a_26122_13945# a_26565_13701# a_26505_14113# VDD sg13_lv_pmos ad=79.8f pd=0.8u as=63f ps=0.72u w=0.42u l=0.13u
X4291 VDD VSS.t958 VDD VDD sg13_lv_pmos ad=0.19p pd=1.38u as=0 ps=0 w=1u l=1u
X4292 VSS.t1215 VDD VSS.t1214 VSS.t70 sg13_lv_nmos ad=0.1428p pd=1.52u as=0 ps=0 w=0.42u l=1u
X4293 VDD VSS.t2428 VDD VDD sg13_lv_pmos ad=0.34p pd=2.68u as=0 ps=0 w=1u l=1u
X4294 VSS.t1515 VDD VSS.t1517 VSS.t1516 sg13_lv_nmos ad=79.8f pd=0.8u as=0 ps=0 w=0.42u l=1u
X4295 VSS.t1367 VDD VSS.t1219 VSS.t70 sg13_lv_nmos ad=0.1428p pd=1.52u as=0 ps=0 w=0.42u l=1u
X4296 VDD VSS.t2263 VDD VDD sg13_lv_pmos ad=0.34p pd=2.68u as=0 ps=0 w=1u l=1u
X4297 VDD VSS.t1861 VDD VDD sg13_lv_pmos ad=0.34p pd=2.68u as=0 ps=0 w=1u l=1u
X4298 VDD VSS.t2709 VDD VDD sg13_lv_pmos ad=0.34p pd=2.68u as=0 ps=0 w=1u l=1u
X4299 VDD sg13cmos5l_dfrbpq_1_0.RESET_B a_2890_15457# VDD sg13_lv_pmos ad=0.1563p pd=1.22u as=0.147p ps=1.54u w=0.42u l=0.13u
X4300 a_21251_13690# sg13cmos5l_or3_1_2.A VSS.t172 VSS.t3251 sg13_lv_nmos ad=0.198p pd=1.27u as=0.13395p ps=1.12u w=0.55u l=0.13u
X4301 VSS.t1250 VDD VSS.t1251 VSS.t70 sg13_lv_nmos ad=79.8f pd=0.8u as=0 ps=0 w=0.42u l=1u
X4302 VDD VSS.t1247 VDD VDD sg13_lv_pmos ad=0.19p pd=1.38u as=0 ps=0 w=1u l=1u
X4303 VDD VSS.t2752 VDD VDD sg13_lv_pmos ad=0.19p pd=1.38u as=0 ps=0 w=1u l=1u
X4304 VDD VSS.t2034 VDD VDD sg13_lv_pmos ad=0.19p pd=1.38u as=0 ps=0 w=1u l=1u
X4305 VSS.t73 sg13cmos5l_tiehi_1.L_HI a_9252_15234# VSS.t89 sg13_lv_nmos ad=0.1626p pd=1.415u as=60.89999f ps=0.71u w=0.42u l=0.13u
X4306 a_16068_14040# a_16042_13945# VDD VDD sg13_lv_pmos ad=0.34p pd=2.68u as=0.36237p ps=2.605u w=1u l=0.13u
X4307 VSS.t642 VDD VSS.t639 VSS.t641 sg13_lv_nmos ad=0.1428p pd=1.52u as=0 ps=0 w=0.42u l=1u
X4308 VDD VSS.t3179 VDD VDD sg13_lv_pmos ad=0.34p pd=2.68u as=0 ps=0 w=1u l=1u
X4309 VSS.t2449 VDD VSS.t2448 VSS.t2447 sg13_lv_nmos ad=0.1428p pd=1.52u as=0 ps=0 w=0.42u l=1u
X4310 VSS.t1872 VDD VSS.t1871 VSS.t1870 sg13_lv_nmos ad=0.1428p pd=1.52u as=0 ps=0 w=0.42u l=1u
X4311 VDD VSS.t2453 VDD VDD sg13_lv_pmos ad=0.34p pd=2.68u as=0 ps=0 w=1u l=1u
X4312 VSS.t946 VDD VSS.t945 VSS.t944 sg13_lv_nmos ad=0.1428p pd=1.52u as=0 ps=0 w=0.42u l=1u
X4313 VDD VSS.t1717 VDD VDD sg13_lv_pmos ad=0.19p pd=1.38u as=0 ps=0 w=1u l=1u
X4314 VSS.t821 VDD VSS.t823 VSS.t822 sg13_lv_nmos ad=79.8f pd=0.8u as=0 ps=0 w=0.42u l=1u
X4315 VSS.t1255 VDD VSS.t1256 VSS.t70 sg13_lv_nmos ad=79.8f pd=0.8u as=0 ps=0 w=0.42u l=1u
X4316 sg13cmos5l_dfrbpq_1_2.CLK a_12010_15202# VSS.t187 VSS.t188 sg13_lv_nmos ad=0.1406p pd=1.12u as=0.1406p ps=1.12u w=0.74u l=0.13u
X4317 VSS.t2514 VDD VSS.t2516 VSS.t2515 sg13_lv_nmos ad=79.8f pd=0.8u as=0 ps=0 w=0.42u l=1u
X4318 VDD VSS.t2401 VDD VDD sg13_lv_pmos ad=0.19p pd=1.38u as=0 ps=0 w=1u l=1u
X4319 VSS.t2062 VDD VSS.t2061 VSS.t2060 sg13_lv_nmos ad=0.1428p pd=1.52u as=0 ps=0 w=0.42u l=1u
X4320 VDD VSS.t1582 VDD VDD sg13_lv_pmos ad=0.19p pd=1.38u as=0 ps=0 w=1u l=1u
X4321 VSS.t2672 VDD VSS.t2673 VSS.t61 sg13_lv_nmos ad=79.8f pd=0.8u as=0 ps=0 w=0.42u l=1u
X4322 VDD VSS.t925 VDD VDD sg13_lv_pmos ad=0.34p pd=2.68u as=0 ps=0 w=1u l=1u
X4323 VSS.t2910 VDD VSS.t2909 VSS.t2908 sg13_lv_nmos ad=0.1428p pd=1.52u as=0 ps=0 w=0.42u l=1u
X4324 VSS.t2659 VDD VSS.t2659 VSS.t61 sg13_lv_nmos ad=0.1428p pd=1.52u as=0 ps=0 w=0.42u l=1u
X4325 VDD VSS.t2673 VDD VDD sg13_lv_pmos ad=0.34p pd=2.68u as=0 ps=0 w=1u l=1u
X4326 VSS.t1947 VDD VSS.t1946 VSS.t1945 sg13_lv_nmos ad=0.1428p pd=1.52u as=0 ps=0 w=0.42u l=1u
X4327 VDD VSS.t427 VDD VDD sg13_lv_pmos ad=0.19p pd=1.38u as=0 ps=0 w=1u l=1u
X4328 VSS.t131 VDD VSS.t363 VSS.t362 sg13_lv_nmos ad=79.8f pd=0.8u as=0 ps=0 w=0.42u l=1u
X4329 VDD VSS.t873 VDD VDD sg13_lv_pmos ad=0.19p pd=1.38u as=0 ps=0 w=1u l=1u
X4330 a_25930_14452# a_26373_14495# a_26313_14531# VDD sg13_lv_pmos ad=79.8f pd=0.8u as=63f ps=0.72u w=0.42u l=0.13u
X4331 sg13cmos5l_buf_8_2.X a_19323_13726# VDD VDD sg13_lv_pmos ad=0.2128p pd=1.5u as=0.2128p ps=1.5u w=1.12u l=0.13u
X4332 VSS.t961 VDD VSS.t960 VSS.t959 sg13_lv_nmos ad=0.1428p pd=1.52u as=0 ps=0 w=0.42u l=1u
X4333 VDD VSS.t2248 VDD VDD sg13_lv_pmos ad=0.34p pd=2.68u as=0 ps=0 w=1u l=1u
X4334 VSS.t1264 VDD VSS.t1265 VSS.t70 sg13_lv_nmos ad=79.8f pd=0.8u as=0 ps=0 w=0.42u l=1u
X4335 VSS.t2479 VDD VSS.t2481 VSS.t2480 sg13_lv_nmos ad=79.8f pd=0.8u as=0 ps=0 w=0.42u l=1u
X4336 a_21348_14909# a_21060_14488# a_21286_14909# VSS.t3295 sg13_lv_nmos ad=0.1428p pd=1.52u as=37.8f ps=0.6u w=0.42u l=0.13u
X4337 VSS.t423 VDD VSS.t422 VSS.t15 sg13_lv_nmos ad=0.1428p pd=1.52u as=0 ps=0 w=0.42u l=1u
X4338 VSS.t1475 VDD VSS.t1474 VSS.t1473 sg13_lv_nmos ad=0.1428p pd=1.52u as=0 ps=0 w=0.42u l=1u
X4339 VDD VSS.t2987 VDD VDD sg13_lv_pmos ad=0.19p pd=1.38u as=0 ps=0 w=1u l=1u
X4340 VDD VSS.t3164 VDD VDD sg13_lv_pmos ad=0.34p pd=2.68u as=0 ps=0 w=1u l=1u
X4341 VSS.t2384 VDD VSS.t2383 VSS.t2382 sg13_lv_nmos ad=0.1428p pd=1.52u as=0 ps=0 w=0.42u l=1u
X4342 VSS.t1857 VDD VSS.t1856 VSS.t1855 sg13_lv_nmos ad=0.1428p pd=1.52u as=0 ps=0 w=0.42u l=1u
X4343 VSS.t791 VDD VSS.t790 VSS.t789 sg13_lv_nmos ad=0.1428p pd=1.52u as=0 ps=0 w=0.42u l=1u
X4344 VDD VSS.t1246 VDD VDD sg13_lv_pmos ad=0.34p pd=2.68u as=0 ps=0 w=1u l=1u
X4345 a_17057_14832# sg13cmos5l_a21oi_1_0.A1 sg13cmos5l_a21oi_1_0.Y VSS.t84 sg13_lv_nmos ad=0.1406p pd=1.12u as=0.1406p ps=1.12u w=0.74u l=0.13u
X4346 VSS.t170 a_6682_13690# a_6401_13912# VSS.t169 sg13_lv_nmos ad=79.8f pd=0.8u as=0.1428p ps=1.52u w=0.42u l=0.5u
X4347 VSS.t535 VDD VSS.t534 VSS.t533 sg13_lv_nmos ad=0.1428p pd=1.52u as=0 ps=0 w=0.42u l=1u
X4348 VSS.t1021 VDD VSS.t1023 VSS.t1022 sg13_lv_nmos ad=79.8f pd=0.8u as=0 ps=0 w=0.42u l=1u
X4349 VDD VSS.t1201 VDD VDD sg13_lv_pmos ad=0.19p pd=1.38u as=0 ps=0 w=1u l=1u
X4350 VSS.t2682 VDD VSS.t2827 VSS.t61 sg13_lv_nmos ad=0.1428p pd=1.52u as=0 ps=0 w=0.42u l=1u
R0 VSS.t54 VSS.n797 2.277e+06
R1 VSS.t244 VSS.n809 1.34743e+06
R2 VSS.t61 VSS.n438 4108.7
R3 VSS.n438 VSS.n495 4108.7
R4 VSS.n495 VSS.n552 4108.7
R5 VSS.n552 VSS.t70 4108.7
R6 VSS.t70 VSS.n641 4108.7
R7 VSS.n641 VSS.n1038 4108.7
R8 VSS.n1038 VSS.n765 4108.7
R9 VSS.t2921 VSS.n30 183.805
R10 VSS.t2916 VSS.n30 183.806
R11 VSS.t2926 VSS.n30 183.806
R12 VSS.n30 VSS.t2946 183.805
R13 VSS.n30 VSS.t2961 183.805
R14 VSS.n30 VSS.t2966 183.805
R15 VSS.n30 VSS.t2986 183.805
R16 VSS.n30 VSS.t2991 183.806
R17 VSS.t3006 VSS.n30 183.806
R18 VSS.t3016 VSS.n30 183.806
R19 VSS.t3026 VSS.n30 183.805
R20 VSS.t3041 VSS.n30 183.805
R21 VSS.t3046 VSS.n30 183.805
R22 VSS.n30 VSS.t3066 183.805
R23 VSS.n30 VSS.t3086 183.805
R24 VSS.n30 VSS.t3116 183.806
R25 VSS.t3131 VSS.n30 183.806
R26 VSS.n30 VSS.t3136 183.805
R27 VSS.t3156 VSS.n30 183.805
R28 VSS.n30 VSS.t3161 183.806
R29 VSS.t3176 VSS.n30 183.805
R30 VSS.t61 VSS.n30 4435.04
R31 VSS.t178 VSS.t25 612.602
R32 VSS.t2330 VSS.n3 109.992
R33 VSS.n2 VSS.t1938 109.992
R34 VSS.n106 VSS.t571 109.992
R35 VSS.t2245 VSS.n3 109.992
R36 VSS.t2250 VSS.n3 109.993
R37 VSS.t2255 VSS.n3 109.992
R38 VSS.t2270 VSS.n3 109.992
R39 VSS.n3 VSS.t2292 108.999
R40 VSS.t2320 VSS.n3 109.992
R41 VSS.t2340 VSS.n3 109.992
R42 VSS.t2360 VSS.n3 109.992
R43 VSS.t2370 VSS.n3 109.992
R44 VSS.t2390 VSS.n3 109.992
R45 VSS.t2410 VSS.n3 109.993
R46 VSS.t2415 VSS.n3 109.992
R47 VSS.t2430 VSS.n3 109.992
R48 VSS.t2460 VSS.n3 109.992
R49 VSS.t2480 VSS.n3 109.993
R50 VSS.n3 VSS.t2485 109.992
R51 VSS.t2490 VSS.n3 109.992
R52 VSS.t1853 VSS.n2 109.992
R53 VSS.t1868 VSS.n2 109.992
R54 VSS.n2 VSS.t1880 108.999
R55 VSS.n2 VSS.t1890 109.001
R56 VSS.n2 VSS.t1903 109.993
R57 VSS.n2 VSS.t1910 108.999
R58 VSS.t1918 VSS.n2 109.992
R59 VSS.n2 VSS.t1953 109.992
R60 VSS.t1958 VSS.n2 109.992
R61 VSS.t1978 VSS.n2 109.993
R62 VSS.n2 VSS.t1983 109.992
R63 VSS.t1998 VSS.n2 109.993
R64 VSS.n2 VSS.t2003 109.992
R65 VSS.t2008 VSS.n2 109.992
R66 VSS.n2 VSS.t2018 109.992
R67 VSS.t2023 VSS.n2 109.993
R68 VSS.t2033 VSS.n2 109.992
R69 VSS.t2053 VSS.n2 109.992
R70 VSS.n2 VSS.t2078 109.992
R71 VSS.n2 VSS.t2098 109.992
R72 VSS.n2 VSS.t2108 109.992
R73 VSS.n2 VSS.t2118 109.992
R74 VSS.n1 VSS.t1463 108.999
R75 VSS.t1471 VSS.n1 109.992
R76 VSS.n1 VSS.t1478 109.001
R77 VSS.n1 VSS.t1498 108.999
R78 VSS.t1516 VSS.n1 109.992
R79 VSS.n1 VSS.t1543 108.999
R80 VSS.n1 VSS.t1561 109.992
R81 VSS.t1586 VSS.n1 109.993
R82 VSS.n1 VSS.t1591 109.992
R83 VSS.t1606 VSS.n1 109.993
R84 VSS.t1641 VSS.n1 109.992
R85 VSS.t1656 VSS.n1 109.993
R86 VSS.t1661 VSS.n1 109.992
R87 VSS.t1681 VSS.n1 109.992
R88 VSS.t1706 VSS.n1 109.992
R89 VSS.n1 VSS.t1711 109.993
R90 VSS.t1716 VSS.n1 109.992
R91 VSS.t782 VSS.n0 109.992
R92 VSS.t807 VSS.n0 109.993
R93 VSS.t827 VSS.n0 109.992
R94 VSS.t837 VSS.n0 109.992
R95 VSS.t852 VSS.n0 109.993
R96 VSS.t872 VSS.n0 109.992
R97 VSS.t897 VSS.n0 109.993
R98 VSS.t902 VSS.n0 109.992
R99 VSS.t942 VSS.n0 109.993
R100 VSS.t967 VSS.n0 109.992
R101 VSS.n0 VSS.t1032 109.993
R102 VSS.n0 VSS.t1042 109.993
R103 VSS.n1018 VSS.n1017 427.132
R104 VSS.n308 VSS.t707 243.47
R105 VSS.n89 VSS.t725 109.644
R106 VSS.n1038 VSS.n115 427.132
R107 VSS.n231 VSS.t512 0.0148802
R108 VSS.n230 VSS.t512 0.00915177
R109 VSS.t546 VSS.n109 109.992
R110 VSS.t551 VSS.n108 109.992
R111 VSS.n229 VSS.t512 0.00915177
R112 VSS.t561 VSS.n107 109.992
R113 VSS.t566 VSS.n228 109.992
R114 VSS.n310 VSS.n842 427.755
R115 VSS.t583 VSS.t92 222.065
R116 VSS.t15 VSS.n33 2.91846
R117 VSS.n10 VSS.t3290 424.017
R118 VSS.t649 VSS.n281 243.169
R119 VSS.n90 VSS.t101 418.56
R120 VSS.n305 VSS.t732 237.142
R121 VSS.n3 VSS.n438 427.5
R122 VSS.n2 VSS.n495 427.5
R123 VSS.n1 VSS.n552 427.5
R124 VSS.n0 VSS.n641 427.5
R125 VSS.n304 VSS.t7 75.7034
R126 VSS.t610 VSS.n303 242.846
R127 VSS.t622 VSS.n301 242.846
R128 VSS.t628 VSS.n300 242.846
R129 VSS.t631 VSS.n170 242.846
R130 VSS.t634 VSS.n299 242.846
R131 VSS.t640 VSS.n298 242.846
R132 VSS.t171 VSS.n860 411.43
R133 VSS.t716 VSS.n98 242.846
R134 VSS.t718 VSS.n307 242.846
R135 VSS.t720 VSS.n275 242.846
R136 VSS.t722 VSS.n306 242.846
R137 VSS.t478 VSS.n45 221.417
R138 VSS.n43 VSS.n765 427.5
R139 VSS.t3291 VSS.n787 408.31
R140 VSS.n853 VSS.t210 407.144
R141 VSS.n1031 VSS.t188 407.144
R142 VSS.t3283 VSS.n963 407.144
R143 VSS.t3237 VSS.n955 407.144
R144 VSS.t2948 VSS.n30 182.042
R145 VSS.t2968 VSS.n30 182.042
R146 VSS.t2973 VSS.n30 182.042
R147 VSS.t2993 VSS.n30 182.042
R148 VSS.n30 VSS.t2998 182.042
R149 VSS.n30 VSS.t3028 182.042
R150 VSS.n30 VSS.t3048 182.042
R151 VSS.n30 VSS.t3058 182.042
R152 VSS.n30 VSS.t3068 182.042
R153 VSS.n30 VSS.t3088 182.042
R154 VSS.t3093 VSS.n30 182.042
R155 VSS.n30 VSS.t3098 182.042
R156 VSS.n30 VSS.t3108 182.042
R157 VSS.n30 VSS.t3138 182.042
R158 VSS.t3143 VSS.n30 182.042
R159 VSS.n30 VSS.t3163 182.042
R160 VSS.n839 VSS.t3210 402.858
R161 VSS.t179 VSS.n309 249.002
R162 VSS.n1011 VSS.t163 398.572
R163 VSS.n1020 VSS.t180 398.572
R164 VSS.t108 VSS.n807 398.572
R165 VSS.t3 VSS.t247 398.572
R166 VSS.n8 VSS.t3204 398.228
R167 VSS.t134 VSS.n4 397.132
R168 VSS.n951 VSS.t160 397.132
R169 VSS.n869 VSS.t12 394.286
R170 VSS.n801 VSS.t3208 391.118
R171 VSS.n1016 VSS.t209 390
R172 VSS.t189 VSS.n820 390
R173 VSS.t48 VSS.n36 36.5344
R174 VSS.t3268 VSS.n21 386.526
R175 VSS.n862 VSS.t3251 385.714
R176 VSS.n779 VSS.t77 385.714
R177 VSS.n5 VSS.t3217 385.334
R178 VSS.t3245 VSS.t15 51.2106
R179 VSS.t3267 VSS.n948 384.274
R180 VSS.t3185 VSS.n829 381.43
R181 VSS.n1032 VSS.t186 381.43
R182 VSS.t125 VSS.n780 381.43
R183 VSS.n6 VSS.t3205 381.036
R184 VSS.t123 VSS.n10 381.036
R185 VSS.t3219 VSS.n832 377.144
R186 VSS.t248 VSS.n815 377.144
R187 VSS.n957 VSS.t3259 377.144
R188 VSS.t3286 VSS.n305 377.353
R189 VSS.t116 VSS.n21 376.724
R190 VSS.t3232 VSS.n852 368.572
R191 VSS.t173 VSS.n870 368.572
R192 VSS.n871 VSS.t156 368.572
R193 VSS.n837 VSS.t3209 368.572
R194 VSS.t3255 VSS.n954 368.572
R195 VSS.t240 VSS.n11 368.142
R196 VSS.n12 VSS.t3294 368.142
R197 VSS.n822 VSS.t190 364.286
R198 VSS.n959 VSS.t3235 364.286
R199 VSS.n1035 VSS.t3298 361.033
R200 VSS.t239 VSS.n788 361.033
R201 VSS.t10 VSS.n778 360
R202 VSS.n855 VSS.t213 355.714
R203 VSS.n1033 VSS.t185 355.714
R204 VSS.t107 VSS.n965 355.714
R205 VSS.t3239 VSS.n953 355.714
R206 VSS.t3287 VSS.n876 351.43
R207 VSS.t7 VSS.n881 351.43
R208 VSS.t230 VSS.n844 351.43
R209 VSS.n835 VSS.t158 351.43
R210 VSS.t97 VSS.n33 60.3116
R211 VSS.t249 VSS.n814 351.43
R212 VSS.n958 VSS.t129 351.43
R213 VSS.t2 VSS.n13 350.95
R214 VSS.n804 VSS.t245 348.139
R215 VSS.t3207 VSS.n845 347.144
R216 VSS.n812 VSS.t52 347.144
R217 VSS.n871 VSS.t3214 342.858
R218 VSS.t122 VSS.n8 342.354
R219 VSS.t140 VSS.n12 342.354
R220 VSS.n1017 VSS.t3226 341.418
R221 VSS.t72 VSS.n783 339.543
R222 VSS.n851 VSS.t206 338.572
R223 VSS.n834 VSS.t3305 338.572
R224 VSS.t3187 VSS.n827 338.572
R225 VSS.n960 VSS.t3234 338.572
R226 VSS.t120 VSS.n971 337.046
R227 VSS.t1 VSS.n798 335.245
R228 VSS.t2906 VSS.n30 183.804
R229 VSS.t2936 VSS.n30 183.806
R230 VSS.t2941 VSS.n30 183.806
R231 VSS.t2956 VSS.n30 183.806
R232 VSS.t2981 VSS.n30 183.806
R233 VSS.t3021 VSS.n30 183.806
R234 VSS.t3036 VSS.n30 183.806
R235 VSS.t3051 VSS.n30 183.806
R236 VSS.t3071 VSS.n30 183.806
R237 VSS.t3081 VSS.n30 183.806
R238 VSS.t3101 VSS.n30 183.806
R239 VSS.t3141 VSS.n30 183.806
R240 VSS.t3171 VSS.n30 183.806
R241 VSS.t3181 VSS.n30 183.806
R242 VSS.t3273 VSS.t14 330.947
R243 VSS.n856 VSS.t214 330
R244 VSS.t46 VSS.n964 330
R245 VSS.n873 VSS.t3279 329.168
R246 VSS.n1024 VSS.t95 329.168
R247 VSS.t21 VSS.n937 329.168
R248 VSS.t243 VSS.n936 329.168
R249 VSS.t63 VSS.n32 83.7485
R250 VSS.n782 VSS.t35 329.168
R251 VSS.t3289 VSS.t155 326.649
R252 VSS.t45 VSS.n880 325.714
R253 VSS.n939 VSS.t250 325.714
R254 VSS.t15 VSS.t86 321.486
R255 VSS.t15 VSS.n37 12.2567
R256 VSS.n92 VSS.t76 319.99
R257 VSS.t3241 VSS.n951 319.99
R258 VSS.t37 VSS.n15 319.99
R259 VSS.n30 VSS.t3178 182.042
R260 VSS.t3173 VSS.n30 182.042
R261 VSS.n30 VSS.t3168 182.042
R262 VSS.n30 VSS.t3166 183.805
R263 VSS.n30 VSS.t3158 182.042
R264 VSS.t3153 VSS.n30 182.042
R265 VSS.n30 VSS.t3148 182.042
R266 VSS.t3146 VSS.n30 183.806
R267 VSS.n30 VSS.t3133 182.042
R268 VSS.t3128 VSS.n30 182.042
R269 VSS.n30 VSS.t3123 182.042
R270 VSS.t3118 VSS.n30 182.042
R271 VSS.n30 VSS.t3113 182.042
R272 VSS.n30 VSS.t3111 183.806
R273 VSS.n30 VSS.t3103 182.042
R274 VSS.t3096 VSS.n30 183.805
R275 VSS.n30 VSS.t3091 183.806
R276 VSS.n30 VSS.t3083 182.042
R277 VSS.t3078 VSS.n30 182.042
R278 VSS.n30 VSS.t3073 182.042
R279 VSS.t3063 VSS.n30 182.042
R280 VSS.n30 VSS.t3061 183.806
R281 VSS.t3053 VSS.n30 182.042
R282 VSS.t3043 VSS.n30 182.042
R283 VSS.t3038 VSS.n30 182.042
R284 VSS.t3033 VSS.n30 182.042
R285 VSS.n30 VSS.t3031 183.806
R286 VSS.t3023 VSS.n30 182.042
R287 VSS.t3018 VSS.n30 182.042
R288 VSS.t3013 VSS.n30 182.042
R289 VSS.t3008 VSS.n30 182.042
R290 VSS.t3003 VSS.n30 182.042
R291 VSS.n30 VSS.t3001 183.805
R292 VSS.t2996 VSS.n30 183.806
R293 VSS.n30 VSS.t2988 182.042
R294 VSS.n30 VSS.t2983 182.042
R295 VSS.n30 VSS.t2978 182.042
R296 VSS.t2976 VSS.n30 183.805
R297 VSS.t2971 VSS.n30 183.806
R298 VSS.n30 VSS.t2963 182.042
R299 VSS.n30 VSS.t2958 182.042
R300 VSS.n30 VSS.t2953 182.042
R301 VSS.t2951 VSS.n30 183.806
R302 VSS.n30 VSS.t2943 182.042
R303 VSS.n30 VSS.t2938 182.042
R304 VSS.n30 VSS.t2933 182.042
R305 VSS.n30 VSS.t2928 182.042
R306 VSS.n30 VSS.t2923 182.042
R307 VSS.t2918 VSS.n30 182.042
R308 VSS.n30 VSS.t2913 182.042
R309 VSS.t2908 VSS.n30 182.042
R310 VSS.n30 VSS.t2903 181.875
R311 VSS.n803 VSS.t3188 313.755
R312 VSS.n809 VSS.t85 313.755
R313 VSS.t258 VSS.n849 312.858
R314 VSS.n838 VSS.t3220 312.858
R315 VSS.n823 VSS.t251 312.858
R316 VSS.n961 VSS.t3250 312.858
R317 VSS.t3261 VSS.n952 312.858
R318 VSS.t737 VSS.n875 305.159
R319 VSS.n797 VSS.n793 305.159
R320 VSS.n1026 VSS.t3266 304.286
R321 VSS.t145 VSS.n971 292.264
R322 VSS.n970 VSS.t26 292.264
R323 VSS.n794 VSS.t3227 292.264
R324 VSS.t266 VSS.n834 291.43
R325 VSS.t3307 VSS.n827 291.43
R326 VSS.n11 VSS.t94 290.779
R327 VSS.t252 VSS.n818 287.144
R328 VSS.n781 VSS.t3293 287.144
R329 VSS.n972 VSS.t119 283.334
R330 VSS.t3193 VSS.n936 283.334
R331 VSS.n946 VSS.t159 283.334
R332 VSS.t133 VSS.t42 279.37
R333 VSS.t3299 VSS.t264 279.37
R334 VSS.t255 VSS.n308 277.755
R335 VSS.n875 VSS.t196 275.072
R336 VSS.n27 VSS.t195 288.68
R337 VSS.n970 VSS.t194 275.072
R338 VSS.t193 VSS.n940 275.072
R339 VSS.n793 VSS.t93 275.072
R340 VSS.n13 VSS.t5 273.587
R341 VSS.n110 VSS.t141 272.846
R342 VSS.t3199 VSS.t121 266.476
R343 VSS.n799 VSS.t3194 266.476
R344 VSS.t238 VSS.t201 266.476
R345 VSS.t199 VSS.t139 266.476
R346 VSS.t44 VSS.t3303 265.714
R347 VSS.n962 VSS.t232 265.714
R348 VSS.n824 VSS.t254 261.43
R349 VSS.n963 VSS.t3248 261.43
R350 VSS.n1013 VSS.t3285 258.334
R351 VSS.t82 VSS.t3184 258.334
R352 VSS.t228 VSS.n1021 258.334
R353 VSS.n973 VSS.t167 258.334
R354 VSS.t68 VSS.t3295 258.334
R355 VSS.t13 VSS.n944 258.334
R356 VSS.t3233 VSS.t3200 258.334
R357 VSS.t151 VSS.n27 37.8459
R358 VSS.n1035 VSS.t461 257.88
R359 VSS.n836 VSS.t169 257.144
R360 VSS.n810 VSS.t3186 257.144
R361 VSS.t83 VSS.n949 257.144
R362 VSS.t200 VSS.n790 253.583
R363 VSS.t514 VSS.n114 252.065
R364 VSS.n117 VSS.t516 252.065
R365 VSS.t519 VSS.n112 252.065
R366 VSS.t512 VSS.n167 0.00916143
R367 VSS.t524 VSS.n169 109.001
R368 VSS.n168 VSS.t526 108.999
R369 VSS.n80 VSS.t605 251.417
R370 VSS.n75 VSS.t608 251.417
R371 VSS.n72 VSS.t611 251.417
R372 VSS.n76 VSS.t614 251.417
R373 VSS.n79 VSS.t617 251.417
R374 VSS.n60 VSS.t620 251.417
R375 VSS.n63 VSS.t623 251.417
R376 VSS.n59 VSS.t626 251.417
R377 VSS.n56 VSS.t629 251.417
R378 VSS.n51 VSS.t632 251.417
R379 VSS.n48 VSS.t635 251.417
R380 VSS.n52 VSS.t638 251.417
R381 VSS.n55 VSS.t641 251.417
R382 VSS.n64 VSS.t644 251.417
R383 VSS.n67 VSS.t647 251.417
R384 VSS.n85 VSS.t717 251.417
R385 VSS.n82 VSS.t719 251.417
R386 VSS.n86 VSS.t721 251.417
R387 VSS.t723 VSS.n88 251.417
R388 VSS.t511 VSS.n115 251.417
R389 VSS.n120 VSS.t665 251.417
R390 VSS.n19 VSS.t403 251.417
R391 VSS.n17 VSS.t476 251.417
R392 VSS.n1025 VSS.t78 250.952
R393 VSS.n947 VSS.t237 250.952
R394 VSS.t3201 VSS.n776 250.952
R395 VSS.n943 VSS.t154 250
R396 VSS.t137 VSS.n26 249.002
R397 VSS.n16 VSS.t3243 249.002
R398 VSS.t54 VSS.n7 243.5
R399 VSS.n114 VSS.t513 243.494
R400 VSS.t515 VSS.n117 243.494
R401 VSS.n112 VSS.t517 243.494
R402 VSS.t520 VSS.n111 109.986
R403 VSS.n169 VSS.t512 0.00915178
R404 VSS.t512 VSS.n168 0.00916143
R405 VSS.n857 VSS.t711 243.47
R406 VSS.n81 VSS.t743 242.846
R407 VSS.n74 VSS.t745 242.846
R408 VSS.n73 VSS.t747 242.846
R409 VSS.n77 VSS.t749 242.846
R410 VSS.n78 VSS.t751 242.846
R411 VSS.n61 VSS.t753 242.846
R412 VSS.n62 VSS.t755 242.846
R413 VSS.n58 VSS.t757 242.846
R414 VSS.n57 VSS.t759 242.846
R415 VSS.n50 VSS.t761 242.846
R416 VSS.n49 VSS.t763 242.846
R417 VSS.n53 VSS.t765 242.846
R418 VSS.n54 VSS.t767 242.846
R419 VSS.n65 VSS.t769 242.846
R420 VSS.n66 VSS.t771 242.846
R421 VSS.n84 VSS.t592 242.846
R422 VSS.n83 VSS.t595 242.846
R423 VSS.n87 VSS.t598 242.846
R424 VSS.n119 VSS.t531 242.846
R425 VSS.n18 VSS.t475 242.846
R426 VSS.n17 VSS.t404 242.846
R427 VSS.t477 VSS.n31 100.871
R428 VSS.n15 VSS.t401 242.846
R429 VSS.t231 VSS.t113 240.689
R430 VSS.n1014 VSS.t734 236.391
R431 VSS.n796 VSS.t463 236.391
R432 VSS.n3 VSS.t2262 108.999
R433 VSS.n3 VSS.t2272 108.999
R434 VSS.n3 VSS.t2277 109.001
R435 VSS.n3 VSS.t2297 109.001
R436 VSS.n3 VSS.t2302 108.999
R437 VSS.n3 VSS.t2312 108.999
R438 VSS.n3 VSS.t2322 108.999
R439 VSS.n3 VSS.t2342 108.999
R440 VSS.n3 VSS.t2347 109.001
R441 VSS.n3 VSS.t2362 108.999
R442 VSS.n3 VSS.t2372 108.999
R443 VSS.n3 VSS.t2377 109.001
R444 VSS.n3 VSS.t2392 108.999
R445 VSS.n3 VSS.t2417 108.999
R446 VSS.n3 VSS.t2432 108.999
R447 VSS.n3 VSS.t2437 109.001
R448 VSS.n3 VSS.t2442 108.999
R449 VSS.n3 VSS.t2467 109.001
R450 VSS.t2502 VSS.n3 108.999
R451 VSS.n3 VSS.t2507 109.001
R452 VSS.n2 VSS.t1855 108.999
R453 VSS.n2 VSS.t1885 108.999
R454 VSS.t1930 VSS.n2 108.999
R455 VSS.n2 VSS.t1945 108.999
R456 VSS.t1960 VSS.n2 108.999
R457 VSS.t1970 VSS.n2 108.999
R458 VSS.n2 VSS.t1985 108.999
R459 VSS.t2025 VSS.n2 108.999
R460 VSS.n2 VSS.t2040 109.001
R461 VSS.t2045 VSS.n2 108.999
R462 VSS.t2055 VSS.n2 108.999
R463 VSS.t2065 VSS.n2 109.001
R464 VSS.n2 VSS.t2080 108.999
R465 VSS.n2 VSS.t2090 108.999
R466 VSS.n2 VSS.t2100 108.999
R467 VSS.n2 VSS.t2120 108.999
R468 VSS.n1 VSS.t1473 108.999
R469 VSS.n1 VSS.t1488 108.999
R470 VSS.n1 VSS.t1508 108.999
R471 VSS.n1 VSS.t1518 108.999
R472 VSS.n1 VSS.t1563 108.999
R473 VSS.t1568 VSS.n1 109.001
R474 VSS.t1578 VSS.n1 108.999
R475 VSS.n1 VSS.t1593 108.999
R476 VSS.t1608 VSS.n1 108.999
R477 VSS.n1 VSS.t1613 108.999
R478 VSS.n1 VSS.t1628 108.999
R479 VSS.n1 VSS.t1633 108.999
R480 VSS.n1 VSS.t1648 108.999
R481 VSS.n1 VSS.t1663 108.999
R482 VSS.n1 VSS.t1673 108.999
R483 VSS.n1 VSS.t1683 108.999
R484 VSS.n1 VSS.t1688 108.999
R485 VSS.t1698 VSS.n1 108.999
R486 VSS.t1718 VSS.n1 108.999
R487 VSS.t1728 VSS.n1 108.999
R488 VSS.n0 VSS.t774 108.722
R489 VSS.n0 VSS.t784 108.999
R490 VSS.n0 VSS.t794 108.999
R491 VSS.n0 VSS.t814 109.001
R492 VSS.n0 VSS.t829 108.999
R493 VSS.n0 VSS.t839 108.999
R494 VSS.n0 VSS.t854 108.999
R495 VSS.n0 VSS.t874 108.999
R496 VSS.n0 VSS.t879 108.999
R497 VSS.n0 VSS.t889 108.999
R498 VSS.n0 VSS.t919 108.999
R499 VSS.n0 VSS.t924 108.999
R500 VSS.n0 VSS.t949 108.999
R501 VSS.n0 VSS.t969 108.999
R502 VSS.n0 VSS.t974 109.001
R503 VSS.n0 VSS.t984 108.999
R504 VSS.n0 VSS.t989 109.001
R505 VSS.n0 VSS.t994 108.999
R506 VSS.n0 VSS.t1009 108.999
R507 VSS.t1019 VSS.n0 108.999
R508 VSS.n0 VSS.t1044 109.001
R509 VSS.t1049 VSS.n0 108.999
R510 VSS.n304 VSS.t742 251.417
R511 VSS.n171 VSS.t744 251.417
R512 VSS.n303 VSS.t746 251.417
R513 VSS.n278 VSS.t748 251.417
R514 VSS.n302 VSS.t750 251.417
R515 VSS.n94 VSS.t752 251.417
R516 VSS.n301 VSS.t754 251.417
R517 VSS.n279 VSS.t756 251.417
R518 VSS.n300 VSS.t758 251.417
R519 VSS.n170 VSS.t760 251.417
R520 VSS.n299 VSS.t762 251.417
R521 VSS.n280 VSS.t764 251.417
R522 VSS.n298 VSS.t766 251.417
R523 VSS.n99 VSS.t768 251.417
R524 VSS.n297 VSS.t770 251.417
R525 VSS.n1019 VSS.t700 235.714
R526 VSS.t704 VSS.n847 235.714
R527 VSS.t586 VSS.n846 235.714
R528 VSS.n850 VSS.t708 235.714
R529 VSS.t712 VSS.n858 235.714
R530 VSS.n862 VSS.t714 235.714
R531 VSS.n98 VSS.t590 251.417
R532 VSS.n307 VSS.t594 251.417
R533 VSS.n275 VSS.t597 251.417
R534 VSS.n306 VSS.t600 251.417
R535 VSS.n872 VSS.t727 235.714
R536 VSS.n839 VSS.t529 235.714
R537 VSS.n840 VSS.t667 235.714
R538 VSS.n273 VSS.t533 252.041
R539 VSS.n229 VSS.t553 109.001
R540 VSS.t512 VSS.n228 0.00915177
R541 VSS.t573 VSS.n121 108.993
R542 VSS.t578 VSS.n310 252.041
R543 VSS.n34 VSS.t15 0.369499
R544 VSS.n1030 VSS.t472 235.714
R545 VSS.n824 VSS.t474 235.714
R546 VSS.n43 VSS.t395 108.722
R547 VSS.t15 VSS.t400 252.065
R548 VSS.n969 VSS.t58 233.333
R549 VSS.t164 VSS.n943 233.333
R550 VSS.n14 VSS.t3292 232.335
R551 VSS.n1023 VSS.t692 229.167
R552 VSS.n35 VSS.t464 102.749
R553 VSS.n3 VSS.t2290 109.992
R554 VSS.n2 VSS.t1848 109.986
R555 VSS.n2 VSS.t1863 109.992
R556 VSS.n2 VSS.t1878 109.992
R557 VSS.n2 VSS.t1908 109.992
R558 VSS.n2 VSS.t1923 109.993
R559 VSS.n1 VSS.t1461 109.992
R560 VSS.n1 VSS.t1496 109.992
R561 VSS.n1 VSS.t1536 109.993
R562 VSS.n1 VSS.t1541 109.992
R563 VSS.n0 VSS.t802 109.992
R564 VSS.n0 VSS.t822 109.993
R565 VSS.n0 VSS.t847 109.992
R566 VSS.n880 VSS.t741 227.143
R567 VSS.n171 VSS.t607 242.846
R568 VSS.n278 VSS.t613 242.846
R569 VSS.n302 VSS.t616 242.846
R570 VSS.n94 VSS.t619 242.846
R571 VSS.n279 VSS.t625 242.846
R572 VSS.n280 VSS.t637 242.846
R573 VSS.n99 VSS.t643 242.846
R574 VSS.n297 VSS.t646 242.846
R575 VSS.t705 VSS.n846 227.143
R576 VSS.n860 VSS.t713 227.143
R577 VSS.n272 VSS.t666 242.846
R578 VSS.n841 VSS.t668 227.143
R579 VSS.n842 VSS.t576 227.143
R580 VSS.t92 VSS.n164 0.0148802
R581 VSS.n1026 VSS.t690 227.143
R582 VSS.t473 VSS.n819 227.143
R583 VSS.t177 VSS.t260 225
R584 VSS.t512 VSS.n232 0.0136587
R585 VSS.t664 VSS.n232 111.022
R586 VSS.t589 VSS.n857 222.041
R587 VSS.t402 VSS.n7 222.011
R588 VSS.t604 VSS.n90 221.417
R589 VSS.n20 VSS.t405 221.417
R590 VSS.t407 VSS.n966 221.417
R591 VSS.n1022 VSS.t694 220.833
R592 VSS.t3280 VSS.t49 212.5
R593 VSS.n35 VSS.t402 214.988
R594 VSS.t710 VSS.t212 205.714
R595 VSS.n858 VSS.t589 205.714
R596 VSS.t726 VSS.n93 102.707
R597 VSS.n872 VSS.t604 205.714
R598 VSS.t478 VSS.n939 205.714
R599 VSS.n45 VSS.t407 221.417
R600 VSS.n35 VSS.t15 7.66894
R601 VSS.t707 VSS.n69 200.613
R602 VSS.t2240 VSS.n3 109.986
R603 VSS.t2285 VSS.n3 109.993
R604 VSS.t2295 VSS.n3 109.993
R605 VSS.t2305 VSS.n3 109.993
R606 VSS.t2335 VSS.n3 109.993
R607 VSS.t2355 VSS.n3 109.993
R608 VSS.t2375 VSS.n3 109.993
R609 VSS.t2385 VSS.n3 109.993
R610 VSS.t2405 VSS.n3 109.993
R611 VSS.t2435 VSS.n3 109.993
R612 VSS.t2445 VSS.n3 109.993
R613 VSS.t2455 VSS.n3 109.993
R614 VSS.t2465 VSS.n3 109.993
R615 VSS.n3 VSS.t2475 109.993
R616 VSS.t2495 VSS.n3 109.993
R617 VSS.t2515 VSS.n3 109.993
R618 VSS.t1873 VSS.n2 109.993
R619 VSS.t1883 VSS.n2 109.993
R620 VSS.t1898 VSS.n2 109.993
R621 VSS.t1943 VSS.n2 109.993
R622 VSS.t1948 VSS.n2 109.993
R623 VSS.t1988 VSS.n2 109.993
R624 VSS.t2013 VSS.n2 109.993
R625 VSS.t2028 VSS.n2 109.993
R626 VSS.t2038 VSS.n2 109.993
R627 VSS.t2048 VSS.n2 109.993
R628 VSS.t2058 VSS.n2 109.993
R629 VSS.t2063 VSS.n2 109.993
R630 VSS.t2073 VSS.n2 109.993
R631 VSS.t2083 VSS.n2 109.993
R632 VSS.t2093 VSS.n2 109.993
R633 VSS.t2113 VSS.n2 109.993
R634 VSS.t2123 VSS.n2 109.993
R635 VSS.t1456 VSS.n1 109.986
R636 VSS.t1476 VSS.n1 109.993
R637 VSS.t1486 VSS.n1 109.993
R638 VSS.t1501 VSS.n1 109.993
R639 VSS.t1531 VSS.n1 109.993
R640 VSS.t1556 VSS.n1 109.993
R641 VSS.t1581 VSS.n1 109.993
R642 VSS.t1596 VSS.n1 109.993
R643 VSS.t1626 VSS.n1 109.993
R644 VSS.t1651 VSS.n1 109.993
R645 VSS.t1666 VSS.n1 109.993
R646 VSS.n1 VSS.t1691 109.993
R647 VSS.t1721 VSS.n1 109.993
R648 VSS.t1731 VSS.n1 109.993
R649 VSS.t777 VSS.n0 109.986
R650 VSS.t787 VSS.n0 109.993
R651 VSS.t812 VSS.n0 109.993
R652 VSS.t857 VSS.n0 109.993
R653 VSS.n0 VSS.t867 109.993
R654 VSS.t882 VSS.n0 109.993
R655 VSS.t892 VSS.n0 109.993
R656 VSS.t907 VSS.n0 109.993
R657 VSS.t912 VSS.n0 109.993
R658 VSS.t922 VSS.n0 109.993
R659 VSS.t937 VSS.n0 109.993
R660 VSS.t952 VSS.n0 109.993
R661 VSS.t962 VSS.n0 109.993
R662 VSS.t982 VSS.n0 109.993
R663 VSS.t997 VSS.n0 109.993
R664 VSS.t1002 VSS.n0 109.993
R665 VSS.t1052 VSS.n0 109.993
R666 VSS.n70 VSS.t705 200.613
R667 VSS.n71 VSS.t588 200.613
R668 VSS.t713 VSS.n859 200.613
R669 VSS.t513 VSS.n116 200.613
R670 VSS.n113 VSS.t515 200.613
R671 VSS.t517 VSS.n118 200.613
R672 VSS.t523 VSS.n167 109.993
R673 VSS.t527 VSS.n168 109.993
R674 VSS.t536 VSS.n231 109.986
R675 VSS.t581 VSS.n164 109.986
R676 VSS.t690 VSS.n163 200.613
R677 VSS.t468 VSS.t15 200.613
R678 VSS.t398 VSS.t15 109.986
R679 VSS.t741 VSS.n879 199.989
R680 VSS.t607 VSS.n81 199.989
R681 VSS.t610 VSS.n74 199.989
R682 VSS.t613 VSS.n73 199.989
R683 VSS.t616 VSS.n77 199.989
R684 VSS.t619 VSS.n78 199.989
R685 VSS.t622 VSS.n61 199.989
R686 VSS.t625 VSS.n62 199.989
R687 VSS.t628 VSS.n58 199.989
R688 VSS.t631 VSS.n57 199.989
R689 VSS.t634 VSS.n50 199.989
R690 VSS.t637 VSS.n49 199.989
R691 VSS.t640 VSS.n53 199.989
R692 VSS.t643 VSS.n54 199.989
R693 VSS.t646 VSS.n65 199.989
R694 VSS.t649 VSS.n66 199.989
R695 VSS.t716 VSS.n68 199.989
R696 VSS.t718 VSS.n84 199.989
R697 VSS.t720 VSS.n83 199.989
R698 VSS.t722 VSS.n87 199.989
R699 VSS.n89 VSS.t602 243.139
R700 VSS.n119 VSS.t666 199.989
R701 VSS.t404 VSS.n18 199.989
R702 VSS.t117 VSS.t3277 193.411
R703 VSS.n3 VSS.t2512 108.999
R704 VSS.n3 VSS.t2510 109.992
R705 VSS.t2505 VSS.n3 109.993
R706 VSS.t2497 VSS.n3 109.001
R707 VSS.n3 VSS.t2492 108.999
R708 VSS.t2487 VSS.n3 109.001
R709 VSS.n3 VSS.t2482 109.001
R710 VSS.t2477 VSS.n3 108.999
R711 VSS.t2472 VSS.n3 108.999
R712 VSS.n3 VSS.t2470 109.992
R713 VSS.t2462 VSS.n3 108.999
R714 VSS.t2457 VSS.n3 109.001
R715 VSS.t2452 VSS.n3 108.999
R716 VSS.t2447 VSS.n3 109.001
R717 VSS.n3 VSS.t2440 109.992
R718 VSS.t2427 VSS.n3 109.001
R719 VSS.t2422 VSS.n3 109.001
R720 VSS.n3 VSS.t2420 109.993
R721 VSS.t2412 VSS.n3 109.001
R722 VSS.t2407 VSS.n3 108.999
R723 VSS.t2402 VSS.n3 108.999
R724 VSS.t2397 VSS.n3 109.001
R725 VSS.n3 VSS.t2395 109.993
R726 VSS.t2387 VSS.n3 109.001
R727 VSS.t2382 VSS.n3 108.999
R728 VSS.n3 VSS.t2380 109.992
R729 VSS.t2367 VSS.n3 109.001
R730 VSS.n3 VSS.t2365 109.993
R731 VSS.t2357 VSS.n3 109.001
R732 VSS.t2352 VSS.n3 108.999
R733 VSS.n3 VSS.t2350 109.992
R734 VSS.n3 VSS.t2345 109.993
R735 VSS.t2337 VSS.n3 109.001
R736 VSS.t2332 VSS.n3 108.999
R737 VSS.n3 VSS.t2325 109.993
R738 VSS.t2317 VSS.n3 109.001
R739 VSS.n3 VSS.t2315 109.993
R740 VSS.t2307 VSS.n3 109.001
R741 VSS.n3 VSS.t2300 109.992
R742 VSS.t2287 VSS.n3 109.001
R743 VSS.t2282 VSS.n3 108.999
R744 VSS.n3 VSS.t2280 109.992
R745 VSS.n3 VSS.t2275 109.993
R746 VSS.t2267 VSS.n3 109.001
R747 VSS.n3 VSS.t2265 109.993
R748 VSS.t2257 VSS.n3 109.001
R749 VSS.t2252 VSS.n3 109.001
R750 VSS.t2247 VSS.n3 108.999
R751 VSS.t2242 VSS.n3 109.001
R752 VSS.t2237 VSS.n3 108.722
R753 VSS.t2327 VSS.n3 109.001
R754 VSS.n2 VSS.t2115 109.001
R755 VSS.t2110 VSS.n2 108.999
R756 VSS.n2 VSS.t2105 109.001
R757 VSS.n2 VSS.t2103 109.993
R758 VSS.n2 VSS.t2095 109.001
R759 VSS.n2 VSS.t2085 109.001
R760 VSS.n2 VSS.t2075 109.001
R761 VSS.t2070 VSS.n2 108.999
R762 VSS.t2068 VSS.n2 109.992
R763 VSS.t2060 VSS.n2 108.999
R764 VSS.t2050 VSS.n2 109.001
R765 VSS.n2 VSS.t2043 109.992
R766 VSS.n2 VSS.t2035 108.999
R767 VSS.t2030 VSS.n2 109.001
R768 VSS.t2020 VSS.n2 108.999
R769 VSS.n2 VSS.t2015 109.001
R770 VSS.t2010 VSS.n2 108.999
R771 VSS.t2005 VSS.n2 109.001
R772 VSS.n2 VSS.t2000 109.001
R773 VSS.t1995 VSS.n2 108.999
R774 VSS.n2 VSS.t1990 109.001
R775 VSS.n2 VSS.t1980 109.001
R776 VSS.t1975 VSS.n2 108.999
R777 VSS.t1973 VSS.n2 109.993
R778 VSS.t1965 VSS.n2 109.001
R779 VSS.t1963 VSS.n2 109.993
R780 VSS.t1955 VSS.n2 109.001
R781 VSS.n2 VSS.t1950 109.001
R782 VSS.n2 VSS.t1940 108.999
R783 VSS.t1933 VSS.n2 109.993
R784 VSS.t1925 VSS.n2 109.001
R785 VSS.n2 VSS.t1920 108.999
R786 VSS.t1915 VSS.n2 109.001
R787 VSS.t1913 VSS.n2 109.993
R788 VSS.t1905 VSS.n2 109.001
R789 VSS.n2 VSS.t1900 108.999
R790 VSS.t1895 VSS.n2 108.999
R791 VSS.t1893 VSS.n2 109.992
R792 VSS.n2 VSS.t1888 109.993
R793 VSS.t1875 VSS.n2 109.001
R794 VSS.n2 VSS.t1870 108.999
R795 VSS.n2 VSS.t1865 109.001
R796 VSS.t1860 VSS.n2 109.001
R797 VSS.n2 VSS.t1858 109.993
R798 VSS.t1850 VSS.n2 109.001
R799 VSS.t1845 VSS.n2 108.722
R800 VSS.n2 VSS.t1935 109.001
R801 VSS.t1723 VSS.n1 109.001
R802 VSS.t1713 VSS.n1 109.001
R803 VSS.n1 VSS.t1708 108.999
R804 VSS.t1703 VSS.n1 109.001
R805 VSS.t1701 VSS.n1 109.993
R806 VSS.t1693 VSS.n1 109.001
R807 VSS.n1 VSS.t1686 109.993
R808 VSS.t1678 VSS.n1 109.001
R809 VSS.n1 VSS.t1676 109.993
R810 VSS.t1668 VSS.n1 109.001
R811 VSS.t1658 VSS.n1 109.001
R812 VSS.t1653 VSS.n1 108.999
R813 VSS.t1643 VSS.n1 109.001
R814 VSS.t1638 VSS.n1 109.001
R815 VSS.n1 VSS.t1636 109.993
R816 VSS.n1 VSS.t1631 109.993
R817 VSS.t1623 VSS.n1 108.999
R818 VSS.n1 VSS.t1618 109.001
R819 VSS.n1 VSS.t1616 109.993
R820 VSS.t1611 VSS.n1 109.993
R821 VSS.t1603 VSS.n1 108.999
R822 VSS.n1 VSS.t1598 109.001
R823 VSS.n1 VSS.t1588 109.001
R824 VSS.t1583 VSS.n1 108.999
R825 VSS.t1573 VSS.n1 109.001
R826 VSS.t1571 VSS.n1 109.992
R827 VSS.n1 VSS.t1566 109.993
R828 VSS.n1 VSS.t1558 109.001
R829 VSS.t1553 VSS.n1 108.999
R830 VSS.n1 VSS.t1548 109.001
R831 VSS.t1538 VSS.n1 109.001
R832 VSS.t1533 VSS.n1 108.999
R833 VSS.t1528 VSS.n1 108.999
R834 VSS.t1523 VSS.n1 109.001
R835 VSS.n1 VSS.t1521 109.993
R836 VSS.t1513 VSS.n1 109.001
R837 VSS.n1 VSS.t1511 109.993
R838 VSS.t1503 VSS.n1 109.001
R839 VSS.t1493 VSS.n1 109.001
R840 VSS.n1 VSS.t1491 109.993
R841 VSS.t1483 VSS.n1 108.999
R842 VSS.n1 VSS.t1481 109.992
R843 VSS.t1468 VSS.n1 109.001
R844 VSS.n1 VSS.t1466 109.993
R845 VSS.t1458 VSS.n1 109.001
R846 VSS.t1453 VSS.n1 108.722
R847 VSS.t1546 VSS.n1 109.993
R848 VSS.n0 VSS.t1047 109.992
R849 VSS.n0 VSS.t1039 108.999
R850 VSS.t1034 VSS.n0 109.001
R851 VSS.n0 VSS.t1029 108.999
R852 VSS.t1024 VSS.n0 109.001
R853 VSS.t1022 VSS.n0 109.993
R854 VSS.t1014 VSS.n0 109.001
R855 VSS.n0 VSS.t1012 109.993
R856 VSS.t1004 VSS.n0 109.001
R857 VSS.t999 VSS.n0 108.999
R858 VSS.n0 VSS.t992 109.992
R859 VSS.n0 VSS.t987 109.993
R860 VSS.t979 VSS.n0 108.999
R861 VSS.n0 VSS.t977 109.992
R862 VSS.n0 VSS.t972 109.993
R863 VSS.t964 VSS.n0 109.001
R864 VSS.t959 VSS.n0 108.999
R865 VSS.t954 VSS.n0 109.001
R866 VSS.t944 VSS.n0 109.001
R867 VSS.t939 VSS.n0 108.999
R868 VSS.t934 VSS.n0 108.999
R869 VSS.t929 VSS.n0 109.001
R870 VSS.n0 VSS.t927 109.993
R871 VSS.t914 VSS.n0 109.001
R872 VSS.t909 VSS.n0 108.999
R873 VSS.t904 VSS.n0 108.999
R874 VSS.t899 VSS.n0 109.001
R875 VSS.t894 VSS.n0 108.999
R876 VSS.t884 VSS.n0 109.001
R877 VSS.n0 VSS.t877 109.993
R878 VSS.t869 VSS.n0 109.001
R879 VSS.t859 VSS.n0 109.001
R880 VSS.t849 VSS.n0 108.999
R881 VSS.t844 VSS.n0 109.001
R882 VSS.n0 VSS.t842 109.993
R883 VSS.t834 VSS.n0 109.001
R884 VSS.n0 VSS.t832 109.993
R885 VSS.t824 VSS.n0 109.001
R886 VSS.t819 VSS.n0 108.999
R887 VSS.n0 VSS.t817 109.992
R888 VSS.t809 VSS.n0 108.999
R889 VSS.t804 VSS.n0 108.999
R890 VSS.t799 VSS.n0 109.001
R891 VSS.n0 VSS.t797 109.993
R892 VSS.t789 VSS.n0 109.001
R893 VSS.t779 VSS.n0 109.001
R894 VSS.t864 VSS.n0 108.999
R895 VSS.n163 VSS.t689 192.042
R896 VSS.n164 VSS.t578 192.054
R897 VSS.t576 VSS.n121 200.624
R898 VSS.t563 VSS.n228 109.001
R899 VSS.t558 VSS.n107 109.001
R900 VSS.n229 VSS.t556 109.992
R901 VSS.t548 VSS.n108 109.001
R902 VSS.t543 VSS.n109 109.001
R903 VSS.t538 VSS.n230 109.001
R904 VSS.t533 VSS.n231 192.054
R905 VSS.n71 VSS.t586 192.042
R906 VSS.n859 VSS.t712 192.042
R907 VSS.t525 VSS.n169 109.992
R908 VSS.t522 VSS.n167 108.999
R909 VSS.n111 VSS.t519 192.054
R910 VSS.t516 VSS.n118 192.042
R911 VSS.n113 VSS.t514 192.042
R912 VSS.n116 VSS.t511 192.042
R913 VSS.n106 VSS.t568 109.001
R914 VSS.t706 VSS.n69 192.041
R915 VSS.t730 VSS.t3302 191.667
R916 VSS.t742 VSS.n80 191.417
R917 VSS.n75 VSS.t744 191.417
R918 VSS.n72 VSS.t746 191.417
R919 VSS.n76 VSS.t748 191.417
R920 VSS.n79 VSS.t750 191.417
R921 VSS.n60 VSS.t752 191.417
R922 VSS.n63 VSS.t754 191.417
R923 VSS.n59 VSS.t756 191.417
R924 VSS.n56 VSS.t758 191.417
R925 VSS.n51 VSS.t760 191.417
R926 VSS.n48 VSS.t762 191.417
R927 VSS.n52 VSS.t764 191.417
R928 VSS.n55 VSS.t766 191.417
R929 VSS.n64 VSS.t768 191.417
R930 VSS.n67 VSS.t770 191.417
R931 VSS.n161 VSS.t700 191.417
R932 VSS.n85 VSS.t590 191.417
R933 VSS.n82 VSS.t594 191.417
R934 VSS.n86 VSS.t597 191.417
R935 VSS.n88 VSS.t600 191.417
R936 VSS.t727 VSS.n92 191.417
R937 VSS.t529 VSS.n120 191.417
R938 VSS.t667 VSS.n110 191.417
R939 VSS.n34 VSS.t469 108.635
R940 VSS.t474 VSS.n19 191.417
R941 VSS.t476 VSS.n20 191.417
R942 VSS.n162 VSS.t692 186.502
R943 VSS.n798 VSS.t54 184.815
R944 VSS.n37 VSS.t89 188.911
R945 VSS.t743 VSS.n877 184.286
R946 VSS.t745 VSS.n882 184.286
R947 VSS.t747 VSS.n883 184.286
R948 VSS.t749 VSS.n884 184.286
R949 VSS.t751 VSS.n885 184.286
R950 VSS.t753 VSS.n886 184.286
R951 VSS.t755 VSS.n887 184.286
R952 VSS.t757 VSS.n888 184.286
R953 VSS.t759 VSS.n889 184.286
R954 VSS.t761 VSS.n1005 184.286
R955 VSS.t763 VSS.n1006 184.286
R956 VSS.t765 VSS.n1007 184.286
R957 VSS.t767 VSS.n1008 184.286
R958 VSS.t769 VSS.n1009 184.286
R959 VSS.t771 VSS.n1010 184.286
R960 VSS.t709 VSS.n848 184.286
R961 VSS.t592 VSS.n863 184.286
R962 VSS.t595 VSS.n864 184.286
R963 VSS.t598 VSS.n866 184.286
R964 VSS.n867 VSS.t602 184.286
R965 VSS.t728 VSS.n868 184.286
R966 VSS.t531 VSS.n828 184.286
R967 VSS.t668 VSS.n826 184.286
R968 VSS.t471 VSS.n813 184.286
R969 VSS.t475 VSS.n817 184.286
R970 VSS.t405 VSS.n31 212.761
R971 VSS.t267 VSS.t9 184.286
R972 VSS.t401 VSS.n777 184.286
R973 VSS.t3292 VSS.n775 183.333
R974 VSS.t208 VSS.t709 180
R975 VSS.t694 VSS.n843 179.167
R976 VSS.t734 VSS.n874 176.219
R977 VSS.n878 VSS.t739 175.714
R978 VSS.t605 VSS.n877 175.714
R979 VSS.t608 VSS.n882 175.714
R980 VSS.t611 VSS.n883 175.714
R981 VSS.t614 VSS.n884 175.714
R982 VSS.t617 VSS.n885 175.714
R983 VSS.t620 VSS.n886 175.714
R984 VSS.t623 VSS.n887 175.714
R985 VSS.t626 VSS.n888 175.714
R986 VSS.t629 VSS.n889 175.714
R987 VSS.t632 VSS.n1005 175.714
R988 VSS.t635 VSS.n1006 175.714
R989 VSS.t638 VSS.n1007 175.714
R990 VSS.t641 VSS.n1008 175.714
R991 VSS.t644 VSS.n1009 175.714
R992 VSS.t647 VSS.n1010 175.714
R993 VSS.n854 VSS.t710 175.714
R994 VSS.t717 VSS.n863 175.714
R995 VSS.t719 VSS.n864 175.714
R996 VSS.t721 VSS.n866 175.714
R997 VSS.n867 VSS.t723 175.714
R998 VSS.t665 VSS.n828 175.714
R999 VSS.n821 VSS.t472 175.714
R1000 VSS.t403 VSS.n817 175.714
R1001 VSS.t25 VSS.t244 171.53
R1002 VSS.t739 VSS.t109 171.429
R1003 VSS.t3225 VSS.t703 171.429
R1004 VSS.t459 VSS.n774 170.833
R1005 VSS.t162 VSS.n1013 166.667
R1006 VSS.n1021 VSS.t179 166.667
R1007 VSS.n973 VSS.t137 166.667
R1008 VSS.t58 VSS.n935 166.667
R1009 VSS.n944 VSS.t164 166.667
R1010 VSS.t3243 VSS.n774 166.667
R1011 VSS.t154 VSS.n942 165.692
R1012 VSS.t461 VSS.n16 165.669
R1013 VSS.n800 VSS.t200 159.026
R1014 VSS.t3285 VSS.n1012 157.335
R1015 VSS.n22 VSS.t115 157.335
R1016 VSS.n795 VSS.t117 154.728
R1017 VSS.t5 VSS.n784 154.728
R1018 VSS.t169 VSS.n831 154.286
R1019 VSS.t141 VSS.n826 154.286
R1020 VSS.n873 VSS.t3304 154.167
R1021 VSS.n1024 VSS.t78 154.167
R1022 VSS.n972 VSS.t50 154.167
R1023 VSS.t69 VSS.n937 154.167
R1024 VSS.t195 VSS.n24 153.243
R1025 VSS.n941 VSS.t193 153.243
R1026 VSS.n1034 VSS.t93 153.243
R1027 VSS.n850 VSS.t255 150
R1028 VSS.n309 VSS.t696 165.669
R1029 VSS.t3211 VSS.n935 150
R1030 VSS.t254 VSS.n818 150
R1031 VSS.t3248 VSS.n962 150
R1032 VSS.t466 VSS.t223 145.714
R1033 VSS.t183 VSS.t471 145.714
R1034 VSS.n1022 VSS.t228 141.667
R1035 VSS.n945 VSS.t13 141.667
R1036 VSS.n246 VSS.t3297 157.335
R1037 VSS.t149 VSS.t468 141.429
R1038 VSS.t196 VSS.n874 137.536
R1039 VSS.t84 VSS.t83 137.143
R1040 VSS.n948 VSS.t267 135.703
R1041 VSS.t257 VSS.n849 124.287
R1042 VSS.n823 VSS.t252 124.287
R1043 VSS.t3249 VSS.n961 124.287
R1044 VSS.n806 VSS.t231 120.344
R1045 VSS.n835 VSS.t266 120.001
R1046 VSS.n840 VSS.t3307 120.001
R1047 VSS.t148 VSS.t466 120.001
R1048 VSS.n1012 VSS.t3296 119.835
R1049 VSS.n25 VSS.t226 119.835
R1050 VSS.t3295 VSS.n22 119.835
R1051 VSS.n968 VSS.t3193 116.668
R1052 VSS.t159 VSS.n945 116.668
R1053 VSS.t463 VSS.t3278 116.046
R1054 VSS.t3190 VSS.t704 115.715
R1055 VSS.t167 VSS.t40 112.501
R1056 VSS.t191 VSS.t473 111.43
R1057 VSS.t115 VSS.t3211 108.334
R1058 VSS.n797 VSS.n792 107.451
R1059 VSS.t3227 VSS.t3244 107.451
R1060 VSS.t94 VSS.t3215 107.451
R1061 VSS.t205 VSS.n37 77.4642
R1062 VSS.n876 VSS.t737 107.144
R1063 VSS.n844 VSS.t696 107.144
R1064 VSS.t215 VSS.n856 107.144
R1065 VSS.t714 VSS.t3263 107.144
R1066 VSS.t76 VSS.n868 107.144
R1067 VSS.t3266 VSS.n1025 107.144
R1068 VSS.n810 VSS.t178 107.144
R1069 VSS.t181 VSS.n813 107.144
R1070 VSS.t9 VSS.n947 107.144
R1071 VSS.n780 VSS.t37 107.144
R1072 VSS.t268 VSS.n776 107.144
R1073 VSS.t3184 VSS.n843 104.168
R1074 VSS.t260 VSS.n946 104.168
R1075 VSS.n246 VSS.t3233 119.835
R1076 VSS.t126 VSS.t3201 100.001
R1077 VSS.n851 VSS.t258 98.5719
R1078 VSS.n829 VSS.t3220 98.5719
R1079 VSS.t251 VSS.n819 98.5719
R1080 VSS.t3254 VSS.t3241 98.5719
R1081 VSS.t400 VSS.t0 98.5719
R1082 VSS.t3194 VSS.t262 94.5564
R1083 VSS.t86 VSS.t3206 94.5564
R1084 VSS.t703 VSS.t80 94.2862
R1085 VSS.t3186 VSS.t153 94.2862
R1086 VSS.t346 VSS.n357 57.0998
R1087 VSS.t3270 VSS.n268 29.6134
R1088 VSS.n795 VSS.t3199 90.2584
R1089 VSS.t3303 VSS.n878 90.0005
R1090 VSS.t80 VSS.n845 90.0005
R1091 VSS.t223 VSS.n812 90.0005
R1092 VSS.n217 VSS.t278 57.0789
R1093 VSS.n266 VSS.t312 57.0475
R1094 VSS.t317 VSS.n212 57.0475
R1095 VSS.t322 VSS.n267 57.0475
R1096 VSS.t327 VSS.n211 57.0475
R1097 VSS.t332 VSS.n359 56.7064
R1098 VSS.t336 VSS.n358 56.7064
R1099 VSS.t341 VSS.n269 57.0475
R1100 VSS.n271 VSS.t349 57.0475
R1101 VSS.n243 VSS.t354 57.0475
R1102 VSS.t103 VSS.n420 89.7897
R1103 VSS.t150 VSS.n23 88.7727
R1104 VSS.t155 VSS.n6 88.7727
R1105 VSS.t3297 VSS.t459 87.5005
R1106 VSS.t143 VSS.n32 66.199
R1107 VSS.t270 VSS.t15 87.1423
R1108 VSS.n26 VSS.t120 86.5025
R1109 VSS.n796 VSS.t122 85.9604
R1110 VSS.t3230 VSS.t238 85.9604
R1111 VSS.t3188 VSS.t55 85.9604
R1112 VSS.t3242 VSS.n910 85.7543
R1113 VSS.n174 VSS.t31 85.7543
R1114 VSS.n881 VSS.t45 85.7148
R1115 VSS.n847 VSS.t3226 85.7148
R1116 VSS.n33 VSS.t149 99.148
R1117 VSS.t250 VSS.n814 85.7148
R1118 VSS.t3271 VSS.n920 83.6281
R1119 VSS.t237 VSS.t63 83.3338
R1120 VSS.t269 VSS.n208 83.3336
R1121 VSS.t214 VSS.n855 81.4291
R1122 VSS.n1033 VSS.t183 81.4291
R1123 VSS.n965 VSS.t46 81.4291
R1124 VSS.n953 VSS.t3240 81.4291
R1125 VSS.t3277 VSS.t15 80.7982
R1126 VSS.n161 VSS.t3207 79.9891
R1127 VSS.t52 VSS.n4 79.9891
R1128 VSS.n765 VSS.n245 3692.29
R1129 VSS.n925 VSS.t3246 77.4615
R1130 VSS.n799 VSS.t1 77.3644
R1131 VSS.n806 VSS.t2 77.3644
R1132 VSS.t711 VSS.t215 77.1434
R1133 VSS.t0 VSS.n778 77.1434
R1134 VSS.t3278 VSS.t15 76.5012
R1135 VSS.n70 VSS.t3190 76.3274
R1136 VSS.n904 VSS.t219 74.234
R1137 VSS.n159 VSS.t3203 20.3752
R1138 VSS.t264 VSS.n792 73.0664
R1139 VSS.t206 VSS.n848 72.8576
R1140 VSS.n272 VSS.t3187 88.5605
R1141 VSS.n822 VSS.t191 72.8576
R1142 VSS.t3250 VSS.t144 72.8576
R1143 VSS.t3234 VSS.n959 72.8576
R1144 VSS.n930 VSS.t3272 72.8451
R1145 VSS.t3229 VSS.n149 72.8441
R1146 VSS.n177 VSS.t3300 72.8441
R1147 VSS.n184 VSS.t3222 72.8441
R1148 VSS.n191 VSS.t33 72.8441
R1149 VSS.t3218 VSS.n158 12.8073
R1150 VSS.n926 VSS.t3269 72.6202
R1151 VSS.t3197 VSS.n909 72.6202
R1152 VSS.t3306 VSS.n898 72.6202
R1153 VSS.t138 VSS.n899 72.6202
R1154 VSS.t15 VSS.t148 72.0417
R1155 VSS.n879 VSS.t44 71.4177
R1156 VSS.n966 VSS.t107 71.4177
R1157 VSS.t95 VSS.n1023 70.8338
R1158 VSS.n967 VSS.t21 70.8338
R1159 VSS.n967 VSS.t243 70.8338
R1160 VSS.t35 VSS.n775 70.8338
R1161 VSS.t135 VSS.n213 72.8451
R1162 VSS.t203 VSS.n210 72.8451
R1163 VSS.t146 VSS.n772 70.1995
R1164 VSS.n931 VSS.t217 70.1995
R1165 VSS.n929 VSS.t127 70.1995
R1166 VSS.t87 VSS.n907 70.1995
R1167 VSS.n900 VSS.t130 70.1995
R1168 VSS.n901 VSS.t272 70.1995
R1169 VSS.n214 VSS.t246 13.9422
R1170 VSS.t3260 VSS.n927 69.3927
R1171 VSS.t168 VSS.t145 68.7684
R1172 VSS.t3263 VSS.n852 68.5719
R1173 VSS.t3214 VSS.n870 68.5719
R1174 VSS.n24 VSS.t168 67.2827
R1175 VSS.n23 VSS.t116 67.2827
R1176 VSS.t14 VSS.n941 67.2827
R1177 VSS.t3298 VSS.n1034 67.2827
R1178 VSS.t3304 VSS.t728 66.6672
R1179 VSS.t3296 VSS.t730 66.6672
R1180 VSS.t50 VSS.t56 66.6672
R1181 VSS.t16 VSS.t69 66.6672
R1182 VSS.t3256 VSS.n926 64.5513
R1183 VSS.t194 VSS.t150 64.4704
R1184 VSS.t245 VSS.n786 64.4704
R1185 VSS.t202 VSS.n908 64.3085
R1186 VSS.t109 VSS.n277 80.6121
R1187 VSS.n130 VSS.t17 63.9684
R1188 VSS.n175 VSS.t29 63.9684
R1189 VSS.n176 VSS.t261 63.9684
R1190 VSS.t3247 VSS.n923 63.7444
R1191 VSS.t3252 VSS.n913 63.7444
R1192 VSS.n903 VSS.t198 63.7444
R1193 VSS.n922 VSS.t3202 62.3556
R1194 VSS.n912 VSS.t3196 62.3556
R1195 VSS.t23 VSS.n207 62.3556
R1196 VSS.n918 VSS.t3270 62.1307
R1197 VSS.n794 VSS.t3299 60.1724
R1198 VSS.t3294 VSS.n785 60.1724
R1199 VSS.t85 VSS.n784 60.1724
R1200 VSS.n1011 VSS.t3287 60.0005
R1201 VSS.n1020 VSS.t230 60.0005
R1202 VSS.t158 VSS.n832 60.0005
R1203 VSS.t153 VSS.n807 60.0005
R1204 VSS.n815 VSS.t249 60.0005
R1205 VSS.n131 VSS.t284 58.6622
R1206 VSS.t286 VSS.n153 58.6622
R1207 VSS.n133 VSS.t289 58.6622
R1208 VSS.t291 VSS.n151 58.6622
R1209 VSS.t297 VSS.n148 58.6622
R1210 VSS.n138 VSS.t300 58.6622
R1211 VSS.t302 VSS.n146 58.6622
R1212 VSS.n140 VSS.t305 58.6622
R1213 VSS.t307 VSS.n144 58.6622
R1214 VSS.n178 VSS.t364 58.6622
R1215 VSS.t366 VSS.n204 58.6622
R1216 VSS.n180 VSS.t369 58.6622
R1217 VSS.t371 VSS.n202 58.6622
R1218 VSS.n182 VSS.t373 58.6622
R1219 VSS.n185 VSS.t379 58.6622
R1220 VSS.t382 VSS.n197 58.6622
R1221 VSS.n187 VSS.t385 58.6622
R1222 VSS.t387 VSS.n195 58.6622
R1223 VSS.n189 VSS.t389 58.6622
R1224 VSS.n68 VSS.t3232 58.5605
R1225 VSS.n130 VSS.t281 58.3211
R1226 VSS.t295 VSS.n149 58.3211
R1227 VSS.n177 VSS.t361 58.3211
R1228 VSS.n184 VSS.t376 58.3211
R1229 VSS.n191 VSS.t392 58.3211
R1230 VSS.n920 VSS.t3253 57.8078
R1231 VSS.t394 VSS.t393 57.0781
R1232 VSS.n131 VSS.t283 57.0465
R1233 VSS.t285 VSS.n153 57.0465
R1234 VSS.n133 VSS.t288 57.0465
R1235 VSS.t290 VSS.n151 57.0465
R1236 VSS.n135 VSS.t293 57.0465
R1237 VSS.t296 VSS.n148 57.0465
R1238 VSS.n138 VSS.t299 57.0465
R1239 VSS.t301 VSS.n146 57.0465
R1240 VSS.n140 VSS.t304 57.0465
R1241 VSS.t306 VSS.n144 57.0465
R1242 VSS.n142 VSS.t308 57.0789
R1243 VSS.n178 VSS.t362 57.0465
R1244 VSS.t365 VSS.n204 57.0465
R1245 VSS.n180 VSS.t368 57.0465
R1246 VSS.t370 VSS.n202 57.0465
R1247 VSS.n182 VSS.t372 57.0465
R1248 VSS.t374 VSS.n200 57.0465
R1249 VSS.n185 VSS.t377 57.0465
R1250 VSS.t380 VSS.n197 57.0465
R1251 VSS.n187 VSS.t384 57.0465
R1252 VSS.t386 VSS.n195 57.0465
R1253 VSS.n189 VSS.t388 57.0465
R1254 VSS.t390 VSS.n193 57.0789
R1255 VSS.t121 VSS.n791 55.8744
R1256 VSS.t3189 VSS.t199 55.8744
R1257 VSS.t139 VSS.n785 55.8744
R1258 VSS.t3183 VSS.t140 55.8744
R1259 VSS.n1018 VSS.t3225 55.7148
R1260 VSS.t213 VSS.n854 55.7148
R1261 VSS.t185 VSS.n1032 55.7148
R1262 VSS.n954 VSS.t3239 55.7148
R1263 VSS.n923 VSS.t234 54.8687
R1264 VSS.n913 VSS.t221 54.8687
R1265 VSS.n903 VSS.t39 54.8687
R1266 VSS.n782 VSS.t126 54.1672
R1267 VSS.n919 VSS.t3258 54.0618
R1268 VSS.t49 VSS.t15 53.8079
R1269 VSS.t15 VSS.t236 53.8079
R1270 VSS.n162 VSS.t82 53.1692
R1271 VSS.t3200 VSS.n14 53.1692
R1272 VSS.t280 VSS.n217 26.5065
R1273 VSS.t294 VSS.n136 53.0738
R1274 VSS.t309 VSS.n142 26.5067
R1275 VSS.n199 VSS.t375 53.0738
R1276 VSS.n193 VSS.t391 26.5067
R1277 VSS.t360 VSS.n206 53.0654
R1278 VSS.n135 VSS.t294 53.014
R1279 VSS.t375 VSS.n200 53.014
R1280 VSS.n176 VSS.t360 52.6729
R1281 VSS.n1014 VSS.t3286 51.5764
R1282 VSS.t262 VSS.n36 66.3233
R1283 VSS.n802 VSS.t239 51.5764
R1284 VSS.t3216 VSS.t240 51.5764
R1285 VSS.t113 VSS.n783 51.5764
R1286 VSS.t588 VSS.t706 51.4291
R1287 VSS.t708 VSS.t257 51.4291
R1288 VSS.n779 VSS.t10 51.4291
R1289 VSS.t278 VSS.n1037 48.6385
R1290 VSS.t283 VSS.n154 48.6385
R1291 VSS.n132 VSS.t285 48.6385
R1292 VSS.t288 VSS.n152 48.6385
R1293 VSS.n134 VSS.t290 48.6385
R1294 VSS.t293 VSS.n150 48.6385
R1295 VSS.n137 VSS.t296 48.6385
R1296 VSS.t299 VSS.n147 48.6385
R1297 VSS.n139 VSS.t301 48.6385
R1298 VSS.t304 VSS.n145 48.6385
R1299 VSS.n141 VSS.t306 48.6385
R1300 VSS.t308 VSS.n143 48.6385
R1301 VSS.n156 VSS.t312 48.6385
R1302 VSS.t317 VSS.n155 48.6385
R1303 VSS.n934 VSS.t322 48.6385
R1304 VSS.n933 VSS.t327 48.6385
R1305 VSS.n932 VSS.t332 48.6385
R1306 VSS.n917 VSS.t336 48.6385
R1307 VSS.n915 VSS.t341 48.6385
R1308 VSS.n914 VSS.t346 48.6385
R1309 VSS.n906 VSS.t349 48.6385
R1310 VSS.t354 VSS.n173 48.6385
R1311 VSS.t359 VSS.n209 48.6385
R1312 VSS.t362 VSS.n205 48.6385
R1313 VSS.n179 VSS.t365 48.6385
R1314 VSS.t368 VSS.n203 48.6385
R1315 VSS.n181 VSS.t370 48.6385
R1316 VSS.t372 VSS.n201 48.6385
R1317 VSS.n183 VSS.t374 48.6385
R1318 VSS.t377 VSS.n198 48.6385
R1319 VSS.n186 VSS.t380 48.6385
R1320 VSS.t384 VSS.n196 48.6385
R1321 VSS.n188 VSS.t386 48.6385
R1322 VSS.t388 VSS.n194 48.6385
R1323 VSS.n190 VSS.t390 48.6385
R1324 VSS.t393 VSS.n192 48.6385
R1325 VSS.t15 VSS.n27 2.49582
R1326 VSS.t3205 VSS.n789 47.2784
R1327 VSS.n801 VSS.t123 47.2784
R1328 VSS.t241 VSS.t72 47.2784
R1329 VSS.n1016 VSS.t208 47.1434
R1330 VSS.t190 VSS.n820 47.1434
R1331 VSS.t3235 VSS.n958 47.1434
R1332 VSS.n1037 VSS.t275 47.0238
R1333 VSS.t281 VSS.n154 47.0238
R1334 VSS.t284 VSS.n132 47.0238
R1335 VSS.n152 VSS.t286 47.0238
R1336 VSS.t289 VSS.n134 47.0238
R1337 VSS.n150 VSS.t291 47.0238
R1338 VSS.n137 VSS.t295 47.0238
R1339 VSS.n147 VSS.t297 47.0238
R1340 VSS.t300 VSS.n139 47.0238
R1341 VSS.n145 VSS.t302 47.0238
R1342 VSS.t305 VSS.n141 47.0238
R1343 VSS.n143 VSS.t307 47.0238
R1344 VSS.t310 VSS.n156 47.0238
R1345 VSS.t314 VSS.n155 47.0238
R1346 VSS.t319 VSS.n934 47.0238
R1347 VSS.t324 VSS.n933 47.0238
R1348 VSS.t329 VSS.n932 47.0238
R1349 VSS.t333 VSS.n917 47.0238
R1350 VSS.t338 VSS.n915 47.0238
R1351 VSS.t343 VSS.n914 47.0238
R1352 VSS.t347 VSS.n906 47.0238
R1353 VSS.t351 VSS.n173 47.0238
R1354 VSS.t356 VSS.n209 47.0238
R1355 VSS.t361 VSS.n205 47.0238
R1356 VSS.t364 VSS.n179 47.0238
R1357 VSS.n203 VSS.t366 47.0238
R1358 VSS.t369 VSS.n181 47.0238
R1359 VSS.n201 VSS.t371 47.0238
R1360 VSS.t373 VSS.n183 47.0238
R1361 VSS.t376 VSS.n198 47.0238
R1362 VSS.t379 VSS.n186 47.0238
R1363 VSS.n196 VSS.t382 47.0238
R1364 VSS.t385 VSS.n188 47.0238
R1365 VSS.n194 VSS.t387 47.0238
R1366 VSS.t389 VSS.n190 47.0238
R1367 VSS.t392 VSS.n192 47.0238
R1368 VSS.t119 VSS.t270 45.8338
R1369 VSS.t226 VSS.t3280 45.8338
R1370 VSS.n942 VSS.t3273 45.7789
R1371 VSS.t40 VSS.n25 44.8359
R1372 VSS.t275 VSS.n245 56.194
R1373 VSS.n213 VSS.t310 58.3202
R1374 VSS.n266 VSS.t314 58.6603
R1375 VSS.n212 VSS.t319 58.6603
R1376 VSS.n267 VSS.t324 58.6603
R1377 VSS.n211 VSS.t329 58.6603
R1378 VSS.n268 VSS.t333 58.6603
R1379 VSS.n916 VSS.t338 44.3792
R1380 VSS.n269 VSS.t343 58.6603
R1381 VSS.n210 VSS.t347 58.3202
R1382 VSS.n271 VSS.t351 58.6603
R1383 VSS.n243 VSS.t356 58.6603
R1384 VSS.t3217 VSS.n786 42.9804
R1385 VSS.n93 VSS.t173 50.7208
R1386 VSS.t3209 VSS.n831 42.8576
R1387 VSS.n949 VSS.t3267 42.8576
R1388 VSS.n420 VSS.t359 56.7064
R1389 VSS.t15 VSS.t241 42.1172
R1390 VSS.t15 VSS.n36 1.60658
R1391 VSS.t3251 VSS.n861 41.4177
R1392 VSS.t3202 VSS.n921 40.8632
R1393 VSS.t3196 VSS.n911 40.8632
R1394 VSS.n897 VSS.t23 40.8632
R1395 VSS.t201 VSS.n789 38.6824
R1396 VSS.n809 VSS.n805 38.6824
R1397 VSS.t129 VSS.t3236 38.5719
R1398 VSS.t3302 VSS.n276 53.8079
R1399 VSS.n968 VSS.t68 37.5005
R1400 VSS.n9 VSS.t3230 37.1968
R1401 VSS.t209 VSS.n1015 37.1319
R1402 VSS.t234 VSS.n922 36.5343
R1403 VSS.t221 VSS.n912 36.5343
R1404 VSS.t39 VSS.n207 36.5343
R1405 VSS.n804 VSS.t3189 34.3845
R1406 VSS.n836 VSS.t3219 34.2862
R1407 VSS.n816 VSS.t248 34.2862
R1408 VSS.t3259 VSS.n956 34.2862
R1409 VSS.t236 VSS.t177 33.3338
R1410 VSS.n950 VSS.t84 32.8462
R1411 VSS.t3253 VSS.n919 31.469
R1412 VSS.t3204 VSS.n791 30.0865
R1413 VSS.t3215 VSS.n787 30.0865
R1414 VSS.n805 VSS.t3183 30.0865
R1415 VSS.t212 VSS.n853 30.0005
R1416 VSS.n837 VSS.t3185 30.0005
R1417 VSS.n841 VSS.t3228 30.0005
R1418 VSS.t689 VSS.t583 30.0005
R1419 VSS.n811 VSS.t134 30.0005
R1420 VSS.n1031 VSS.t186 30.0005
R1421 VSS.n955 VSS.t3238 30.0005
R1422 VSS.n781 VSS.t125 30.0005
R1423 VSS.t3244 VSS.t15 29.2233
R1424 VSS.n969 VSS.t3268 29.1672
R1425 VSS.t55 VSS.n5 28.6008
R1426 VSS.n924 VSS.t3247 28.0006
R1427 VSS.t198 VSS.n208 27.6595
R1428 VSS.t17 VSS.n158 38.7811
R1429 VSS.n909 VSS.t202 27.4346
R1430 VSS.t29 VSS.n898 27.4346
R1431 VSS.t261 VSS.n899 27.4346
R1432 VSS.n940 VSS.t133 25.7885
R1433 VSS.t3198 VSS.n869 25.7148
R1434 VSS.t144 VSS.n960 25.7148
R1435 VSS.t77 VSS.n777 25.7148
R1436 VSS.t247 VSS.t15 24.8989
R1437 VSS.t101 VSS.n91 24.2748
R1438 VSS.t105 VSS.n950 24.2748
R1439 VSS.t3258 VSS.n918 23.4002
R1440 VSS.n928 VSS.t3260 22.3524
R1441 VSS.n136 VSS.t146 21.6092
R1442 VSS.n157 VSS.t3223 13.9422
R1443 VSS.t272 VSS.n199 21.6092
R1444 VSS.n214 VSS.t30 3.37712
R1445 VSS.t130 VSS.n206 21.5998
R1446 VSS.n908 VSS.t87 21.5455
R1447 VSS.t127 VSS.n928 21.5436
R1448 VSS.t3208 VSS.n788 21.4905
R1449 VSS.n821 VSS.t189 21.4291
R1450 VSS.t232 VSS.t3249 21.4291
R1451 VSS.t3236 VSS.n957 21.4291
R1452 VSS.t160 VSS.t105 21.4291
R1453 VSS.t217 VSS.n930 21.2035
R1454 VSS.t3290 VSS.n9 20.0048
R1455 VSS.n1015 VSS.t210 19.9891
R1456 VSS.t18 VSS.n158 2.99891
R1457 VSS.n910 VSS.t3197 18.7838
R1458 VSS.n174 VSS.t3306 18.7838
R1459 VSS.n175 VSS.t138 18.7838
R1460 VSS.n159 VSS.t19 14.8819
R1461 VSS.n772 VSS.t3229 18.5589
R1462 VSS.n157 VSS.t135 29.5272
R1463 VSS.t3213 VSS.n931 18.5589
R1464 VSS.t3272 VSS.n929 18.5589
R1465 VSS.n907 VSS.t203 18.5589
R1466 VSS.t3300 VSS.n900 18.5589
R1467 VSS.t3222 VSS.n901 18.5589
R1468 VSS.t33 VSS.n214 29.5272
R1469 VSS.n921 VSS.t3271 17.4635
R1470 VSS.n911 VSS.t3242 17.4635
R1471 VSS.t31 VSS.n897 17.4635
R1472 VSS.t156 VSS.t3198 17.1434
R1473 VSS.t12 VSS.t263 17.1434
R1474 VSS.t3240 VSS.t3261 17.1434
R1475 VSS.t3293 VSS.t268 17.1434
R1476 VSS.n245 VSS.t18 2.5939
R1477 VSS.n30 VSS.n361 5.64438
R1478 VSS.n30 VSS.n362 5.64438
R1479 VSS.n217 VSS.t18 0.0329225
R1480 VSS.t18 VSS.n159 2.33095
R1481 VSS.t18 VSS.n772 17.0005
R1482 VSS.t18 VSS.n157 3.37712
R1483 VSS.t18 VSS.n213 0.405951
R1484 VSS.t18 VSS.n266 0.0643469
R1485 VSS.t18 VSS.n265 5.6463
R1486 VSS.n212 VSS.t18 0.0643469
R1487 VSS.n267 VSS.t18 0.0643469
R1488 VSS.n211 VSS.t18 0.0643469
R1489 VSS.n359 VSS.t18 0.405951
R1490 VSS.n931 VSS.t18 17.0005
R1491 VSS.n929 VSS.t18 17.0005
R1492 VSS.n927 VSS.t18 17.0005
R1493 VSS.n926 VSS.t18 17.0005
R1494 VSS.n925 VSS.t18 17.0005
R1495 VSS.n923 VSS.t18 17.0005
R1496 VSS.n919 VSS.t18 17.0005
R1497 VSS.n918 VSS.t18 17.0005
R1498 VSS.n358 VSS.t18 0.405951
R1499 VSS.n916 VSS.t30 17.0005
R1500 VSS.n269 VSS.t30 0.0643469
R1501 VSS.n357 VSS.t30 0.0109756
R1502 VSS.n913 VSS.t30 17.0005
R1503 VSS.n909 VSS.t30 17.0005
R1504 VSS.n907 VSS.t30 17.0005
R1505 VSS.t30 VSS.n271 0.0643469
R1506 VSS.n270 VSS.t30 5.6463
R1507 VSS.t30 VSS.n243 0.0643469
R1508 VSS.t30 VSS.n904 17.0005
R1509 VSS.t30 VSS.n903 17.0005
R1510 VSS.t30 VSS.n898 17.0005
R1511 VSS.t30 VSS.n899 17.0005
R1512 VSS.t30 VSS.n900 17.0005
R1513 VSS.t30 VSS.n901 17.0005
R1514 VSS.n126 VSS.n160 2.72109
R1515 VSS.n105 VSS.n350 5.61485
R1516 VSS.n3 VSS.n338 5.64438
R1517 VSS.n339 VSS.n3 5.64438
R1518 VSS.n336 VSS.n2 5.64438
R1519 VSS.n2 VSS.n337 5.64438
R1520 VSS.n1 VSS.n334 5.64438
R1521 VSS.n335 VSS.n1 5.64438
R1522 VSS.t70 VSS.t1221 17.0005
R1523 VSS.n234 VSS.t70 4.17719
R1524 VSS.t1309 VSS.n629 0.120486
R1525 VSS.n0 VSS.n312 5.64438
R1526 VSS.n313 VSS.n0 5.64438
R1527 VSS.t92 VSS.n711 5.6463
R1528 VSS.t92 VSS.n309 0.666899
R1529 VSS.n1021 VSS.t92 17.0005
R1530 VSS.t92 VSS.n1022 17.0005
R1531 VSS.t92 VSS.n843 17.0005
R1532 VSS.n1023 VSS.t92 17.0005
R1533 VSS.t92 VSS.n1024 17.0005
R1534 VSS.n1025 VSS.t92 17.0005
R1535 VSS.t92 VSS.n1026 17.0005
R1536 VSS.n842 VSS.t512 17.0005
R1537 VSS.t512 VSS.n273 0.0258175
R1538 VSS.t512 VSS.n841 17.0005
R1539 VSS.t512 VSS.n826 17.0005
R1540 VSS.t512 VSS.n840 17.0005
R1541 VSS.t512 VSS.n827 17.0005
R1542 VSS.t512 VSS.n272 0.649813
R1543 VSS.t512 VSS.n828 17.0005
R1544 VSS.t512 VSS.n839 17.0005
R1545 VSS.n838 VSS.t512 17.0005
R1546 VSS.t512 VSS.n829 17.0005
R1547 VSS.t512 VSS.n837 17.0005
R1548 VSS.t512 VSS.n831 17.0005
R1549 VSS.t512 VSS.n836 17.0005
R1550 VSS.t512 VSS.n832 17.0005
R1551 VSS.t512 VSS.n835 17.0005
R1552 VSS.t197 VSS.n846 17.0005
R1553 VSS.t197 VSS.n847 17.0005
R1554 VSS.t92 VSS.n1018 17.0005
R1555 VSS.t92 VSS.n845 17.0005
R1556 VSS.n1019 VSS.t92 17.0005
R1557 VSS.t92 VSS.n1020 17.0005
R1558 VSS.t92 VSS.n844 17.0005
R1559 VSS.t197 VSS.n308 0.0258175
R1560 VSS.n858 VSS.t197 17.0005
R1561 VSS.n856 VSS.t197 17.0005
R1562 VSS.n855 VSS.t197 17.0005
R1563 VSS.n854 VSS.t197 17.0005
R1564 VSS.n853 VSS.t197 17.0005
R1565 VSS.t197 VSS.n1016 17.0005
R1566 VSS.t197 VSS.n848 17.0005
R1567 VSS.t197 VSS.n851 17.0005
R1568 VSS.t197 VSS.n849 17.0005
R1569 VSS.t197 VSS.n850 17.0005
R1570 VSS.t197 VSS.n867 17.0005
R1571 VSS.t197 VSS.n306 0.649813
R1572 VSS.t197 VSS.n865 17.0005
R1573 VSS.t197 VSS.n866 17.0005
R1574 VSS.t197 VSS.n275 0.649813
R1575 VSS.t197 VSS.n864 17.0005
R1576 VSS.t197 VSS.n307 0.649813
R1577 VSS.t197 VSS.n863 17.0005
R1578 VSS.t197 VSS.n98 0.649813
R1579 VSS.t197 VSS.n852 17.0005
R1580 VSS.t197 VSS.n862 17.0005
R1581 VSS.n860 VSS.t197 17.0005
R1582 VSS.t197 VSS.n1014 17.0005
R1583 VSS.n305 VSS.t197 0.0266767
R1584 VSS.n1013 VSS.t197 17.0005
R1585 VSS.n276 VSS.t197 0.0271432
R1586 VSS.t197 VSS.n873 17.0005
R1587 VSS.t197 VSS.n868 17.0005
R1588 VSS.t197 VSS.n872 17.0005
R1589 VSS.t197 VSS.n869 17.0005
R1590 VSS.t197 VSS.n871 17.0005
R1591 VSS.t197 VSS.n870 17.0005
R1592 VSS.t197 VSS.n93 8.48859
R1593 VSS.t197 VSS.n874 17.0005
R1594 VSS.t197 VSS.n281 0.325424
R1595 VSS.t197 VSS.n1010 17.0005
R1596 VSS.n297 VSS.t197 0.649813
R1597 VSS.t197 VSS.n1009 17.0005
R1598 VSS.n99 VSS.t197 0.649813
R1599 VSS.t197 VSS.n1008 17.0005
R1600 VSS.t197 VSS.n298 0.649813
R1601 VSS.t197 VSS.n1007 17.0005
R1602 VSS.n280 VSS.t197 0.649813
R1603 VSS.t197 VSS.n1006 17.0005
R1604 VSS.t197 VSS.n299 0.649813
R1605 VSS.t197 VSS.n1005 17.0005
R1606 VSS.t197 VSS.n170 0.649813
R1607 VSS.t197 VSS.n889 17.0005
R1608 VSS.t197 VSS.n300 0.649813
R1609 VSS.t197 VSS.n888 17.0005
R1610 VSS.n279 VSS.t197 0.649813
R1611 VSS.t197 VSS.n887 17.0005
R1612 VSS.t197 VSS.n301 0.649813
R1613 VSS.t197 VSS.n886 17.0005
R1614 VSS.n94 VSS.t197 0.649813
R1615 VSS.t197 VSS.n885 17.0005
R1616 VSS.n302 VSS.t197 0.649813
R1617 VSS.t197 VSS.n884 17.0005
R1618 VSS.n278 VSS.t197 0.649813
R1619 VSS.t197 VSS.n883 17.0005
R1620 VSS.t197 VSS.n303 0.649813
R1621 VSS.t197 VSS.n882 17.0005
R1622 VSS.n171 VSS.t197 0.649813
R1623 VSS.t197 VSS.n877 17.0005
R1624 VSS.n304 VSS.t197 0.649813
R1625 VSS.n881 VSS.t197 17.0005
R1626 VSS.n880 VSS.t197 17.0005
R1627 VSS.n878 VSS.t197 17.0005
R1628 VSS.t197 VSS.n277 0.0258175
R1629 VSS.t197 VSS.n1011 17.0005
R1630 VSS.t197 VSS.n876 17.0005
R1631 VSS.t197 VSS.n875 17.0005
R1632 VSS.t512 VSS.n834 17.0005
R1633 VSS.t15 VSS.n31 9.30614
R1634 VSS.t15 VSS.n817 17.0005
R1635 VSS.t15 VSS.n824 17.0005
R1636 VSS.t15 VSS.n818 17.0005
R1637 VSS.t15 VSS.n823 17.0005
R1638 VSS.t15 VSS.n819 17.0005
R1639 VSS.t15 VSS.n822 17.0005
R1640 VSS.t15 VSS.n820 17.0005
R1641 VSS.t15 VSS.n821 17.0005
R1642 VSS.n1030 VSS.t15 17.0005
R1643 VSS.t15 VSS.n1031 17.0005
R1644 VSS.n1032 VSS.t15 17.0005
R1645 VSS.t15 VSS.n1033 17.0005
R1646 VSS.t15 VSS.n813 17.0005
R1647 VSS.n943 VSS.t15 17.0005
R1648 VSS.n944 VSS.t15 17.0005
R1649 VSS.n945 VSS.t15 17.0005
R1650 VSS.n946 VSS.t15 17.0005
R1651 VSS.n32 VSS.t15 3.41984
R1652 VSS.n947 VSS.t15 17.0005
R1653 VSS.n949 VSS.t15 17.0005
R1654 VSS.n952 VSS.t15 17.0005
R1655 VSS.n953 VSS.t15 17.0005
R1656 VSS.n954 VSS.t15 17.0005
R1657 VSS.n955 VSS.t15 17.0005
R1658 VSS.n956 VSS.t15 17.0005
R1659 VSS.n957 VSS.t15 17.0005
R1660 VSS.n958 VSS.t15 17.0005
R1661 VSS.n959 VSS.t15 17.0005
R1662 VSS.n960 VSS.t15 17.0005
R1663 VSS.n961 VSS.t15 17.0005
R1664 VSS.n962 VSS.t15 17.0005
R1665 VSS.n963 VSS.t15 17.0005
R1666 VSS.n964 VSS.t15 17.0005
R1667 VSS.n965 VSS.t15 17.0005
R1668 VSS.t15 VSS.n45 0.649813
R1669 VSS.t15 VSS.n939 17.0005
R1670 VSS.t15 VSS.n814 17.0005
R1671 VSS.t15 VSS.n815 17.0005
R1672 VSS.t15 VSS.n816 17.0005
R1673 VSS.n940 VSS.t15 17.0005
R1674 VSS.t15 VSS.n969 17.0005
R1675 VSS.t15 VSS.n935 17.0005
R1676 VSS.t15 VSS.n968 17.0005
R1677 VSS.t15 VSS.n936 17.0005
R1678 VSS.t15 VSS.n967 17.0005
R1679 VSS.t15 VSS.n937 17.0005
R1680 VSS.t15 VSS.n970 17.0005
R1681 VSS.t15 VSS.n971 17.0005
R1682 VSS.t15 VSS.n973 17.0005
R1683 VSS.t15 VSS.n972 17.0005
R1684 VSS.n38 VSS.t3191 0.406954
R1685 VSS.n812 VSS.t15 17.0005
R1686 VSS.t15 VSS.n811 17.0005
R1687 VSS.t15 VSS.n807 17.0005
R1688 VSS.t15 VSS.n810 17.0005
R1689 VSS.t15 VSS.n783 17.0005
R1690 VSS.t15 VSS.n806 17.0005
R1691 VSS.t15 VSS.n784 17.0005
R1692 VSS.t15 VSS.n805 17.0005
R1693 VSS.t15 VSS.n785 17.0005
R1694 VSS.t15 VSS.n804 17.0005
R1695 VSS.t15 VSS.n786 17.0005
R1696 VSS.t15 VSS.n803 17.0005
R1697 VSS.t15 VSS.n787 17.0005
R1698 VSS.t15 VSS.n802 17.0005
R1699 VSS.t15 VSS.n788 17.0005
R1700 VSS.t15 VSS.n801 17.0005
R1701 VSS.t15 VSS.n789 17.0005
R1702 VSS.t15 VSS.n800 17.0005
R1703 VSS.t15 VSS.n790 17.0005
R1704 VSS.t15 VSS.n799 17.0005
R1705 VSS.t15 VSS.n798 17.0005
R1706 VSS.t15 VSS.n796 17.0005
R1707 VSS.t15 VSS.n791 17.0005
R1708 VSS.t15 VSS.n795 17.0005
R1709 VSS.t15 VSS.n794 17.0005
R1710 VSS.t15 VSS.n792 17.0005
R1711 VSS.t15 VSS.n793 17.0005
R1712 VSS.t15 VSS.n1035 17.0005
R1713 VSS.t15 VSS.n774 17.0005
R1714 VSS.t15 VSS.n246 0.666899
R1715 VSS.t15 VSS.n775 17.0005
R1716 VSS.t15 VSS.n782 17.0005
R1717 VSS.t15 VSS.n776 17.0005
R1718 VSS.t15 VSS.n781 17.0005
R1719 VSS.t15 VSS.n780 17.0005
R1720 VSS.t15 VSS.n777 17.0005
R1721 VSS.t15 VSS.n779 17.0005
R1722 VSS.t15 VSS.n778 17.0005
R1723 VSS.t263 VSS.n91 15.7034
R1724 VSS.n861 VSS.t171 15.7034
R1725 VSS.t219 VSS.n896 15.0429
R1726 VSS.t3246 VSS.n924 14.2816
R1727 VSS.t282 VSS.n1036 14.1658
R1728 VSS.t378 VSS.n890 14.1658
R1729 VSS.n975 VSS.t353 14.1658
R1730 VSS.n984 VSS.n983 14.1658
R1731 VSS.n986 VSS.t3145 14.1658
R1732 VSS.n1040 VSS.n1039 14.1658
R1733 VSS.n1029 VSS.t316 14.1658
R1734 VSS.n1036 VSS.t462 13.5005
R1735 VSS.t521 VSS.n773 13.5005
R1736 VSS.t793 VSS.n1001 13.5005
R1737 VSS.n1000 VSS.t1177 13.5005
R1738 VSS.t1472 VSS.n893 13.5005
R1739 VSS.n989 VSS.t1864 13.5005
R1740 VSS.t2256 VSS.n990 13.5005
R1741 VSS.t2639 VSS.n770 13.5005
R1742 VSS.n1041 VSS.t2922 13.5005
R1743 VSS.n975 VSS.n974 13.5005
R1744 VSS.n976 VSS.t599 13.5005
R1745 VSS.n977 VSS.n892 13.5005
R1746 VSS.n979 VSS.t1265 13.5005
R1747 VSS.n996 VSS.n995 13.5005
R1748 VSS.n994 VSS.n981 13.5005
R1749 VSS.n987 VSS.n980 13.5005
R1750 VSS.n985 VSS.n984 13.5005
R1751 VSS.t434 VSS.n890 13.5005
R1752 VSS.t627 VSS.n1004 13.5005
R1753 VSS.n1003 VSS.t1016 13.5005
R1754 VSS.n978 VSS.n891 13.5005
R1755 VSS.n982 VSS.t1695 13.5005
R1756 VSS.t2087 VSS.n993 13.5005
R1757 VSS.n992 VSS.t2479 13.5005
R1758 VSS.n986 VSS.t2770 13.5005
R1759 VSS.n1039 VSS.t2827 13.5005
R1760 VSS.n991 VSS.n771 13.5005
R1761 VSS.n988 VSS.n894 13.5005
R1762 VSS.n998 VSS.n997 13.5005
R1763 VSS.t1369 VSS.n999 13.5005
R1764 VSS.n1002 VSS.n825 13.5005
R1765 VSS.n1028 VSS.n1027 13.5005
R1766 VSS.t253 VSS.n1029 13.5005
R1767 VSS.n896 VSS.t103 13.4291
R1768 VSS.n927 VSS.t3256 12.9107
R1769 VSS.t26 VSS.t65 12.8945
R1770 VSS.t3206 VSS.n790 12.8945
R1771 VSS.n800 VSS.t3289 12.8945
R1772 VSS.t180 VSS.n1019 12.8576
R1773 VSS.n811 VSS.t108 12.8576
R1774 VSS.t3238 VSS.t3255 12.8576
R1775 VSS.t732 VSS.t162 12.5005
R1776 VSS.n803 VSS.t3216 8.59649
R1777 VSS.t3210 VSS.n838 8.57193
R1778 VSS.n952 VSS.t3254 8.57193
R1779 VSS.n42 VSS.n363 3.31921
R1780 VSS.n640 VSS.t70 4.19248
R1781 VSS.t3182 VSS.n30 8.50199
R1782 VSS.t2516 VSS.n3 8.50198
R1783 VSS.n2 VSS.t2124 8.50198
R1784 VSS.t1732 VSS.n1 8.50198
R1785 VSS.t1053 VSS.n0 8.50198
R1786 VSS.n419 VSS.t3179 0.130189
R1787 VSS.t3177 VSS.n30 8.501
R1788 VSS.n418 VSS.t3174 0.130189
R1789 VSS.t3172 VSS.n30 8.501
R1790 VSS.n417 VSS.t3169 0.130189
R1791 VSS.t3167 VSS.n30 8.501
R1792 VSS.n416 VSS.t3164 0.130189
R1793 VSS.t3162 VSS.n30 8.501
R1794 VSS.n415 VSS.t3159 0.130189
R1795 VSS.t3157 VSS.n30 8.501
R1796 VSS.n414 VSS.t3154 0.130189
R1797 VSS.t3152 VSS.n30 8.501
R1798 VSS.n413 VSS.t3149 0.130189
R1799 VSS.t3147 VSS.n361 0.0362711
R1800 VSS.n412 VSS.t3144 0.0793054
R1801 VSS.t3142 VSS.n30 8.501
R1802 VSS.n411 VSS.t3139 0.130189
R1803 VSS.t3137 VSS.n30 8.501
R1804 VSS.n410 VSS.t3134 0.130189
R1805 VSS.t3132 VSS.n30 8.501
R1806 VSS.n409 VSS.t3129 0.130189
R1807 VSS.t3127 VSS.n30 8.501
R1808 VSS.n408 VSS.t3124 0.130189
R1809 VSS.t3122 VSS.n30 8.501
R1810 VSS.n407 VSS.t3119 0.130189
R1811 VSS.t3117 VSS.n30 8.501
R1812 VSS.n406 VSS.t3114 0.130189
R1813 VSS.t3112 VSS.n30 8.501
R1814 VSS.n405 VSS.t3109 0.130189
R1815 VSS.t3107 VSS.n30 8.501
R1816 VSS.n404 VSS.t3104 0.130189
R1817 VSS.t3102 VSS.n30 8.501
R1818 VSS.n403 VSS.t3099 0.130189
R1819 VSS.t3097 VSS.n30 8.501
R1820 VSS.n402 VSS.t3094 0.130189
R1821 VSS.t3092 VSS.n30 8.501
R1822 VSS.n401 VSS.t3089 0.130189
R1823 VSS.t3087 VSS.n30 8.501
R1824 VSS.n400 VSS.t3084 0.130189
R1825 VSS.t3082 VSS.n30 8.501
R1826 VSS.n399 VSS.t3079 0.130189
R1827 VSS.t3077 VSS.n30 8.501
R1828 VSS.n398 VSS.t3074 0.130189
R1829 VSS.t3072 VSS.n362 0.0362711
R1830 VSS.n397 VSS.t3069 0.0793054
R1831 VSS.n30 VSS.t3067 8.501
R1832 VSS.t3064 VSS.n396 0.130189
R1833 VSS.t3062 VSS.n30 8.501
R1834 VSS.t3059 VSS.n395 0.130189
R1835 VSS.t3057 VSS.n30 8.501
R1836 VSS.t3054 VSS.n394 0.130189
R1837 VSS.t3052 VSS.n30 8.501
R1838 VSS.t3049 VSS.n393 0.130189
R1839 VSS.t3047 VSS.n30 8.501
R1840 VSS.t3044 VSS.n392 0.130189
R1841 VSS.t3042 VSS.n30 8.501
R1842 VSS.t3039 VSS.n391 0.130189
R1843 VSS.t3037 VSS.n30 8.501
R1844 VSS.t3034 VSS.n390 0.130189
R1845 VSS.t3032 VSS.n30 8.501
R1846 VSS.t3029 VSS.n389 0.130189
R1847 VSS.t3027 VSS.n30 8.501
R1848 VSS.t3024 VSS.n388 0.130189
R1849 VSS.t3022 VSS.n30 8.501
R1850 VSS.t3019 VSS.n387 0.130189
R1851 VSS.t3017 VSS.n30 8.501
R1852 VSS.t3014 VSS.n386 0.130189
R1853 VSS.t3012 VSS.n30 8.501
R1854 VSS.t3009 VSS.n385 0.130189
R1855 VSS.t3007 VSS.n30 8.501
R1856 VSS.t3004 VSS.n384 0.130189
R1857 VSS.t3002 VSS.n30 8.501
R1858 VSS.t2999 VSS.n383 0.130189
R1859 VSS.n30 VSS.t2997 8.501
R1860 VSS.t2994 VSS.n382 0.130189
R1861 VSS.t2992 VSS.n30 8.501
R1862 VSS.t2989 VSS.n381 0.130189
R1863 VSS.t2987 VSS.n30 8.501
R1864 VSS.t2984 VSS.n380 0.130189
R1865 VSS.t2982 VSS.n30 8.501
R1866 VSS.t2979 VSS.n379 0.130189
R1867 VSS.t2977 VSS.n30 8.501
R1868 VSS.t2974 VSS.n378 0.130189
R1869 VSS.t2972 VSS.n30 8.501
R1870 VSS.t2969 VSS.n377 0.130189
R1871 VSS.t2967 VSS.n30 8.501
R1872 VSS.t2964 VSS.n376 0.130189
R1873 VSS.t2962 VSS.n30 8.501
R1874 VSS.t2959 VSS.n375 0.130189
R1875 VSS.t2957 VSS.n30 8.501
R1876 VSS.t2954 VSS.n374 0.130189
R1877 VSS.t2952 VSS.n30 8.501
R1878 VSS.t2949 VSS.n373 0.130189
R1879 VSS.t2947 VSS.n30 8.501
R1880 VSS.t2944 VSS.n372 0.130189
R1881 VSS.t2942 VSS.n30 8.501
R1882 VSS.t2939 VSS.n371 0.130189
R1883 VSS.t2937 VSS.n30 8.501
R1884 VSS.t2934 VSS.n370 0.130189
R1885 VSS.t2932 VSS.n30 8.501
R1886 VSS.n369 VSS.t2929 0.130189
R1887 VSS.t2927 VSS.n30 8.501
R1888 VSS.n368 VSS.t2924 0.130189
R1889 VSS.t2919 VSS.n367 0.215686
R1890 VSS.t2917 VSS.n30 8.501
R1891 VSS.n366 VSS.t2914 0.130189
R1892 VSS.t2912 VSS.n30 8.501
R1893 VSS.n365 VSS.t2909 0.130189
R1894 VSS.t2907 VSS.n30 8.501
R1895 VSS.n30 VSS.n364 3.33079
R1896 VSS.t18 VSS.t276 8.501
R1897 VSS.n769 VSS.t18 3.32876
R1898 VSS.t20 VSS.n360 0.801469
R1899 VSS.t136 VSS.n421 0.964792
R1900 VSS.t18 VSS.n422 3.32876
R1901 VSS.t315 VSS.n265 0.0333775
R1902 VSS.n423 VSS.t18 4.20253
R1903 VSS.t320 VSS.t18 8.501
R1904 VSS.n424 VSS.t18 3.32876
R1905 VSS.t325 VSS.t18 8.501
R1906 VSS.n425 VSS.t18 3.32876
R1907 VSS.t330 VSS.t18 8.501
R1908 VSS.n426 VSS.t18 3.32876
R1909 VSS.n427 VSS.t18 0.35896
R1910 VSS.n428 VSS.t18 3.32876
R1911 VSS.t339 VSS.t18 8.501
R1912 VSS.n429 VSS.t30 3.32876
R1913 VSS.t344 VSS.t30 8.501
R1914 VSS.n430 VSS.t30 3.32876
R1915 VSS.t88 VSS.n431 0.835741
R1916 VSS.t30 VSS.n432 3.32876
R1917 VSS.n270 VSS.t352 0.0333775
R1918 VSS.n433 VSS.t30 4.20253
R1919 VSS.t357 VSS.t30 8.501
R1920 VSS.n434 VSS.t30 3.32876
R1921 VSS.t61 VSS.n47 0.179752
R1922 VSS.n125 VSS.n124 0.00966788
R1923 VSS.n127 VSS.n126 0.00966788
R1924 VSS.t61 VSS.n95 0.679262
R1925 VSS.n129 VSS.n128 0.00966788
R1926 VSS.t61 VSS.n96 0.679262
R1927 VSS.n494 VSS.t2513 0.130189
R1928 VSS.t2511 VSS.n3 8.501
R1929 VSS.n493 VSS.t2508 0.130189
R1930 VSS.t2506 VSS.n3 8.501
R1931 VSS.n492 VSS.t2503 0.130189
R1932 VSS.t2501 VSS.n3 8.501
R1933 VSS.n491 VSS.t2498 0.130189
R1934 VSS.t2496 VSS.n3 8.501
R1935 VSS.n490 VSS.t2493 0.130189
R1936 VSS.t2491 VSS.n3 8.501
R1937 VSS.n489 VSS.t2488 0.130189
R1938 VSS.t2486 VSS.n3 8.501
R1939 VSS.n488 VSS.t2483 0.130189
R1940 VSS.t2481 VSS.n338 0.0362711
R1941 VSS.n487 VSS.t2478 0.0793054
R1942 VSS.n3 VSS.t2476 8.501
R1943 VSS.t2473 VSS.n486 0.130189
R1944 VSS.t2471 VSS.n3 8.501
R1945 VSS.t2468 VSS.n485 0.130189
R1946 VSS.t2466 VSS.n3 8.501
R1947 VSS.t2463 VSS.n484 0.130189
R1948 VSS.t2461 VSS.n3 8.501
R1949 VSS.t2458 VSS.n483 0.130189
R1950 VSS.t2456 VSS.n3 8.501
R1951 VSS.t2453 VSS.n482 0.130189
R1952 VSS.t2451 VSS.n3 8.501
R1953 VSS.t2448 VSS.n481 0.130189
R1954 VSS.t2446 VSS.n3 8.501
R1955 VSS.t2443 VSS.n480 0.130189
R1956 VSS.t2441 VSS.n3 8.501
R1957 VSS.t2438 VSS.n479 0.130189
R1958 VSS.t2436 VSS.n3 8.501
R1959 VSS.t2433 VSS.n478 0.130189
R1960 VSS.t2431 VSS.n3 8.501
R1961 VSS.t2428 VSS.n477 0.130189
R1962 VSS.t2426 VSS.n3 8.501
R1963 VSS.t2423 VSS.n476 0.130189
R1964 VSS.t2421 VSS.n3 8.501
R1965 VSS.t2418 VSS.n475 0.130189
R1966 VSS.t2416 VSS.n3 8.501
R1967 VSS.t2413 VSS.n474 0.130189
R1968 VSS.t2411 VSS.n3 8.501
R1969 VSS.t2408 VSS.n473 0.130189
R1970 VSS.t2406 VSS.n339 0.0362711
R1971 VSS.t2403 VSS.n472 0.0793054
R1972 VSS.t2401 VSS.n3 8.501
R1973 VSS.t2398 VSS.n471 0.130189
R1974 VSS.t2396 VSS.n3 8.501
R1975 VSS.t2393 VSS.n470 0.130189
R1976 VSS.t2391 VSS.n3 8.501
R1977 VSS.t2388 VSS.n469 0.130189
R1978 VSS.t2386 VSS.n3 8.501
R1979 VSS.t2383 VSS.n468 0.130189
R1980 VSS.t2381 VSS.n3 8.501
R1981 VSS.t2378 VSS.n467 0.130189
R1982 VSS.t2376 VSS.n3 8.501
R1983 VSS.t2373 VSS.n466 0.130189
R1984 VSS.t2371 VSS.n3 8.501
R1985 VSS.t2368 VSS.n465 0.130189
R1986 VSS.t2366 VSS.n3 8.501
R1987 VSS.t2363 VSS.n464 0.130189
R1988 VSS.t2361 VSS.n3 8.501
R1989 VSS.t2358 VSS.n463 0.130189
R1990 VSS.t2356 VSS.n3 8.501
R1991 VSS.t2353 VSS.n462 0.130189
R1992 VSS.t2351 VSS.n3 8.501
R1993 VSS.t2348 VSS.n461 0.130189
R1994 VSS.t2346 VSS.n3 8.501
R1995 VSS.t2343 VSS.n460 0.130189
R1996 VSS.t2341 VSS.n3 8.501
R1997 VSS.t2338 VSS.n459 0.130189
R1998 VSS.t2336 VSS.n3 8.501
R1999 VSS.t2333 VSS.n458 0.130189
R2000 VSS.t2328 VSS.n457 0.130189
R2001 VSS.t2326 VSS.n3 8.501
R2002 VSS.t2323 VSS.n456 0.130189
R2003 VSS.t2321 VSS.n3 8.501
R2004 VSS.t2318 VSS.n455 0.130189
R2005 VSS.t2316 VSS.n3 8.501
R2006 VSS.t2313 VSS.n454 0.130189
R2007 VSS.t2311 VSS.n3 8.501
R2008 VSS.t2308 VSS.n453 0.130189
R2009 VSS.t2306 VSS.n3 8.501
R2010 VSS.t2303 VSS.n452 0.130189
R2011 VSS.t2301 VSS.n3 8.501
R2012 VSS.t2298 VSS.n451 0.130189
R2013 VSS.t2296 VSS.n3 8.501
R2014 VSS.t2293 VSS.n450 0.130189
R2015 VSS.t2291 VSS.n3 8.501
R2016 VSS.t2288 VSS.n449 0.130189
R2017 VSS.t2286 VSS.n3 8.501
R2018 VSS.t2283 VSS.n448 0.130189
R2019 VSS.t2281 VSS.n3 8.501
R2020 VSS.t2278 VSS.n447 0.130189
R2021 VSS.t2276 VSS.n3 8.501
R2022 VSS.t2273 VSS.n446 0.130189
R2023 VSS.t2271 VSS.n3 8.501
R2024 VSS.t2268 VSS.n445 0.130189
R2025 VSS.t2266 VSS.n3 8.501
R2026 VSS.t2263 VSS.n444 0.130189
R2027 VSS.t2261 VSS.n3 8.501
R2028 VSS.t2258 VSS.n443 0.130189
R2029 VSS.t2256 VSS.n3 8.501
R2030 VSS.t2253 VSS.n442 0.130189
R2031 VSS.t2251 VSS.n3 8.501
R2032 VSS.t2248 VSS.n441 0.130189
R2033 VSS.t2246 VSS.n3 8.501
R2034 VSS.t2243 VSS.n440 0.130189
R2035 VSS.t2241 VSS.n3 8.501
R2036 VSS.n439 VSS.n3 3.33079
R2037 VSS.n551 VSS.t2121 0.130189
R2038 VSS.t2119 VSS.n2 8.501
R2039 VSS.n550 VSS.t2116 0.130189
R2040 VSS.t2114 VSS.n2 8.501
R2041 VSS.n549 VSS.t2111 0.130189
R2042 VSS.t2109 VSS.n2 8.501
R2043 VSS.n548 VSS.t2106 0.130189
R2044 VSS.t2104 VSS.n2 8.501
R2045 VSS.n547 VSS.t2101 0.130189
R2046 VSS.t2099 VSS.n2 8.501
R2047 VSS.n546 VSS.t2096 0.130189
R2048 VSS.t2094 VSS.n2 8.501
R2049 VSS.n545 VSS.t2091 0.130189
R2050 VSS.t2089 VSS.n336 0.0362711
R2051 VSS.n544 VSS.t2086 0.0793054
R2052 VSS.t2084 VSS.n2 8.501
R2053 VSS.n543 VSS.t2081 0.130189
R2054 VSS.t2079 VSS.n2 8.501
R2055 VSS.n542 VSS.t2076 0.130189
R2056 VSS.t2074 VSS.n2 8.501
R2057 VSS.n541 VSS.t2071 0.130189
R2058 VSS.t2069 VSS.n2 8.501
R2059 VSS.n540 VSS.t2066 0.130189
R2060 VSS.t2064 VSS.n2 8.501
R2061 VSS.n539 VSS.t2061 0.130189
R2062 VSS.t2059 VSS.n2 8.501
R2063 VSS.n538 VSS.t2056 0.130189
R2064 VSS.t2054 VSS.n2 8.501
R2065 VSS.n537 VSS.t2051 0.130189
R2066 VSS.t2049 VSS.n2 8.501
R2067 VSS.n536 VSS.t2046 0.130189
R2068 VSS.t2044 VSS.n2 8.501
R2069 VSS.n535 VSS.t2041 0.130189
R2070 VSS.t2039 VSS.n2 8.501
R2071 VSS.n534 VSS.t2036 0.130189
R2072 VSS.t2034 VSS.n2 8.501
R2073 VSS.n533 VSS.t2031 0.130189
R2074 VSS.t2029 VSS.n2 8.501
R2075 VSS.n532 VSS.t2026 0.130189
R2076 VSS.t2024 VSS.n2 8.501
R2077 VSS.n531 VSS.t2021 0.130189
R2078 VSS.t2019 VSS.n2 8.501
R2079 VSS.n530 VSS.t2016 0.130189
R2080 VSS.t2014 VSS.n337 0.0362711
R2081 VSS.n529 VSS.t2011 0.0793054
R2082 VSS.n2 VSS.t2009 8.501
R2083 VSS.n528 VSS.t2006 0.130189
R2084 VSS.t2004 VSS.n2 8.501
R2085 VSS.n527 VSS.t2001 0.130189
R2086 VSS.t1999 VSS.n2 8.501
R2087 VSS.n526 VSS.t1996 0.130189
R2088 VSS.t1994 VSS.n2 8.501
R2089 VSS.n525 VSS.t1991 0.130189
R2090 VSS.t1989 VSS.n2 8.501
R2091 VSS.n524 VSS.t1986 0.130189
R2092 VSS.t1984 VSS.n2 8.501
R2093 VSS.n523 VSS.t1981 0.130189
R2094 VSS.t1979 VSS.n2 8.501
R2095 VSS.n522 VSS.t1976 0.130189
R2096 VSS.t1974 VSS.n2 8.501
R2097 VSS.n521 VSS.t1971 0.130189
R2098 VSS.t1969 VSS.n2 8.501
R2099 VSS.n520 VSS.t1966 0.130189
R2100 VSS.t1964 VSS.n2 8.501
R2101 VSS.n519 VSS.t1961 0.130189
R2102 VSS.t1959 VSS.n2 8.501
R2103 VSS.n518 VSS.t1956 0.130189
R2104 VSS.t1954 VSS.n2 8.501
R2105 VSS.n517 VSS.t1951 0.130189
R2106 VSS.t1949 VSS.n2 8.501
R2107 VSS.n516 VSS.t1946 0.130189
R2108 VSS.t1944 VSS.n2 8.501
R2109 VSS.n515 VSS.t1941 0.130189
R2110 VSS.n514 VSS.t1936 0.130189
R2111 VSS.t1934 VSS.n2 8.501
R2112 VSS.n513 VSS.t1931 0.130189
R2113 VSS.t1929 VSS.n2 8.501
R2114 VSS.n512 VSS.t1926 0.130189
R2115 VSS.t1924 VSS.n2 8.501
R2116 VSS.n511 VSS.t1921 0.130189
R2117 VSS.t1919 VSS.n2 8.501
R2118 VSS.n510 VSS.t1916 0.130189
R2119 VSS.t1914 VSS.n2 8.501
R2120 VSS.n509 VSS.t1911 0.130189
R2121 VSS.t1909 VSS.n2 8.501
R2122 VSS.n508 VSS.t1906 0.130189
R2123 VSS.t1904 VSS.n2 8.501
R2124 VSS.n507 VSS.t1901 0.130189
R2125 VSS.t1899 VSS.n2 8.501
R2126 VSS.n506 VSS.t1896 0.130189
R2127 VSS.t1894 VSS.n2 8.501
R2128 VSS.n505 VSS.t1891 0.130189
R2129 VSS.t1889 VSS.n2 8.501
R2130 VSS.n504 VSS.t1886 0.130189
R2131 VSS.t1884 VSS.n2 8.501
R2132 VSS.n503 VSS.t1881 0.130189
R2133 VSS.t1879 VSS.n2 8.501
R2134 VSS.n502 VSS.t1876 0.130189
R2135 VSS.t1874 VSS.n2 8.501
R2136 VSS.n501 VSS.t1871 0.130189
R2137 VSS.t1869 VSS.n2 8.501
R2138 VSS.n500 VSS.t1866 0.130189
R2139 VSS.t1864 VSS.n2 8.501
R2140 VSS.t1861 VSS.n499 0.130189
R2141 VSS.t1859 VSS.n2 8.501
R2142 VSS.t1856 VSS.n498 0.130189
R2143 VSS.t1854 VSS.n2 8.501
R2144 VSS.t1851 VSS.n497 0.130189
R2145 VSS.t1849 VSS.n2 8.501
R2146 VSS.n496 VSS.n2 3.33079
R2147 VSS.n608 VSS.t1729 0.130189
R2148 VSS.t1727 VSS.n1 8.501
R2149 VSS.n607 VSS.t1724 0.130189
R2150 VSS.t1722 VSS.n1 8.501
R2151 VSS.n606 VSS.t1719 0.130189
R2152 VSS.t1717 VSS.n1 8.501
R2153 VSS.n605 VSS.t1714 0.130189
R2154 VSS.t1712 VSS.n1 8.501
R2155 VSS.n604 VSS.t1709 0.130189
R2156 VSS.t1707 VSS.n1 8.501
R2157 VSS.n603 VSS.t1704 0.130189
R2158 VSS.t1702 VSS.n1 8.501
R2159 VSS.n602 VSS.t1699 0.130189
R2160 VSS.t1697 VSS.n334 0.0362711
R2161 VSS.n601 VSS.t1694 0.0793054
R2162 VSS.n1 VSS.t1692 8.501
R2163 VSS.t1689 VSS.n600 0.130189
R2164 VSS.t1687 VSS.n1 8.501
R2165 VSS.t1684 VSS.n599 0.130189
R2166 VSS.t1682 VSS.n1 8.501
R2167 VSS.t1679 VSS.n598 0.130189
R2168 VSS.t1677 VSS.n1 8.501
R2169 VSS.t1674 VSS.n597 0.130189
R2170 VSS.t1672 VSS.n1 8.501
R2171 VSS.t1669 VSS.n596 0.130189
R2172 VSS.t1667 VSS.n1 8.501
R2173 VSS.t1664 VSS.n595 0.130189
R2174 VSS.t1662 VSS.n1 8.501
R2175 VSS.t1659 VSS.n594 0.130189
R2176 VSS.t1657 VSS.n1 8.501
R2177 VSS.t1654 VSS.n593 0.130189
R2178 VSS.t1652 VSS.n1 8.501
R2179 VSS.t1649 VSS.n592 0.130189
R2180 VSS.t1647 VSS.n1 8.501
R2181 VSS.t1644 VSS.n591 0.130189
R2182 VSS.t1642 VSS.n1 8.501
R2183 VSS.t1639 VSS.n590 0.130189
R2184 VSS.t1637 VSS.n1 8.501
R2185 VSS.t1634 VSS.n589 0.130189
R2186 VSS.t1632 VSS.n1 8.501
R2187 VSS.t1629 VSS.n588 0.130189
R2188 VSS.t1627 VSS.n1 8.501
R2189 VSS.t1624 VSS.n587 0.130189
R2190 VSS.t1622 VSS.n335 0.0362711
R2191 VSS.n586 VSS.t1619 0.0793054
R2192 VSS.t1617 VSS.n1 8.501
R2193 VSS.n585 VSS.t1614 0.130189
R2194 VSS.t1612 VSS.n1 8.501
R2195 VSS.n584 VSS.t1609 0.130189
R2196 VSS.t1607 VSS.n1 8.501
R2197 VSS.n583 VSS.t1604 0.130189
R2198 VSS.t1602 VSS.n1 8.501
R2199 VSS.n582 VSS.t1599 0.130189
R2200 VSS.t1597 VSS.n1 8.501
R2201 VSS.n581 VSS.t1594 0.130189
R2202 VSS.t1592 VSS.n1 8.501
R2203 VSS.n580 VSS.t1589 0.130189
R2204 VSS.t1587 VSS.n1 8.501
R2205 VSS.n579 VSS.t1584 0.130189
R2206 VSS.t1582 VSS.n1 8.501
R2207 VSS.n578 VSS.t1579 0.130189
R2208 VSS.t1577 VSS.n1 8.501
R2209 VSS.n577 VSS.t1574 0.130189
R2210 VSS.t1572 VSS.n1 8.501
R2211 VSS.n576 VSS.t1569 0.130189
R2212 VSS.t1567 VSS.n1 8.501
R2213 VSS.n575 VSS.t1564 0.130189
R2214 VSS.t1562 VSS.n1 8.501
R2215 VSS.n574 VSS.t1559 0.130189
R2216 VSS.t1557 VSS.n1 8.501
R2217 VSS.n573 VSS.t1554 0.130189
R2218 VSS.t1552 VSS.n1 8.501
R2219 VSS.n572 VSS.t1549 0.130189
R2220 VSS.n571 VSS.t1544 0.130189
R2221 VSS.t1542 VSS.n1 8.501
R2222 VSS.t1539 VSS.n570 0.130189
R2223 VSS.t1537 VSS.n1 8.501
R2224 VSS.t1534 VSS.n569 0.130189
R2225 VSS.t1532 VSS.n1 8.501
R2226 VSS.t1529 VSS.n568 0.130189
R2227 VSS.t1527 VSS.n1 8.501
R2228 VSS.t1524 VSS.n567 0.130189
R2229 VSS.t1522 VSS.n1 8.501
R2230 VSS.t1519 VSS.n566 0.130189
R2231 VSS.t1517 VSS.n1 8.501
R2232 VSS.t1514 VSS.n565 0.130189
R2233 VSS.t1512 VSS.n1 8.501
R2234 VSS.t1509 VSS.n564 0.130189
R2235 VSS.t1507 VSS.n1 8.501
R2236 VSS.t1504 VSS.n563 0.130189
R2237 VSS.t1502 VSS.n1 8.501
R2238 VSS.t1499 VSS.n562 0.130189
R2239 VSS.t1497 VSS.n1 8.501
R2240 VSS.t1494 VSS.n561 0.130189
R2241 VSS.t1492 VSS.n1 8.501
R2242 VSS.t1489 VSS.n560 0.130189
R2243 VSS.t1487 VSS.n1 8.501
R2244 VSS.t1484 VSS.n559 0.130189
R2245 VSS.t1482 VSS.n1 8.501
R2246 VSS.t1479 VSS.n558 0.130189
R2247 VSS.t1477 VSS.n1 8.501
R2248 VSS.t1474 VSS.n557 0.130189
R2249 VSS.t1472 VSS.n1 8.501
R2250 VSS.t1469 VSS.n556 0.130189
R2251 VSS.t1467 VSS.n1 8.501
R2252 VSS.t1464 VSS.n555 0.130189
R2253 VSS.t1462 VSS.n1 8.501
R2254 VSS.t1459 VSS.n554 0.130189
R2255 VSS.t1457 VSS.n1 8.501
R2256 VSS.n553 VSS.n1 3.33079
R2257 VSS.n697 VSS.t1050 0.130189
R2258 VSS.t1048 VSS.n0 8.501
R2259 VSS.n696 VSS.t1045 0.130189
R2260 VSS.t1043 VSS.n0 8.501
R2261 VSS.n695 VSS.t1040 0.130189
R2262 VSS.t1038 VSS.n0 8.501
R2263 VSS.n694 VSS.t1035 0.130189
R2264 VSS.t1033 VSS.n0 8.501
R2265 VSS.n693 VSS.t1030 0.130189
R2266 VSS.t1028 VSS.n0 8.501
R2267 VSS.n692 VSS.t1025 0.130189
R2268 VSS.t1023 VSS.n0 8.501
R2269 VSS.n691 VSS.t1020 0.130189
R2270 VSS.t1018 VSS.n312 0.0362711
R2271 VSS.n690 VSS.t1015 0.0793054
R2272 VSS.n0 VSS.t1013 8.501
R2273 VSS.t1010 VSS.n689 0.130189
R2274 VSS.t1008 VSS.n0 8.501
R2275 VSS.t1005 VSS.n688 0.130189
R2276 VSS.t1003 VSS.n0 8.501
R2277 VSS.t1000 VSS.n687 0.130189
R2278 VSS.t998 VSS.n0 8.501
R2279 VSS.t995 VSS.n686 0.130189
R2280 VSS.t993 VSS.n0 8.501
R2281 VSS.t990 VSS.n685 0.130189
R2282 VSS.t988 VSS.n0 8.501
R2283 VSS.t985 VSS.n684 0.130189
R2284 VSS.t983 VSS.n0 8.501
R2285 VSS.t980 VSS.n683 0.130189
R2286 VSS.t978 VSS.n0 8.501
R2287 VSS.t975 VSS.n682 0.130189
R2288 VSS.t973 VSS.n0 8.501
R2289 VSS.t970 VSS.n681 0.130189
R2290 VSS.t968 VSS.n0 8.501
R2291 VSS.t965 VSS.n680 0.130189
R2292 VSS.t963 VSS.n0 8.501
R2293 VSS.t960 VSS.n679 0.130189
R2294 VSS.t958 VSS.n0 8.501
R2295 VSS.t955 VSS.n678 0.130189
R2296 VSS.t953 VSS.n0 8.501
R2297 VSS.t950 VSS.n677 0.130189
R2298 VSS.t948 VSS.n0 8.501
R2299 VSS.t945 VSS.n676 0.130189
R2300 VSS.t943 VSS.n313 0.0362711
R2301 VSS.t940 VSS.n675 0.0793054
R2302 VSS.t938 VSS.n0 8.501
R2303 VSS.t935 VSS.n674 0.130189
R2304 VSS.t933 VSS.n0 8.501
R2305 VSS.t930 VSS.n673 0.130189
R2306 VSS.t928 VSS.n0 8.501
R2307 VSS.t925 VSS.n672 0.130189
R2308 VSS.t923 VSS.n0 8.501
R2309 VSS.t920 VSS.n671 0.130189
R2310 VSS.t918 VSS.n0 8.501
R2311 VSS.t915 VSS.n670 0.130189
R2312 VSS.t913 VSS.n0 8.501
R2313 VSS.t910 VSS.n669 0.130189
R2314 VSS.t908 VSS.n0 8.501
R2315 VSS.t905 VSS.n668 0.130189
R2316 VSS.t903 VSS.n0 8.501
R2317 VSS.t900 VSS.n667 0.130189
R2318 VSS.t898 VSS.n0 8.501
R2319 VSS.t895 VSS.n666 0.130189
R2320 VSS.t893 VSS.n0 8.501
R2321 VSS.t890 VSS.n665 0.130189
R2322 VSS.t888 VSS.n0 8.501
R2323 VSS.t885 VSS.n664 0.130189
R2324 VSS.t883 VSS.n0 8.501
R2325 VSS.t880 VSS.n663 0.130189
R2326 VSS.t878 VSS.n0 8.501
R2327 VSS.t875 VSS.n662 0.130189
R2328 VSS.t873 VSS.n0 8.501
R2329 VSS.t870 VSS.n661 0.130189
R2330 VSS.t865 VSS.n660 0.130189
R2331 VSS.t863 VSS.n0 8.501
R2332 VSS.t860 VSS.n659 0.130189
R2333 VSS.t858 VSS.n0 8.501
R2334 VSS.t855 VSS.n658 0.130189
R2335 VSS.t853 VSS.n0 8.501
R2336 VSS.t850 VSS.n657 0.130189
R2337 VSS.t848 VSS.n0 8.501
R2338 VSS.t845 VSS.n656 0.130189
R2339 VSS.t843 VSS.n0 8.501
R2340 VSS.t840 VSS.n655 0.130189
R2341 VSS.t838 VSS.n0 8.501
R2342 VSS.t835 VSS.n654 0.130189
R2343 VSS.t833 VSS.n0 8.501
R2344 VSS.t830 VSS.n653 0.130189
R2345 VSS.t828 VSS.n0 8.501
R2346 VSS.t825 VSS.n652 0.130189
R2347 VSS.t823 VSS.n0 8.501
R2348 VSS.t820 VSS.n651 0.130189
R2349 VSS.t818 VSS.n0 8.501
R2350 VSS.t815 VSS.n650 0.130189
R2351 VSS.t813 VSS.n0 8.501
R2352 VSS.t810 VSS.n649 0.130189
R2353 VSS.t808 VSS.n0 8.501
R2354 VSS.t805 VSS.n648 0.130189
R2355 VSS.t803 VSS.n0 8.501
R2356 VSS.t800 VSS.n647 0.130189
R2357 VSS.t798 VSS.n0 8.501
R2358 VSS.t795 VSS.n646 0.130189
R2359 VSS.t793 VSS.n0 8.501
R2360 VSS.t790 VSS.n645 0.130189
R2361 VSS.t788 VSS.n0 8.501
R2362 VSS.t785 VSS.n644 0.130189
R2363 VSS.t783 VSS.n0 8.501
R2364 VSS.t780 VSS.n643 0.130189
R2365 VSS.t778 VSS.n0 8.501
R2366 VSS.n642 VSS.n0 3.33079
R2367 VSS.t697 VSS.n711 0.0333775
R2368 VSS.t695 VSS.t92 8.501
R2369 VSS.t79 VSS.n710 0.129991
R2370 VSS.t691 VSS.t92 8.501
R2371 VSS.t585 VSS.n709 0.123414
R2372 VSS.t582 VSS.t92 8.501
R2373 VSS.t579 VSS.n708 0.130189
R2374 VSS.t577 VSS.t92 8.501
R2375 VSS.n707 VSS.t574 0.130189
R2376 VSS.n706 VSS.t569 0.130189
R2377 VSS.t567 VSS.t512 8.501
R2378 VSS.t564 VSS.n705 0.130189
R2379 VSS.t562 VSS.t512 8.501
R2380 VSS.t559 VSS.n704 0.130189
R2381 VSS.t557 VSS.t512 8.501
R2382 VSS.t554 VSS.n703 0.130189
R2383 VSS.t552 VSS.t512 8.501
R2384 VSS.t549 VSS.n702 0.130189
R2385 VSS.t547 VSS.t512 8.501
R2386 VSS.t544 VSS.n701 0.130189
R2387 VSS.t542 VSS.t512 8.501
R2388 VSS.t539 VSS.n700 0.130189
R2389 VSS.t537 VSS.t512 8.501
R2390 VSS.t534 VSS.n699 0.130189
R2391 VSS.t142 VSS.n311 0.330919
R2392 VSS.n311 VSS.t512 1.74963
R2393 VSS.t530 VSS.n698 0.235729
R2394 VSS.t81 VSS.n713 0.581374
R2395 VSS.t701 VSS.n712 0.130189
R2396 VSS.n295 VSS.t699 0.0836055
R2397 VSS.n172 VSS.t197 1.74964
R2398 VSS.t207 VSS.n172 0.331253
R2399 VSS.t601 VSS.n718 0.235729
R2400 VSS.t596 VSS.n717 0.182614
R2401 VSS.t593 VSS.n716 0.235729
R2402 VSS.t591 VSS.n715 0.235729
R2403 VSS.t172 VSS.n714 0.129991
R2404 VSS.n274 VSS.t197 0.991884
R2405 VSS.t603 VSS.t197 8.501
R2406 VSS.t735 VSS.n721 0.130189
R2407 VSS.t733 VSS.t197 8.501
R2408 VSS.n720 VSS.t729 0.130189
R2409 VSS.t157 VSS.n719 0.652244
R2410 VSS.t648 VSS.n738 0.096752
R2411 VSS.t645 VSS.n737 0.235729
R2412 VSS.t642 VSS.n736 0.235729
R2413 VSS.t639 VSS.n735 0.235729
R2414 VSS.t636 VSS.n734 0.235729
R2415 VSS.t633 VSS.n733 0.235729
R2416 VSS.t630 VSS.n732 0.235729
R2417 VSS.t627 VSS.n731 0.235729
R2418 VSS.t624 VSS.n730 0.235729
R2419 VSS.t621 VSS.n729 0.235729
R2420 VSS.t618 VSS.n728 0.235729
R2421 VSS.t615 VSS.n727 0.235729
R2422 VSS.t612 VSS.n726 0.235729
R2423 VSS.t609 VSS.n725 0.235729
R2424 VSS.t606 VSS.n724 0.235729
R2425 VSS.t8 VSS.n723 0.235729
R2426 VSS.t197 VSS.n722 2.31576
R2427 VSS.t738 VSS.t197 8.501
R2428 VSS.t187 VSS.n296 0.0432886
R2429 VSS.n296 VSS.t15 4.23011
R2430 VSS.n44 VSS.t15 0.526883
R2431 VSS.n739 VSS.t15 0.99289
R2432 VSS.t16 VSS.t15 0.737579
R2433 VSS.n244 VSS.t15 2.31665
R2434 VSS.t15 VSS.t409 8.501
R2435 VSS.t15 VSS.t56 0.429154
R2436 VSS.t455 VSS.n761 0.096752
R2437 VSS.t15 VSS.t454 8.501
R2438 VSS.t452 VSS.n760 0.130189
R2439 VSS.t15 VSS.t451 8.501
R2440 VSS.t449 VSS.n759 0.130189
R2441 VSS.t15 VSS.t448 8.501
R2442 VSS.t446 VSS.n758 0.130189
R2443 VSS.t15 VSS.t445 8.501
R2444 VSS.t443 VSS.n757 0.130189
R2445 VSS.t15 VSS.t442 8.501
R2446 VSS.t440 VSS.n756 0.130189
R2447 VSS.t15 VSS.t439 8.501
R2448 VSS.t437 VSS.n755 0.130189
R2449 VSS.t15 VSS.t436 8.501
R2450 VSS.t434 VSS.n754 0.130189
R2451 VSS.t15 VSS.t433 8.501
R2452 VSS.t431 VSS.n753 0.130189
R2453 VSS.t15 VSS.t430 8.501
R2454 VSS.t428 VSS.n752 0.130189
R2455 VSS.t15 VSS.t427 8.501
R2456 VSS.t425 VSS.n751 0.130189
R2457 VSS.t15 VSS.t424 8.501
R2458 VSS.t422 VSS.n750 0.130189
R2459 VSS.t15 VSS.t421 8.501
R2460 VSS.t419 VSS.n749 0.130189
R2461 VSS.t15 VSS.t418 8.501
R2462 VSS.t416 VSS.n748 0.130189
R2463 VSS.t15 VSS.t415 8.501
R2464 VSS.n747 VSS.t413 0.130189
R2465 VSS.t412 VSS.t15 8.501
R2466 VSS.n746 VSS.t32 0.130189
R2467 VSS.n764 VSS.t470 0.130189
R2468 VSS.t98 VSS.t15 8.501
R2469 VSS.n763 VSS.t53 0.130189
R2470 VSS.n762 VSS.t15 0.574293
R2471 VSS.t462 VSS.n28 0.19172
R2472 VSS.n768 VSS.t15 3.33079
R2473 VSS.t11 VSS.n767 0.570079
R2474 VSS.t399 VSS.t15 8.501
R2475 VSS.n766 VSS.t15 3.33079
R2476 VSS.t2331 VSS.n3 8.5005
R2477 VSS.n2 VSS.t1939 8.5005
R2478 VSS.n1 VSS.t1547 8.5005
R2479 VSS.t868 VSS.n0 8.5005
R2480 VSS.t512 VSS.t572 8.5005
R2481 VSS.t772 VSS.n281 8.00267
R2482 VSS.n412 VSS.n30 4.20468
R2483 VSS.n397 VSS.n30 4.20468
R2484 VSS.t316 VSS.n423 0.173604
R2485 VSS.n433 VSS.t353 0.153604
R2486 VSS.n435 VSS.t2771 0.17801
R2487 VSS.n97 VSS.n436 3.30696
R2488 VSS.t2892 VSS.n342 0.17801
R2489 VSS.n341 VSS.t2779 0.17801
R2490 VSS.n97 VSS.n437 3.30696
R2491 VSS.t2899 VSS.n340 0.17801
R2492 VSS.n215 VSS.n293 3.30688
R2493 VSS.n216 VSS.t2789 0.149187
R2494 VSS.t2766 VSS.n294 0.177814
R2495 VSS.t2764 VSS.n343 0.177814
R2496 VSS.t2758 VSS.n292 0.177814
R2497 VSS.t2753 VSS.n344 0.17801
R2498 VSS.t2747 VSS.n345 0.17801
R2499 VSS.t2741 VSS.n291 0.17801
R2500 VSS.t2726 VSS.n126 8.47111
R2501 VSS.t2720 VSS.n346 0.177814
R2502 VSS.t2714 VSS.n290 0.177814
R2503 VSS.t2709 VSS.n347 0.177814
R2504 VSS.t2703 VSS.n348 0.177814
R2505 VSS.t2697 VSS.n289 0.177814
R2506 VSS.t2692 VSS.n349 0.17801
R2507 VSS.t2686 VSS.n288 0.17801
R2508 VSS.t2682 VSS.n350 0.0605362
R2509 VSS.t2680 VSS.n105 8.47111
R2510 VSS.t2676 VSS.n351 0.177814
R2511 VSS.t2671 VSS.n287 0.177814
R2512 VSS.n352 VSS.t2667 0.177814
R2513 VSS.n353 VSS.t2661 0.177814
R2514 VSS.n286 VSS.t2655 0.177814
R2515 VSS.n354 VSS.t2650 0.17801
R2516 VSS.n285 VSS.t2647 0.177814
R2517 VSS.t2645 VSS.n355 0.177814
R2518 VSS.n42 VSS.n284 3.30688
R2519 VSS.t2637 VSS.n283 0.17801
R2520 VSS.n356 VSS.t2633 0.177814
R2521 VSS.n487 VSS.n3 4.20468
R2522 VSS.n3 VSS.n472 4.20468
R2523 VSS.n544 VSS.n2 4.20468
R2524 VSS.n529 VSS.n2 4.20468
R2525 VSS.n601 VSS.n1 4.20468
R2526 VSS.n586 VSS.n1 4.20468
R2527 VSS.t1222 VSS.n609 0.17801
R2528 VSS.n610 VSS.t70 3.30688
R2529 VSS.t1224 VSS.t70 8.47111
R2530 VSS.n611 VSS.t70 3.30688
R2531 VSS.t1227 VSS.t70 8.47111
R2532 VSS.n322 VSS.t70 3.30696
R2533 VSS.n321 VSS.t70 3.30688
R2534 VSS.t1234 VSS.t70 8.47111
R2535 VSS.t1235 VSS.n235 0.119605
R2536 VSS.t1237 VSS.n612 0.17801
R2537 VSS.n235 VSS.t70 4.177
R2538 VSS.n320 VSS.t70 3.30696
R2539 VSS.t1242 VSS.n613 0.119605
R2540 VSS.n613 VSS.t70 4.177
R2541 VSS.n236 VSS.t70 3.30688
R2542 VSS.t1246 VSS.n614 0.119605
R2543 VSS.n614 VSS.t70 4.177
R2544 VSS.n319 VSS.t70 4.177
R2545 VSS.t1250 VSS.n319 0.119605
R2546 VSS.n318 VSS.t70 4.177
R2547 VSS.t1254 VSS.n318 0.119605
R2548 VSS.t1259 VSS.n123 0.119605
R2549 VSS.t1261 VSS.n615 0.17801
R2550 VSS.n123 VSS.t70 4.177
R2551 VSS.n616 VSS.t70 3.30688
R2552 VSS.t1263 VSS.t70 8.47111
R2553 VSS.n617 VSS.t70 3.30688
R2554 VSS.t70 VSS.t1266 8.47111
R2555 VSS.n618 VSS.t70 4.177
R2556 VSS.t70 VSS.t1268 8.47111
R2557 VSS.t1269 VSS.n618 0.119605
R2558 VSS.t1270 VSS.t70 8.47111
R2559 VSS.t70 VSS.n619 4.177
R2560 VSS.n619 VSS.t1272 0.119605
R2561 VSS.n620 VSS.t1273 0.119605
R2562 VSS.t1408 VSS.t70 8.47111
R2563 VSS.t70 VSS.n620 4.177
R2564 VSS.n621 VSS.t70 3.30688
R2565 VSS.t1411 VSS.t70 8.47111
R2566 VSS.t1278 VSS.n622 0.119605
R2567 VSS.n622 VSS.t70 4.177
R2568 VSS.t1281 VSS.n623 0.17801
R2569 VSS.t1416 VSS.n317 0.119605
R2570 VSS.n317 VSS.t70 4.177
R2571 VSS.t1285 VSS.t70 8.47111
R2572 VSS.n624 VSS.t1286 0.119605
R2573 VSS.t70 VSS.n624 4.177
R2574 VSS.t70 VSS.n237 3.30688
R2575 VSS.n625 VSS.t1290 0.119605
R2576 VSS.t70 VSS.n625 4.177
R2577 VSS.t70 VSS.n316 4.177
R2578 VSS.n316 VSS.t1294 0.119605
R2579 VSS.t70 VSS.n315 3.30688
R2580 VSS.t70 VSS.t1297 8.47111
R2581 VSS.n238 VSS.t70 4.177
R2582 VSS.n238 VSS.t1298 0.119605
R2583 VSS.t1299 VSS.n626 0.17801
R2584 VSS.t1430 VSS.t70 8.47111
R2585 VSS.n627 VSS.t70 3.30688
R2586 VSS.t1433 VSS.t70 8.47111
R2587 VSS.n628 VSS.t70 3.30688
R2588 VSS.t1436 VSS.t70 8.47111
R2589 VSS.n629 VSS.t70 5.61485
R2590 VSS.n227 VSS.t70 4.177
R2591 VSS.n227 VSS.t1438 0.119605
R2592 VSS.n630 VSS.t70 3.30688
R2593 VSS.n631 VSS.t1316 0.119605
R2594 VSS.t70 VSS.n631 4.177
R2595 VSS.t70 VSS.n239 3.30688
R2596 VSS.n632 VSS.t1320 0.119605
R2597 VSS.t70 VSS.n632 4.177
R2598 VSS.t70 VSS.n314 4.177
R2599 VSS.n314 VSS.t1324 0.119605
R2600 VSS.t1451 VSS.n249 0.17801
R2601 VSS.n633 VSS.t70 4.177
R2602 VSS.n633 VSS.t1219 0.119605
R2603 VSS.t70 VSS.n240 4.177
R2604 VSS.n240 VSS.t1217 0.119605
R2605 VSS.t70 VSS.n634 4.177
R2606 VSS.n634 VSS.t1214 0.119605
R2607 VSS.t70 VSS.n635 4.177
R2608 VSS.n635 VSS.t1211 0.119605
R2609 VSS.t70 VSS.n241 4.177
R2610 VSS.t1209 VSS.n241 0.119605
R2611 VSS.n165 VSS.t70 4.177
R2612 VSS.t1207 VSS.n165 0.119605
R2613 VSS.n636 VSS.t70 4.177
R2614 VSS.t1356 VSS.n636 0.119605
R2615 VSS.t70 VSS.n242 4.177
R2616 VSS.n242 VSS.t1203 0.119605
R2617 VSS.t70 VSS.n166 4.177
R2618 VSS.n166 VSS.t1201 0.119605
R2619 VSS.n323 VSS.t1199 0.17801
R2620 VSS.n324 VSS.t1197 0.177814
R2621 VSS.n325 VSS.t1195 0.119605
R2622 VSS.t70 VSS.n325 4.177
R2623 VSS.t70 VSS.n637 4.177
R2624 VSS.n637 VSS.t1192 0.119605
R2625 VSS.n326 VSS.t1190 0.17801
R2626 VSS.n327 VSS.t1188 0.177814
R2627 VSS.n328 VSS.t1186 0.119605
R2628 VSS.t70 VSS.n328 4.177
R2629 VSS.t70 VSS.n638 4.177
R2630 VSS.n638 VSS.t1183 0.119605
R2631 VSS.n329 VSS.t1181 0.17801
R2632 VSS.n330 VSS.t1179 0.177814
R2633 VSS.t1337 VSS.n331 0.119605
R2634 VSS.n331 VSS.t70 4.177
R2635 VSS.n639 VSS.t70 4.177
R2636 VSS.t1174 VSS.n639 0.119605
R2637 VSS.t1172 VSS.n332 0.177814
R2638 VSS.t1170 VSS.n333 0.177814
R2639 VSS.t1168 VSS.t70 8.47111
R2640 VSS.t1167 VSS.n640 0.10425
R2641 VSS.n690 VSS.n0 4.20468
R2642 VSS.n0 VSS.n675 4.20468
R2643 VSS.n295 VSS.t92 4.20253
R2644 VSS.t512 VSS.n830 8.47111
R2645 VSS.n740 VSS.t15 4.177
R2646 VSS.t43 VSS.n740 0.119605
R2647 VSS.t43 VSS.n741 1.12296
R2648 VSS.n742 VSS.t15 3.30688
R2649 VSS.n743 VSS.t15 4.177
R2650 VSS.t60 VSS.n743 0.119605
R2651 VSS.t67 VSS.n744 0.119605
R2652 VSS.n744 VSS.t15 4.177
R2653 VSS.t15 VSS.n233 4.177
R2654 VSS.t15 VSS.n745 5.61485
R2655 VSS.n247 VSS.t66 0.177814
R2656 VSS.n38 VSS.t15 1.97627
R2657 VSS.n974 VSS.n233 0.289894
R2658 VSS.n904 VSS.t269 8.06935
R2659 VSS.t91 VSS.t696 7.1604
R2660 VSS.t178 VSS.t90 7.1604
R2661 VSS.n47 VSS.n97 0.0146344
R2662 VSS.t61 VSS.n125 0.433294
R2663 VSS.t61 VSS.n127 0.433294
R2664 VSS.t61 VSS.n129 0.433294
R2665 VSS.t61 VSS.n40 0.104501
R2666 VSS.n40 VSS.n39 0.0209008
R2667 VSS.n39 VSS.n42 0.0209724
R2668 VSS.t197 VSS.n738 3.35999
R2669 VSS.n216 VSS.n215 3.32902
R2670 VSS.n419 VSS.n30 3.33079
R2671 VSS.n30 VSS.n418 3.33079
R2672 VSS.n417 VSS.n30 3.33079
R2673 VSS.n30 VSS.n416 3.33079
R2674 VSS.n415 VSS.n30 3.33079
R2675 VSS.n30 VSS.n414 3.33079
R2676 VSS.n413 VSS.n30 3.33079
R2677 VSS.n30 VSS.n411 3.33079
R2678 VSS.n410 VSS.n30 3.33079
R2679 VSS.n30 VSS.n409 3.33079
R2680 VSS.n408 VSS.n30 3.33079
R2681 VSS.n30 VSS.n407 3.33079
R2682 VSS.n406 VSS.n30 3.33079
R2683 VSS.n30 VSS.n405 3.33079
R2684 VSS.n404 VSS.n30 3.33079
R2685 VSS.n30 VSS.n403 3.33079
R2686 VSS.n402 VSS.n30 3.33079
R2687 VSS.n30 VSS.n401 3.33079
R2688 VSS.n400 VSS.n30 3.33079
R2689 VSS.n30 VSS.n399 3.33079
R2690 VSS.n398 VSS.n30 3.33079
R2691 VSS.n30 VSS.n396 3.33079
R2692 VSS.n395 VSS.n30 3.33079
R2693 VSS.n394 VSS.n30 3.33079
R2694 VSS.n393 VSS.n30 3.33079
R2695 VSS.n392 VSS.n30 3.33079
R2696 VSS.n391 VSS.n30 3.33079
R2697 VSS.n390 VSS.n30 3.33079
R2698 VSS.n389 VSS.n30 3.33079
R2699 VSS.n388 VSS.n30 3.33079
R2700 VSS.n387 VSS.n30 3.33079
R2701 VSS.n386 VSS.n30 3.33079
R2702 VSS.n385 VSS.n30 3.33079
R2703 VSS.n384 VSS.n30 3.33079
R2704 VSS.n383 VSS.n30 3.33079
R2705 VSS.n382 VSS.n30 3.33079
R2706 VSS.n381 VSS.n30 3.33079
R2707 VSS.n380 VSS.n30 3.33079
R2708 VSS.n379 VSS.n30 3.33079
R2709 VSS.n378 VSS.n30 3.33079
R2710 VSS.n377 VSS.n30 3.33079
R2711 VSS.n376 VSS.n30 3.33079
R2712 VSS.n375 VSS.n30 3.33079
R2713 VSS.n374 VSS.n30 3.33079
R2714 VSS.n373 VSS.n30 3.33079
R2715 VSS.n372 VSS.n30 3.33079
R2716 VSS.n371 VSS.n30 3.33079
R2717 VSS.n370 VSS.n30 3.33079
R2718 VSS.n369 VSS.n30 3.33079
R2719 VSS.n30 VSS.n368 3.33079
R2720 VSS.n366 VSS.n30 3.33079
R2721 VSS.n30 VSS.n365 3.33079
R2722 VSS.t2905 VSS.n364 0.0863258
R2723 VSS.t277 VSS.n769 0.0896992
R2724 VSS.t311 VSS.n422 0.0896992
R2725 VSS.t321 VSS.n424 0.0896992
R2726 VSS.t326 VSS.n425 0.0896992
R2727 VSS.t331 VSS.n426 0.0896992
R2728 VSS.t335 VSS.n428 0.0896992
R2729 VSS.t340 VSS.n429 0.0896992
R2730 VSS.t345 VSS.n430 0.0896992
R2731 VSS.t348 VSS.n432 0.0896992
R2732 VSS.n434 VSS.t358 0.0896992
R2733 VSS.n218 VSS.n46 2.72082
R2734 VSS.n46 VSS.n435 3.30688
R2735 VSS.t2773 VSS.n97 5.61485
R2736 VSS.t2775 VSS.n436 0.118193
R2737 VSS.n97 VSS.t2776 5.61485
R2738 VSS.n97 VSS.n342 3.30688
R2739 VSS.n97 VSS.n341 3.30688
R2740 VSS.t2781 VSS.n97 5.61485
R2741 VSS.t2783 VSS.n437 0.118193
R2742 VSS.n97 VSS.t2784 5.61485
R2743 VSS.n97 VSS.n340 3.30688
R2744 VSS.n293 VSS.t2788 0.118323
R2745 VSS.t2768 VSS.n218 0.175714
R2746 VSS.n46 VSS.t2767 5.61485
R2747 VSS.n294 VSS.n100 3.30696
R2748 VSS.n343 VSS.n100 3.30696
R2749 VSS.t2761 VSS.n262 0.175714
R2750 VSS.n262 VSS.n100 2.72082
R2751 VSS.t2759 VSS.n100 5.61485
R2752 VSS.n292 VSS.n100 3.30696
R2753 VSS.t2755 VSS.n219 0.175714
R2754 VSS.n219 VSS.n102 2.72082
R2755 VSS.n102 VSS.n344 3.30688
R2756 VSS.t2751 VSS.n261 0.175554
R2757 VSS.n261 VSS.n102 2.7209
R2758 VSS.t2748 VSS.n102 5.61485
R2759 VSS.n102 VSS.n345 3.30688
R2760 VSS.t2745 VSS.n260 0.175554
R2761 VSS.n260 VSS.n124 2.7209
R2762 VSS.t2742 VSS.n124 5.61485
R2763 VSS.n124 VSS.n291 3.30688
R2764 VSS.t2739 VSS.n103 5.61485
R2765 VSS.t2737 VSS.n264 0.286604
R2766 VSS.n264 VSS.n103 1.97605
R2767 VSS.n259 VSS.t2734 0.175395
R2768 VSS.n259 VSS.n103 2.72098
R2769 VSS.t2731 VSS.n263 0.286604
R2770 VSS.n263 VSS.n103 1.97605
R2771 VSS.n258 VSS.t2728 0.175395
R2772 VSS.n258 VSS.n126 2.72098
R2773 VSS.n220 VSS.t2722 0.175395
R2774 VSS.n220 VSS.n95 2.72098
R2775 VSS.n346 VSS.n95 3.30696
R2776 VSS.t2717 VSS.n257 0.175554
R2777 VSS.n95 VSS.n257 2.7209
R2778 VSS.t2715 VSS.n95 5.61485
R2779 VSS.n290 VSS.n95 3.30696
R2780 VSS.t2711 VSS.n221 0.175554
R2781 VSS.n104 VSS.n221 2.7209
R2782 VSS.n347 VSS.n104 3.30696
R2783 VSS.t2707 VSS.n256 0.175714
R2784 VSS.n256 VSS.n104 2.72082
R2785 VSS.n104 VSS.t2704 5.61485
R2786 VSS.n348 VSS.n104 3.30696
R2787 VSS.t2701 VSS.n255 0.175714
R2788 VSS.n255 VSS.n128 2.72082
R2789 VSS.n128 VSS.t2698 5.61485
R2790 VSS.n289 VSS.n128 3.30696
R2791 VSS.t2695 VSS.n222 0.175714
R2792 VSS.n222 VSS.n96 2.72082
R2793 VSS.n349 VSS.n96 3.30688
R2794 VSS.t2690 VSS.n254 0.175554
R2795 VSS.n254 VSS.n96 2.7209
R2796 VSS.t2687 VSS.n96 5.61485
R2797 VSS.n288 VSS.n96 3.30688
R2798 VSS.t2684 VSS.n223 0.175554
R2799 VSS.n223 VSS.n105 2.7209
R2800 VSS.n253 VSS.t2679 0.175554
R2801 VSS.n105 VSS.n253 2.7209
R2802 VSS.t2677 VSS.n105 5.61485
R2803 VSS.n351 VSS.n105 3.30696
R2804 VSS.n252 VSS.t2674 0.175554
R2805 VSS.n39 VSS.n252 2.7209
R2806 VSS.t2672 VSS.n39 5.61485
R2807 VSS.n287 VSS.n39 3.30696
R2808 VSS.n224 VSS.t2669 0.175554
R2809 VSS.n39 VSS.n224 2.7209
R2810 VSS.n352 VSS.n39 3.30696
R2811 VSS.t2664 VSS.n251 0.175714
R2812 VSS.n39 VSS.n251 2.72082
R2813 VSS.n39 VSS.t2662 5.61485
R2814 VSS.n353 VSS.n39 3.30696
R2815 VSS.t2658 VSS.n250 0.175714
R2816 VSS.n42 VSS.n250 2.72082
R2817 VSS.n42 VSS.t2656 5.61485
R2818 VSS.n286 VSS.n42 3.30696
R2819 VSS.n225 VSS.n42 2.72082
R2820 VSS.n225 VSS.t2651 0.175714
R2821 VSS.n42 VSS.n354 3.30688
R2822 VSS.t2648 VSS.n42 5.61485
R2823 VSS.n285 VSS.n42 3.30696
R2824 VSS.n355 VSS.n42 3.30696
R2825 VSS.n42 VSS.t2643 5.61485
R2826 VSS.n284 VSS.t2641 0.118323
R2827 VSS.t2640 VSS.n42 5.61485
R2828 VSS.t2638 VSS.n42 5.61485
R2829 VSS.n42 VSS.n283 3.30688
R2830 VSS.n226 VSS.t2635 0.175395
R2831 VSS.n226 VSS.n42 2.72098
R2832 VSS.n356 VSS.n42 3.30696
R2833 VSS.n42 VSS.t2631 5.61485
R2834 VSS.n363 VSS.t2630 0.106161
R2835 VSS.n457 VSS.n3 3.33079
R2836 VSS.n494 VSS.n3 3.33079
R2837 VSS.n3 VSS.n493 3.33079
R2838 VSS.n492 VSS.n3 3.33079
R2839 VSS.n3 VSS.n491 3.33079
R2840 VSS.n490 VSS.n3 3.33079
R2841 VSS.n3 VSS.n489 3.33079
R2842 VSS.n488 VSS.n3 3.33079
R2843 VSS.n3 VSS.n486 3.33079
R2844 VSS.n485 VSS.n3 3.33079
R2845 VSS.n484 VSS.n3 3.33079
R2846 VSS.n483 VSS.n3 3.33079
R2847 VSS.n482 VSS.n3 3.33079
R2848 VSS.n481 VSS.n3 3.33079
R2849 VSS.n480 VSS.n3 3.33079
R2850 VSS.n479 VSS.n3 3.33079
R2851 VSS.n478 VSS.n3 3.33079
R2852 VSS.n477 VSS.n3 3.33079
R2853 VSS.n476 VSS.n3 3.33079
R2854 VSS.n475 VSS.n3 3.33079
R2855 VSS.n474 VSS.n3 3.33079
R2856 VSS.n473 VSS.n3 3.33079
R2857 VSS.n471 VSS.n3 3.33079
R2858 VSS.n470 VSS.n3 3.33079
R2859 VSS.n469 VSS.n3 3.33079
R2860 VSS.n468 VSS.n3 3.33079
R2861 VSS.n467 VSS.n3 3.33079
R2862 VSS.n466 VSS.n3 3.33079
R2863 VSS.n465 VSS.n3 3.33079
R2864 VSS.n464 VSS.n3 3.33079
R2865 VSS.n463 VSS.n3 3.33079
R2866 VSS.n462 VSS.n3 3.33079
R2867 VSS.n461 VSS.n3 3.33079
R2868 VSS.n460 VSS.n3 3.33079
R2869 VSS.n459 VSS.n3 3.33079
R2870 VSS.n458 VSS.n3 3.33079
R2871 VSS.n456 VSS.n3 3.33079
R2872 VSS.n455 VSS.n3 3.33079
R2873 VSS.n454 VSS.n3 3.33079
R2874 VSS.n453 VSS.n3 3.33079
R2875 VSS.n452 VSS.n3 3.33079
R2876 VSS.n451 VSS.n3 3.33079
R2877 VSS.n450 VSS.n3 3.33079
R2878 VSS.n449 VSS.n3 3.33079
R2879 VSS.n448 VSS.n3 3.33079
R2880 VSS.n447 VSS.n3 3.33079
R2881 VSS.n446 VSS.n3 3.33079
R2882 VSS.n445 VSS.n3 3.33079
R2883 VSS.n444 VSS.n3 3.33079
R2884 VSS.n443 VSS.n3 3.33079
R2885 VSS.n441 VSS.n3 3.33079
R2886 VSS.n440 VSS.n3 3.33079
R2887 VSS.t2239 VSS.n439 0.0863258
R2888 VSS.n2 VSS.n514 3.33079
R2889 VSS.n2 VSS.n551 3.33079
R2890 VSS.n550 VSS.n2 3.33079
R2891 VSS.n2 VSS.n549 3.33079
R2892 VSS.n548 VSS.n2 3.33079
R2893 VSS.n2 VSS.n547 3.33079
R2894 VSS.n546 VSS.n2 3.33079
R2895 VSS.n2 VSS.n545 3.33079
R2896 VSS.n2 VSS.n543 3.33079
R2897 VSS.n542 VSS.n2 3.33079
R2898 VSS.n2 VSS.n541 3.33079
R2899 VSS.n540 VSS.n2 3.33079
R2900 VSS.n2 VSS.n539 3.33079
R2901 VSS.n538 VSS.n2 3.33079
R2902 VSS.n2 VSS.n537 3.33079
R2903 VSS.n536 VSS.n2 3.33079
R2904 VSS.n2 VSS.n535 3.33079
R2905 VSS.n534 VSS.n2 3.33079
R2906 VSS.n2 VSS.n533 3.33079
R2907 VSS.n532 VSS.n2 3.33079
R2908 VSS.n2 VSS.n531 3.33079
R2909 VSS.n530 VSS.n2 3.33079
R2910 VSS.n2 VSS.n528 3.33079
R2911 VSS.n527 VSS.n2 3.33079
R2912 VSS.n2 VSS.n526 3.33079
R2913 VSS.n525 VSS.n2 3.33079
R2914 VSS.n2 VSS.n524 3.33079
R2915 VSS.n523 VSS.n2 3.33079
R2916 VSS.n2 VSS.n522 3.33079
R2917 VSS.n521 VSS.n2 3.33079
R2918 VSS.n2 VSS.n520 3.33079
R2919 VSS.n519 VSS.n2 3.33079
R2920 VSS.n2 VSS.n518 3.33079
R2921 VSS.n517 VSS.n2 3.33079
R2922 VSS.n2 VSS.n516 3.33079
R2923 VSS.n515 VSS.n2 3.33079
R2924 VSS.n513 VSS.n2 3.33079
R2925 VSS.n2 VSS.n512 3.33079
R2926 VSS.n511 VSS.n2 3.33079
R2927 VSS.n2 VSS.n510 3.33079
R2928 VSS.n509 VSS.n2 3.33079
R2929 VSS.n2 VSS.n508 3.33079
R2930 VSS.n507 VSS.n2 3.33079
R2931 VSS.n2 VSS.n506 3.33079
R2932 VSS.n505 VSS.n2 3.33079
R2933 VSS.n2 VSS.n504 3.33079
R2934 VSS.n503 VSS.n2 3.33079
R2935 VSS.n2 VSS.n502 3.33079
R2936 VSS.n501 VSS.n2 3.33079
R2937 VSS.n2 VSS.n500 3.33079
R2938 VSS.n498 VSS.n2 3.33079
R2939 VSS.n497 VSS.n2 3.33079
R2940 VSS.t1847 VSS.n496 0.0863258
R2941 VSS.n571 VSS.n1 3.33079
R2942 VSS.n608 VSS.n1 3.33079
R2943 VSS.n1 VSS.n607 3.33079
R2944 VSS.n606 VSS.n1 3.33079
R2945 VSS.n1 VSS.n605 3.33079
R2946 VSS.n604 VSS.n1 3.33079
R2947 VSS.n1 VSS.n603 3.33079
R2948 VSS.n602 VSS.n1 3.33079
R2949 VSS.n1 VSS.n600 3.33079
R2950 VSS.n599 VSS.n1 3.33079
R2951 VSS.n598 VSS.n1 3.33079
R2952 VSS.n597 VSS.n1 3.33079
R2953 VSS.n596 VSS.n1 3.33079
R2954 VSS.n595 VSS.n1 3.33079
R2955 VSS.n594 VSS.n1 3.33079
R2956 VSS.n593 VSS.n1 3.33079
R2957 VSS.n592 VSS.n1 3.33079
R2958 VSS.n591 VSS.n1 3.33079
R2959 VSS.n590 VSS.n1 3.33079
R2960 VSS.n589 VSS.n1 3.33079
R2961 VSS.n588 VSS.n1 3.33079
R2962 VSS.n587 VSS.n1 3.33079
R2963 VSS.n1 VSS.n585 3.33079
R2964 VSS.n584 VSS.n1 3.33079
R2965 VSS.n1 VSS.n583 3.33079
R2966 VSS.n582 VSS.n1 3.33079
R2967 VSS.n1 VSS.n581 3.33079
R2968 VSS.n580 VSS.n1 3.33079
R2969 VSS.n1 VSS.n579 3.33079
R2970 VSS.n578 VSS.n1 3.33079
R2971 VSS.n1 VSS.n577 3.33079
R2972 VSS.n576 VSS.n1 3.33079
R2973 VSS.n1 VSS.n575 3.33079
R2974 VSS.n574 VSS.n1 3.33079
R2975 VSS.n1 VSS.n573 3.33079
R2976 VSS.n572 VSS.n1 3.33079
R2977 VSS.n570 VSS.n1 3.33079
R2978 VSS.n569 VSS.n1 3.33079
R2979 VSS.n568 VSS.n1 3.33079
R2980 VSS.n567 VSS.n1 3.33079
R2981 VSS.n566 VSS.n1 3.33079
R2982 VSS.n565 VSS.n1 3.33079
R2983 VSS.n564 VSS.n1 3.33079
R2984 VSS.n563 VSS.n1 3.33079
R2985 VSS.n562 VSS.n1 3.33079
R2986 VSS.n561 VSS.n1 3.33079
R2987 VSS.n560 VSS.n1 3.33079
R2988 VSS.n559 VSS.n1 3.33079
R2989 VSS.n558 VSS.n1 3.33079
R2990 VSS.n557 VSS.n1 3.33079
R2991 VSS.n555 VSS.n1 3.33079
R2992 VSS.n554 VSS.n1 3.33079
R2993 VSS.t1455 VSS.n553 0.0863258
R2994 VSS.n609 VSS.t70 3.30688
R2995 VSS.t1226 VSS.n610 0.118323
R2996 VSS.t1229 VSS.n611 0.118323
R2997 VSS.t1230 VSS.n322 0.118193
R2998 VSS.t1232 VSS.n321 0.118323
R2999 VSS.n612 VSS.t70 3.30688
R3000 VSS.t1239 VSS.n320 0.118193
R3001 VSS.t1241 VSS.t70 5.61485
R3002 VSS.t1244 VSS.n236 0.118323
R3003 VSS.t1248 VSS.t70 5.61485
R3004 VSS.t1251 VSS.n41 0.175395
R3005 VSS.n41 VSS.t70 2.72098
R3006 VSS.t1255 VSS.t70 5.61485
R3007 VSS.t1256 VSS.n282 0.175554
R3008 VSS.n282 VSS.t70 2.7209
R3009 VSS.n615 VSS.t70 3.30688
R3010 VSS.n617 VSS.t1267 0.118323
R3011 VSS.n621 VSS.t1276 0.118323
R3012 VSS.t1280 VSS.t70 5.61485
R3013 VSS.t70 VSS.n623 3.30688
R3014 VSS.t1288 VSS.n237 0.118323
R3015 VSS.t70 VSS.t1292 5.61485
R3016 VSS.n315 VSS.t1295 0.118323
R3017 VSS.t70 VSS.n626 3.30688
R3018 VSS.n627 VSS.t1303 0.118323
R3019 VSS.n628 VSS.t1306 0.118323
R3020 VSS.n630 VSS.t1312 0.118323
R3021 VSS.t70 VSS.n101 2.72098
R3022 VSS.t1315 VSS.n101 0.175395
R3023 VSS.t1318 VSS.n239 0.118323
R3024 VSS.t70 VSS.t1322 5.61485
R3025 VSS.t70 VSS.t1325 5.61485
R3026 VSS.t1326 VSS.n122 0.175714
R3027 VSS.t70 VSS.n249 3.30688
R3028 VSS.t1220 VSS.n234 0.0599544
R3029 VSS.t70 VSS.t1216 5.61485
R3030 VSS.t70 VSS.t1213 5.61485
R3031 VSS.t1206 VSS.t70 5.61485
R3032 VSS.t70 VSS.t1200 5.61485
R3033 VSS.t70 VSS.n323 3.30688
R3034 VSS.n324 VSS.t70 3.30696
R3035 VSS.t70 VSS.t1191 5.61485
R3036 VSS.t70 VSS.n326 3.30688
R3037 VSS.n327 VSS.t70 3.30696
R3038 VSS.t70 VSS.t1182 5.61485
R3039 VSS.t70 VSS.n329 3.30688
R3040 VSS.n330 VSS.t70 3.30696
R3041 VSS.t70 VSS.t1173 5.61485
R3042 VSS.n332 VSS.t70 3.30696
R3043 VSS.n333 VSS.t70 3.30696
R3044 VSS.n660 VSS.n0 3.33079
R3045 VSS.n697 VSS.n0 3.33079
R3046 VSS.n0 VSS.n696 3.33079
R3047 VSS.n695 VSS.n0 3.33079
R3048 VSS.n0 VSS.n694 3.33079
R3049 VSS.n693 VSS.n0 3.33079
R3050 VSS.n0 VSS.n692 3.33079
R3051 VSS.n691 VSS.n0 3.33079
R3052 VSS.n0 VSS.n689 3.33079
R3053 VSS.n688 VSS.n0 3.33079
R3054 VSS.n687 VSS.n0 3.33079
R3055 VSS.n686 VSS.n0 3.33079
R3056 VSS.n685 VSS.n0 3.33079
R3057 VSS.n684 VSS.n0 3.33079
R3058 VSS.n683 VSS.n0 3.33079
R3059 VSS.n682 VSS.n0 3.33079
R3060 VSS.n681 VSS.n0 3.33079
R3061 VSS.n680 VSS.n0 3.33079
R3062 VSS.n679 VSS.n0 3.33079
R3063 VSS.n678 VSS.n0 3.33079
R3064 VSS.n677 VSS.n0 3.33079
R3065 VSS.n676 VSS.n0 3.33079
R3066 VSS.n674 VSS.n0 3.33079
R3067 VSS.n673 VSS.n0 3.33079
R3068 VSS.n672 VSS.n0 3.33079
R3069 VSS.n671 VSS.n0 3.33079
R3070 VSS.n670 VSS.n0 3.33079
R3071 VSS.n669 VSS.n0 3.33079
R3072 VSS.n668 VSS.n0 3.33079
R3073 VSS.n667 VSS.n0 3.33079
R3074 VSS.n666 VSS.n0 3.33079
R3075 VSS.n665 VSS.n0 3.33079
R3076 VSS.n664 VSS.n0 3.33079
R3077 VSS.n663 VSS.n0 3.33079
R3078 VSS.n662 VSS.n0 3.33079
R3079 VSS.n661 VSS.n0 3.33079
R3080 VSS.n659 VSS.n0 3.33079
R3081 VSS.n658 VSS.n0 3.33079
R3082 VSS.n657 VSS.n0 3.33079
R3083 VSS.n656 VSS.n0 3.33079
R3084 VSS.n655 VSS.n0 3.33079
R3085 VSS.n654 VSS.n0 3.33079
R3086 VSS.n653 VSS.n0 3.33079
R3087 VSS.n652 VSS.n0 3.33079
R3088 VSS.n651 VSS.n0 3.33079
R3089 VSS.n650 VSS.n0 3.33079
R3090 VSS.n649 VSS.n0 3.33079
R3091 VSS.n648 VSS.n0 3.33079
R3092 VSS.n647 VSS.n0 3.33079
R3093 VSS.n646 VSS.n0 3.33079
R3094 VSS.n644 VSS.n0 3.33079
R3095 VSS.n643 VSS.n0 3.33079
R3096 VSS.t776 VSS.n642 0.0863258
R3097 VSS.n706 VSS.t512 3.33079
R3098 VSS.t92 VSS.n710 3.33087
R3099 VSS.t92 VSS.n709 3.33348
R3100 VSS.n708 VSS.t92 3.33079
R3101 VSS.n707 VSS.t512 3.33079
R3102 VSS.n705 VSS.t512 3.33079
R3103 VSS.n704 VSS.t512 3.33079
R3104 VSS.n703 VSS.t512 3.33079
R3105 VSS.n702 VSS.t512 3.33079
R3106 VSS.n701 VSS.t512 3.33079
R3107 VSS.n700 VSS.t512 3.33079
R3108 VSS.n699 VSS.t512 3.33079
R3109 VSS.t92 VSS.n712 3.33079
R3110 VSS.t197 VSS.n714 3.33087
R3111 VSS.n720 VSS.t197 3.33079
R3112 VSS.t197 VSS.n721 3.33079
R3113 VSS.t15 VSS.n764 3.33079
R3114 VSS.t204 VSS.n244 0.208234
R3115 VSS.n742 VSS.t106 0.118323
R3116 VSS.t15 VSS.n938 5.61485
R3117 VSS.n247 VSS.t15 3.30696
R3118 VSS.t57 VSS.n248 0.175714
R3119 VSS.t15 VSS.n248 2.72082
R3120 VSS.t15 VSS.n760 3.33079
R3121 VSS.t15 VSS.n759 3.33079
R3122 VSS.t15 VSS.n758 3.33079
R3123 VSS.t15 VSS.n757 3.33079
R3124 VSS.t15 VSS.n756 3.33079
R3125 VSS.t15 VSS.n755 3.33079
R3126 VSS.t15 VSS.n754 3.33079
R3127 VSS.t15 VSS.n753 3.33079
R3128 VSS.t15 VSS.n752 3.33079
R3129 VSS.t15 VSS.n751 3.33079
R3130 VSS.t15 VSS.n750 3.33079
R3131 VSS.t15 VSS.n749 3.33079
R3132 VSS.t15 VSS.n748 3.33079
R3133 VSS.t15 VSS.n747 3.33079
R3134 VSS.n746 VSS.t15 3.33079
R3135 VSS.n763 VSS.t15 3.33079
R3136 VSS.t460 VSS.n768 0.0863258
R3137 VSS.t397 VSS.n766 0.0863258
R3138 VSS.t3269 VSS.n925 4.84181
R3139 VSS.n802 VSS.t3291 4.29849
R3140 VSS.t188 VSS.n1030 4.28621
R3141 VSS.n816 VSS.t3 4.28621
R3142 VSS.n964 VSS.t3283 4.28621
R3143 VSS.n956 VSS.t3237 4.28621
R3144 VSS.t70 VSS.t1330 5.64594
R3145 VSS.t92 VSS.t91 4.251
R3146 VSS.n761 VSS.t15 3.36082
R3147 VSS.t15 VSS.t90 4.2505
R3148 VSS.t197 VSS.n717 2.74175
R3149 VSS.t178 VSS.n808 3.50108
R3150 VSS.n808 VSS.t89 3.50108
R3151 VSS.t512 VSS.n698 2.31585
R3152 VSS.t197 VSS.n718 2.31585
R3153 VSS.t197 VSS.n716 2.31585
R3154 VSS.t197 VSS.n715 2.31585
R3155 VSS.t197 VSS.n737 2.31585
R3156 VSS.t197 VSS.n736 2.31585
R3157 VSS.t197 VSS.n735 2.31585
R3158 VSS.t197 VSS.n734 2.31585
R3159 VSS.t197 VSS.n733 2.31585
R3160 VSS.t197 VSS.n732 2.31585
R3161 VSS.t197 VSS.n731 2.31585
R3162 VSS.t197 VSS.n730 2.31585
R3163 VSS.t197 VSS.n729 2.31585
R3164 VSS.t197 VSS.n728 2.31585
R3165 VSS.t197 VSS.n727 2.31585
R3166 VSS.t197 VSS.n726 2.31585
R3167 VSS.t197 VSS.n725 2.31585
R3168 VSS.t197 VSS.n724 2.31585
R3169 VSS.t197 VSS.n723 2.31585
R3170 VSS.t740 VSS.n722 0.0923917
R3171 VSS.n905 VSS.t18 2.72109
R3172 VSS.t3213 VSS.n359 72.8451
R3173 VSS.n921 VSS.t18 2.59384
R3174 VSS.n920 VSS.t18 2.59384
R3175 VSS.n916 VSS.n358 91.4034
R3176 VSS.n911 VSS.t30 2.59384
R3177 VSS.n210 VSS.t30 0.405951
R3178 VSS.t30 VSS.n420 0.405951
R3179 VSS.t30 VSS.n896 2.59384
R3180 VSS.t30 VSS.n897 2.59384
R3181 VSS.n895 VSS.t30 2.29778
R3182 VSS.t15 VSS.n808 1.88939
R3183 VSS.t16 VSS.t42 1.37665
R3184 VSS.n29 VSS.t124 0.380447
R3185 VSS.n739 VSS.t406 0.0815508
R3186 VSS.n767 VSS.t15 0.991912
R3187 VSS.t15 VSS.t192 1.20419
R3188 VSS.t197 VSS.n713 0.983384
R3189 VSS.t363 VSS.t131 1.17344
R3190 VSS.t32 VSS.t28 1.16978
R3191 VSS.n28 VSS.t15 0.994
R3192 VSS.n421 VSS.t303 0.0329209
R3193 VSS.n427 VSS.t334 0.94915
R3194 VSS.t292 VSS.t147 1.1131
R3195 VSS.n902 VSS.t24 1.10319
R3196 VSS.t28 VSS.t41 1.09968
R3197 VSS.t273 VSS.t367 1.08659
R3198 VSS.t34 VSS.t383 1.08583
R3199 VSS.t528 VSS.t170 1.01987
R3200 VSS.n741 VSS.t64 1.07177
R3201 VSS.t282 VSS.t287 1.01774
R3202 VSS.t303 VSS.t298 1.01465
R3203 VSS.n431 VSS.t222 1.06044
R3204 VSS.t273 VSS.t378 0.975846
R3205 VSS.n719 VSS.t197 0.808749
R3206 VSS.t3212 VSS.t22 0.965304
R3207 VSS.t3212 VSS.t27 0.964486
R3208 VSS.t282 VSS.n360 0.845789
R3209 VSS.n762 VSS.t53 1.00103
R3210 VSS.n44 VSS.t47 0.79002
R3211 VSS.t521 VSS.t528 0.931054
R3212 VSS.t73 VSS.n762 0.752541
R3213 VSS.t73 VSS.t6 0.876684
R3214 VSS.n29 VSS.t6 0.229787
R3215 VSS.t512 VSS.n833 0.846093
R3216 VSS.t287 VSS.t292 0.841646
R3217 VSS.t56 VSS.t65 0.829229
R3218 VSS.t30 VSS.t381 0.816242
R3219 VSS.t363 VSS.t367 0.807755
R3220 VSS.t102 VSS.t729 0.806182
R3221 VSS.t3212 VSS.t15 0.800437
R3222 VSS.t15 VSS.n29 0.357292
R3223 VSS.n719 VSS.t102 0.0757059
R3224 VSS.t587 VSS.t256 0.716723
R3225 VSS.t253 VSS.t192 0.714038
R3226 VSS.n713 VSS.t587 0.083181
R3227 VSS.t192 VSS.t187 0.707985
R3228 VSS.n902 VSS.t131 0.698053
R3229 VSS.t38 VSS.n767 0.0822487
R3230 VSS.t4 VSS.n739 0.56497
R3231 VSS.t92 VSS.n162 0.666899
R3232 VSS.n1012 VSS.t197 0.666899
R3233 VSS.n276 VSS.t3279 87.1423
R3234 VSS.t15 VSS.n22 0.666899
R3235 VSS.t15 VSS.n26 0.666899
R3236 VSS.t15 VSS.n25 0.666899
R3237 VSS.t15 VSS.n16 0.666899
R3238 VSS.t15 VSS.n14 0.666899
R3239 VSS.n1041 VSS.n770 0.66578
R3240 VSS.n990 VSS.n770 0.66578
R3241 VSS.n990 VSS.n989 0.66578
R3242 VSS.n989 VSS.n893 0.66578
R3243 VSS.n1000 VSS.n893 0.66578
R3244 VSS.n1001 VSS.n1000 0.66578
R3245 VSS.n1001 VSS.n773 0.66578
R3246 VSS.n1036 VSS.n773 0.66578
R3247 VSS.n984 VSS.n980 0.66578
R3248 VSS.n994 VSS.n980 0.66578
R3249 VSS.n995 VSS.n994 0.66578
R3250 VSS.n995 VSS.n979 0.66578
R3251 VSS.n979 VSS.n977 0.66578
R3252 VSS.n977 VSS.n976 0.66578
R3253 VSS.n976 VSS.n975 0.66578
R3254 VSS.n992 VSS.n986 0.66578
R3255 VSS.n993 VSS.n992 0.66578
R3256 VSS.n993 VSS.n982 0.66578
R3257 VSS.n982 VSS.n891 0.66578
R3258 VSS.n1003 VSS.n891 0.66578
R3259 VSS.n1004 VSS.n1003 0.66578
R3260 VSS.n1004 VSS.n890 0.66578
R3261 VSS.n1039 VSS.n771 0.66578
R3262 VSS.n894 VSS.n771 0.66578
R3263 VSS.n998 VSS.n894 0.66578
R3264 VSS.n999 VSS.n998 0.66578
R3265 VSS.n999 VSS.n825 0.66578
R3266 VSS.n1028 VSS.n825 0.66578
R3267 VSS.n1029 VSS.n1028 0.66578
R3268 VSS.n942 VSS.t15 0.655024
R3269 VSS.t15 VSS.n21 0.655024
R3270 VSS.n310 VSS.t92 0.0258175
R3271 VSS.t3228 VSS.n273 397.755
R3272 VSS.t512 VSS.n110 0.649813
R3273 VSS.t512 VSS.n119 0.649813
R3274 VSS.t512 VSS.n120 0.649813
R3275 VSS.n1017 VSS.t197 0.649813
R3276 VSS.t92 VSS.n161 0.649813
R3277 VSS.n1015 VSS.t197 0.649813
R3278 VSS.t197 VSS.n89 0.356983
R3279 VSS.t197 VSS.n88 0.649813
R3280 VSS.t197 VSS.n87 0.649813
R3281 VSS.t197 VSS.n86 0.649813
R3282 VSS.t197 VSS.n83 0.649813
R3283 VSS.t197 VSS.n82 0.649813
R3284 VSS.t197 VSS.n84 0.649813
R3285 VSS.t197 VSS.n85 0.649813
R3286 VSS.t197 VSS.n68 0.649813
R3287 VSS.n861 VSS.t197 0.649813
R3288 VSS.t197 VSS.n92 0.649813
R3289 VSS.t197 VSS.n90 0.649813
R3290 VSS.t197 VSS.n91 0.649813
R3291 VSS.t197 VSS.n66 0.649813
R3292 VSS.t197 VSS.n67 0.649813
R3293 VSS.t197 VSS.n65 0.649813
R3294 VSS.t197 VSS.n64 0.649813
R3295 VSS.t197 VSS.n54 0.649813
R3296 VSS.t197 VSS.n55 0.649813
R3297 VSS.t197 VSS.n53 0.649813
R3298 VSS.t197 VSS.n52 0.649813
R3299 VSS.t197 VSS.n49 0.649813
R3300 VSS.t197 VSS.n48 0.649813
R3301 VSS.t197 VSS.n50 0.649813
R3302 VSS.t197 VSS.n51 0.649813
R3303 VSS.t197 VSS.n57 0.649813
R3304 VSS.t197 VSS.n56 0.649813
R3305 VSS.t197 VSS.n58 0.649813
R3306 VSS.t197 VSS.n59 0.649813
R3307 VSS.t197 VSS.n62 0.649813
R3308 VSS.t197 VSS.n63 0.649813
R3309 VSS.t197 VSS.n61 0.649813
R3310 VSS.t197 VSS.n60 0.649813
R3311 VSS.t197 VSS.n78 0.649813
R3312 VSS.t197 VSS.n79 0.649813
R3313 VSS.t197 VSS.n77 0.649813
R3314 VSS.t197 VSS.n76 0.649813
R3315 VSS.t197 VSS.n73 0.649813
R3316 VSS.t197 VSS.n72 0.649813
R3317 VSS.t197 VSS.n74 0.649813
R3318 VSS.t197 VSS.n75 0.649813
R3319 VSS.t197 VSS.n81 0.649813
R3320 VSS.t197 VSS.n80 0.649813
R3321 VSS.n879 VSS.t197 0.649813
R3322 VSS.t163 VSS.n277 29.1846
R3323 VSS.t512 VSS.n115 0.649813
R3324 VSS.t15 VSS.n17 0.649813
R3325 VSS.t15 VSS.n20 0.649813
R3326 VSS.t15 VSS.n18 0.649813
R3327 VSS.t15 VSS.n19 0.649813
R3328 VSS.n34 VSS.t181 320.269
R3329 VSS.n948 VSS.t15 0.649813
R3330 VSS.n950 VSS.t15 0.649813
R3331 VSS.n951 VSS.t15 0.649813
R3332 VSS.n966 VSS.t15 0.649813
R3333 VSS.t15 VSS.n4 0.649813
R3334 VSS.t15 VSS.n15 0.649813
R3335 VSS.n941 VSS.t15 0.648101
R3336 VSS.t15 VSS.n23 0.648101
R3337 VSS.t15 VSS.n24 0.648101
R3338 VSS.t15 VSS.n13 0.648101
R3339 VSS.t15 VSS.n12 0.648101
R3340 VSS.t15 VSS.n5 0.648101
R3341 VSS.t15 VSS.n11 0.648101
R3342 VSS.t15 VSS.n10 0.648101
R3343 VSS.t15 VSS.n9 0.648101
R3344 VSS.t15 VSS.n6 0.648101
R3345 VSS.t15 VSS.n7 0.648101
R3346 VSS.t15 VSS.n8 0.648101
R3347 VSS.n1034 VSS.t15 0.648101
R3348 VSS.n360 VSS.t18 0.532065
R3349 VSS.t378 VSS.t381 0.627769
R3350 VSS.t64 VSS.n44 0.983348
R3351 VSS.n274 VSS.t216 0.575462
R3352 VSS.t147 VSS.t298 0.611475
R3353 VSS.t211 VSS.n274 0.571832
R3354 VSS.t38 VSS.t36 0.600657
R3355 VSS.t30 VSS.n902 0.594402
R3356 VSS.n431 VSS.t30 0.480953
R3357 VSS.n741 VSS.t15 0.432259
R3358 VSS.t18 VSS.t147 0.508724
R3359 VSS.t406 VSS.t253 0.489392
R3360 VSS.t381 VSS.t383 0.453316
R3361 VSS.t104 VSS.n895 0.452661
R3362 VSS.t128 VSS.n427 1.13923
R3363 VSS.n1037 VSS.t18 0.405951
R3364 VSS.t18 VSS.n130 0.405951
R3365 VSS.t18 VSS.n154 0.405951
R3366 VSS.t18 VSS.n132 0.405951
R3367 VSS.t18 VSS.n152 0.405951
R3368 VSS.t18 VSS.n134 0.405951
R3369 VSS.t18 VSS.n150 0.405951
R3370 VSS.t18 VSS.n149 0.405951
R3371 VSS.t18 VSS.n137 0.405951
R3372 VSS.t18 VSS.n147 0.405951
R3373 VSS.t18 VSS.n139 0.405951
R3374 VSS.t18 VSS.n145 0.405951
R3375 VSS.t18 VSS.n141 0.405951
R3376 VSS.t18 VSS.n143 0.405951
R3377 VSS.t18 VSS.n156 0.405951
R3378 VSS.t18 VSS.n155 0.405951
R3379 VSS.n934 VSS.t18 0.405951
R3380 VSS.n933 VSS.t18 0.405951
R3381 VSS.n932 VSS.t18 0.405951
R3382 VSS.n930 VSS.t18 0.405951
R3383 VSS.n922 VSS.t18 0.405951
R3384 VSS.n268 VSS.t18 0.0643469
R3385 VSS.n917 VSS.t18 0.405951
R3386 VSS.n915 VSS.t30 0.405951
R3387 VSS.n914 VSS.t30 0.405951
R3388 VSS.n912 VSS.t30 0.405951
R3389 VSS.n910 VSS.t30 0.405951
R3390 VSS.n906 VSS.t30 0.405951
R3391 VSS.t30 VSS.n173 0.405951
R3392 VSS.t30 VSS.n209 0.405951
R3393 VSS.t30 VSS.n208 0.405951
R3394 VSS.t30 VSS.n207 0.405951
R3395 VSS.t30 VSS.n174 0.405951
R3396 VSS.t30 VSS.n175 0.405951
R3397 VSS.t30 VSS.n176 0.405951
R3398 VSS.t30 VSS.n177 0.405951
R3399 VSS.t30 VSS.n205 0.405951
R3400 VSS.t30 VSS.n179 0.405951
R3401 VSS.t30 VSS.n203 0.405951
R3402 VSS.t30 VSS.n181 0.405951
R3403 VSS.t30 VSS.n201 0.405951
R3404 VSS.t30 VSS.n183 0.405951
R3405 VSS.t30 VSS.n184 0.405951
R3406 VSS.t30 VSS.n198 0.405951
R3407 VSS.t30 VSS.n186 0.405951
R3408 VSS.t30 VSS.n196 0.405951
R3409 VSS.t30 VSS.n188 0.405951
R3410 VSS.t30 VSS.n194 0.405951
R3411 VSS.t30 VSS.n190 0.405951
R3412 VSS.t30 VSS.n191 0.405951
R3413 VSS.t30 VSS.n192 0.405951
R3414 VSS.n905 VSS.t218 0.396535
R3415 VSS.t2631 VSS.t2632 0.36115
R3416 VSS.t2743 VSS.t2742 0.36115
R3417 VSS.t2749 VSS.t2748 0.36115
R3418 VSS.n219 VSS.t2754 0.175714
R3419 VSS.n262 VSS.t2760 0.175714
R3420 VSS.t1256 VSS.t1255 0.36115
R3421 VSS.t2643 VSS.t2644 0.36115
R3422 VSS.n225 VSS.t2652 0.175714
R3423 VSS.t2657 VSS.n250 0.175714
R3424 VSS.t2663 VSS.n251 0.175714
R3425 VSS.t2669 VSS.t2670 0.36115
R3426 VSS.t2674 VSS.t2675 0.36115
R3427 VSS.t2689 VSS.t2687 0.36115
R3428 VSS.n222 VSS.t2693 0.175714
R3429 VSS.n255 VSS.t2699 0.175714
R3430 VSS.n256 VSS.t2705 0.175714
R3431 VSS.t2713 VSS.t2711 0.36115
R3432 VSS.t2719 VSS.t2717 0.36115
R3433 VSS.t2783 VSS.t2784 0.36115
R3434 VSS.t2775 VSS.t2776 0.36115
R3435 VSS.n122 VSS.t1327 0.175714
R3436 VSS.n248 VSS.t3195 0.175714
R3437 VSS.t2652 VSS.t2653 0.360811
R3438 VSS.t2658 VSS.t2659 0.360811
R3439 VSS.t2664 VSS.t2665 0.360811
R3440 VSS.t2678 VSS.n253 0.175554
R3441 VSS.t2673 VSS.n252 0.175554
R3442 VSS.t2668 VSS.n224 0.175554
R3443 VSS.t2662 VSS.t2663 0.360811
R3444 VSS.t2656 VSS.t2657 0.360811
R3445 VSS.t2636 VSS.t2635 0.360811
R3446 VSS.n223 VSS.t2683 0.175554
R3447 VSS.n254 VSS.t2689 0.175554
R3448 VSS.t2696 VSS.t2695 0.360811
R3449 VSS.t2699 VSS.t2698 0.360811
R3450 VSS.t2702 VSS.t2701 0.360811
R3451 VSS.t2705 VSS.t2704 0.360811
R3452 VSS.t2708 VSS.t2707 0.360811
R3453 VSS.n221 VSS.t2710 0.175554
R3454 VSS.n257 VSS.t2716 0.175554
R3455 VSS.t2723 VSS.t2722 0.360811
R3456 VSS.t2729 VSS.t2728 0.360811
R3457 VSS.t2733 VSS.t2731 0.360811
R3458 VSS.t2735 VSS.t2734 0.360811
R3459 VSS.t2739 VSS.t2737 0.360811
R3460 VSS.n260 VSS.t2743 0.175554
R3461 VSS.n261 VSS.t2749 0.175554
R3462 VSS.t2757 VSS.t2755 0.360811
R3463 VSS.t2763 VSS.t2761 0.360811
R3464 VSS.t2768 VSS.t2767 0.360811
R3465 VSS.t1230 VSS.t1229 0.360811
R3466 VSS.t1239 VSS.t1238 0.360811
R3467 VSS.t1258 VSS.n282 0.175554
R3468 VSS.t1326 VSS.t1325 0.360811
R3469 VSS.t1312 VSS.t1314 0.360811
R3470 VSS.t57 VSS.n247 0.478504
R3471 VSS.t106 VSS.n938 0.360811
R3472 VSS.t2677 VSS.t2678 0.360471
R3473 VSS.t2672 VSS.t2673 0.360471
R3474 VSS.t2648 VSS.t2649 0.360471
R3475 VSS.t2640 VSS.t2641 0.360471
R3476 VSS.t2634 VSS.n226 0.175395
R3477 VSS.t2630 VSS.t2631 0.360471
R3478 VSS.t2685 VSS.t2684 0.360471
R3479 VSS.t2691 VSS.t2690 0.360471
R3480 VSS.t2715 VSS.t2716 0.360471
R3481 VSS.t2721 VSS.n220 0.175395
R3482 VSS.t2727 VSS.n258 0.175395
R3483 VSS.t2733 VSS.n259 0.175395
R3484 VSS.t2739 VSS.t2740 0.360471
R3485 VSS.t2745 VSS.t2746 0.360471
R3486 VSS.t2751 VSS.t2752 0.360471
R3487 VSS.t2760 VSS.t2759 0.360471
R3488 VSS.t2781 VSS.t2780 0.360471
R3489 VSS.t2773 VSS.t2772 0.360471
R3490 VSS.t1252 VSS.n41 0.175395
R3491 VSS.n101 VSS.t1314 0.175395
R3492 VSS.t15 VSS.t28 0.355489
R3493 VSS.t724 VSS.t603 0.344562
R3494 VSS.n698 VSS.t532 0.436369
R3495 VSS.t645 VSS.n736 0.433869
R3496 VSS.t642 VSS.n735 0.433869
R3497 VSS.t639 VSS.n734 0.433869
R3498 VSS.t636 VSS.n733 0.433869
R3499 VSS.t633 VSS.n732 0.433869
R3500 VSS.t630 VSS.n731 0.433869
R3501 VSS.t627 VSS.n730 0.433869
R3502 VSS.t624 VSS.n729 0.433869
R3503 VSS.t621 VSS.n728 0.433869
R3504 VSS.t618 VSS.n727 0.433869
R3505 VSS.t615 VSS.n726 0.433869
R3506 VSS.t612 VSS.n725 0.433869
R3507 VSS.t609 VSS.n724 0.433869
R3508 VSS.t596 VSS.n716 0.433869
R3509 VSS.t593 VSS.n715 0.433869
R3510 VSS.t740 VSS.t8 0.341746
R3511 VSS.t532 VSS.n311 0.328762
R3512 VSS.t256 VSS.n172 0.328435
R3513 VSS.t128 VSS.n905 0.338658
R3514 VSS.t110 VSS.n722 0.23595
R3515 VSS.n723 VSS.t606 0.433869
R3516 VSS.n718 VSS.t724 0.0923073
R3517 VSS.t648 VSS.n737 0.422619
R3518 VSS.t1329 VSS.t1330 0.311525
R3519 VSS.n367 VSS.t2920 0.0850573
R3520 VSS.n833 VSS.t521 0.302628
R3521 VSS.t2645 VSS.t2646 0.301114
R3522 VSS.t2671 VSS.t2672 0.301114
R3523 VSS.t2676 VSS.t2677 0.301114
R3524 VSS.t2636 VSS.n283 0.118323
R3525 VSS.t1367 VSS.t1220 0.301114
R3526 VSS.n349 VSS.t2691 0.118323
R3527 VSS.n288 VSS.t2685 0.118323
R3528 VSS.n340 VSS.t2786 0.118323
R3529 VSS.n342 VSS.t2778 0.118323
R3530 VSS.t1253 VSS.t1252 0.301114
R3531 VSS.n249 VSS.t1329 0.118323
R3532 VSS.t1280 VSS.t1281 0.301114
R3533 VSS.t1400 VSS.n617 0.17801
R3534 VSS.t1223 VSS.n609 0.118323
R3535 VSS.n610 VSS.t1225 0.17801
R3536 VSS.n611 VSS.t1228 0.17801
R3537 VSS.t1238 VSS.n612 0.118323
R3538 VSS.t1262 VSS.n615 0.118323
R3539 VSS.n616 VSS.t1264 0.17801
R3540 VSS.t2637 VSS.t2638 0.301114
R3541 VSS.n354 VSS.t2649 0.118323
R3542 VSS.t2647 VSS.t2648 0.301114
R3543 VSS.t2642 VSS.n284 0.17801
R3544 VSS.t2633 VSS.t2634 0.301114
R3545 VSS.t1169 VSS.t1168 0.301114
R3546 VSS.t1171 VSS.t1170 0.301114
R3547 VSS.t1174 VSS.t1173 0.301114
R3548 VSS.t1205 VSS.t1206 0.301114
R3549 VSS.t2683 VSS.t2682 0.301114
R3550 VSS.t2715 VSS.t2714 0.301114
R3551 VSS.t2721 VSS.t2720 0.301114
R3552 VSS.n160 VSS.t2723 0.176072
R3553 VSS.t2727 VSS.t2726 0.301114
R3554 VSS.n263 VSS.t2729 0.28702
R3555 VSS.n264 VSS.t2735 0.28702
R3556 VSS.n291 VSS.t2740 0.118323
R3557 VSS.n345 VSS.t2746 0.118323
R3558 VSS.n344 VSS.t2752 0.118323
R3559 VSS.t2759 VSS.t2758 0.301114
R3560 VSS.t2765 VSS.t2764 0.301114
R3561 VSS.t2787 VSS.n293 0.17801
R3562 VSS.t2781 VSS.t2782 0.301114
R3563 VSS.n341 VSS.t2780 0.118323
R3564 VSS.t2773 VSS.t2774 0.301114
R3565 VSS.n435 VSS.t2772 0.118323
R3566 VSS.t1233 VSS.n321 0.17801
R3567 VSS.t1242 VSS.t1241 0.301114
R3568 VSS.t1245 VSS.n236 0.17801
R3569 VSS.t1248 VSS.t1247 0.301114
R3570 VSS.t1251 VSS.t1250 0.301114
R3571 VSS.t1322 VSS.t1323 0.301114
R3572 VSS.n239 VSS.t1319 0.17801
R3573 VSS.t1315 VSS.t1316 0.301114
R3574 VSS.t1311 VSS.n630 0.17801
R3575 VSS.t1305 VSS.n628 0.17801
R3576 VSS.t1302 VSS.n627 0.17801
R3577 VSS.n626 VSS.t1300 0.118323
R3578 VSS.n315 VSS.t1296 0.17801
R3579 VSS.t1292 VSS.t1293 0.301114
R3580 VSS.n237 VSS.t1289 0.17801
R3581 VSS.n623 VSS.t1282 0.118323
R3582 VSS.t1275 VSS.n621 0.17801
R3583 VSS.t22 VSS.n742 0.17801
R3584 VSS.t1216 VSS.t1217 0.301114
R3585 VSS.t1213 VSS.t1214 0.301114
R3586 VSS.t1201 VSS.t1200 0.301114
R3587 VSS.t1198 VSS.n323 0.118323
R3588 VSS.t1195 VSS.t1196 0.301114
R3589 VSS.t1192 VSS.t1191 0.301114
R3590 VSS.t1189 VSS.n326 0.118323
R3591 VSS.t1186 VSS.t1187 0.301114
R3592 VSS.t1183 VSS.t1182 0.301114
R3593 VSS.t1180 VSS.n329 0.118323
R3594 VSS.t2679 VSS.t2680 0.301114
R3595 VSS.t2644 VSS.n355 0.118193
R3596 VSS.t2670 VSS.n287 0.118193
R3597 VSS.t2675 VSS.n351 0.118193
R3598 VSS.t2632 VSS.n356 0.118193
R3599 VSS.t2646 VSS.n285 0.118193
R3600 VSS.t2653 VSS.n286 0.118193
R3601 VSS.t2659 VSS.n353 0.118193
R3602 VSS.t2665 VSS.n352 0.118193
R3603 VSS.t2667 VSS.t2668 0.300775
R3604 VSS.t2661 VSS.t2662 0.300775
R3605 VSS.t2655 VSS.t2656 0.300775
R3606 VSS.t2650 VSS.t2651 0.300775
R3607 VSS.t2642 VSS.t2643 0.300775
R3608 VSS.n333 VSS.t1169 0.118193
R3609 VSS.n332 VSS.t1171 0.118193
R3610 VSS.t1172 VSS.t1173 0.300775
R3611 VSS.t1206 VSS.t1207 0.300775
R3612 VSS.t2687 VSS.t2686 0.300775
R3613 VSS.t2693 VSS.t2692 0.300775
R3614 VSS.n289 VSS.t2696 0.118193
R3615 VSS.t1178 VSS.n330 0.118193
R3616 VSS.t1187 VSS.n327 0.118193
R3617 VSS.t1196 VSS.n324 0.118193
R3618 VSS.t2697 VSS.t2698 0.300775
R3619 VSS.n348 VSS.t2702 0.118193
R3620 VSS.t2703 VSS.t2704 0.300775
R3621 VSS.n347 VSS.t2708 0.118193
R3622 VSS.t2709 VSS.t2710 0.300775
R3623 VSS.n290 VSS.t2713 0.118193
R3624 VSS.n346 VSS.t2719 0.118193
R3625 VSS.t2742 VSS.t2741 0.300775
R3626 VSS.t2748 VSS.t2747 0.300775
R3627 VSS.t2754 VSS.t2753 0.300775
R3628 VSS.n292 VSS.t2757 0.118193
R3629 VSS.n343 VSS.t2763 0.118193
R3630 VSS.n294 VSS.t2765 0.118193
R3631 VSS.t2766 VSS.t2767 0.300775
R3632 VSS.t2788 VSS.t2789 0.300775
R3633 VSS.t2786 VSS.t2787 0.300775
R3634 VSS.t2784 VSS.t2899 0.300775
R3635 VSS.n437 VSS.t2782 0.177814
R3636 VSS.t2778 VSS.t2779 0.300775
R3637 VSS.t2776 VSS.t2892 0.300775
R3638 VSS.n436 VSS.t2774 0.177814
R3639 VSS.t1224 VSS.t1223 0.300775
R3640 VSS.t1227 VSS.t1226 0.300775
R3641 VSS.t1231 VSS.n322 0.177814
R3642 VSS.t1232 VSS.t1231 0.300775
R3643 VSS.t1240 VSS.n320 0.177814
R3644 VSS.t1241 VSS.t1240 0.300775
R3645 VSS.t1244 VSS.t1243 0.300775
R3646 VSS.t1249 VSS.t1248 0.300775
R3647 VSS.t1255 VSS.t1254 0.300775
R3648 VSS.t1259 VSS.t1258 0.300775
R3649 VSS.t1263 VSS.t1262 0.300775
R3650 VSS.t1327 VSS.t1451 0.300775
R3651 VSS.t1324 VSS.t1325 0.300775
R3652 VSS.t1321 VSS.t1322 0.300775
R3653 VSS.t1318 VSS.t1317 0.300775
R3654 VSS.t1306 VSS.t1436 0.300775
R3655 VSS.t1303 VSS.t1433 0.300775
R3656 VSS.t1300 VSS.t1430 0.300775
R3657 VSS.t1294 VSS.t1295 0.300775
R3658 VSS.t1291 VSS.t1292 0.300775
R3659 VSS.t1288 VSS.t1287 0.300775
R3660 VSS.t1282 VSS.t1416 0.300775
R3661 VSS.t1280 VSS.t1279 0.300775
R3662 VSS.t1276 VSS.t1411 0.300775
R3663 VSS.t1267 VSS.t1268 0.300775
R3664 VSS.t174 VSS.t3195 0.300775
R3665 VSS.t1215 VSS.t1216 0.300775
R3666 VSS.t1212 VSS.t1213 0.300775
R3667 VSS.t1199 VSS.t1200 0.300775
R3668 VSS.t1197 VSS.t1198 0.300775
R3669 VSS.t1190 VSS.t1191 0.300775
R3670 VSS.t1188 VSS.t1189 0.300775
R3671 VSS.t1181 VSS.t1182 0.300775
R3672 VSS.t1179 VSS.t1180 0.300775
R3673 VSS.t512 VSS.t528 0.282094
R3674 VSS.t18 VSS.n421 0.242614
R3675 VSS.t599 VSS.n717 0.379757
R3676 VSS.n363 VSS.t62 0.160265
R3677 VSS.n216 VSS.t2790 0.0997446
R3678 VSS.n636 VSS.t1205 0.119605
R3679 VSS.n165 VSS.t1208 0.119605
R3680 VSS.t1403 VSS.n618 0.119605
R3681 VSS.t1408 VSS.t1275 0.241078
R3682 VSS.t1411 VSS.t1278 0.241078
R3683 VSS.n317 VSS.t1284 0.119605
R3684 VSS.t1427 VSS.t1299 0.241078
R3685 VSS.t1430 VSS.t1302 0.241078
R3686 VSS.t1433 VSS.t1305 0.241078
R3687 VSS.t1436 VSS.t1308 0.241078
R3688 VSS.n227 VSS.t1310 0.119605
R3689 VSS.t1310 VSS.t1311 0.241078
R3690 VSS.n745 VSS.t66 0.301114
R3691 VSS.t1168 VSS.t1167 0.241078
R3692 VSS.t1175 VSS.n639 0.119605
R3693 VSS.t1176 VSS.t1175 0.241078
R3694 VSS.n331 VSS.t1176 0.119605
R3695 VSS.t1208 VSS.t1209 0.241078
R3696 VSS.t1225 VSS.t1224 0.241078
R3697 VSS.t1228 VSS.t1227 0.241078
R3698 VSS.t1234 VSS.t1233 0.241078
R3699 VSS.t1235 VSS.t1234 0.241078
R3700 VSS.t1236 VSS.n235 0.119605
R3701 VSS.t1237 VSS.t1236 0.241078
R3702 VSS.t1243 VSS.n613 0.119605
R3703 VSS.t1246 VSS.t1245 0.241078
R3704 VSS.t1247 VSS.n614 0.119605
R3705 VSS.n319 VSS.t1249 0.119605
R3706 VSS.n318 VSS.t1253 0.119605
R3707 VSS.t1260 VSS.n123 0.119605
R3708 VSS.t1261 VSS.t1260 0.241078
R3709 VSS.t1264 VSS.t1263 0.241078
R3710 VSS.t1269 VSS.t1270 0.241078
R3711 VSS.n622 VSS.t1279 0.119605
R3712 VSS.t1284 VSS.t1285 0.241078
R3713 VSS.t1323 VSS.n314 0.119605
R3714 VSS.n632 VSS.t1321 0.119605
R3715 VSS.t1319 VSS.t1320 0.241078
R3716 VSS.n631 VSS.t1317 0.119605
R3717 VSS.n238 VSS.t1427 0.119605
R3718 VSS.t1297 VSS.t1298 0.241078
R3719 VSS.t1296 VSS.t1297 0.241078
R3720 VSS.t1293 VSS.n316 0.119605
R3721 VSS.n625 VSS.t1291 0.119605
R3722 VSS.t1289 VSS.t1290 0.241078
R3723 VSS.t1285 VSS.t1286 0.241078
R3724 VSS.n624 VSS.t1287 0.119605
R3725 VSS.t1274 VSS.t1408 0.241078
R3726 VSS.n620 VSS.t1274 0.119605
R3727 VSS.t1272 VSS.t1273 0.241078
R3728 VSS.t1270 VSS.t1271 0.241078
R3729 VSS.t1271 VSS.n619 0.119605
R3730 VSS.t1268 VSS.t1403 0.241078
R3731 VSS.t1266 VSS.t1400 0.241078
R3732 VSS.n743 VSS.t3275 0.119605
R3733 VSS.t3275 VSS.n233 0.360183
R3734 VSS.t204 VSS.n740 0.420219
R3735 VSS.n744 VSS.t27 0.119605
R3736 VSS.n633 VSS.t1367 0.119605
R3737 VSS.t1218 VSS.t1219 0.241078
R3738 VSS.n240 VSS.t1218 0.119605
R3739 VSS.n634 VSS.t1215 0.119605
R3740 VSS.n635 VSS.t1212 0.119605
R3741 VSS.n241 VSS.t1210 0.119605
R3742 VSS.t1210 VSS.t1211 0.241078
R3743 VSS.t1204 VSS.t1356 0.241078
R3744 VSS.n242 VSS.t1204 0.119605
R3745 VSS.t1202 VSS.t1203 0.241078
R3746 VSS.n166 VSS.t1202 0.119605
R3747 VSS.t1194 VSS.n325 0.119605
R3748 VSS.t1193 VSS.t1194 0.241078
R3749 VSS.n637 VSS.t1193 0.119605
R3750 VSS.t1185 VSS.n328 0.119605
R3751 VSS.t1184 VSS.t1185 0.241078
R3752 VSS.n638 VSS.t1184 0.119605
R3753 VSS.t174 VSS.n38 0.346359
R3754 VSS.n895 VSS.t24 0.232128
R3755 VSS.t1265 VSS.n616 0.348308
R3756 VSS.t30 VSS.t363 0.228622
R3757 VSS.n769 VSS.t279 0.135296
R3758 VSS.t350 VSS.n432 0.135296
R3759 VSS.t222 VSS.n430 0.135296
R3760 VSS.t342 VSS.n429 0.135296
R3761 VSS.t337 VSS.n428 0.135296
R3762 VSS.t218 VSS.n426 0.135296
R3763 VSS.t328 VSS.n425 0.135296
R3764 VSS.t323 VSS.n424 0.135296
R3765 VSS.t313 VSS.n422 0.135296
R3766 VSS.n434 VSS.t104 0.135296
R3767 VSS.t693 VSS.t695 0.227075
R3768 VSS.t691 VSS.t584 0.227075
R3769 VSS.t2905 VSS.t2907 0.226736
R3770 VSS.t2912 VSS.t2910 0.226736
R3771 VSS.t2915 VSS.t2917 0.226736
R3772 VSS.t3075 VSS.t3077 0.226736
R3773 VSS.t3082 VSS.t3080 0.226736
R3774 VSS.t3085 VSS.t3087 0.226736
R3775 VSS.t3092 VSS.t3090 0.226736
R3776 VSS.t3095 VSS.t3097 0.226736
R3777 VSS.t3102 VSS.t3100 0.226736
R3778 VSS.t3105 VSS.t3107 0.226736
R3779 VSS.t3112 VSS.t3110 0.226736
R3780 VSS.t3115 VSS.t3117 0.226736
R3781 VSS.t3122 VSS.t3120 0.226736
R3782 VSS.t3125 VSS.t3127 0.226736
R3783 VSS.t3132 VSS.t3130 0.226736
R3784 VSS.t3135 VSS.t3137 0.226736
R3785 VSS.t3142 VSS.t3140 0.226736
R3786 VSS.t3150 VSS.t3152 0.226736
R3787 VSS.t3157 VSS.t3155 0.226736
R3788 VSS.t3160 VSS.t3162 0.226736
R3789 VSS.t3167 VSS.t3165 0.226736
R3790 VSS.t3170 VSS.t3172 0.226736
R3791 VSS.t3177 VSS.t3175 0.226736
R3792 VSS.t3180 VSS.t3182 0.226736
R3793 VSS.t3002 VSS.t3000 0.226736
R3794 VSS.t3007 VSS.t3005 0.226736
R3795 VSS.t3012 VSS.t3010 0.226736
R3796 VSS.t3017 VSS.t3015 0.226736
R3797 VSS.t3022 VSS.t3020 0.226736
R3798 VSS.t3027 VSS.t3025 0.226736
R3799 VSS.t3032 VSS.t3030 0.226736
R3800 VSS.t3037 VSS.t3035 0.226736
R3801 VSS.t3042 VSS.t3040 0.226736
R3802 VSS.t3047 VSS.t3045 0.226736
R3803 VSS.t3052 VSS.t3050 0.226736
R3804 VSS.t3057 VSS.t3055 0.226736
R3805 VSS.t3062 VSS.t3060 0.226736
R3806 VSS.t3067 VSS.t3065 0.226736
R3807 VSS.t2990 VSS.t2992 0.226736
R3808 VSS.t2985 VSS.t2987 0.226736
R3809 VSS.t2980 VSS.t2982 0.226736
R3810 VSS.t2975 VSS.t2977 0.226736
R3811 VSS.t2970 VSS.t2972 0.226736
R3812 VSS.t2965 VSS.t2967 0.226736
R3813 VSS.t2960 VSS.t2962 0.226736
R3814 VSS.t2955 VSS.t2957 0.226736
R3815 VSS.t2950 VSS.t2952 0.226736
R3816 VSS.t2945 VSS.t2947 0.226736
R3817 VSS.t2940 VSS.t2942 0.226736
R3818 VSS.t2935 VSS.t2937 0.226736
R3819 VSS.t2930 VSS.t2932 0.226736
R3820 VSS.t2927 VSS.t2925 0.226736
R3821 VSS.t2241 VSS.t2239 0.226736
R3822 VSS.t2246 VSS.t2244 0.226736
R3823 VSS.t2251 VSS.t2249 0.226736
R3824 VSS.t2256 VSS.t2254 0.226736
R3825 VSS.t2261 VSS.t2259 0.226736
R3826 VSS.t2266 VSS.t2264 0.226736
R3827 VSS.t2271 VSS.t2269 0.226736
R3828 VSS.t2276 VSS.t2274 0.226736
R3829 VSS.t2281 VSS.t2279 0.226736
R3830 VSS.t2286 VSS.t2284 0.226736
R3831 VSS.t2291 VSS.t2289 0.226736
R3832 VSS.t2296 VSS.t2294 0.226736
R3833 VSS.t2301 VSS.t2299 0.226736
R3834 VSS.t2306 VSS.t2304 0.226736
R3835 VSS.t2311 VSS.t2309 0.226736
R3836 VSS.t2316 VSS.t2314 0.226736
R3837 VSS.t2321 VSS.t2319 0.226736
R3838 VSS.t2326 VSS.t2324 0.226736
R3839 VSS.t2336 VSS.t2334 0.226736
R3840 VSS.t2341 VSS.t2339 0.226736
R3841 VSS.t2346 VSS.t2344 0.226736
R3842 VSS.t2351 VSS.t2349 0.226736
R3843 VSS.t2356 VSS.t2354 0.226736
R3844 VSS.t2361 VSS.t2359 0.226736
R3845 VSS.t2366 VSS.t2364 0.226736
R3846 VSS.t2371 VSS.t2369 0.226736
R3847 VSS.t2376 VSS.t2374 0.226736
R3848 VSS.t2381 VSS.t2379 0.226736
R3849 VSS.t2386 VSS.t2384 0.226736
R3850 VSS.t2391 VSS.t2389 0.226736
R3851 VSS.t2396 VSS.t2394 0.226736
R3852 VSS.t2401 VSS.t2399 0.226736
R3853 VSS.t2411 VSS.t2409 0.226736
R3854 VSS.t2416 VSS.t2414 0.226736
R3855 VSS.t2421 VSS.t2419 0.226736
R3856 VSS.t2426 VSS.t2424 0.226736
R3857 VSS.t2431 VSS.t2429 0.226736
R3858 VSS.t2436 VSS.t2434 0.226736
R3859 VSS.t2441 VSS.t2439 0.226736
R3860 VSS.t2446 VSS.t2444 0.226736
R3861 VSS.t2451 VSS.t2449 0.226736
R3862 VSS.t2456 VSS.t2454 0.226736
R3863 VSS.t2461 VSS.t2459 0.226736
R3864 VSS.t2466 VSS.t2464 0.226736
R3865 VSS.t2471 VSS.t2469 0.226736
R3866 VSS.t2476 VSS.t2474 0.226736
R3867 VSS.t2484 VSS.t2486 0.226736
R3868 VSS.t2491 VSS.t2489 0.226736
R3869 VSS.t2494 VSS.t2496 0.226736
R3870 VSS.t2501 VSS.t2499 0.226736
R3871 VSS.t2504 VSS.t2506 0.226736
R3872 VSS.t2511 VSS.t2509 0.226736
R3873 VSS.t2514 VSS.t2516 0.226736
R3874 VSS.t1849 VSS.t1847 0.226736
R3875 VSS.t1854 VSS.t1852 0.226736
R3876 VSS.t1859 VSS.t1857 0.226736
R3877 VSS.t1864 VSS.t1862 0.226736
R3878 VSS.t1869 VSS.t1867 0.226736
R3879 VSS.t1872 VSS.t1874 0.226736
R3880 VSS.t1879 VSS.t1877 0.226736
R3881 VSS.t1882 VSS.t1884 0.226736
R3882 VSS.t1889 VSS.t1887 0.226736
R3883 VSS.t1892 VSS.t1894 0.226736
R3884 VSS.t1899 VSS.t1897 0.226736
R3885 VSS.t1902 VSS.t1904 0.226736
R3886 VSS.t1909 VSS.t1907 0.226736
R3887 VSS.t1912 VSS.t1914 0.226736
R3888 VSS.t1919 VSS.t1917 0.226736
R3889 VSS.t1922 VSS.t1924 0.226736
R3890 VSS.t1929 VSS.t1927 0.226736
R3891 VSS.t1932 VSS.t1934 0.226736
R3892 VSS.t1942 VSS.t1944 0.226736
R3893 VSS.t1949 VSS.t1947 0.226736
R3894 VSS.t1952 VSS.t1954 0.226736
R3895 VSS.t1959 VSS.t1957 0.226736
R3896 VSS.t1962 VSS.t1964 0.226736
R3897 VSS.t1969 VSS.t1967 0.226736
R3898 VSS.t1972 VSS.t1974 0.226736
R3899 VSS.t1979 VSS.t1977 0.226736
R3900 VSS.t1982 VSS.t1984 0.226736
R3901 VSS.t1989 VSS.t1987 0.226736
R3902 VSS.t1992 VSS.t1994 0.226736
R3903 VSS.t1999 VSS.t1997 0.226736
R3904 VSS.t2002 VSS.t2004 0.226736
R3905 VSS.t2009 VSS.t2007 0.226736
R3906 VSS.t2017 VSS.t2019 0.226736
R3907 VSS.t2024 VSS.t2022 0.226736
R3908 VSS.t2027 VSS.t2029 0.226736
R3909 VSS.t2034 VSS.t2032 0.226736
R3910 VSS.t2037 VSS.t2039 0.226736
R3911 VSS.t2044 VSS.t2042 0.226736
R3912 VSS.t2047 VSS.t2049 0.226736
R3913 VSS.t2054 VSS.t2052 0.226736
R3914 VSS.t2057 VSS.t2059 0.226736
R3915 VSS.t2064 VSS.t2062 0.226736
R3916 VSS.t2067 VSS.t2069 0.226736
R3917 VSS.t2074 VSS.t2072 0.226736
R3918 VSS.t2077 VSS.t2079 0.226736
R3919 VSS.t2084 VSS.t2082 0.226736
R3920 VSS.t2094 VSS.t2092 0.226736
R3921 VSS.t2097 VSS.t2099 0.226736
R3922 VSS.t2104 VSS.t2102 0.226736
R3923 VSS.t2107 VSS.t2109 0.226736
R3924 VSS.t2114 VSS.t2112 0.226736
R3925 VSS.t2117 VSS.t2119 0.226736
R3926 VSS.t2124 VSS.t2122 0.226736
R3927 VSS.t1457 VSS.t1455 0.226736
R3928 VSS.t1462 VSS.t1460 0.226736
R3929 VSS.t1467 VSS.t1465 0.226736
R3930 VSS.t1472 VSS.t1470 0.226736
R3931 VSS.t1477 VSS.t1475 0.226736
R3932 VSS.t1482 VSS.t1480 0.226736
R3933 VSS.t1487 VSS.t1485 0.226736
R3934 VSS.t1492 VSS.t1490 0.226736
R3935 VSS.t1497 VSS.t1495 0.226736
R3936 VSS.t1502 VSS.t1500 0.226736
R3937 VSS.t1507 VSS.t1505 0.226736
R3938 VSS.t1512 VSS.t1510 0.226736
R3939 VSS.t1517 VSS.t1515 0.226736
R3940 VSS.t1522 VSS.t1520 0.226736
R3941 VSS.t1527 VSS.t1525 0.226736
R3942 VSS.t1532 VSS.t1530 0.226736
R3943 VSS.t1537 VSS.t1535 0.226736
R3944 VSS.t1542 VSS.t1540 0.226736
R3945 VSS.t1550 VSS.t1552 0.226736
R3946 VSS.t1557 VSS.t1555 0.226736
R3947 VSS.t1560 VSS.t1562 0.226736
R3948 VSS.t1567 VSS.t1565 0.226736
R3949 VSS.t1570 VSS.t1572 0.226736
R3950 VSS.t1577 VSS.t1575 0.226736
R3951 VSS.t1580 VSS.t1582 0.226736
R3952 VSS.t1587 VSS.t1585 0.226736
R3953 VSS.t1590 VSS.t1592 0.226736
R3954 VSS.t1597 VSS.t1595 0.226736
R3955 VSS.t1600 VSS.t1602 0.226736
R3956 VSS.t1607 VSS.t1605 0.226736
R3957 VSS.t1610 VSS.t1612 0.226736
R3958 VSS.t1617 VSS.t1615 0.226736
R3959 VSS.t1627 VSS.t1625 0.226736
R3960 VSS.t1632 VSS.t1630 0.226736
R3961 VSS.t1637 VSS.t1635 0.226736
R3962 VSS.t1642 VSS.t1640 0.226736
R3963 VSS.t1647 VSS.t1645 0.226736
R3964 VSS.t1652 VSS.t1650 0.226736
R3965 VSS.t1657 VSS.t1655 0.226736
R3966 VSS.t1662 VSS.t1660 0.226736
R3967 VSS.t1667 VSS.t1665 0.226736
R3968 VSS.t1672 VSS.t1670 0.226736
R3969 VSS.t1677 VSS.t1675 0.226736
R3970 VSS.t1682 VSS.t1680 0.226736
R3971 VSS.t1687 VSS.t1685 0.226736
R3972 VSS.t1692 VSS.t1690 0.226736
R3973 VSS.t1700 VSS.t1702 0.226736
R3974 VSS.t1707 VSS.t1705 0.226736
R3975 VSS.t1710 VSS.t1712 0.226736
R3976 VSS.t1717 VSS.t1715 0.226736
R3977 VSS.t1720 VSS.t1722 0.226736
R3978 VSS.t1727 VSS.t1725 0.226736
R3979 VSS.t1730 VSS.t1732 0.226736
R3980 VSS.t778 VSS.t776 0.226736
R3981 VSS.t783 VSS.t781 0.226736
R3982 VSS.t788 VSS.t786 0.226736
R3983 VSS.t793 VSS.t791 0.226736
R3984 VSS.t798 VSS.t796 0.226736
R3985 VSS.t803 VSS.t801 0.226736
R3986 VSS.t808 VSS.t806 0.226736
R3987 VSS.t813 VSS.t811 0.226736
R3988 VSS.t818 VSS.t816 0.226736
R3989 VSS.t823 VSS.t821 0.226736
R3990 VSS.t828 VSS.t826 0.226736
R3991 VSS.t833 VSS.t831 0.226736
R3992 VSS.t838 VSS.t836 0.226736
R3993 VSS.t843 VSS.t841 0.226736
R3994 VSS.t848 VSS.t846 0.226736
R3995 VSS.t853 VSS.t851 0.226736
R3996 VSS.t858 VSS.t856 0.226736
R3997 VSS.t863 VSS.t861 0.226736
R3998 VSS.t873 VSS.t871 0.226736
R3999 VSS.t878 VSS.t876 0.226736
R4000 VSS.t883 VSS.t881 0.226736
R4001 VSS.t888 VSS.t886 0.226736
R4002 VSS.t893 VSS.t891 0.226736
R4003 VSS.t898 VSS.t896 0.226736
R4004 VSS.t903 VSS.t901 0.226736
R4005 VSS.t908 VSS.t906 0.226736
R4006 VSS.t913 VSS.t911 0.226736
R4007 VSS.t918 VSS.t916 0.226736
R4008 VSS.t923 VSS.t921 0.226736
R4009 VSS.t928 VSS.t926 0.226736
R4010 VSS.t933 VSS.t931 0.226736
R4011 VSS.t938 VSS.t936 0.226736
R4012 VSS.t948 VSS.t946 0.226736
R4013 VSS.t953 VSS.t951 0.226736
R4014 VSS.t958 VSS.t956 0.226736
R4015 VSS.t963 VSS.t961 0.226736
R4016 VSS.t968 VSS.t966 0.226736
R4017 VSS.t973 VSS.t971 0.226736
R4018 VSS.t978 VSS.t976 0.226736
R4019 VSS.t983 VSS.t981 0.226736
R4020 VSS.t988 VSS.t986 0.226736
R4021 VSS.t993 VSS.t991 0.226736
R4022 VSS.t998 VSS.t996 0.226736
R4023 VSS.t1003 VSS.t1001 0.226736
R4024 VSS.t1008 VSS.t1006 0.226736
R4025 VSS.t1013 VSS.t1011 0.226736
R4026 VSS.t1021 VSS.t1023 0.226736
R4027 VSS.t1028 VSS.t1026 0.226736
R4028 VSS.t1031 VSS.t1033 0.226736
R4029 VSS.t1038 VSS.t1036 0.226736
R4030 VSS.t1041 VSS.t1043 0.226736
R4031 VSS.t1048 VSS.t1046 0.226736
R4032 VSS.t1051 VSS.t1053 0.226736
R4033 VSS.t738 VSS.t736 0.226736
R4034 VSS.t731 VSS.t733 0.226736
R4035 VSS.t580 VSS.t582 0.226736
R4036 VSS.t575 VSS.t577 0.226736
R4037 VSS.t537 VSS.t535 0.226736
R4038 VSS.t542 VSS.t540 0.226736
R4039 VSS.t547 VSS.t545 0.226736
R4040 VSS.t552 VSS.t550 0.226736
R4041 VSS.t557 VSS.t555 0.226736
R4042 VSS.t562 VSS.t560 0.226736
R4043 VSS.t567 VSS.t565 0.226736
R4044 VSS.t411 VSS.t412 0.226736
R4045 VSS.t415 VSS.t414 0.226736
R4046 VSS.t418 VSS.t417 0.226736
R4047 VSS.t421 VSS.t420 0.226736
R4048 VSS.t424 VSS.t423 0.226736
R4049 VSS.t427 VSS.t426 0.226736
R4050 VSS.t430 VSS.t429 0.226736
R4051 VSS.t433 VSS.t432 0.226736
R4052 VSS.t436 VSS.t435 0.226736
R4053 VSS.t439 VSS.t438 0.226736
R4054 VSS.t442 VSS.t441 0.226736
R4055 VSS.t445 VSS.t444 0.226736
R4056 VSS.t448 VSS.t447 0.226736
R4057 VSS.t451 VSS.t450 0.226736
R4058 VSS.t454 VSS.t453 0.226736
R4059 VSS.t399 VSS.t397 0.226736
R4060 VSS.t462 VSS.t460 0.226736
R4061 VSS.t467 VSS.t98 0.226736
R4062 VSS.t184 VSS.t182 0.226736
R4063 VSS.t81 VSS.t702 0.226736
R4064 VSS.t591 VSS.t715 0.224575
R4065 VSS.n28 VSS.t265 0.0268837
R4066 VSS.n369 VSS.t2930 0.0863258
R4067 VSS.n370 VSS.t2935 0.0863258
R4068 VSS.n371 VSS.t2940 0.0863258
R4069 VSS.n372 VSS.t2945 0.0863258
R4070 VSS.n373 VSS.t2950 0.0863258
R4071 VSS.n374 VSS.t2955 0.0863258
R4072 VSS.n375 VSS.t2960 0.0863258
R4073 VSS.n376 VSS.t2965 0.0863258
R4074 VSS.n377 VSS.t2970 0.0863258
R4075 VSS.n378 VSS.t2975 0.0863258
R4076 VSS.n379 VSS.t2980 0.0863258
R4077 VSS.n380 VSS.t2985 0.0863258
R4078 VSS.n381 VSS.t2990 0.0863258
R4079 VSS.n382 VSS.t2995 0.0863258
R4080 VSS.n763 VSS.t467 0.0863258
R4081 VSS.n707 VSS.t575 0.0863258
R4082 VSS.n708 VSS.t580 0.0863258
R4083 VSS.n720 VSS.t731 0.0863258
R4084 VSS.n691 VSS.t1021 0.0863258
R4085 VSS.n693 VSS.t1031 0.0863258
R4086 VSS.n695 VSS.t1041 0.0863258
R4087 VSS.n697 VSS.t1051 0.0863258
R4088 VSS.t1046 VSS.n696 0.0863258
R4089 VSS.t1036 VSS.n694 0.0863258
R4090 VSS.t1026 VSS.n692 0.0863258
R4091 VSS.t1011 VSS.n689 0.0863258
R4092 VSS.t866 VSS.n660 0.0863258
R4093 VSS.n642 VSS.t775 0.130189
R4094 VSS.t781 VSS.n643 0.0863258
R4095 VSS.t786 VSS.n644 0.0863258
R4096 VSS.t791 VSS.n645 0.0863258
R4097 VSS.n572 VSS.t1550 0.0863258
R4098 VSS.n574 VSS.t1560 0.0863258
R4099 VSS.n576 VSS.t1570 0.0863258
R4100 VSS.n578 VSS.t1580 0.0863258
R4101 VSS.n580 VSS.t1590 0.0863258
R4102 VSS.n582 VSS.t1600 0.0863258
R4103 VSS.n584 VSS.t1610 0.0863258
R4104 VSS.n530 VSS.t2017 0.0863258
R4105 VSS.n532 VSS.t2027 0.0863258
R4106 VSS.n534 VSS.t2037 0.0863258
R4107 VSS.n536 VSS.t2047 0.0863258
R4108 VSS.n538 VSS.t2057 0.0863258
R4109 VSS.n540 VSS.t2067 0.0863258
R4110 VSS.n542 VSS.t2077 0.0863258
R4111 VSS.n488 VSS.t2484 0.0863258
R4112 VSS.n490 VSS.t2494 0.0863258
R4113 VSS.n492 VSS.t2504 0.0863258
R4114 VSS.n494 VSS.t2514 0.0863258
R4115 VSS.t2509 VSS.n493 0.0863258
R4116 VSS.t2499 VSS.n491 0.0863258
R4117 VSS.t2489 VSS.n489 0.0863258
R4118 VSS.t2474 VSS.n486 0.0863258
R4119 VSS.t2329 VSS.n457 0.0863258
R4120 VSS.n439 VSS.t2238 0.130189
R4121 VSS.t2244 VSS.n440 0.0863258
R4122 VSS.t2249 VSS.n441 0.0863258
R4123 VSS.t2254 VSS.n442 0.0863258
R4124 VSS.n501 VSS.t1872 0.0863258
R4125 VSS.n503 VSS.t1882 0.0863258
R4126 VSS.n505 VSS.t1892 0.0863258
R4127 VSS.n507 VSS.t1902 0.0863258
R4128 VSS.n509 VSS.t1912 0.0863258
R4129 VSS.n511 VSS.t1922 0.0863258
R4130 VSS.n513 VSS.t1932 0.0863258
R4131 VSS.n515 VSS.t1942 0.0863258
R4132 VSS.n517 VSS.t1952 0.0863258
R4133 VSS.n519 VSS.t1962 0.0863258
R4134 VSS.n521 VSS.t1972 0.0863258
R4135 VSS.n523 VSS.t1982 0.0863258
R4136 VSS.n525 VSS.t1992 0.0863258
R4137 VSS.n527 VSS.t2002 0.0863258
R4138 VSS.t2007 VSS.n528 0.0863258
R4139 VSS.t1997 VSS.n526 0.0863258
R4140 VSS.t1987 VSS.n524 0.0863258
R4141 VSS.t1977 VSS.n522 0.0863258
R4142 VSS.t1967 VSS.n520 0.0863258
R4143 VSS.t1957 VSS.n518 0.0863258
R4144 VSS.t1947 VSS.n516 0.0863258
R4145 VSS.t1937 VSS.n514 0.0863258
R4146 VSS.t1927 VSS.n512 0.0863258
R4147 VSS.t1917 VSS.n510 0.0863258
R4148 VSS.t1907 VSS.n508 0.0863258
R4149 VSS.t1897 VSS.n506 0.0863258
R4150 VSS.t1887 VSS.n504 0.0863258
R4151 VSS.t1877 VSS.n502 0.0863258
R4152 VSS.t1867 VSS.n500 0.0863258
R4153 VSS.n496 VSS.t1846 0.130189
R4154 VSS.t1852 VSS.n497 0.0863258
R4155 VSS.t1857 VSS.n498 0.0863258
R4156 VSS.t1862 VSS.n499 0.0863258
R4157 VSS.t2259 VSS.n443 0.0863258
R4158 VSS.t2264 VSS.n444 0.0863258
R4159 VSS.t2269 VSS.n445 0.0863258
R4160 VSS.t2274 VSS.n446 0.0863258
R4161 VSS.t2279 VSS.n447 0.0863258
R4162 VSS.t2284 VSS.n448 0.0863258
R4163 VSS.t2289 VSS.n449 0.0863258
R4164 VSS.t2294 VSS.n450 0.0863258
R4165 VSS.t2299 VSS.n451 0.0863258
R4166 VSS.t2304 VSS.n452 0.0863258
R4167 VSS.t2309 VSS.n453 0.0863258
R4168 VSS.t2314 VSS.n454 0.0863258
R4169 VSS.t2319 VSS.n455 0.0863258
R4170 VSS.t2324 VSS.n456 0.0863258
R4171 VSS.t2334 VSS.n458 0.0863258
R4172 VSS.t2339 VSS.n459 0.0863258
R4173 VSS.t2344 VSS.n460 0.0863258
R4174 VSS.t2349 VSS.n461 0.0863258
R4175 VSS.t2354 VSS.n462 0.0863258
R4176 VSS.t2359 VSS.n463 0.0863258
R4177 VSS.t2364 VSS.n464 0.0863258
R4178 VSS.t2369 VSS.n465 0.0863258
R4179 VSS.t2374 VSS.n466 0.0863258
R4180 VSS.t2379 VSS.n467 0.0863258
R4181 VSS.t2384 VSS.n468 0.0863258
R4182 VSS.t2389 VSS.n469 0.0863258
R4183 VSS.t2394 VSS.n470 0.0863258
R4184 VSS.t2399 VSS.n471 0.0863258
R4185 VSS.t2409 VSS.n473 0.0863258
R4186 VSS.t2414 VSS.n474 0.0863258
R4187 VSS.t2419 VSS.n475 0.0863258
R4188 VSS.t2424 VSS.n476 0.0863258
R4189 VSS.t2429 VSS.n477 0.0863258
R4190 VSS.t2434 VSS.n478 0.0863258
R4191 VSS.t2439 VSS.n479 0.0863258
R4192 VSS.t2444 VSS.n480 0.0863258
R4193 VSS.t2449 VSS.n481 0.0863258
R4194 VSS.t2454 VSS.n482 0.0863258
R4195 VSS.t2459 VSS.n483 0.0863258
R4196 VSS.t2464 VSS.n484 0.0863258
R4197 VSS.t2469 VSS.n485 0.0863258
R4198 VSS.n398 VSS.t3075 0.0863258
R4199 VSS.n400 VSS.t3085 0.0863258
R4200 VSS.n402 VSS.t3095 0.0863258
R4201 VSS.n404 VSS.t3105 0.0863258
R4202 VSS.n406 VSS.t3115 0.0863258
R4203 VSS.n408 VSS.t3125 0.0863258
R4204 VSS.n410 VSS.t3135 0.0863258
R4205 VSS.n413 VSS.t3150 0.0863258
R4206 VSS.n415 VSS.t3160 0.0863258
R4207 VSS.n417 VSS.t3170 0.0863258
R4208 VSS.n419 VSS.t3180 0.0863258
R4209 VSS.t3175 VSS.n418 0.0863258
R4210 VSS.t3165 VSS.n416 0.0863258
R4211 VSS.t3155 VSS.n414 0.0863258
R4212 VSS.t3140 VSS.n411 0.0863258
R4213 VSS.t3130 VSS.n409 0.0863258
R4214 VSS.t3120 VSS.n407 0.0863258
R4215 VSS.t3110 VSS.n405 0.0863258
R4216 VSS.t3100 VSS.n403 0.0863258
R4217 VSS.t3090 VSS.n401 0.0863258
R4218 VSS.t3080 VSS.n399 0.0863258
R4219 VSS.t3065 VSS.n396 0.0863258
R4220 VSS.t3000 VSS.n383 0.0863258
R4221 VSS.t3005 VSS.n384 0.0863258
R4222 VSS.t3010 VSS.n385 0.0863258
R4223 VSS.t3015 VSS.n386 0.0863258
R4224 VSS.t3020 VSS.n387 0.0863258
R4225 VSS.t3025 VSS.n388 0.0863258
R4226 VSS.t3030 VSS.n389 0.0863258
R4227 VSS.t3035 VSS.n390 0.0863258
R4228 VSS.t3040 VSS.n391 0.0863258
R4229 VSS.t3045 VSS.n392 0.0863258
R4230 VSS.t3050 VSS.n393 0.0863258
R4231 VSS.t3055 VSS.n394 0.0863258
R4232 VSS.t3060 VSS.n395 0.0863258
R4233 VSS.n602 VSS.t1700 0.0863258
R4234 VSS.n604 VSS.t1710 0.0863258
R4235 VSS.n606 VSS.t1720 0.0863258
R4236 VSS.n608 VSS.t1730 0.0863258
R4237 VSS.t1725 VSS.n607 0.0863258
R4238 VSS.t1715 VSS.n605 0.0863258
R4239 VSS.t1705 VSS.n603 0.0863258
R4240 VSS.t1690 VSS.n600 0.0863258
R4241 VSS.t1625 VSS.n587 0.0863258
R4242 VSS.t1630 VSS.n588 0.0863258
R4243 VSS.t1635 VSS.n589 0.0863258
R4244 VSS.t1640 VSS.n590 0.0863258
R4245 VSS.t1645 VSS.n591 0.0863258
R4246 VSS.t1650 VSS.n592 0.0863258
R4247 VSS.t1655 VSS.n593 0.0863258
R4248 VSS.t1660 VSS.n594 0.0863258
R4249 VSS.t1665 VSS.n595 0.0863258
R4250 VSS.t1670 VSS.n596 0.0863258
R4251 VSS.t1675 VSS.n597 0.0863258
R4252 VSS.t1680 VSS.n598 0.0863258
R4253 VSS.t1685 VSS.n599 0.0863258
R4254 VSS.n546 VSS.t2097 0.0863258
R4255 VSS.n548 VSS.t2107 0.0863258
R4256 VSS.n550 VSS.t2117 0.0863258
R4257 VSS.t2122 VSS.n551 0.0863258
R4258 VSS.t2112 VSS.n549 0.0863258
R4259 VSS.t2102 VSS.n547 0.0863258
R4260 VSS.t2092 VSS.n545 0.0863258
R4261 VSS.t2082 VSS.n543 0.0863258
R4262 VSS.t2072 VSS.n541 0.0863258
R4263 VSS.t2062 VSS.n539 0.0863258
R4264 VSS.t2052 VSS.n537 0.0863258
R4265 VSS.t2042 VSS.n535 0.0863258
R4266 VSS.t2032 VSS.n533 0.0863258
R4267 VSS.t2022 VSS.n531 0.0863258
R4268 VSS.n746 VSS.t411 0.0863258
R4269 VSS.n760 VSS.t453 0.0863258
R4270 VSS.n759 VSS.t450 0.0863258
R4271 VSS.n758 VSS.t447 0.0863258
R4272 VSS.n757 VSS.t444 0.0863258
R4273 VSS.n756 VSS.t441 0.0863258
R4274 VSS.n755 VSS.t438 0.0863258
R4275 VSS.n754 VSS.t435 0.0863258
R4276 VSS.n753 VSS.t432 0.0863258
R4277 VSS.n752 VSS.t429 0.0863258
R4278 VSS.n751 VSS.t426 0.0863258
R4279 VSS.n750 VSS.t423 0.0863258
R4280 VSS.n749 VSS.t420 0.0863258
R4281 VSS.n748 VSS.t417 0.0863258
R4282 VSS.t414 VSS.n747 0.0863258
R4283 VSS.t1615 VSS.n585 0.0863258
R4284 VSS.t1605 VSS.n583 0.0863258
R4285 VSS.t1595 VSS.n581 0.0863258
R4286 VSS.t1585 VSS.n579 0.0863258
R4287 VSS.t1575 VSS.n577 0.0863258
R4288 VSS.t1565 VSS.n575 0.0863258
R4289 VSS.t1555 VSS.n573 0.0863258
R4290 VSS.n553 VSS.t1454 0.130189
R4291 VSS.t1460 VSS.n554 0.0863258
R4292 VSS.t1465 VSS.n555 0.0863258
R4293 VSS.t1470 VSS.n556 0.0863258
R4294 VSS.t1475 VSS.n557 0.0863258
R4295 VSS.t1480 VSS.n558 0.0863258
R4296 VSS.t1485 VSS.n559 0.0863258
R4297 VSS.t1490 VSS.n560 0.0863258
R4298 VSS.t1495 VSS.n561 0.0863258
R4299 VSS.t1500 VSS.n562 0.0863258
R4300 VSS.t1505 VSS.n563 0.0863258
R4301 VSS.t1510 VSS.n564 0.0863258
R4302 VSS.t1515 VSS.n565 0.0863258
R4303 VSS.t1520 VSS.n566 0.0863258
R4304 VSS.t1525 VSS.n567 0.0863258
R4305 VSS.t1530 VSS.n568 0.0863258
R4306 VSS.t1535 VSS.n569 0.0863258
R4307 VSS.t1540 VSS.n570 0.0863258
R4308 VSS.n571 VSS.t1545 0.0863258
R4309 VSS.t796 VSS.n646 0.0863258
R4310 VSS.t801 VSS.n647 0.0863258
R4311 VSS.t806 VSS.n648 0.0863258
R4312 VSS.t811 VSS.n649 0.0863258
R4313 VSS.t816 VSS.n650 0.0863258
R4314 VSS.t821 VSS.n651 0.0863258
R4315 VSS.t826 VSS.n652 0.0863258
R4316 VSS.t831 VSS.n653 0.0863258
R4317 VSS.t836 VSS.n654 0.0863258
R4318 VSS.t841 VSS.n655 0.0863258
R4319 VSS.t846 VSS.n656 0.0863258
R4320 VSS.t851 VSS.n657 0.0863258
R4321 VSS.t856 VSS.n658 0.0863258
R4322 VSS.t861 VSS.n659 0.0863258
R4323 VSS.t871 VSS.n661 0.0863258
R4324 VSS.t876 VSS.n662 0.0863258
R4325 VSS.t881 VSS.n663 0.0863258
R4326 VSS.t886 VSS.n664 0.0863258
R4327 VSS.t891 VSS.n665 0.0863258
R4328 VSS.t896 VSS.n666 0.0863258
R4329 VSS.t901 VSS.n667 0.0863258
R4330 VSS.t906 VSS.n668 0.0863258
R4331 VSS.t911 VSS.n669 0.0863258
R4332 VSS.t916 VSS.n670 0.0863258
R4333 VSS.t921 VSS.n671 0.0863258
R4334 VSS.t926 VSS.n672 0.0863258
R4335 VSS.t931 VSS.n673 0.0863258
R4336 VSS.t936 VSS.n674 0.0863258
R4337 VSS.t946 VSS.n676 0.0863258
R4338 VSS.t951 VSS.n677 0.0863258
R4339 VSS.t956 VSS.n678 0.0863258
R4340 VSS.t961 VSS.n679 0.0863258
R4341 VSS.t966 VSS.n680 0.0863258
R4342 VSS.t971 VSS.n681 0.0863258
R4343 VSS.t976 VSS.n682 0.0863258
R4344 VSS.t981 VSS.n683 0.0863258
R4345 VSS.t986 VSS.n684 0.0863258
R4346 VSS.t991 VSS.n685 0.0863258
R4347 VSS.t996 VSS.n686 0.0863258
R4348 VSS.t1001 VSS.n687 0.0863258
R4349 VSS.t1006 VSS.n688 0.0863258
R4350 VSS.n721 VSS.t736 0.0863258
R4351 VSS.t702 VSS.n712 0.0863258
R4352 VSS.t535 VSS.n699 0.0863258
R4353 VSS.t540 VSS.n700 0.0863258
R4354 VSS.t545 VSS.n701 0.0863258
R4355 VSS.t550 VSS.n702 0.0863258
R4356 VSS.t555 VSS.n703 0.0863258
R4357 VSS.t560 VSS.n704 0.0863258
R4358 VSS.t565 VSS.n705 0.0863258
R4359 VSS.n706 VSS.t570 0.0863258
R4360 VSS.t182 VSS.n764 0.0863258
R4361 VSS.n766 VSS.t396 0.130189
R4362 VSS.n768 VSS.t36 0.130189
R4363 VSS.t2904 VSS.n364 0.130189
R4364 VSS.n366 VSS.t2915 0.0863258
R4365 VSS.t2910 VSS.n365 0.0863258
R4366 VSS.t2925 VSS.n368 0.0863258
R4367 VSS.t276 VSS.t277 0.217986
R4368 VSS.t348 VSS.t88 0.217986
R4369 VSS.t345 VSS.t344 0.217986
R4370 VSS.t340 VSS.t339 0.217986
R4371 VSS.t335 VSS.t334 0.217986
R4372 VSS.t331 VSS.t330 0.217986
R4373 VSS.t326 VSS.t325 0.217986
R4374 VSS.t321 VSS.t320 0.217986
R4375 VSS.t311 VSS.t136 0.217986
R4376 VSS.t358 VSS.t357 0.217986
R4377 VSS.n714 VSS.t715 0.0861948
R4378 VSS.n710 VSS.t693 0.0861948
R4379 VSS.t2995 VSS.n1040 0.210486
R4380 VSS.n991 VSS.t2329 0.210486
R4381 VSS.t1937 VSS.n988 0.210486
R4382 VSS.n997 VSS.t1545 0.210486
R4383 VSS.n1002 VSS.t866 0.210486
R4384 VSS.n1027 VSS.t570 0.210486
R4385 VSS.n640 VSS.t71 0.104635
R4386 VSS.n709 VSS.t584 0.0818513
R4387 VSS.n938 VSS.t479 0.206736
R4388 VSS.t30 VSS.t34 0.204291
R4389 VSS.t30 VSS.t273 0.203557
R4390 VSS.t2638 VSS.t2639 0.190486
R4391 VSS.n711 VSS.t698 0.24604
R4392 VSS.t2725 VSS.n160 0.295354
R4393 VSS.n350 VSS.t2681 0.120486
R4394 VSS.t1308 VSS.n629 0.0605362
R4395 VSS.t1222 VSS.t1221 0.180789
R4396 VSS.t170 VSS.n830 0.180789
R4397 VSS.t2639 VSS.t2640 0.170825
R4398 VSS.t1177 VSS.t1178 0.170825
R4399 VSS.t2770 VSS.t2771 0.170789
R4400 VSS.t1438 VSS.n978 0.170789
R4401 VSS.t941 VSS.n892 0.170789
R4402 VSS.t1620 VSS.n996 0.170789
R4403 VSS.n981 VSS.t2012 0.170789
R4404 VSS.t2404 VSS.n987 0.170789
R4405 VSS.n983 VSS.t3070 0.170789
R4406 VSS.n433 VSS.t355 0.0836055
R4407 VSS.t698 VSS.n295 0.083315
R4408 VSS.t318 VSS.n423 0.0836055
R4409 VSS.n830 VSS.t530 0.164539
R4410 VSS.t773 VSS.n738 0.0647427
R4411 VSS.n761 VSS.t456 0.0647427
R4412 VSS.t3070 VSS.n397 0.07903
R4413 VSS.t2404 VSS.n472 0.07903
R4414 VSS.t2012 VSS.n529 0.07903
R4415 VSS.n586 VSS.t1620 0.07903
R4416 VSS.t941 VSS.n675 0.07903
R4417 VSS.t18 VSS.t287 0.157212
R4418 VSS.t479 VSS.n244 0.232574
R4419 VSS.t409 VSS.t67 0.153289
R4420 VSS.t2827 VSS.t2680 0.150789
R4421 VSS.t409 VSS.t60 0.147039
R4422 VSS.t2922 VSS.t2920 0.135506
R4423 VSS.t1177 VSS.t1337 0.130789
R4424 VSS.t2770 VSS.n218 0.305699
R4425 VSS.t353 VSS.n270 0.175751
R4426 VSS.t2725 VSS.n985 0.1105
R4427 VSS.n362 VSS.n983 0.081538
R4428 VSS.n361 VSS.t3145 0.181538
R4429 VSS.n339 VSS.n987 0.081538
R4430 VSS.n338 VSS.t2479 0.181538
R4431 VSS.n337 VSS.n981 0.081538
R4432 VSS.t2087 VSS.n336 0.181538
R4433 VSS.n335 VSS.n996 0.081538
R4434 VSS.n334 VSS.t1695 0.181538
R4435 VSS.n313 VSS.n892 0.081538
R4436 VSS.n312 VSS.t1016 0.181538
R4437 VSS.t601 VSS.n865 0.10425
R4438 VSS.n265 VSS.t316 0.155751
R4439 VSS.t1369 VSS.n234 0.269511
R4440 VSS.t2907 VSS.t2909 0.0855
R4441 VSS.t2914 VSS.t2912 0.0855
R4442 VSS.t2917 VSS.t2919 0.0855
R4443 VSS.t350 VSS.t352 0.0855
R4444 VSS.t355 VSS.t357 0.0855
R4445 VSS.t3074 VSS.t3072 0.0855
R4446 VSS.t3077 VSS.t3079 0.0855
R4447 VSS.t3084 VSS.t3082 0.0855
R4448 VSS.t3087 VSS.t3089 0.0855
R4449 VSS.t3094 VSS.t3092 0.0855
R4450 VSS.t3097 VSS.t3099 0.0855
R4451 VSS.t3104 VSS.t3102 0.0855
R4452 VSS.t3107 VSS.t3109 0.0855
R4453 VSS.t3114 VSS.t3112 0.0855
R4454 VSS.t3117 VSS.t3119 0.0855
R4455 VSS.t3124 VSS.t3122 0.0855
R4456 VSS.t3127 VSS.t3129 0.0855
R4457 VSS.t3134 VSS.t3132 0.0855
R4458 VSS.t3137 VSS.t3139 0.0855
R4459 VSS.t3144 VSS.t3142 0.0855
R4460 VSS.t3149 VSS.t3147 0.0855
R4461 VSS.t3152 VSS.t3154 0.0855
R4462 VSS.t3159 VSS.t3157 0.0855
R4463 VSS.t3162 VSS.t3164 0.0855
R4464 VSS.t3169 VSS.t3167 0.0855
R4465 VSS.t3172 VSS.t3174 0.0855
R4466 VSS.t3179 VSS.t3177 0.0855
R4467 VSS.t2999 VSS.t2997 0.0855
R4468 VSS.t3004 VSS.t3002 0.0855
R4469 VSS.t3009 VSS.t3007 0.0855
R4470 VSS.t3014 VSS.t3012 0.0855
R4471 VSS.t3019 VSS.t3017 0.0855
R4472 VSS.t3024 VSS.t3022 0.0855
R4473 VSS.t3029 VSS.t3027 0.0855
R4474 VSS.t3034 VSS.t3032 0.0855
R4475 VSS.t3039 VSS.t3037 0.0855
R4476 VSS.t3044 VSS.t3042 0.0855
R4477 VSS.t3049 VSS.t3047 0.0855
R4478 VSS.t3054 VSS.t3052 0.0855
R4479 VSS.t3059 VSS.t3057 0.0855
R4480 VSS.t3064 VSS.t3062 0.0855
R4481 VSS.t3067 VSS.t3069 0.0855
R4482 VSS.t2992 VSS.t2994 0.0855
R4483 VSS.t2987 VSS.t2989 0.0855
R4484 VSS.t2982 VSS.t2984 0.0855
R4485 VSS.t2977 VSS.t2979 0.0855
R4486 VSS.t2972 VSS.t2974 0.0855
R4487 VSS.t2967 VSS.t2969 0.0855
R4488 VSS.t2962 VSS.t2964 0.0855
R4489 VSS.t2957 VSS.t2959 0.0855
R4490 VSS.t2952 VSS.t2954 0.0855
R4491 VSS.t2947 VSS.t2949 0.0855
R4492 VSS.t2942 VSS.t2944 0.0855
R4493 VSS.t2937 VSS.t2939 0.0855
R4494 VSS.t2932 VSS.t2934 0.0855
R4495 VSS.t2929 VSS.t2927 0.0855
R4496 VSS.t2922 VSS.t2924 0.0855
R4497 VSS.t2243 VSS.t2241 0.0855
R4498 VSS.t2248 VSS.t2246 0.0855
R4499 VSS.t2253 VSS.t2251 0.0855
R4500 VSS.t2258 VSS.t2256 0.0855
R4501 VSS.t2263 VSS.t2261 0.0855
R4502 VSS.t2268 VSS.t2266 0.0855
R4503 VSS.t2273 VSS.t2271 0.0855
R4504 VSS.t2278 VSS.t2276 0.0855
R4505 VSS.t2283 VSS.t2281 0.0855
R4506 VSS.t2288 VSS.t2286 0.0855
R4507 VSS.t2293 VSS.t2291 0.0855
R4508 VSS.t2298 VSS.t2296 0.0855
R4509 VSS.t2303 VSS.t2301 0.0855
R4510 VSS.t2308 VSS.t2306 0.0855
R4511 VSS.t2313 VSS.t2311 0.0855
R4512 VSS.t2318 VSS.t2316 0.0855
R4513 VSS.t2323 VSS.t2321 0.0855
R4514 VSS.t2328 VSS.t2326 0.0855
R4515 VSS.t2333 VSS.t2331 0.0855
R4516 VSS.t2338 VSS.t2336 0.0855
R4517 VSS.t2343 VSS.t2341 0.0855
R4518 VSS.t2348 VSS.t2346 0.0855
R4519 VSS.t2353 VSS.t2351 0.0855
R4520 VSS.t2358 VSS.t2356 0.0855
R4521 VSS.t2363 VSS.t2361 0.0855
R4522 VSS.t2368 VSS.t2366 0.0855
R4523 VSS.t2373 VSS.t2371 0.0855
R4524 VSS.t2378 VSS.t2376 0.0855
R4525 VSS.t2383 VSS.t2381 0.0855
R4526 VSS.t2388 VSS.t2386 0.0855
R4527 VSS.t2393 VSS.t2391 0.0855
R4528 VSS.t2398 VSS.t2396 0.0855
R4529 VSS.t2403 VSS.t2401 0.0855
R4530 VSS.t2408 VSS.t2406 0.0855
R4531 VSS.t2413 VSS.t2411 0.0855
R4532 VSS.t2418 VSS.t2416 0.0855
R4533 VSS.t2423 VSS.t2421 0.0855
R4534 VSS.t2428 VSS.t2426 0.0855
R4535 VSS.t2433 VSS.t2431 0.0855
R4536 VSS.t2438 VSS.t2436 0.0855
R4537 VSS.t2443 VSS.t2441 0.0855
R4538 VSS.t2448 VSS.t2446 0.0855
R4539 VSS.t2453 VSS.t2451 0.0855
R4540 VSS.t2458 VSS.t2456 0.0855
R4541 VSS.t2463 VSS.t2461 0.0855
R4542 VSS.t2468 VSS.t2466 0.0855
R4543 VSS.t2473 VSS.t2471 0.0855
R4544 VSS.t2476 VSS.t2478 0.0855
R4545 VSS.t2483 VSS.t2481 0.0855
R4546 VSS.t2486 VSS.t2488 0.0855
R4547 VSS.t2493 VSS.t2491 0.0855
R4548 VSS.t2496 VSS.t2498 0.0855
R4549 VSS.t2503 VSS.t2501 0.0855
R4550 VSS.t2506 VSS.t2508 0.0855
R4551 VSS.t2513 VSS.t2511 0.0855
R4552 VSS.t1851 VSS.t1849 0.0855
R4553 VSS.t1856 VSS.t1854 0.0855
R4554 VSS.t1861 VSS.t1859 0.0855
R4555 VSS.t1864 VSS.t1866 0.0855
R4556 VSS.t1871 VSS.t1869 0.0855
R4557 VSS.t1874 VSS.t1876 0.0855
R4558 VSS.t1881 VSS.t1879 0.0855
R4559 VSS.t1884 VSS.t1886 0.0855
R4560 VSS.t1891 VSS.t1889 0.0855
R4561 VSS.t1894 VSS.t1896 0.0855
R4562 VSS.t1901 VSS.t1899 0.0855
R4563 VSS.t1904 VSS.t1906 0.0855
R4564 VSS.t1911 VSS.t1909 0.0855
R4565 VSS.t1914 VSS.t1916 0.0855
R4566 VSS.t1921 VSS.t1919 0.0855
R4567 VSS.t1924 VSS.t1926 0.0855
R4568 VSS.t1931 VSS.t1929 0.0855
R4569 VSS.t1934 VSS.t1936 0.0855
R4570 VSS.t1941 VSS.t1939 0.0855
R4571 VSS.t1944 VSS.t1946 0.0855
R4572 VSS.t1951 VSS.t1949 0.0855
R4573 VSS.t1954 VSS.t1956 0.0855
R4574 VSS.t1961 VSS.t1959 0.0855
R4575 VSS.t1964 VSS.t1966 0.0855
R4576 VSS.t1971 VSS.t1969 0.0855
R4577 VSS.t1974 VSS.t1976 0.0855
R4578 VSS.t1981 VSS.t1979 0.0855
R4579 VSS.t1984 VSS.t1986 0.0855
R4580 VSS.t1991 VSS.t1989 0.0855
R4581 VSS.t1994 VSS.t1996 0.0855
R4582 VSS.t2001 VSS.t1999 0.0855
R4583 VSS.t2004 VSS.t2006 0.0855
R4584 VSS.t2009 VSS.t2011 0.0855
R4585 VSS.t2016 VSS.t2014 0.0855
R4586 VSS.t2019 VSS.t2021 0.0855
R4587 VSS.t2026 VSS.t2024 0.0855
R4588 VSS.t2029 VSS.t2031 0.0855
R4589 VSS.t2036 VSS.t2034 0.0855
R4590 VSS.t2039 VSS.t2041 0.0855
R4591 VSS.t2046 VSS.t2044 0.0855
R4592 VSS.t2049 VSS.t2051 0.0855
R4593 VSS.t2056 VSS.t2054 0.0855
R4594 VSS.t2059 VSS.t2061 0.0855
R4595 VSS.t2066 VSS.t2064 0.0855
R4596 VSS.t2069 VSS.t2071 0.0855
R4597 VSS.t2076 VSS.t2074 0.0855
R4598 VSS.t2079 VSS.t2081 0.0855
R4599 VSS.t2086 VSS.t2084 0.0855
R4600 VSS.t2089 VSS.t2091 0.0855
R4601 VSS.t2096 VSS.t2094 0.0855
R4602 VSS.t2099 VSS.t2101 0.0855
R4603 VSS.t2106 VSS.t2104 0.0855
R4604 VSS.t2109 VSS.t2111 0.0855
R4605 VSS.t2116 VSS.t2114 0.0855
R4606 VSS.t2119 VSS.t2121 0.0855
R4607 VSS.t1459 VSS.t1457 0.0855
R4608 VSS.t1464 VSS.t1462 0.0855
R4609 VSS.t1469 VSS.t1467 0.0855
R4610 VSS.t1474 VSS.t1472 0.0855
R4611 VSS.t1479 VSS.t1477 0.0855
R4612 VSS.t1484 VSS.t1482 0.0855
R4613 VSS.t1489 VSS.t1487 0.0855
R4614 VSS.t1494 VSS.t1492 0.0855
R4615 VSS.t1499 VSS.t1497 0.0855
R4616 VSS.t1504 VSS.t1502 0.0855
R4617 VSS.t1509 VSS.t1507 0.0855
R4618 VSS.t1514 VSS.t1512 0.0855
R4619 VSS.t1519 VSS.t1517 0.0855
R4620 VSS.t1524 VSS.t1522 0.0855
R4621 VSS.t1529 VSS.t1527 0.0855
R4622 VSS.t1534 VSS.t1532 0.0855
R4623 VSS.t1539 VSS.t1537 0.0855
R4624 VSS.t1544 VSS.t1542 0.0855
R4625 VSS.t1549 VSS.t1547 0.0855
R4626 VSS.t1552 VSS.t1554 0.0855
R4627 VSS.t1559 VSS.t1557 0.0855
R4628 VSS.t1562 VSS.t1564 0.0855
R4629 VSS.t1569 VSS.t1567 0.0855
R4630 VSS.t1572 VSS.t1574 0.0855
R4631 VSS.t1579 VSS.t1577 0.0855
R4632 VSS.t1582 VSS.t1584 0.0855
R4633 VSS.t1589 VSS.t1587 0.0855
R4634 VSS.t1592 VSS.t1594 0.0855
R4635 VSS.t1599 VSS.t1597 0.0855
R4636 VSS.t1602 VSS.t1604 0.0855
R4637 VSS.t1609 VSS.t1607 0.0855
R4638 VSS.t1612 VSS.t1614 0.0855
R4639 VSS.t1619 VSS.t1617 0.0855
R4640 VSS.t1624 VSS.t1622 0.0855
R4641 VSS.t1629 VSS.t1627 0.0855
R4642 VSS.t1634 VSS.t1632 0.0855
R4643 VSS.t1639 VSS.t1637 0.0855
R4644 VSS.t1644 VSS.t1642 0.0855
R4645 VSS.t1649 VSS.t1647 0.0855
R4646 VSS.t1654 VSS.t1652 0.0855
R4647 VSS.t1659 VSS.t1657 0.0855
R4648 VSS.t1664 VSS.t1662 0.0855
R4649 VSS.t1669 VSS.t1667 0.0855
R4650 VSS.t1674 VSS.t1672 0.0855
R4651 VSS.t1679 VSS.t1677 0.0855
R4652 VSS.t1684 VSS.t1682 0.0855
R4653 VSS.t1689 VSS.t1687 0.0855
R4654 VSS.t1692 VSS.t1694 0.0855
R4655 VSS.t1699 VSS.t1697 0.0855
R4656 VSS.t1702 VSS.t1704 0.0855
R4657 VSS.t1709 VSS.t1707 0.0855
R4658 VSS.t1712 VSS.t1714 0.0855
R4659 VSS.t1719 VSS.t1717 0.0855
R4660 VSS.t1722 VSS.t1724 0.0855
R4661 VSS.t1729 VSS.t1727 0.0855
R4662 VSS.t780 VSS.t778 0.0855
R4663 VSS.t785 VSS.t783 0.0855
R4664 VSS.t790 VSS.t788 0.0855
R4665 VSS.t795 VSS.t793 0.0855
R4666 VSS.t800 VSS.t798 0.0855
R4667 VSS.t805 VSS.t803 0.0855
R4668 VSS.t810 VSS.t808 0.0855
R4669 VSS.t815 VSS.t813 0.0855
R4670 VSS.t820 VSS.t818 0.0855
R4671 VSS.t825 VSS.t823 0.0855
R4672 VSS.t830 VSS.t828 0.0855
R4673 VSS.t835 VSS.t833 0.0855
R4674 VSS.t840 VSS.t838 0.0855
R4675 VSS.t845 VSS.t843 0.0855
R4676 VSS.t850 VSS.t848 0.0855
R4677 VSS.t855 VSS.t853 0.0855
R4678 VSS.t860 VSS.t858 0.0855
R4679 VSS.t865 VSS.t863 0.0855
R4680 VSS.t870 VSS.t868 0.0855
R4681 VSS.t875 VSS.t873 0.0855
R4682 VSS.t880 VSS.t878 0.0855
R4683 VSS.t885 VSS.t883 0.0855
R4684 VSS.t890 VSS.t888 0.0855
R4685 VSS.t895 VSS.t893 0.0855
R4686 VSS.t900 VSS.t898 0.0855
R4687 VSS.t905 VSS.t903 0.0855
R4688 VSS.t910 VSS.t908 0.0855
R4689 VSS.t915 VSS.t913 0.0855
R4690 VSS.t920 VSS.t918 0.0855
R4691 VSS.t925 VSS.t923 0.0855
R4692 VSS.t930 VSS.t928 0.0855
R4693 VSS.t935 VSS.t933 0.0855
R4694 VSS.t940 VSS.t938 0.0855
R4695 VSS.t945 VSS.t943 0.0855
R4696 VSS.t950 VSS.t948 0.0855
R4697 VSS.t955 VSS.t953 0.0855
R4698 VSS.t960 VSS.t958 0.0855
R4699 VSS.t965 VSS.t963 0.0855
R4700 VSS.t970 VSS.t968 0.0855
R4701 VSS.t975 VSS.t973 0.0855
R4702 VSS.t980 VSS.t978 0.0855
R4703 VSS.t985 VSS.t983 0.0855
R4704 VSS.t990 VSS.t988 0.0855
R4705 VSS.t995 VSS.t993 0.0855
R4706 VSS.t1000 VSS.t998 0.0855
R4707 VSS.t1005 VSS.t1003 0.0855
R4708 VSS.t1010 VSS.t1008 0.0855
R4709 VSS.t1013 VSS.t1015 0.0855
R4710 VSS.t1020 VSS.t1018 0.0855
R4711 VSS.t1023 VSS.t1025 0.0855
R4712 VSS.t1030 VSS.t1028 0.0855
R4713 VSS.t1033 VSS.t1035 0.0855
R4714 VSS.t1040 VSS.t1038 0.0855
R4715 VSS.t1043 VSS.t1045 0.0855
R4716 VSS.t1050 VSS.t1048 0.0855
R4717 VSS.t110 VSS.t738 0.0855
R4718 VSS.t733 VSS.t735 0.0855
R4719 VSS.t211 VSS.t207 0.0855
R4720 VSS.t701 VSS.t699 0.0855
R4721 VSS.t697 VSS.t695 0.0855
R4722 VSS.t79 VSS.t691 0.0855
R4723 VSS.t577 VSS.t579 0.0855
R4724 VSS.t574 VSS.t572 0.0855
R4725 VSS.t534 VSS.t142 0.0855
R4726 VSS.t539 VSS.t537 0.0855
R4727 VSS.t544 VSS.t542 0.0855
R4728 VSS.t549 VSS.t547 0.0855
R4729 VSS.t554 VSS.t552 0.0855
R4730 VSS.t559 VSS.t557 0.0855
R4731 VSS.t564 VSS.t562 0.0855
R4732 VSS.t569 VSS.t567 0.0855
R4733 VSS.n745 VSS.t41 0.205486
R4734 VSS.t412 VSS.t413 0.0855
R4735 VSS.t415 VSS.t416 0.0855
R4736 VSS.t418 VSS.t419 0.0855
R4737 VSS.t421 VSS.t422 0.0855
R4738 VSS.t424 VSS.t425 0.0855
R4739 VSS.t427 VSS.t428 0.0855
R4740 VSS.t430 VSS.t431 0.0855
R4741 VSS.t433 VSS.t434 0.0855
R4742 VSS.t436 VSS.t437 0.0855
R4743 VSS.t439 VSS.t440 0.0855
R4744 VSS.t442 VSS.t443 0.0855
R4745 VSS.t445 VSS.t446 0.0855
R4746 VSS.t448 VSS.t449 0.0855
R4747 VSS.t451 VSS.t452 0.0855
R4748 VSS.t11 VSS.t399 0.0855
R4749 VSS.t98 VSS.t470 0.0855
R4750 VSS.n296 VSS.t184 0.0432886
R4751 VSS.t320 VSS.t318 0.0855
R4752 VSS.t325 VSS.t323 0.0855
R4753 VSS.t330 VSS.t328 0.0855
R4754 VSS.t339 VSS.t337 0.0855
R4755 VSS.t344 VSS.t342 0.0855
R4756 VSS.t313 VSS.t315 0.0855
R4757 VSS.t216 VSS.t172 0.0855
R4758 VSS.t603 VSS.t157 0.07425
R4759 VSS.t582 VSS.t585 0.07425
R4760 VSS.t454 VSS.t455 0.07425
R4761 VSS.t279 VSS.t20 0.07425
R4762 VSS.n985 VSS.t2726 0.070789
R4763 VSS.t1265 VSS.t1266 0.070789
R4764 VSS.t1016 VSS.n690 0.149319
R4765 VSS.n544 VSS.t2087 0.149319
R4766 VSS.t2479 VSS.n487 0.149319
R4767 VSS.n412 VSS.t3145 0.149319
R4768 VSS.t1695 VSS.n601 0.149319
R4769 VSS.t18 VSS.n131 0.0643474
R4770 VSS.t18 VSS.n153 0.0643474
R4771 VSS.t18 VSS.n133 0.0643474
R4772 VSS.t18 VSS.n151 0.0643474
R4773 VSS.t18 VSS.n135 0.0643474
R4774 VSS.t18 VSS.n148 0.0643474
R4775 VSS.t18 VSS.n138 0.0643474
R4776 VSS.t18 VSS.n146 0.0643474
R4777 VSS.t18 VSS.n140 0.0643474
R4778 VSS.t18 VSS.n144 0.0643474
R4779 VSS.t18 VSS.n142 0.0329225
R4780 VSS.n928 VSS.t18 0.0643474
R4781 VSS.n924 VSS.t18 0.0643474
R4782 VSS.t3252 VSS.n357 28.0549
R4783 VSS.n908 VSS.t30 0.0643474
R4784 VSS.t30 VSS.n178 0.0643474
R4785 VSS.t30 VSS.n204 0.0643474
R4786 VSS.t30 VSS.n180 0.0643474
R4787 VSS.t30 VSS.n202 0.0643474
R4788 VSS.t30 VSS.n182 0.0643474
R4789 VSS.t30 VSS.n200 0.0643474
R4790 VSS.t30 VSS.n185 0.0643474
R4791 VSS.t30 VSS.n197 0.0643474
R4792 VSS.t30 VSS.n187 0.0643474
R4793 VSS.t30 VSS.n195 0.0643474
R4794 VSS.t30 VSS.n189 0.0643474
R4795 VSS.t30 VSS.n193 0.0329225
R4796 VSS.t47 VSS.t4 0.05925
R4797 VSS.n833 VSS.t518 0.0505812
R4798 VSS.t30 VSS.t394 0.0327393
R4799 VSS.t2827 VSS.t2681 0.0305
R4800 VSS.t1221 VSS.t1369 0.0305
R4801 VSS.n3 VSS.t2500 109.992
R4802 VSS.n3 VSS.t2450 109.992
R4803 VSS.n3 VSS.t2425 109.992
R4804 VSS.n3 VSS.t2400 109.992
R4805 VSS.n3 VSS.t2310 109.992
R4806 VSS.n3 VSS.t2260 109.992
R4807 VSS.t2088 VSS.n2 109.992
R4808 VSS.t1993 VSS.n2 109.992
R4809 VSS.n2 VSS.t1968 109.992
R4810 VSS.n2 VSS.t1928 109.992
R4811 VSS.n1 VSS.t1726 109.992
R4812 VSS.n1 VSS.t1696 109.992
R4813 VSS.n1 VSS.t1671 109.992
R4814 VSS.n1 VSS.t1646 109.992
R4815 VSS.t1621 VSS.n1 109.992
R4816 VSS.t1601 VSS.n1 109.992
R4817 VSS.n1 VSS.t1576 109.992
R4818 VSS.t1551 VSS.n1 109.992
R4819 VSS.n1 VSS.t1526 109.992
R4820 VSS.n1 VSS.t1506 109.992
R4821 VSS.n0 VSS.t1037 109.992
R4822 VSS.n0 VSS.t1027 109.992
R4823 VSS.n0 VSS.t1017 109.992
R4824 VSS.n0 VSS.t1007 109.992
R4825 VSS.n0 VSS.t957 109.992
R4826 VSS.n0 VSS.t947 109.992
R4827 VSS.n0 VSS.t932 109.992
R4828 VSS.n0 VSS.t917 109.992
R4829 VSS.n0 VSS.t887 109.992
R4830 VSS.n0 VSS.t862 109.992
R4831 VSS.n0 VSS.t792 109.992
R4832 VSS.t512 VSS.n106 0.00915177
R4833 VSS.t92 VSS.n163 0.0258175
R4834 VSS.n121 VSS.t512 0.0153688
R4835 VSS.t512 VSS.n107 0.00915177
R4836 VSS.t512 VSS.n108 0.00915177
R4837 VSS.t512 VSS.n109 0.00915177
R4838 VSS.n230 VSS.t541 109.992
R4839 VSS.t197 VSS.n69 0.0258175
R4840 VSS.t197 VSS.n71 0.0258175
R4841 VSS.t197 VSS.n70 0.0258175
R4842 VSS.n859 VSS.t197 0.0258175
R4843 VSS.n232 VSS.t3305 89.1967
R4844 VSS.t512 VSS.n111 0.0148802
R4845 VSS.t512 VSS.n118 0.0258175
R4846 VSS.t512 VSS.n113 0.0258175
R4847 VSS.t512 VSS.n116 0.0258175
R4848 VSS VSS.n1041 0.01986
R4849 VSS.n1040 VSS.t2997 0.01675
R4850 VSS.t2331 VSS.n991 0.01675
R4851 VSS.n988 VSS.t1939 0.01675
R4852 VSS.n997 VSS.t1547 0.01675
R4853 VSS.t868 VSS.n1002 0.01675
R4854 VSS.n1027 VSS.t572 0.01675
R4855 VSS.t30 VSS.n199 0.0112735
R4856 VSS.t30 VSS.n206 0.0109756
R4857 VSS.t1309 VSS.n978 0.0105
R4858 VSS.t599 VSS.n865 0.0105
R4859 VSS.n974 VSS.t3191 0.0105
R4860 VSS.t3151 VSS.n30 183.805
R4861 VSS.t3126 VSS.n30 183.805
R4862 VSS.n30 VSS.t3121 183.805
R4863 VSS.t3106 VSS.n30 183.805
R4864 VSS.t3076 VSS.n30 183.805
R4865 VSS.n30 VSS.t3056 183.805
R4866 VSS.n30 VSS.t3011 183.805
R4867 VSS.t2931 VSS.n30 183.805
R4868 VSS.n857 VSS.t197 0.0432851
R4869 VSS.t92 VSS.t197 0.0279676
R4870 VSS.n97 VSS.n215 0.0267027
R4871 VSS.n46 VSS.n100 0.0262179
R4872 VSS.n96 VSS.n105 0.0244777
R4873 VSS.n95 VSS.n104 0.0244777
R4874 VSS.n40 VSS.n105 0.0706505
R4875 VSS.n129 VSS.n104 0.017046
R4876 VSS.n127 VSS.n103 0.017046
R4877 VSS.n125 VSS.n102 0.017046
R4878 VSS.t92 VSS.t512 0.014903
R4879 VSS.t18 VSS.t30 0.0147735
R4880 VSS.t18 VSS.n136 0.0127735
R4881 VSS.n128 VSS.n96 0.0126632
R4882 VSS.n126 VSS.n95 0.0126632
R4883 VSS.n124 VSS.n103 0.0126632
R4884 VSS.n100 VSS.n102 0.0126632
R4885 VSS.n47 VSS.n46 0.0117401
R4886 VSS.t512 VSS.n114 0.0103339
R4887 VSS.t512 VSS.n117 0.0103339
R4888 VSS.t512 VSS.n112 0.0103155
R4889 VSS.n30 VSS.t2911 183.805
R4890 VSS.n645 VSS.n0 4.29336
R4891 VSS.n556 VSS.n1 4.29335
R4892 VSS.n499 VSS.n2 4.29333
R4893 VSS.n442 VSS.n3 4.29331
R4894 VSS.t70 VSS.n122 2.98437
R4895 VSS.n367 VSS.n30 2.86036
R4896 VSS.n43 VSS.t15 1.19599
C0 a_7937_13912# a_8218_13690# 0.18796f
C1 a_25670_14922# a_25956_14488# 0.26205f
C2 a_24169_14508# sg13cmos5l_o21ai_1_2.B1 0.24209f
C3 a_14261_15238# VDD 0.49384f
C4 sg13cmos5l_or3_1_1.B sg13cmos5l_nor2_1_0.B 0.1517f
C5 sg13cmos5l_or3_1_1.A sg13cmos5l_dfrbpq_1_7.RESET_B 0.02533f
C6 a_21034_14452# a_21477_14495# 0.02241f
C7 a_25670_14922# a_26475_14495# 0.07916f
C8 sg13cmos5l_buf_8_2.X a_25670_14922# 0.01876f
C9 a_6401_13912# sg13cmos5l_dlygate4sd3_1_0.A 0.04884f
C10 sg13cmos5l_dfrbpq_1_2.CLK a_6789_14495# 0.2273f
C11 sg13cmos5l_or3_1_1.X a_24923_15996# 0.06735f
C12 a_5896_13854# sg13cmos5l_dlygate4sd3_1_0.X 0.01652f
C13 sg13cmos5l_or3_1_2.X a_21185_15424# 0.02913f
C14 sg13cmos5l_dlygate4sd3_1_0.X a_5613_14832# 0.20961f
C15 counter_value_o[2] VDD 0.12104f
C16 a_4474_14448# a_4193_14750# 0.18796f
C17 a_15870_15486# sg13cmos5l_nor2_1_0.B 0.0389f
C18 a_1192_3900# enable_i 0.1951f
C19 a_2916_15552# VDD 0.09493f
C20 sg13cmos5l_dfrbpq_1_6.RESET_B VDD 1.15314f
C21 a_2890_15457# sg13cmos5l_dlygate4sd3_1_3.A 0.01478f
C22 sg13cmos5l_dlygate4sd3_1_8.A a_9963_15356# 0.0308f
C23 a_27407_13799# a_26148_14040# 0.01412f
C24 sg13cmos5l_a21oi_1_3.Y a_25109_12972# 0.10082f
C25 a_26170_15202# VDD 0.25937f
C26 sg13cmos5l_a21oi_1_0.A1 a_16955_14484# 0.02731f
C27 a_9444_15552# a_10703_15311# 0.01412f
C28 a_37484_15960# counter_value_o[7] 0.15504f
C29 a_27472_14726# a_27882_14484# 0.07015f
C30 a_9158_15234# sg13cmos5l_nand4_1_0.Y 0.02144f
C31 a_15671_15315# sg13cmos5l_inv_1_0.A 0.03242f
C32 sg13cmos5l_dfrbpq_1_5.D a_25862_13722# 0.17436f
C33 a_4175_15311# VDD 0.17883f
C34 a_21034_14452# sg13cmos5l_dfrbpq_1_6.RESET_B 0.17208f
C35 a_9158_15234# a_9861_15213# 0.02453f
C36 sg13cmos5l_dfrbpq_1_7.Q a_25956_14488# 0.03198f
C37 sg13cmos5l_dfrbpq_1_3.RESET_B a_18123_14495# 0.28174f
C38 counter_value_o[1] VDD 0.11682f
C39 a_24824_14525# sg13cmos5l_dlygate4sd3_1_17.A 0.29888f
C40 a_5886_15486# VDD 0.09482f
C41 sg13cmos5l_dfrbpq_1_7.Q a_26475_14495# 0.03274f
C42 a_22576_14726# sg13cmos5l_dfrbpq_1_6.RESET_B 0.09622f
C43 sg13cmos5l_buf_8_2.X sg13cmos5l_dfrbpq_1_7.Q 0.1448f
C44 sg13cmos5l_o21ai_1_1.Y VDD 0.29617f
C45 a_23552_14570# VDD 0.06435f
C46 sg13cmos5l_dlygate4sd3_1_3.A sg13cmos5l_dfrbpq_1_2.CLK 0.05316f
C47 sg13cmos5l_and2_1_2.B sg13cmos5l_dfrbpq_1_2.CLK 0.03578f
C48 a_26638_15423# sg13cmos5l_or3_1_1.A 0.01026f
C49 sg13cmos5l_a21oi_1_3.B1 a_18123_14495# 0.01374f
C50 sg13cmos5l_dfrbpq_1_3.Q counter_value_o[4] 0.01007f
C51 sg13cmos5l_o21ai_1_2.B1 sg13cmos5l_o21ai_1_2.Y 0.55898f
C52 sg13cmos5l_a21oi_1_0.Y sg13cmos5l_buf_8_2.A 0.21299f
C53 sg13cmos5l_buf_1_0.X a_2916_15552# 0.0434f
C54 a_6372_14488# a_6660_14909# 0.24435f
C55 sg13cmos5l_a21oi_1_1.Y sg13cmos5l_or3_1_2.B 0.39227f
C56 sg13cmos5l_o21ai_1_3.Y sg13cmos5l_or3_1_1.C 0.05321f
C57 sg13cmos5l_a21oi_1_0.A2 a_16955_14484# 0.05566f
C58 a_16552_15996# counter_value_o[3] 0.1598f
C59 a_11370_15532# VDD 0.27891f
C60 a_19450_15202# sg13cmos5l_dfrbpq_1_2.Q 0.02358f
C61 sg13cmos5l_dfrbpq_1_3.RESET_B sg13cmos5l_dfrbpq_1_2.Q 0.24996f
C62 sg13cmos5l_xnor2_1_2.A a_7822_13911# 0.11116f
C63 sg13cmos5l_xor2_1_0.B sg13cmos5l_dlygate4sd3_1_3.A 0.05133f
C64 sg13cmos5l_and2_1_2.X sg13cmos5l_nand4_1_0.Y 0.01576f
C65 a_19120_14726# VDD 0.13647f
C66 sg13cmos5l_dfrbpq_1_6.D sg13cmos5l_dfrbpq_1_6.RESET_B 0.64332f
C67 a_6891_14495# a_7631_14845# 0.17382f
C68 a_21477_14495# a_21466_15202# 0.01088f
C69 sg13cmos5l_dfrbpq_1_2.Q a_17806_15423# 0.01441f
C70 sg13cmos5l_dfrbpq_1_3.RESET_B a_17604_14488# 0.30415f
C71 sg13cmos5l_a21oi_1_3.B1 sg13cmos5l_dfrbpq_1_2.Q 0.27687f
C72 a_17710_16263# sg13cmos5l_a21oi_1_0.A1 0.10824f
C73 a_21251_13690# a_21460_14020# 0.01485f
C74 sg13cmos5l_or3_1_2.X a_20968_13854# 0.02112f
C75 sg13cmos5l_buf_1_0.X a_4175_15311# 0.0138f
C76 sg13cmos5l_or3_1_2.X sg13cmos5l_or3_1_2.C 0.02676f
C77 counter_value_o[0] VDD 0.11896f
C78 sg13cmos5l_or3_1_1.B sg13cmos5l_buf_8_2.A 0.33039f
C79 a_27407_13799# VDD 0.18933f
C80 sg13cmos5l_tiehi_1.L_HI a_9963_15356# 0.28158f
C81 a_25206_15302# sg13cmos5l_a21oi_1_3.A1 0.11555f
C82 sg13cmos5l_dfrbpq_1_5.RESET_B a_26565_13701# 0.03932f
C83 a_22319_14845# VDD 0.19988f
C84 a_22025_16334# VDD 0.07626f
C85 sg13cmos5l_a21oi_1_3.A1 sg13cmos5l_o21ai_1_2.B1 0.02427f
C86 sg13cmos5l_a21oi_1_3.B1 a_17604_14488# 0.03688f
C87 sg13cmos5l_dlygate4sd3_1_4.X sg13cmos5l_dfrbpq_1_2.Q 0.07532f
C88 a_9658_14725# a_9861_14521# 0.02453f
C89 sg13cmos5l_a21oi_1_0.Y a_16955_14484# 0.0998f
C90 a_3333_15213# a_3204_15247# 0.01562f
C91 a_2890_15457# a_3333_15213# 0.02241f
C92 sg13cmos5l_and2_1_0.X a_2630_15234# 0.18471f
C93 a_23736_14464# VDD 0.01784f
C94 a_18021_14495# VDD 0.24448f
C95 a_16856_15238# sg13cmos5l_dfrbpq_1_2.CLK 0.01408f
C96 sg13cmos5l_o21ai_1_1.Y sg13cmos5l_dfrbpq_1_6.D 0.09542f
C97 sg13cmos5l_dlygate4sd3_1_1.A a_6789_14495# 0.01319f
C98 sg13cmos5l_nand3_1_0.Y a_7923_15532# 0.01019f
C99 a_18106_15960# sg13cmos5l_or3_1_2.B 0.01302f
C100 sg13cmos5l_dfrbpq_1_2.CLK a_4193_14750# 0.01906f
C101 a_10222_14751# a_10016_14570# 0.01604f
C102 a_24824_15238# VDD 0.26964f
C103 a_10703_15311# VDD 0.19385f
C104 sg13cmos5l_tiehi_1.L_HI a_9658_14725# 0.06039f
C105 sg13cmos5l_or3_1_2.X sg13cmos5l_or3_1_2.B 0.03269f
C106 sg13cmos5l_o21ai_1_2.Y sg13cmos5l_dfrbpq_1_6.Q 0.02669f
C107 a_6086_14922# a_6346_14452# 0.45119f
C108 sg13cmos5l_dfrbpq_1_3.D a_17318_14922# 0.17256f
C109 sg13cmos5l_dlygate4sd3_1_4.X a_17825_16262# 0.01299f
C110 a_27215_14845# VDD 0.17631f
C111 a_18769_14845# a_17604_14488# 0.25046f
C112 sg13cmos5l_dlygate4sd3_1_1.A a_7537_14845# 0.01546f
C113 sg13cmos5l_dfrbpq_1_7.RESET_B a_25930_14452# 0.17295f
C114 a_9444_15552# VDD 0.0722f
C115 sg13cmos5l_xnor2_1_2.B a_6346_14452# 0.01548f
C116 sg13cmos5l_dlygate4sd3_1_8.X a_7680_15549# 0.10198f
C117 a_22319_14845# a_22576_14726# 0.23043f
C118 VDD a_24841_13726# 0.26704f
C119 sg13cmos5l_dfrbpq_1_2.CLK sg13cmos5l_inv_1_0.A 0.34455f
C120 sg13cmos5l_xor2_1_0.B a_4193_14750# 0.01654f
C121 a_18106_15960# sg13cmos5l_dlygate4sd3_1_5.A 0.28314f
C122 a_21185_15424# sg13cmos5l_or3_1_2.A 0.01897f
C123 a_22986_14484# a_23368_14570# 0.01648f
C124 sg13cmos5l_a21oi_1_3.B1 a_25206_15302# 0.01649f
C125 VDD a_26148_14040# 0.08291f
C126 sg13cmos5l_a21oi_1_3.B1 sg13cmos5l_o21ai_1_2.B1 0.01704f
C127 sg13cmos5l_buf_1_10.X a_7631_14845# 0.02226f
C128 a_16175_15238# sg13cmos5l_inv_1_0.Y 0.01129f
C129 VDD a_7888_14726# 0.13652f
C130 a_17921_15424# sg13cmos5l_dfrbpq_1_2.Q 0.03888f
C131 a_16068_14040# a_16587_13844# 0.20773f
C132 a_3333_15213# sg13cmos5l_dfrbpq_1_2.CLK 0.20287f
C133 a_21477_14495# sg13cmos5l_buf_8_2.X 0.21497f
C134 sg13cmos5l_or3_1_1.A sg13cmos5l_o21ai_1_2.Y 0.04759f
C135 a_21466_15202# sg13cmos5l_o21ai_1_1.Y 0.28384f
C136 sg13cmos5l_a21oi_1_0.A2 sg13cmos5l_dfrbpq_1_3.D 0.13532f
C137 a_22025_16334# a_22149_16033# 0.08186f
C138 sg13cmos5l_dfrbpq_1_3.RESET_B a_18665_15180# 0.01111f
C139 a_25774_15423# VDD 0.15949f
C140 a_18202_15202# sg13cmos5l_dfrbpq_1_3.RESET_B 0.06264f
C141 a_19530_14484# sg13cmos5l_dfrbpq_1_3.Q 0.08004f
C142 sg13cmos5l_dlygate4sd3_1_8.A counter_value_o[2] 0.01367f
C143 a_16068_14040# a_16356_13735# 0.24435f
C144 sg13cmos5l_dlygate4sd3_1_1.A sg13cmos5l_dlygate4sd3_1_3.A 0.1901f
C145 a_24169_14508# sg13cmos5l_a21oi_1_3.A2 0.12591f
C146 sg13cmos5l_or3_1_2.C a_20218_15238# 0.01849f
C147 sg13cmos5l_or3_1_1.X a_24841_13726# 0.12621f
C148 VDD a_10618_14448# 0.28771f
C149 sg13cmos5l_dlygate4sd3_1_8.X sg13cmos5l_nand4_1_0.Y 0.20079f
C150 counter_value_o[2] clock_i 0.0407f
C151 a_9861_15213# a_10609_15311# 0.01058f
C152 a_17327_13799# a_17233_13799# 0.16704f
C153 sg13cmos5l_a21oi_1_1.Y sg13cmos5l_dfrbpq_1_3.Q 0.01499f
C154 a_21562_15960# a_21281_16262# 0.18796f
C155 a_16485_13701# VDD 0.27675f
C156 sg13cmos5l_dfrbpq_1_6.RESET_B sg13cmos5l_buf_8_2.X 0.0379f
C157 a_19169_15424# VDD 0.21183f
C158 a_18586_15455# VDD 0.09516f
C159 sg13cmos5l_a21oi_1_3.A1 sg13cmos5l_or3_1_1.A 0.08765f
C160 sg13cmos5l_dlygate4sd3_1_4.X a_18665_15180# 0.04007f
C161 sg13cmos5l_dfrbpq_1_1.RESET_B a_6346_14452# 0.18209f
C162 sg13cmos5l_dfrbpq_1_2.Q a_22030_15423# 0.01335f
C163 sg13cmos5l_or3_1_1.B a_21251_13690# 0.02075f
C164 sg13cmos5l_o21ai_1_2.A2 VDD 0.55223f
C165 a_17238_15302# VDD 0.16045f
C166 a_16175_15238# sg13cmos5l_or3_1_1.B 0.02065f
C167 a_3333_16033# VDD 0.07215f
C168 a_27617_15424# a_27898_15202# 0.18796f
C169 sg13cmos5l_xnor2_1_2.B a_6575_13342# 0.01242f
C170 sg13cmos5l_a21oi_1_3.B1 sg13cmos5l_buf_1_10.X 0.10047f
C171 sg13cmos5l_dfrbpq_1_2.CLK a_12010_15202# 0.67763f
C172 sg13cmos5l_dlygate4sd3_1_8.X a_9737_14822# 0.02198f
C173 a_26753_15424# VDD 0.20784f
C174 sg13cmos5l_a21oi_1_3.B1 sg13cmos5l_dfrbpq_1_6.Q 0.03563f
C175 a_5504_14570# VDD 0.08633f
C176 a_27034_15202# sg13cmos5l_dfrbpq_1_6.Q 0.01446f
C177 a_6280_13058# VDD 0.16648f
C178 sg13cmos5l_dfrbpq_1_1.RESET_B a_7631_14845# 0.10879f
C179 sg13cmos5l_or3_1_2.B sg13cmos5l_inv_1_0.A 0.02593f
C180 counter_value_o[1] clock_i 0.0407f
C181 sg13cmos5l_dlygate4sd3_1_1.A a_7822_13911# 0.01022f
C182 sg13cmos5l_inv_1_0.Y a_16140_15424# 0.08646f
C183 sg13cmos5l_o21ai_1_3.Y sg13cmos5l_dlygate4sd3_1_17.A 0.0459f
C184 sg13cmos5l_dlygate4sd3_1_8.X a_10016_14570# 0.01314f
C185 sg13cmos5l_dfrbpq_1_2.Q a_18123_14495# 0.04207f
C186 a_25390_16263# VDD 0.16049f
C187 sg13cmos5l_nand3_1_0.Y sg13cmos5l_dlygate4sd3_1_3.A 0.01196f
C188 sg13cmos5l_dlygate4sd3_1_8.A a_11370_15532# 0.09118f
C189 a_26249_16334# sg13cmos5l_dfrbpq_1_5.RESET_B 0.01855f
C190 a_23638_14862# sg13cmos5l_o21ai_1_2.Y 0.06016f
C191 sg13cmos5l_or3_1_2.C sg13cmos5l_or3_1_2.A 0.72302f
C192 a_16068_14040# sg13cmos5l_dfrbpq_1_2.RESET_B 0.30414f
C193 a_26249_16334# a_26170_16237# 0.08889f
C194 a_21070_15423# a_21185_15424# 0.3854f
C195 a_1192_9948# VDD 0.18614f
C196 a_7680_15549# sg13cmos5l_xnor2_1_0.Y 0.14663f
C197 sg13cmos5l_xnor2_1_2.A sg13cmos5l_nand4_1_0.Y 0.05029f
C198 sg13cmos5l_o21ai_1_1.Y sg13cmos5l_buf_8_2.X 0.26217f
C199 a_26667_13844# a_27664_13942# 0.03412f
C200 a_17604_14488# a_18123_14495# 0.20754f
C201 sg13cmos5l_a21oi_1_3.A2 sg13cmos5l_o21ai_1_2.Y 0.04308f
C202 sg13cmos5l_dlygate4sd3_1_5.A a_18552_15976# 0.01087f
C203 sg13cmos5l_dlygate4sd3_1_17.A a_24923_15996# 0.11419f
C204 a_26757_16033# VDD 0.07049f
C205 a_16140_15424# sg13cmos5l_a21oi_1_0.Y 0.03336f
C206 sg13cmos5l_a21oi_1_3.B1 sg13cmos5l_or3_1_1.A 0.13946f
C207 sg13cmos5l_or3_1_1.A a_27034_15202# 0.05929f
C208 a_17921_15424# a_18202_15202# 0.18796f
C209 a_27500_15960# sg13cmos5l_dfrbpq_1_6.Q 0.19565f
C210 a_25774_15423# sg13cmos5l_dfrbpq_1_7.D 0.10701f
C211 sg13cmos5l_xnor2_1_2.B a_6682_13690# 0.01246f
C212 sg13cmos5l_buf_8_2.A a_19232_13854# 0.0236f
C213 a_37484_15960# a_37192_16082# 0.01635f
C214 sg13cmos5l_buf_8_2.X a_19120_14726# 0.01548f
C215 sg13cmos5l_or3_1_1.C a_24841_13726# 0.14829f
C216 a_21034_14452# VDD 0.09647f
C217 a_6401_13912# VDD 0.20914f
C218 a_2516_14484# VDD 0.14128f
C219 sg13cmos5l_or3_1_2.B sg13cmos5l_or3_1_2.A 0.76615f
C220 sg13cmos5l_dfrbpq_1_7.RESET_B sg13cmos5l_dfrbpq_1_5.RESET_B 0.12636f
C221 counter_value_o[0] clock_i 0.04197f
C222 a_3435_15356# sg13cmos5l_dlygate4sd3_1_3.A 0.0271f
C223 a_26170_16237# sg13cmos5l_dfrbpq_1_7.RESET_B 0.0434f
C224 sg13cmos5l_or3_1_1.X a_25390_16263# 0.03003f
C225 sg13cmos5l_a21oi_1_3.B1 sg13cmos5l_a21oi_1_2.A1 0.05556f
C226 a_15671_15549# VDD 0.08776f
C227 sg13cmos5l_or3_1_1.X VDD 0.43882f
C228 a_22576_14726# VDD 0.13981f
C229 sg13cmos5l_dfrbpq_1_2.Q a_17604_14488# 0.02704f
C230 a_7822_13911# a_7937_13912# 0.3854f
C231 sg13cmos5l_nand4_1_0.Y sg13cmos5l_dfrbpq_1_2.CLK 1.61147f
C232 sg13cmos5l_nand4_1_0.Y sg13cmos5l_xnor2_1_0.Y 0.04658f
C233 a_24169_14508# sg13cmos5l_or3_1_2.B 0.16618f
C234 a_22319_14845# sg13cmos5l_buf_8_2.X 0.02057f
C235 a_9861_15213# sg13cmos5l_dfrbpq_1_2.CLK 0.21068f
C236 sg13cmos5l_or3_1_1.B a_16140_15424# 0.03017f
C237 sg13cmos5l_a21oi_1_3.A2 sg13cmos5l_a21oi_1_3.A1 0.17776f
C238 sg13cmos5l_buf_1_0.X VDD 3.99477f
C239 a_20774_14922# a_21477_14495# 0.02431f
C240 a_7829_15238# a_7680_15549# 0.19075f
C241 sg13cmos5l_dlygate4sd3_1_8.A a_10703_15311# 0.05509f
C242 a_17578_14452# a_18021_14495# 0.02241f
C243 sg13cmos5l_dfrbpq_1_2.CLK a_6346_14452# 0.01513f
C244 a_4078_14751# a_3872_14570# 0.01604f
C245 sg13cmos5l_dfrbpq_1_5.Q a_27882_14484# 0.01003f
C246 sg13cmos5l_dlygate4sd3_1_3.A a_4842_15532# 0.12425f
C247 a_22149_16033# VDD 0.06428f
C248 sg13cmos5l_dfrbpq_1_2.RESET_B a_16042_13945# 0.19612f
C249 sg13cmos5l_dfrbpq_1_6.D VDD 0.33298f
C250 a_21060_14488# a_21579_14495# 0.20754f
C251 sg13cmos5l_dlygate4sd3_1_8.A a_9444_15552# 0.02593f
C252 a_21477_14495# a_21348_14909# 0.01562f
C253 a_25956_14488# a_27215_14845# 0.01412f
C254 a_18021_14495# sg13cmos5l_buf_8_2.X 0.20547f
C255 sg13cmos5l_dlygate4sd3_1_9.X a_20603_15532# 0.06946f
C256 sg13cmos5l_or3_1_1.B a_14261_15238# 0.25178f
C257 a_23960_15242# sg13cmos5l_dfrbpq_1_6.Q 0.01412f
C258 a_21562_15960# sg13cmos5l_a21oi_1_1.Y 0.28648f
C259 sg13cmos5l_buf_1_0.X a_2516_14484# 0.01414f
C260 a_26475_14495# a_27215_14845# 0.17382f
C261 a_19048_13854# a_19232_13854# 0.05762f
C262 a_19816_15366# a_20000_15366# 0.05762f
C263 a_18021_14495# a_17318_14922# 0.02431f
C264 sg13cmos5l_dfrbpq_1_7.D VDD 0.19689f
C265 a_26638_15423# sg13cmos5l_dfrbpq_1_5.RESET_B 0.01351f
C266 a_20774_14922# sg13cmos5l_dfrbpq_1_6.RESET_B 0.07398f
C267 sg13cmos5l_dfrbpq_1_1.RESET_B a_6682_13690# 0.01306f
C268 sg13cmos5l_xnor2_1_2.A a_6575_13342# 0.01681f
C269 a_22986_14484# sg13cmos5l_dfrbpq_1_6.Q 0.08106f
C270 sg13cmos5l_buf_1_10.X sg13cmos5l_and2_1_0.X 0.04444f
C271 sg13cmos5l_buf_8_2.X a_26148_14040# 0.04861f
C272 sg13cmos5l_a21oi_1_3.Y sg13cmos5l_dfrbpq_1_7.RESET_B 0.10426f
C273 a_2528_15366# VDD 0.08632f
C274 a_21466_15202# VDD 0.265f
C275 a_23368_14570# sg13cmos5l_dfrbpq_1_6.Q 0.0251f
C276 a_16587_13844# sg13cmos5l_dfrbpq_1_2.CLK 0.04306f
C277 sg13cmos5l_dlygate4sd3_1_8.A a_10618_14448# 0.28818f
C278 a_25889_15424# sg13cmos5l_or3_1_1.A 0.01269f
C279 a_25094_15238# a_24824_15238# 0.18796f
C280 sg13cmos5l_dlygate4sd3_1_1.A a_7680_15549# 0.05742f
C281 a_6372_14488# a_6789_14495# 0.28418f
C282 a_20278_14862# sg13cmos5l_or3_1_2.A 0.02431f
C283 a_18665_15180# sg13cmos5l_dfrbpq_1_2.Q 0.02237f
C284 sg13cmos5l_or3_1_1.C VDD 0.82343f
C285 a_18202_15202# sg13cmos5l_dfrbpq_1_2.Q 0.34354f
C286 a_26122_13945# a_26148_14040# 0.24169f
C287 a_21281_16262# sg13cmos5l_dfrbpq_1_6.RESET_B 0.02115f
C288 sg13cmos5l_dfrbpq_1_2.Q a_17994_14020# 0.0782f
C289 a_6372_14488# a_7537_14845# 0.25046f
C290 sg13cmos5l_a21oi_1_3.B1 sg13cmos5l_dfrbpq_1_2.CLK 0.1602f
C291 sg13cmos5l_dfrbpq_1_2.Q a_23168_15366# 0.02676f
C292 a_20774_14922# sg13cmos5l_o21ai_1_1.Y 0.03526f
C293 sg13cmos5l_and2_1_2.X a_9158_15234# 0.16719f
C294 sg13cmos5l_xnor2_1_2.A a_6682_13690# 0.03858f
C295 sg13cmos5l_tiehi_1.L_HI a_10703_15311# 0.1087f
C296 a_3333_15213# a_3435_15356# 0.36168f
C297 a_9418_15457# sg13cmos5l_nand4_1_0.Y 0.01592f
C298 a_18454_16374# sg13cmos5l_inv_1_0.Y 0.05732f
C299 a_21348_14909# sg13cmos5l_o21ai_1_1.Y 0.02008f
C300 a_9418_15457# a_9861_15213# 0.02241f
C301 sg13cmos5l_tiehi_1.L_HI a_9444_15552# 0.29159f
C302 sg13cmos5l_dfrbpq_1_3.RESET_B a_17892_14909# 0.0197f
C303 sg13cmos5l_a21oi_1_1.Y sg13cmos5l_dlygate4sd3_1_9.X 0.07532f
C304 sg13cmos5l_dfrbpq_1_2.Q sg13cmos5l_dfrbpq_1_6.Q 0.44792f
C305 sg13cmos5l_dlygate4sd3_1_1.A sg13cmos5l_nand4_1_0.Y 0.27454f
C306 sg13cmos5l_o21ai_1_2.A2 sg13cmos5l_buf_8_2.X 0.05556f
C307 a_26638_15423# sg13cmos5l_a21oi_1_3.Y 0.01596f
C308 sg13cmos5l_dlygate4sd3_1_8.A VDD 0.84676f
C309 sg13cmos5l_dfrbpq_1_5.RESET_B a_27664_13942# 0.09962f
C310 a_3435_15356# a_4432_15454# 0.03412f
C311 a_2630_15234# a_3204_15247# 0.18486f
C312 a_2890_15457# a_2630_15234# 0.45119f
C313 sg13cmos5l_and2_1_2.X a_8685_14832# 0.07413f
C314 a_5687_15549# a_5886_15486# 0.08889f
C315 a_5600_15366# a_5687_15315# 0.03131f
C316 a_17578_14452# VDD 0.09602f
C317 a_25956_14488# VDD 0.07273f
C318 a_2490_14447# sg13cmos5l_and2_1_0.X 0.05334f
C319 sg13cmos5l_dlygate4sd3_1_17.A a_24824_15238# 0.06549f
C320 sg13cmos5l_nand3_1_0.Y a_7680_15549# 0.23616f
C321 a_16969_16020# sg13cmos5l_or3_1_2.B 0.17174f
C322 clock_i VDD 1.62643f
C323 sg13cmos5l_a21oi_1_3.B1 sg13cmos5l_or3_1_2.C 0.03201f
C324 sg13cmos5l_buf_8_2.X VDD 1.73258f
C325 a_26475_14495# VDD 0.20647f
C326 a_27121_14845# a_26373_14495# 0.01058f
C327 sg13cmos5l_dfrbpq_1_2.RESET_B sg13cmos5l_dfrbpq_1_2.CLK 0.04617f
C328 sg13cmos5l_dlygate4sd3_1_1.A a_7631_14845# 0.04295f
C329 sg13cmos5l_dfrbpq_1_7.RESET_B a_25670_14922# 0.07823f
C330 sg13cmos5l_dfrbpq_1_5.RESET_B sg13cmos5l_dfrbpq_1_5.D 0.09565f
C331 sg13cmos5l_a21oi_1_0.A1 VDD 0.33029f
C332 a_6086_14922# a_6891_14495# 0.07916f
C333 a_4432_15454# a_4842_15532# 0.07015f
C334 sg13cmos5l_or3_1_2.X a_21251_13690# 0.13427f
C335 VDD a_17318_14922# 0.52408f
C336 sg13cmos5l_dlygate4sd3_1_0.A a_6540_13238# 0.12959f
C337 VDD a_26122_13945# 0.09474f
C338 a_15782_13722# a_16485_13701# 0.02453f
C339 sg13cmos5l_a21oi_1_3.B1 sg13cmos5l_or3_1_2.B 1.50917f
C340 sg13cmos5l_a21oi_1_0.A2 a_17238_15302# 0.03082f
C341 a_22025_16334# counter_value_o[4] 0.0192f
C342 a_15671_15549# clock_i 0.03769f
C343 sg13cmos5l_dlygate4sd3_1_9.X sg13cmos5l_or3_1_2.X 0.17041f
C344 a_18586_15455# a_18789_15277# 0.02453f
C345 sg13cmos5l_a21oi_1_3.A1 a_25203_13320# 0.01172f
C346 a_25094_15238# VDD 0.20673f
C347 sg13cmos5l_buf_1_10.X a_8685_14832# 0.108f
C348 sg13cmos5l_or3_1_1.B a_24841_13726# 0.16221f
C349 counter_value_o[7] VDD 0.1164f
C350 sg13cmos5l_nand3_1_0.Y sg13cmos5l_nand4_1_0.Y 0.14351f
C351 a_22426_15202# VDD 0.29669f
C352 a_8694_15302# sg13cmos5l_and2_1_2.B 0.12545f
C353 a_16587_13844# a_17327_13799# 0.17382f
C354 a_12524_15960# counter_value_o[2] 0.15504f
C355 sg13cmos5l_o21ai_1_2.B1 sg13cmos5l_dfrbpq_1_6.Q 1.63709f
C356 sg13cmos5l_or3_1_1.X sg13cmos5l_buf_8_2.X 0.02628f
C357 a_22576_14726# sg13cmos5l_buf_8_2.X 0.0155f
C358 sg13cmos5l_dfrbpq_1_3.RESET_B a_17327_13799# 0.01722f
C359 sg13cmos5l_buf_1_10.X a_10222_14751# 0.01427f
C360 sg13cmos5l_buf_1_10.X sg13cmos5l_and2_1_2.X 0.01634f
C361 sg13cmos5l_a21oi_1_3.B1 a_15579_14854# 0.06371f
C362 VDD a_9861_14521# 0.06515f
C363 sg13cmos5l_dlygate4sd3_1_4.X sg13cmos5l_or3_1_2.B 0.18148f
C364 sg13cmos5l_a21oi_1_0.A2 VDD 0.3392f
C365 a_9861_15213# a_9732_15247# 0.01562f
C366 sg13cmos5l_dfrbpq_1_7.Q sg13cmos5l_dfrbpq_1_7.RESET_B 0.0164f
C367 sg13cmos5l_dfrbpq_1_0.RESET_B sg13cmos5l_dlygate4sd3_1_3.A 0.11811f
C368 a_21166_16263# a_20960_16082# 0.01604f
C369 a_7532_15960# sg13cmos5l_dlygate4sd3_1_1.A 0.19272f
C370 VDD sg13cmos5l_dfrbpq_1_2.D 0.43023f
C371 sg13cmos5l_tiehi_1.L_HI VDD 1.09488f
C372 a_15782_13722# VDD 0.52997f
C373 sg13cmos5l_dfrbpq_1_6.D sg13cmos5l_buf_8_2.X 0.02715f
C374 a_18789_15277# VDD 0.06795f
C375 a_25206_15302# sg13cmos5l_or3_1_1.A 0.01524f
C376 a_12010_15202# sg13cmos5l_buf_8_2.A 0.34017f
C377 sg13cmos5l_a21oi_1_1.Y sg13cmos5l_dfrbpq_1_6.RESET_B 0.15755f
C378 sg13cmos5l_dlygate4sd3_1_4.X sg13cmos5l_dlygate4sd3_1_5.A 0.24548f
C379 sg13cmos5l_or3_1_2.B a_21060_14488# 0.01273f
C380 sg13cmos5l_inv_1_0.Y VDD 0.76193f
C381 sg13cmos5l_o21ai_1_2.B1 sg13cmos5l_or3_1_1.A 0.03039f
C382 sg13cmos5l_dlygate4sd3_1_4.X a_19054_15423# 0.10798f
C383 sg13cmos5l_or3_1_1.X a_25094_15238# 0.04107f
C384 sg13cmos5l_a21oi_1_3.Y sg13cmos5l_dfrbpq_1_5.D 0.30057f
C385 sg13cmos5l_dlygate4sd3_1_8.X a_6891_14495# 0.01277f
C386 a_18863_14845# sg13cmos5l_buf_8_2.A 0.01736f
C387 a_17584_13942# VDD 0.13897f
C388 counter_value_o[6] VDD 0.12121f
C389 sg13cmos5l_xnor2_1_2.B a_6086_14922# 0.05954f
C390 a_2824_16082# VDD 0.12267f
C391 a_27502_15423# a_27617_15424# 0.3854f
C392 a_16168_15996# sg13cmos5l_dfrbpq_1_2.Q 0.01748f
C393 sg13cmos5l_xor2_1_0.B sg13cmos5l_and2_1_0.X 0.16893f
C394 sg13cmos5l_dfrbpq_1_7.D sg13cmos5l_buf_8_2.X 0.01301f
C395 a_16068_14040# a_16042_13945# 0.24169f
C396 sg13cmos5l_dfrbpq_1_1.RESET_B a_6891_14495# 0.28013f
C397 sg13cmos5l_or3_1_1.B a_16485_13701# 0.02104f
C398 sg13cmos5l_xnor2_1_2.B sg13cmos5l_buf_1_10.X 0.01762f
C399 sg13cmos5l_o21ai_1_3.Y a_26249_16334# 0.01284f
C400 sg13cmos5l_a21oi_1_0.Y VDD 0.26526f
C401 sg13cmos5l_dlygate4sd3_1_17.A VDD 0.29477f
C402 a_38720_15366# VDD 0.09056f
C403 sg13cmos5l_dlygate4sd3_1_8.X sg13cmos5l_and2_1_2.X 0.03283f
C404 sg13cmos5l_dfrbpq_1_2.RESET_B a_15579_14854# 0.11274f
C405 sg13cmos5l_dlygate4sd3_1_8.X a_10222_14751# 0.1126f
C406 a_25109_12972# VDD 0.21318f
C407 a_27296_16082# VDD 0.10061f
C408 a_24169_14508# a_24365_14508# 0.01485f
C409 sg13cmos5l_inv_1_0.Y a_15671_15549# 0.01387f
C410 sg13cmos5l_a21oi_1_3.B1 a_20278_14862# 0.01435f
C411 a_19530_14484# a_19120_14726# 0.07015f
C412 a_24824_14525# sg13cmos5l_o21ai_1_2.Y 0.01349f
C413 a_17327_13799# sg13cmos5l_dfrbpq_1_2.RESET_B 0.10868f
C414 a_38720_3986# VDD 0.0582f
C415 sg13cmos5l_and2_1_1.X a_6086_14922# 0.18067f
C416 a_25786_15960# a_26170_16237# 0.01303f
C417 sg13cmos5l_o21ai_1_3.Y a_25505_16262# 0.02436f
C418 a_26373_16033# VDD 0.0659f
C419 sg13cmos5l_dfrbpq_1_2.Q sg13cmos5l_dfrbpq_1_2.CLK 0.01544f
C420 sg13cmos5l_or3_1_1.A a_24310_15230# 0.02324f
C421 counter_value_o[5] VDD 0.13222f
C422 sg13cmos5l_or3_1_1.C sg13cmos5l_buf_8_2.X 0.01896f
C423 sg13cmos5l_a21oi_1_3.A1 sg13cmos5l_a21oi_1_3.Y 0.35f
C424 sg13cmos5l_a21oi_1_3.B1 sg13cmos5l_nor2_1_0.B 0.08511f
C425 sg13cmos5l_xnor2_1_2.B sg13cmos5l_and2_1_1.X 0.04672f
C426 a_27664_13942# a_28074_14020# 0.07015f
C427 sg13cmos5l_buf_1_10.X sg13cmos5l_and2_1_1.X 0.04042f
C428 a_17892_14909# a_18123_14495# 0.07823f
C429 a_20774_14922# VDD 0.52379f
C430 a_8218_13690# VDD 0.29954f
C431 sg13cmos5l_or3_1_1.B VDD 1.88587f
C432 a_5896_13854# VDD 0.14015f
C433 sg13cmos5l_or3_1_2.X sg13cmos5l_dfrbpq_1_6.RESET_B 0.36966f
C434 sg13cmos5l_nand4_1_0.Y sg13cmos5l_buf_8_2.A 0.03656f
C435 a_19450_15202# sg13cmos5l_dfrbpq_1_3.Q 0.28632f
C436 a_5613_14832# VDD 0.30068f
C437 a_4078_14751# VDD 0.15946f
C438 sg13cmos5l_xnor2_1_2.A a_6891_14495# 0.06395f
C439 a_2916_15552# sg13cmos5l_dlygate4sd3_1_3.A 0.0212f
C440 sg13cmos5l_a21oi_1_2.A1 a_25025_16344# 0.01276f
C441 sg13cmos5l_or3_1_1.X sg13cmos5l_dlygate4sd3_1_17.A 0.05473f
C442 sg13cmos5l_or3_1_1.A sg13cmos5l_dfrbpq_1_6.Q 1.7649f
C443 a_15870_15486# VDD 0.09411f
C444 sg13cmos5l_dfrbpq_1_3.D sg13cmos5l_inv_1_0.A 0.1171f
C445 a_22145_15424# a_22030_15423# 0.3854f
C446 a_21824_15366# sg13cmos5l_o21ai_1_1.Y 0.03907f
C447 a_23638_14862# sg13cmos5l_o21ai_1_2.B1 0.02318f
C448 sg13cmos5l_a21oi_1_3.B1 sg13cmos5l_dfrbpq_1_3.Q 0.86219f
C449 sg13cmos5l_nand4_1_0.Y a_8312_15238# 0.0158f
C450 sg13cmos5l_dlygate4sd3_1_8.X sg13cmos5l_buf_1_10.X 1.2223f
C451 a_38536_13854# a_38720_13854# 0.05762f
C452 a_9158_15234# sg13cmos5l_dfrbpq_1_2.CLK 0.01121f
C453 sg13cmos5l_dfrbpq_1_1.RESET_B a_6086_14922# 0.07767f
C454 a_20774_14922# a_21034_14452# 0.45119f
C455 sg13cmos5l_dfrbpq_1_2.Q a_17892_14909# 0.02394f
C456 sg13cmos5l_dlygate4sd3_1_8.A clock_i 0.08616f
C457 sg13cmos5l_a21oi_1_1.Y a_22025_16334# 0.01284f
C458 sg13cmos5l_dfrbpq_1_0.RESET_B a_3333_15213# 0.03853f
C459 sg13cmos5l_or3_1_2.A a_21251_13690# 0.20657f
C460 a_25930_14452# a_26373_14495# 0.02241f
C461 sg13cmos5l_dfrbpq_1_5.D a_25670_14922# 0.04812f
C462 sg13cmos5l_dfrbpq_1_1.RESET_B sg13cmos5l_xnor2_1_2.B 0.15083f
C463 counter_value_o[4] VDD 0.09581f
C464 sg13cmos5l_dfrbpq_1_2.Q sg13cmos5l_or3_1_2.C 0.11689f
C465 sg13cmos5l_dfrbpq_1_1.RESET_B sg13cmos5l_buf_1_10.X 0.02402f
C466 sg13cmos5l_dlygate4sd3_1_3.A a_4175_15311# 0.04571f
C467 sg13cmos5l_buf_1_10.X a_2490_14447# 0.01712f
C468 a_21281_16262# VDD 0.2072f
C469 a_26565_13701# a_26148_14040# 0.28324f
C470 a_26667_13844# a_25862_13722# 0.07916f
C471 a_5687_15549# VDD 0.09536f
C472 a_1965_14832# VDD 0.305f
C473 a_26373_14495# a_26244_14909# 0.01562f
C474 a_25956_14488# a_26475_14495# 0.20754f
C475 a_17604_14488# a_17892_14909# 0.24435f
C476 sg13cmos5l_buf_8_2.X a_25956_14488# 0.09542f
C477 sg13cmos5l_dfrbpq_1_2.CLK a_6891_14495# 0.02479f
C478 sg13cmos5l_or3_1_2.X sg13cmos5l_o21ai_1_1.Y 0.05673f
C479 sg13cmos5l_a21oi_1_3.B1 sg13cmos5l_a21oi_1_3.Y 0.63581f
C480 sg13cmos5l_dfrbpq_1_2.RESET_B sg13cmos5l_nor2_1_0.B 0.07964f
C481 a_15870_15486# a_15671_15549# 0.08889f
C482 sg13cmos5l_dlygate4sd3_1_3.A a_5886_15486# 0.03759f
C483 a_26436_13735# a_25862_13722# 0.18486f
C484 a_7240_16082# counter_value_o[1] 0.02116f
C485 sg13cmos5l_buf_8_2.X a_26475_14495# 0.0491f
C486 sg13cmos5l_dfrbpq_1_0.RESET_B a_4432_15454# 0.09976f
C487 a_16140_15424# sg13cmos5l_inv_1_0.A 0.01251f
C488 a_17578_14452# a_17318_14922# 0.45119f
C489 sg13cmos5l_dfrbpq_1_2.Q a_22145_15424# 0.01328f
C490 a_20774_14922# sg13cmos5l_dfrbpq_1_6.D 0.17726f
C491 sg13cmos5l_and2_1_2.X sg13cmos5l_dfrbpq_1_2.CLK 0.02931f
C492 sg13cmos5l_xnor2_1_2.A a_6086_14922# 0.01661f
C493 sg13cmos5l_dfrbpq_1_1.RESET_B sg13cmos5l_and2_1_1.X 0.07099f
C494 sg13cmos5l_or3_1_2.B sg13cmos5l_dfrbpq_1_2.Q 0.38942f
C495 a_9963_15356# sg13cmos5l_nand4_1_0.Y 0.02274f
C496 sg13cmos5l_dfrbpq_1_3.RESET_B sg13cmos5l_buf_8_2.A 0.03701f
C497 sg13cmos5l_buf_1_10.X reset_n_i 0.01015f
C498 sg13cmos5l_xnor2_1_2.A sg13cmos5l_xnor2_1_2.B 0.34537f
C499 a_9861_15213# a_9963_15356# 0.36168f
C500 a_26170_15202# sg13cmos5l_dfrbpq_1_7.RESET_B 0.03678f
C501 sg13cmos5l_xnor2_1_2.A sg13cmos5l_buf_1_10.X 0.03534f
C502 counter_value_o[3] VDD 0.07686f
C503 a_20603_15532# VDD 0.16158f
C504 a_16068_14040# sg13cmos5l_dfrbpq_1_2.CLK 0.04723f
C505 a_24841_13726# a_24935_14020# 0.02103f
C506 a_24520_13854# a_24704_13854# 0.05762f
C507 sg13cmos5l_xor2_1_0.X VDD 0.14666f
C508 a_25094_14484# sg13cmos5l_or3_1_1.A 0.0598f
C509 a_8582_15238# a_8312_15238# 0.18796f
C510 sg13cmos5l_a21oi_1_3.B1 sg13cmos5l_buf_8_2.A 0.56082f
C511 a_6346_14452# a_6372_14488# 0.24169f
C512 sg13cmos5l_dfrbpq_1_7.Q a_27882_14484# 0.09875f
C513 a_25206_14508# VDD 0.16141f
C514 a_19054_15423# sg13cmos5l_dfrbpq_1_2.Q 0.01821f
C515 sg13cmos5l_dlygate4sd3_1_8.A sg13cmos5l_tiehi_1.L_HI 0.02474f
C516 a_22149_16033# counter_value_o[4] 0.0172f
C517 a_22508_15960# sg13cmos5l_dfrbpq_1_3.Q 0.19275f
C518 a_6372_14488# a_7631_14845# 0.01412f
C519 sg13cmos5l_dfrbpq_1_2.CLK a_6086_14922# 0.01616f
C520 clock_i sg13cmos5l_dfrbpq_1_2.D 0.02532f
C521 a_2916_15552# a_3333_15213# 0.28324f
C522 a_2630_15234# a_3435_15356# 0.07916f
C523 sg13cmos5l_a21oi_1_0.A2 sg13cmos5l_a21oi_1_0.A1 0.83799f
C524 a_18106_15960# a_18454_16374# 0.02803f
C525 sg13cmos5l_xor2_1_0.X a_2516_14484# 0.06124f
C526 sg13cmos5l_xnor2_1_2.B sg13cmos5l_dfrbpq_1_2.CLK 0.02511f
C527 a_7631_14845# a_8298_14484# 0.09257f
C528 sg13cmos5l_buf_1_10.X sg13cmos5l_dfrbpq_1_2.CLK 2.24876f
C529 sg13cmos5l_inv_1_0.Y clock_i 0.06063f
C530 a_26565_13701# VDD 0.28166f
C531 a_9418_15457# a_9158_15234# 0.45119f
C532 sg13cmos5l_or3_1_1.B sg13cmos5l_or3_1_1.C 0.12764f
C533 sg13cmos5l_a21oi_1_3.B1 a_25670_14922# 0.0136f
C534 sg13cmos5l_a21oi_1_3.A2 sg13cmos5l_or3_1_1.A 0.11755f
C535 a_8694_15302# sg13cmos5l_nand4_1_0.Y 0.0137f
C536 sg13cmos5l_dlygate4sd3_1_9.X a_21070_15423# 0.10667f
C537 sg13cmos5l_a21oi_1_0.A1 sg13cmos5l_inv_1_0.Y 0.05298f
C538 sg13cmos5l_xnor2_1_2.A sg13cmos5l_dlygate4sd3_1_8.X 0.06752f
C539 sg13cmos5l_xor2_1_0.B sg13cmos5l_xnor2_1_2.B 0.02186f
C540 a_25206_14508# sg13cmos5l_or3_1_1.X 0.04711f
C541 a_6280_13058# a_6540_13238# 0.01728f
C542 a_37192_16082# VDD 0.16744f
C543 sg13cmos5l_xor2_1_0.B sg13cmos5l_buf_1_10.X 2.58844f
C544 sg13cmos5l_or3_1_2.B sg13cmos5l_o21ai_1_2.B1 0.35664f
C545 a_9737_14822# a_9658_14725# 0.08889f
C546 sg13cmos5l_dfrbpq_1_5.Q sg13cmos5l_dfrbpq_1_6.Q 0.01209f
C547 a_12524_15960# VDD 0.22898f
C548 sg13cmos5l_or3_1_2.A sg13cmos5l_dfrbpq_1_6.RESET_B 0.02401f
C549 a_19530_14484# VDD 0.28068f
C550 sg13cmos5l_dfrbpq_1_2.RESET_B sg13cmos5l_buf_8_2.A 0.08449f
C551 a_6540_13238# VDD 0.19533f
C552 sg13cmos5l_dfrbpq_1_1.RESET_B sg13cmos5l_xnor2_1_2.A 0.04487f
C553 sg13cmos5l_dfrbpq_1_2.CLK sg13cmos5l_and2_1_1.X 0.02079f
C554 sg13cmos5l_dfrbpq_1_2.CLK a_4474_14448# 0.01341f
C555 sg13cmos5l_dlygate4sd3_1_17.A sg13cmos5l_buf_8_2.X 0.02847f
C556 a_16552_15996# sg13cmos5l_dfrbpq_1_2.Q 0.19543f
C557 sg13cmos5l_a21oi_1_0.A1 sg13cmos5l_a21oi_1_0.Y 0.0944f
C558 sg13cmos5l_dfrbpq_1_5.RESET_B a_26373_14495# 0.01805f
C559 sg13cmos5l_dlygate4sd3_1_1.A a_6891_14495# 0.03657f
C560 sg13cmos5l_o21ai_1_3.Y sg13cmos5l_o21ai_1_2.Y 0.07365f
C561 sg13cmos5l_a21oi_1_1.Y VDD 0.38748f
C562 VDD a_19232_13854# 0.06399f
C563 a_20000_15366# VDD 0.07202f
C564 a_4175_15311# a_4432_15454# 0.23043f
C565 sg13cmos5l_xor2_1_0.B sg13cmos5l_and2_1_1.X 0.01253f
C566 sg13cmos5l_dfrbpq_1_2.CLK a_10609_15311# 0.0137f
C567 a_16969_16020# a_17710_16263# 0.01693f
C568 sg13cmos5l_dlygate4sd3_1_8.X sg13cmos5l_dfrbpq_1_2.CLK 0.39427f
C569 sg13cmos5l_dlygate4sd3_1_1.A a_8685_14832# 0.06006f
C570 sg13cmos5l_a21oi_1_0.A2 sg13cmos5l_inv_1_0.Y 0.01864f
C571 sg13cmos5l_dlygate4sd3_1_8.X sg13cmos5l_xnor2_1_0.Y 0.01362f
C572 a_27034_15202# sg13cmos5l_dfrbpq_1_7.Q 0.28887f
C573 sg13cmos5l_or3_1_1.B clock_i 0.07955f
C574 a_15782_13722# sg13cmos5l_dfrbpq_1_2.D 0.16401f
C575 VDD a_6789_14495# 0.24623f
C576 a_25206_14508# sg13cmos5l_dfrbpq_1_7.D 0.01672f
C577 a_20774_14922# sg13cmos5l_buf_8_2.X 0.01038f
C578 sg13cmos5l_or3_1_2.B a_24310_15230# 0.07683f
C579 sg13cmos5l_or3_1_1.B sg13cmos5l_buf_8_2.X 0.1628f
C580 sg13cmos5l_o21ai_1_1.Y sg13cmos5l_or3_1_2.A 0.23707f
C581 sg13cmos5l_dlygate4sd3_1_17.A a_25094_15238# 0.01415f
C582 sg13cmos5l_dfrbpq_1_7.RESET_B a_27215_14845# 0.10879f
C583 sg13cmos5l_dfrbpq_1_1.RESET_B sg13cmos5l_dfrbpq_1_2.CLK 0.03866f
C584 a_2540_15960# a_2248_16082# 0.01635f
C585 sg13cmos5l_dfrbpq_1_2.Q sg13cmos5l_dfrbpq_1_3.Q 2.85025f
C586 sg13cmos5l_dfrbpq_1_5.RESET_B a_25862_13722# 0.11402f
C587 a_5886_15486# a_5687_15315# 0.02453f
C588 a_8582_15238# a_8694_15302# 0.3854f
C589 a_21824_15366# VDD 0.07818f
C590 a_16068_14040# a_17327_13799# 0.01412f
C591 sg13cmos5l_or3_1_2.B sg13cmos5l_dfrbpq_1_6.Q 0.20181f
C592 a_21579_14495# sg13cmos5l_or3_1_2.C 0.01468f
C593 sg13cmos5l_dfrbpq_1_1.RESET_B sg13cmos5l_xor2_1_0.B 0.04436f
C594 sg13cmos5l_xor2_1_0.B a_2490_14447# 0.22356f
C595 a_9158_15234# a_9732_15247# 0.18486f
C596 a_17327_13799# a_17994_14020# 0.09257f
C597 a_16485_13701# a_17233_13799# 0.01058f
C598 sg13cmos5l_o21ai_1_2.B1 sg13cmos5l_dfrbpq_1_5.RESET_B 0.12304f
C599 sg13cmos5l_dfrbpq_1_0.RESET_B a_2540_15960# 0.0105f
C600 sg13cmos5l_nand4_1_0.Y a_14261_15238# 0.23765f
C601 VDD a_14344_14570# 0.15065f
C602 a_3130_16237# a_3008_16082# 0.01854f
C603 sg13cmos5l_dfrbpq_1_3.RESET_B sg13cmos5l_dfrbpq_1_3.D 0.09733f
C604 a_18106_15960# VDD 0.28888f
C605 sg13cmos5l_a21oi_1_3.B1 sg13cmos5l_dlygate4sd3_1_9.X 0.10511f
C606 a_25774_15423# sg13cmos5l_dfrbpq_1_7.RESET_B 0.02935f
C607 sg13cmos5l_inv_1_0.Y sg13cmos5l_a21oi_1_0.Y 0.02996f
C608 sg13cmos5l_or3_1_2.X VDD 0.34653f
C609 sg13cmos5l_dlygate4sd3_1_8.X a_7829_15238# 0.02577f
C610 a_3130_16237# a_3209_16334# 0.08889f
C611 sg13cmos5l_dlygate4sd3_1_4.X a_17710_16263# 0.01296f
C612 a_21166_16263# sg13cmos5l_dfrbpq_1_6.RESET_B 0.02119f
C613 sg13cmos5l_a21oi_1_1.Y sg13cmos5l_dfrbpq_1_6.D 0.02843f
C614 sg13cmos5l_xnor2_1_2.A sg13cmos5l_dfrbpq_1_2.CLK 0.07807f
C615 a_21070_15423# sg13cmos5l_dfrbpq_1_6.RESET_B 0.05075f
C616 sg13cmos5l_dlygate4sd3_1_3.A VDD 1.34734f
C617 a_18123_14495# sg13cmos5l_buf_8_2.A 0.02096f
C618 sg13cmos5l_and2_1_2.B VDD 0.23394f
C619 sg13cmos5l_buf_1_10.X sg13cmos5l_dlygate4sd3_1_1.A 0.16121f
C620 sg13cmos5l_a21oi_1_3.B1 sg13cmos5l_dfrbpq_1_3.D 0.03309f
C621 a_7240_16082# VDD 0.1655f
C622 sg13cmos5l_or3_1_2.B a_21579_14495# 0.01018f
C623 a_19120_14726# a_18863_14845# 0.23043f
C624 sg13cmos5l_xor2_1_0.B sg13cmos5l_xnor2_1_2.A 0.34223f
C625 sg13cmos5l_or3_1_1.B a_15782_13722# 0.04779f
C626 sg13cmos5l_or3_1_2.X a_21034_14452# 0.02296f
C627 sg13cmos5l_a21oi_1_3.B1 sg13cmos5l_o21ai_1_3.Y 0.37884f
C628 a_26249_16334# VDD 0.07375f
C629 a_27617_15424# VDD 0.20604f
C630 sg13cmos5l_or3_1_1.B sg13cmos5l_inv_1_0.Y 0.86348f
C631 a_27898_15202# sg13cmos5l_dfrbpq_1_6.Q 0.012f
C632 sg13cmos5l_or3_1_1.B a_17584_13942# 0.01425f
C633 sg13cmos5l_dfrbpq_1_2.Q sg13cmos5l_buf_8_2.A 0.04399f
C634 a_25786_15960# sg13cmos5l_o21ai_1_3.Y 0.29053f
C635 a_26633_16334# a_26554_16237# 0.08889f
C636 a_16969_16020# a_17165_16020# 0.01485f
C637 a_38536_10034# a_38720_10034# 0.05762f
C638 a_1192_3900# VDD 0.18614f
C639 a_25390_16263# a_25505_16262# 0.3854f
C640 sg13cmos5l_a21oi_1_3.B1 a_24923_15996# 0.01453f
C641 a_25505_16262# VDD 0.20709f
C642 a_17604_14488# sg13cmos5l_buf_8_2.A 0.01462f
C643 sg13cmos5l_dfrbpq_1_5.RESET_B sg13cmos5l_dfrbpq_1_6.Q 0.03307f
C644 a_25206_14508# sg13cmos5l_buf_8_2.X 0.01098f
C645 a_27296_16082# counter_value_o[5] 0.01377f
C646 sg13cmos5l_or3_1_1.B sg13cmos5l_a21oi_1_0.Y 0.21476f
C647 sg13cmos5l_xnor2_1_2.B a_6286_13911# 0.05827f
C648 a_27407_13799# a_27664_13942# 0.23043f
C649 a_26667_13844# a_26436_13735# 0.07823f
C650 sg13cmos5l_a21oi_1_3.Y sg13cmos5l_o21ai_1_2.B1 0.05014f
C651 sg13cmos5l_buf_1_0.X sg13cmos5l_dlygate4sd3_1_3.A 0.67869f
C652 a_7822_13911# VDD 0.16525f
C653 sg13cmos5l_dlygate4sd3_1_0.A a_6575_13342# 0.03821f
C654 a_38720_14570# VDD 0.08963f
C655 sg13cmos5l_xor2_1_0.B sg13cmos5l_dfrbpq_1_2.CLK 0.10767f
C656 sg13cmos5l_nand4_1_0.Y a_11370_15532# 0.01256f
C657 sg13cmos5l_or3_1_2.X sg13cmos5l_dfrbpq_1_6.D 0.04306f
C658 sg13cmos5l_dlygate4sd3_1_8.X sg13cmos5l_dlygate4sd3_1_1.A 0.16183f
C659 sg13cmos5l_dfrbpq_1_7.RESET_B VDD 1.10388f
C660 a_26554_16237# sg13cmos5l_dfrbpq_1_5.RESET_B 0.0434f
C661 a_9963_15356# a_10960_15454# 0.03412f
C662 sg13cmos5l_xnor2_1_2.B sg13cmos5l_dlygate4sd3_1_0.X 0.10767f
C663 a_16856_15238# VDD 0.28158f
C664 sg13cmos5l_buf_1_10.X sg13cmos5l_dlygate4sd3_1_0.X 0.06585f
C665 a_17238_15302# sg13cmos5l_inv_1_0.A 0.01275f
C666 a_12524_15960# sg13cmos5l_dlygate4sd3_1_8.A 0.1978f
C667 a_4193_14750# VDD 0.20555f
C668 sg13cmos5l_dfrbpq_1_1.RESET_B sg13cmos5l_dlygate4sd3_1_1.A 0.02096f
C669 sg13cmos5l_buf_8_2.X a_26565_13701# 0.21461f
C670 sg13cmos5l_or3_1_2.B a_21185_15424# 0.03542f
C671 a_23638_14862# sg13cmos5l_or3_1_2.B 0.06579f
C672 sg13cmos5l_or3_1_1.A sg13cmos5l_dfrbpq_1_5.RESET_B 0.02336f
C673 sg13cmos5l_dfrbpq_1_0.RESET_B a_2630_15234# 0.10309f
C674 a_25670_14922# a_26373_14495# 0.02431f
C675 a_16168_15996# sg13cmos5l_or3_1_2.B 0.15767f
C676 a_6286_13911# a_6080_13854# 0.01604f
C677 sg13cmos5l_or3_1_1.X a_25505_16262# 0.01201f
C678 sg13cmos5l_inv_1_0.A VDD 0.2568f
C679 sg13cmos5l_a21oi_1_3.B1 sg13cmos5l_dfrbpq_1_6.RESET_B 0.0175f
C680 a_22304_16082# VDD 0.07521f
C681 a_18552_15976# VDD 0.01784f
C682 sg13cmos5l_dfrbpq_1_3.Q sg13cmos5l_dfrbpq_1_6.Q 0.18548f
C683 sg13cmos5l_buf_1_0.X a_1192_3900# 0.15903f
C684 a_26565_13701# a_26122_13945# 0.02241f
C685 a_20774_14922# a_21348_14909# 0.18486f
C686 a_21060_14488# a_21477_14495# 0.28418f
C687 a_7829_15238# sg13cmos5l_xnor2_1_0.Y 0.02386f
C688 a_19530_14484# sg13cmos5l_buf_8_2.X 0.02075f
C689 a_6682_13690# sg13cmos5l_dlygate4sd3_1_0.A 0.31148f
C690 a_6080_13854# sg13cmos5l_dlygate4sd3_1_0.X 0.01464f
C691 sg13cmos5l_or3_1_1.X sg13cmos5l_dfrbpq_1_7.RESET_B 0.01339f
C692 sg13cmos5l_dlygate4sd3_1_0.X sg13cmos5l_and2_1_1.X 0.05101f
C693 a_26638_15423# a_26753_15424# 0.3854f
C694 sg13cmos5l_inv_1_0.Y counter_value_o[3] 0.15994f
C695 a_3333_15213# VDD 0.28955f
C696 sg13cmos5l_o21ai_1_2.Y a_23736_14464# 0.01095f
C697 sg13cmos5l_a21oi_1_0.A1 a_17057_14832# 0.01159f
C698 a_24824_15238# sg13cmos5l_o21ai_1_2.Y 0.27487f
C699 sg13cmos5l_nand4_1_0.Y a_10703_15311# 0.01618f
C700 sg13cmos5l_xnor2_1_2.A sg13cmos5l_dlygate4sd3_1_1.A 0.06433f
C701 a_26638_15423# VDD 0.15952f
C702 sg13cmos5l_dlygate4sd3_1_8.X sg13cmos5l_nand3_1_0.Y 0.28523f
C703 sg13cmos5l_a21oi_1_3.Y sg13cmos5l_dfrbpq_1_6.Q 0.01464f
C704 a_7532_15960# counter_value_o[1] 0.15504f
C705 a_37192_16082# counter_value_o[7] 0.02116f
C706 a_27215_14845# a_27882_14484# 0.09257f
C707 a_9444_15552# sg13cmos5l_nand4_1_0.Y 0.02334f
C708 sg13cmos5l_dfrbpq_1_0.RESET_B sg13cmos5l_and2_1_0.X 0.07063f
C709 a_24169_14508# sg13cmos5l_o21ai_1_2.A2 0.15962f
C710 a_15671_15549# sg13cmos5l_inv_1_0.A 0.01207f
C711 sg13cmos5l_a21oi_1_3.B1 sg13cmos5l_o21ai_1_1.Y 0.03114f
C712 sg13cmos5l_dfrbpq_1_7.Q a_26373_14495# 0.01321f
C713 sg13cmos5l_dfrbpq_1_1.RESET_B sg13cmos5l_nand3_1_0.Y 0.01467f
C714 a_4432_15454# VDD 0.13966f
C715 a_21060_14488# sg13cmos5l_dfrbpq_1_6.RESET_B 0.27212f
C716 a_9444_15552# a_9861_15213# 0.28324f
C717 a_9158_15234# a_9963_15356# 0.07916f
C718 sg13cmos5l_or3_1_2.A VDD 0.38339f
C719 sg13cmos5l_dfrbpq_1_3.RESET_B a_19120_14726# 0.09622f
C720 counter_value_o[0] a_2540_15960# 0.15504f
C721 sg13cmos5l_dfrbpq_1_7.Q a_27472_14726# 0.01873f
C722 a_5687_15315# VDD 0.07168f
C723 sg13cmos5l_dfrbpq_1_7.D sg13cmos5l_dfrbpq_1_7.RESET_B 0.11217f
C724 a_24169_14508# VDD 0.25699f
C725 sg13cmos5l_a21oi_1_3.Y sg13cmos5l_or3_1_1.A 0.01853f
C726 sg13cmos5l_dlygate4sd3_1_1.A sg13cmos5l_dfrbpq_1_2.CLK 0.27858f
C727 sg13cmos5l_buf_1_0.X a_3333_15213# 0.01557f
C728 a_22149_16033# a_22304_16082# 0.03131f
C729 sg13cmos5l_buf_1_10.X sg13cmos5l_buf_8_2.A 0.38553f
C730 a_6372_14488# a_6891_14495# 0.20754f
C731 a_6789_14495# a_6660_14909# 0.01562f
C732 a_21034_14452# sg13cmos5l_or3_1_2.A 0.02529f
C733 a_22225_14845# a_21060_14488# 0.25046f
C734 a_12010_15202# VDD 1.01037f
C735 sg13cmos5l_or3_1_2.B sg13cmos5l_or3_1_2.C 0.64121f
C736 sg13cmos5l_dlygate4sd3_1_9.X sg13cmos5l_dfrbpq_1_2.Q 0.01954f
C737 sg13cmos5l_xnor2_1_2.A a_7937_13912# 0.01378f
C738 sg13cmos5l_a21oi_1_3.A1 a_24841_13726# 0.05315f
C739 a_2630_15234# a_2916_15552# 0.26205f
C740 a_17710_16263# a_17825_16262# 0.3854f
C741 a_18863_14845# VDD 0.17376f
C742 a_7888_14726# a_7631_14845# 0.23043f
C743 sg13cmos5l_xor2_1_0.B sg13cmos5l_dlygate4sd3_1_1.A 0.01964f
C744 a_21060_14488# sg13cmos5l_o21ai_1_1.Y 0.0268f
C745 sg13cmos5l_dfrbpq_1_2.Q sg13cmos5l_dfrbpq_1_3.D 0.01008f
C746 sg13cmos5l_or3_1_2.X sg13cmos5l_buf_8_2.X 0.02259f
C747 sg13cmos5l_dlygate4sd3_1_3.A clock_i 0.14753f
C748 sg13cmos5l_dfrbpq_1_3.RESET_B a_18021_14495# 0.04294f
C749 a_7680_15549# VDD 0.1878f
C750 a_21251_13690# a_21549_14020# 0.02103f
C751 a_24824_14525# sg13cmos5l_or3_1_1.A 0.0282f
C752 a_27898_15202# sg13cmos5l_dfrbpq_1_5.Q 0.2865f
C753 a_27664_13942# VDD 0.14131f
C754 a_25889_15424# a_26170_15202# 0.18796f
C755 sg13cmos5l_dfrbpq_1_5.RESET_B a_26667_13844# 0.28617f
C756 a_32200_16082# a_32492_15960# 0.01635f
C757 sg13cmos5l_a21oi_1_3.B1 a_18021_14495# 0.01249f
C758 sg13cmos5l_o21ai_1_2.A2 sg13cmos5l_o21ai_1_2.Y 0.08237f
C759 sg13cmos5l_or3_1_2.A sg13cmos5l_dfrbpq_1_6.D 0.02907f
C760 a_38536_13854# VDD 0.13998f
C761 sg13cmos5l_xor2_1_0.X a_1965_14832# 0.19131f
C762 a_3435_15356# a_3204_15247# 0.07823f
C763 a_2916_15552# a_4081_15311# 0.25046f
C764 a_11370_15532# a_11752_15366# 0.01648f
C765 sg13cmos5l_dfrbpq_1_5.D VDD 0.42253f
C766 sg13cmos5l_nor2_1_0.B sg13cmos5l_dfrbpq_1_2.CLK 0.18311f
C767 sg13cmos5l_dfrbpq_1_5.RESET_B a_25930_14452# 0.0148f
C768 sg13cmos5l_o21ai_1_3.Y a_24408_15552# 0.01291f
C769 sg13cmos5l_nand3_1_0.Y sg13cmos5l_xnor2_1_0.Y 0.05205f
C770 a_21166_16263# VDD 0.15938f
C771 sg13cmos5l_dlygate4sd3_1_5.A sg13cmos5l_or3_1_2.B 0.19226f
C772 a_10222_14751# a_10337_14750# 0.3854f
C773 sg13cmos5l_dfrbpq_1_2.CLK sg13cmos5l_dlygate4sd3_1_0.X 0.03779f
C774 a_22319_14845# a_21060_14488# 0.01412f
C775 sg13cmos5l_o21ai_1_2.Y VDD 0.33363f
C776 a_21070_15423# VDD 0.15921f
C777 sg13cmos5l_dfrbpq_1_2.Q a_16140_15424# 0.03116f
C778 a_6086_14922# a_6372_14488# 0.26205f
C779 sg13cmos5l_nand4_1_0.Y VDD 1.02388f
C780 sg13cmos5l_dfrbpq_1_2.CLK a_9732_15247# 0.01421f
C781 sg13cmos5l_dlygate4sd3_1_4.X a_18454_16374# 0.02479f
C782 a_27882_14484# VDD 0.28095f
C783 a_24824_14525# a_25094_14484# 0.18796f
C784 a_18769_14845# a_18021_14495# 0.01058f
C785 sg13cmos5l_dfrbpq_1_5.RESET_B a_26244_14909# 0.01674f
C786 sg13cmos5l_dfrbpq_1_7.RESET_B a_25956_14488# 0.28972f
C787 sg13cmos5l_xnor2_1_2.B a_6372_14488# 0.03099f
C788 a_9861_15213# VDD 0.24352f
C789 VDD a_24520_13854# 0.14054f
C790 sg13cmos5l_buf_1_10.X a_6372_14488# 0.01881f
C791 a_8694_15302# sg13cmos5l_and2_1_2.X 0.02064f
C792 a_4175_15311# a_4081_15311# 0.16704f
C793 VDD a_6346_14452# 0.09662f
C794 a_21466_15202# sg13cmos5l_or3_1_2.A 0.03705f
C795 sg13cmos5l_dfrbpq_1_7.RESET_B a_26475_14495# 0.27969f
C796 sg13cmos5l_a21oi_1_3.B1 a_25774_15423# 0.01368f
C797 sg13cmos5l_buf_8_2.X sg13cmos5l_dfrbpq_1_7.RESET_B 0.0607f
C798 a_18106_15960# sg13cmos5l_inv_1_0.Y 0.01212f
C799 sg13cmos5l_buf_1_10.X a_8298_14484# 0.03737f
C800 a_20278_14862# sg13cmos5l_or3_1_2.C 0.06102f
C801 sg13cmos5l_dfrbpq_1_7.Q sg13cmos5l_dfrbpq_1_6.Q 0.04426f
C802 VDD a_7631_14845# 0.17872f
C803 a_16485_13701# a_16587_13844# 0.36168f
C804 a_3435_15356# sg13cmos5l_dfrbpq_1_2.CLK 0.01756f
C805 sg13cmos5l_a21oi_1_0.A1 a_16856_15238# 0.067f
C806 a_23368_14570# a_23552_14570# 0.05762f
C807 a_19169_15424# a_19450_15202# 0.18796f
C808 sg13cmos5l_a21oi_1_3.A1 VDD 0.28007f
C809 VDD a_9737_14822# 0.0769f
C810 a_18586_15455# sg13cmos5l_dfrbpq_1_3.RESET_B 0.04249f
C811 sg13cmos5l_dfrbpq_1_2.Q sg13cmos5l_dfrbpq_1_6.RESET_B 0.01328f
C812 a_27121_14845# sg13cmos5l_dfrbpq_1_7.Q 0.02056f
C813 a_16485_13701# a_16356_13735# 0.01562f
C814 clock_i sg13cmos5l_inv_1_0.A 0.04697f
C815 a_2824_16082# sg13cmos5l_dlygate4sd3_1_3.A 0.03948f
C816 a_24824_14525# sg13cmos5l_a21oi_1_3.A2 0.06269f
C817 a_24169_14508# sg13cmos5l_or3_1_1.C 0.03594f
C818 sg13cmos5l_buf_1_10.X a_10337_14750# 0.01927f
C819 VDD a_10016_14570# 0.07441f
C820 sg13cmos5l_buf_1_0.X sg13cmos5l_nand4_1_0.Y 0.0546f
C821 a_16969_16020# VDD 0.24435f
C822 sg13cmos5l_a21oi_1_0.A1 sg13cmos5l_inv_1_0.A 0.01808f
C823 a_10960_15454# a_11370_15532# 0.07015f
C824 sg13cmos5l_a21oi_1_1.Y a_21281_16262# 0.02116f
C825 a_21562_15960# a_21946_16237# 0.01303f
C826 sg13cmos5l_or3_1_2.B a_20278_14862# 0.08485f
C827 a_21166_16263# sg13cmos5l_dfrbpq_1_6.D 0.10665f
C828 sg13cmos5l_or3_1_1.A sg13cmos5l_dfrbpq_1_7.Q 0.08495f
C829 a_16552_15996# sg13cmos5l_or3_1_2.B 0.09282f
C830 sg13cmos5l_or3_1_2.C sg13cmos5l_dfrbpq_1_3.Q 0.20063f
C831 sg13cmos5l_a21oi_1_3.Y a_25930_14452# 0.0453f
C832 a_21070_15423# sg13cmos5l_dfrbpq_1_6.D 0.03572f
C833 a_17238_15302# a_17806_15423# 0.01641f
C834 a_17126_15238# sg13cmos5l_dfrbpq_1_3.D 0.02016f
C835 a_22319_14845# a_22986_14484# 0.09257f
C836 a_2540_15960# VDD 0.19767f
C837 sg13cmos5l_dlygate4sd3_1_8.X a_6372_14488# 0.02859f
C838 a_8582_15238# VDD 0.21098f
C839 a_16587_13844# VDD 0.21312f
C840 a_19450_15202# VDD 0.27372f
C841 sg13cmos5l_or3_1_2.B sg13cmos5l_nor2_1_0.B 0.03734f
C842 sg13cmos5l_dfrbpq_1_3.RESET_B VDD 1.16418f
C843 sg13cmos5l_dfrbpq_1_0.RESET_B a_3209_16334# 0.01409f
C844 a_26753_15424# a_27034_15202# 0.18796f
C845 a_18123_14495# a_19120_14726# 0.03546f
C846 sg13cmos5l_or3_1_1.X sg13cmos5l_a21oi_1_3.A1 0.59456f
C847 sg13cmos5l_a21oi_1_3.Y a_26244_14909# 0.01169f
C848 sg13cmos5l_dfrbpq_1_7.D sg13cmos5l_dfrbpq_1_5.D 0.03838f
C849 sg13cmos5l_dfrbpq_1_1.RESET_B a_6372_14488# 0.29766f
C850 sg13cmos5l_dfrbpq_1_2.Q sg13cmos5l_o21ai_1_1.Y 0.02544f
C851 sg13cmos5l_or3_1_2.X a_20774_14922# 0.02499f
C852 sg13cmos5l_or3_1_2.X sg13cmos5l_or3_1_1.B 0.01428f
C853 a_7532_15960# VDD 0.22643f
C854 a_17806_15423# VDD 0.1592f
C855 sg13cmos5l_o21ai_1_3.Y a_24310_15230# 0.06016f
C856 sg13cmos5l_dfrbpq_1_2.CLK sg13cmos5l_buf_8_2.A 0.3488f
C857 sg13cmos5l_a21oi_1_3.B1 VDD 1.64688f
C858 a_27034_15202# VDD 0.25715f
C859 a_27502_15423# sg13cmos5l_dfrbpq_1_6.Q 0.0569f
C860 a_22145_15424# sg13cmos5l_dfrbpq_1_3.Q 0.01469f
C861 sg13cmos5l_or3_1_2.A sg13cmos5l_buf_8_2.X 0.58091f
C862 sg13cmos5l_or3_1_2.B sg13cmos5l_dfrbpq_1_3.Q 0.36223f
C863 sg13cmos5l_dlygate4sd3_1_1.A a_7937_13912# 0.02056f
C864 sg13cmos5l_a21oi_1_0.A2 sg13cmos5l_inv_1_0.A 0.0306f
C865 a_25786_15960# VDD 0.26183f
C866 sg13cmos5l_a21oi_1_1.Y a_20603_15532# 0.09955f
C867 sg13cmos5l_dlygate4sd3_1_8.X a_10337_14750# 0.01066f
C868 sg13cmos5l_dlygate4sd3_1_8.A a_12010_15202# 0.02872f
C869 a_26633_16334# sg13cmos5l_dfrbpq_1_5.RESET_B 0.01098f
C870 a_16485_13701# sg13cmos5l_dfrbpq_1_2.RESET_B 0.0353f
C871 a_26249_16334# a_26373_16033# 0.08186f
C872 a_38536_10034# VDD 0.1399f
C873 a_8312_15238# sg13cmos5l_dfrbpq_1_2.CLK 0.01101f
C874 a_20376_14464# sg13cmos5l_or3_1_2.C 0.01238f
C875 sg13cmos5l_dlygate4sd3_1_1.A sg13cmos5l_nand3_1_0.Y 0.37433f
C876 a_8312_15238# sg13cmos5l_xnor2_1_0.Y 0.30653f
C877 sg13cmos5l_dlygate4sd3_1_4.X VDD 0.58517f
C878 a_25774_15423# a_25889_15424# 0.3854f
C879 a_26170_15202# sg13cmos5l_o21ai_1_2.B1 0.05397f
C880 a_10703_15311# a_10960_15454# 0.23043f
C881 a_18021_14495# a_18123_14495# 0.3643f
C882 sg13cmos5l_buf_1_10.X a_1856_14570# 0.02603f
C883 sg13cmos5l_or3_1_1.C sg13cmos5l_o21ai_1_2.Y 0.14946f
C884 sg13cmos5l_inv_1_0.Y sg13cmos5l_inv_1_0.A 0.12555f
C885 a_27500_15960# VDD 0.22496f
C886 a_16856_15238# sg13cmos5l_a21oi_1_0.Y 0.27231f
C887 sg13cmos5l_xnor2_1_2.A a_6372_14488# 0.01799f
C888 sg13cmos5l_or3_1_1.A a_27502_15423# 0.12348f
C889 sg13cmos5l_a21oi_1_3.A1 sg13cmos5l_dfrbpq_1_7.D 0.09285f
C890 sg13cmos5l_xnor2_1_2.B sg13cmos5l_dlygate4sd3_1_0.A 0.34813f
C891 sg13cmos5l_a21oi_1_3.B1 sg13cmos5l_or3_1_1.X 0.09969f
C892 a_27407_13799# a_27313_13799# 0.16704f
C893 sg13cmos5l_dfrbpq_1_5.Q a_28074_14020# 0.07823f
C894 a_37484_15960# sg13cmos5l_dfrbpq_1_5.Q 0.19611f
C895 sg13cmos5l_buf_8_2.X a_18863_14845# 0.02216f
C896 sg13cmos5l_or3_1_1.C a_24520_13854# 0.0191f
C897 a_5687_15549# sg13cmos5l_dlygate4sd3_1_3.A 0.01959f
C898 a_21060_14488# VDD 0.07667f
C899 a_6682_13690# VDD 0.28405f
C900 a_2942_14484# VDD 0.01096f
C901 sg13cmos5l_o21ai_1_3.Y sg13cmos5l_or3_1_1.A 0.21954f
C902 a_16955_14484# sg13cmos5l_dfrbpq_1_2.CLK 0.02772f
C903 sg13cmos5l_dfrbpq_1_2.RESET_B VDD 1.18089f
C904 sg13cmos5l_a21oi_1_0.Y sg13cmos5l_inv_1_0.A 0.03371f
C905 sg13cmos5l_dfrbpq_1_2.Q a_18021_14495# 0.02098f
C906 a_25670_14922# a_25930_14452# 0.45119f
C907 a_11752_15366# VDD 0.15245f
C908 sg13cmos5l_a21oi_1_3.B1 sg13cmos5l_dfrbpq_1_6.D 0.04716f
C909 a_9963_15356# sg13cmos5l_dfrbpq_1_2.CLK 0.02366f
C910 sg13cmos5l_a21oi_1_2.A1 sg13cmos5l_o21ai_1_3.Y 0.03141f
C911 a_17921_15424# VDD 0.20695f
C912 a_21034_14452# a_21060_14488# 0.24169f
C913 a_25670_14922# a_26244_14909# 0.18486f
C914 a_6401_13912# a_6682_13690# 0.18796f
C915 a_17604_14488# a_18021_14495# 0.28418f
C916 sg13cmos5l_dfrbpq_1_2.CLK a_6372_14488# 0.08815f
C917 sg13cmos5l_or3_1_2.X a_20603_15532# 0.06091f
C918 a_6286_13911# sg13cmos5l_dlygate4sd3_1_0.X 0.10725f
C919 a_4078_14751# a_4193_14750# 0.3854f
C920 sg13cmos5l_dlygate4sd3_1_8.A sg13cmos5l_nand4_1_0.Y 0.30072f
C921 a_2630_15234# VDD 0.54684f
C922 a_22508_15960# VDD 0.22831f
C923 sg13cmos5l_dfrbpq_1_7.Q a_32492_15960# 0.1927f
C924 a_21477_14495# a_21579_14495# 0.3643f
C925 sg13cmos5l_dlygate4sd3_1_8.A a_9861_15213# 0.01043f
C926 sg13cmos5l_buf_8_2.X sg13cmos5l_dfrbpq_1_5.D 0.07404f
C927 sg13cmos5l_nand4_1_0.Y clock_i 0.14857f
C928 sg13cmos5l_a21oi_1_2.A1 a_24923_15996# 0.0686f
C929 sg13cmos5l_a21oi_1_3.B1 sg13cmos5l_dfrbpq_1_7.D 0.26997f
C930 a_25889_15424# VDD 0.20712f
C931 sg13cmos5l_xor2_1_0.B a_6372_14488# 0.02396f
C932 sg13cmos5l_or3_1_1.B sg13cmos5l_inv_1_0.A 0.44688f
C933 sg13cmos5l_o21ai_1_2.Y sg13cmos5l_buf_8_2.X 0.51052f
C934 a_15671_15549# sg13cmos5l_dfrbpq_1_2.RESET_B 0.01966f
C935 sg13cmos5l_buf_8_2.A a_15579_14854# 0.68123f
C936 a_27313_13799# a_26148_14040# 0.25046f
C937 a_27472_14726# a_27215_14845# 0.23043f
C938 sg13cmos5l_dfrbpq_1_7.Q sg13cmos5l_dfrbpq_1_5.Q 0.45875f
C939 sg13cmos5l_dfrbpq_1_0.RESET_B a_2890_15457# 0.20779f
C940 sg13cmos5l_a21oi_1_3.Y sg13cmos5l_dfrbpq_1_5.RESET_B 0.50817f
C941 a_9158_15234# a_9444_15552# 0.26205f
C942 a_21060_14488# sg13cmos5l_dfrbpq_1_6.D 0.03479f
C943 a_22986_14484# VDD 0.30036f
C944 a_24169_14508# sg13cmos5l_dlygate4sd3_1_17.A 0.01646f
C945 a_21579_14495# sg13cmos5l_dfrbpq_1_6.RESET_B 0.27969f
C946 sg13cmos5l_a21oi_1_3.B1 sg13cmos5l_or3_1_1.C 0.10968f
C947 sg13cmos5l_and2_1_0.X VDD 0.30117f
C948 a_23368_14570# VDD 0.13204f
C949 a_22030_15423# VDD 0.16094f
C950 a_19323_13726# sg13cmos5l_buf_8_2.A 0.35369f
C951 sg13cmos5l_o21ai_1_1.Y sg13cmos5l_dfrbpq_1_6.Q 0.01042f
C952 a_26170_15202# sg13cmos5l_or3_1_1.A 0.01215f
C953 a_22304_16082# counter_value_o[4] 0.01136f
C954 sg13cmos5l_a21oi_1_3.A1 sg13cmos5l_buf_8_2.X 0.02668f
C955 a_20774_14922# sg13cmos5l_or3_1_2.A 0.03212f
C956 sg13cmos5l_or3_1_1.B sg13cmos5l_or3_1_2.A 0.02451f
C957 a_10960_15454# VDD 0.13649f
C958 a_19169_15424# sg13cmos5l_dfrbpq_1_2.Q 0.0208f
C959 a_18586_15455# sg13cmos5l_dfrbpq_1_2.Q 0.04669f
C960 a_25862_13722# a_26148_14040# 0.26205f
C961 a_18123_14495# VDD 0.20905f
C962 a_21946_16237# sg13cmos5l_dfrbpq_1_6.RESET_B 0.04633f
C963 a_15338_14484# sg13cmos5l_dfrbpq_1_2.D 0.01367f
C964 a_6891_14495# a_7888_14726# 0.03546f
C965 a_6789_14495# a_7537_14845# 0.01058f
C966 a_21348_14909# sg13cmos5l_or3_1_2.A 0.01104f
C967 sg13cmos5l_dfrbpq_1_2.Q sg13cmos5l_o21ai_1_2.A2 0.02634f
C968 a_22986_14484# a_22576_14726# 0.07015f
C969 sg13cmos5l_and2_1_0.X a_2516_14484# 0.03166f
C970 sg13cmos5l_dfrbpq_1_2.Q a_17238_15302# 0.01082f
C971 sg13cmos5l_xnor2_1_2.A sg13cmos5l_dlygate4sd3_1_0.A 0.09582f
C972 a_18202_15202# a_18021_14495# 0.0121f
C973 sg13cmos5l_dfrbpq_1_3.RESET_B a_17578_14452# 0.19309f
C974 a_16969_16020# sg13cmos5l_a21oi_1_0.A1 0.01278f
C975 a_21251_13690# a_20968_13854# 0.01625f
C976 sg13cmos5l_tiehi_1.L_HI sg13cmos5l_nand4_1_0.Y 0.03669f
C977 sg13cmos5l_or3_1_2.C a_21251_13690# 0.16807f
C978 sg13cmos5l_tiehi_1.L_HI a_9861_15213# 0.03738f
C979 a_25206_15302# a_25774_15423# 0.01641f
C980 sg13cmos5l_dfrbpq_1_3.RESET_B sg13cmos5l_buf_8_2.X 0.01196f
C981 sg13cmos5l_a21oi_1_3.B1 a_17578_14452# 0.01016f
C982 sg13cmos5l_dfrbpq_1_2.Q VDD 1.33086f
C983 sg13cmos5l_buf_1_0.X a_4081_15311# 0.0102f
C984 sg13cmos5l_nor2_1_0.B sg13cmos5l_buf_8_2.A 0.19122f
C985 sg13cmos5l_buf_1_0.X sg13cmos5l_and2_1_0.X 0.11175f
C986 sg13cmos5l_a21oi_1_3.B1 clock_i 0.02814f
C987 a_9737_14822# a_9861_14521# 0.08186f
C988 a_9658_14725# a_9536_14570# 0.01854f
C989 a_2916_15552# a_3204_15247# 0.24435f
C990 a_2890_15457# a_2916_15552# 0.24169f
C991 sg13cmos5l_a21oi_1_3.B1 sg13cmos5l_buf_8_2.X 0.47568f
C992 sg13cmos5l_dfrbpq_1_3.RESET_B a_17318_14922# 0.10741f
C993 sg13cmos5l_dfrbpq_1_1.RESET_B a_5886_15486# 0.04267f
C994 a_26373_14495# VDD 0.24869f
C995 a_5687_15549# a_5687_15315# 0.08186f
C996 a_21185_15424# sg13cmos5l_dfrbpq_1_6.RESET_B 0.04526f
C997 a_17604_14488# VDD 0.07286f
C998 sg13cmos5l_dlygate4sd3_1_1.A a_6372_14488# 0.03332f
C999 sg13cmos5l_dlygate4sd3_1_17.A sg13cmos5l_o21ai_1_2.Y 0.21213f
C1000 sg13cmos5l_dfrbpq_1_5.RESET_B a_25670_14922# 0.04146f
C1001 sg13cmos5l_a21oi_1_0.A1 sg13cmos5l_a21oi_1_3.B1 0.06245f
C1002 a_17825_16262# VDD 0.20672f
C1003 sg13cmos5l_or3_1_2.B a_21251_13690# 0.15851f
C1004 a_9861_14521# a_10016_14570# 0.03131f
C1005 a_24408_15552# VDD 0.01784f
C1006 sg13cmos5l_tiehi_1.L_HI a_9737_14822# 0.01916f
C1007 a_16969_16020# sg13cmos5l_a21oi_1_0.A2 0.13879f
C1008 a_27472_14726# VDD 0.13629f
C1009 sg13cmos5l_a21oi_1_3.B1 a_17318_14922# 0.01499f
C1010 sg13cmos5l_dlygate4sd3_1_1.A a_8298_14484# 0.09568f
C1011 a_9158_15234# VDD 0.52421f
C1012 a_22319_14845# a_21579_14495# 0.17382f
C1013 sg13cmos5l_xor2_1_0.B a_3872_14570# 0.01249f
C1014 sg13cmos5l_dfrbpq_1_2.CLK a_14261_15238# 0.01831f
C1015 sg13cmos5l_dlygate4sd3_1_4.X sg13cmos5l_a21oi_1_0.A1 0.09426f
C1016 a_27121_14845# a_27215_14845# 0.16704f
C1017 sg13cmos5l_o21ai_1_2.B1 sg13cmos5l_o21ai_1_2.A2 0.18866f
C1018 sg13cmos5l_a21oi_1_0.A2 sg13cmos5l_dfrbpq_1_3.RESET_B 0.01456f
C1019 a_16969_16020# sg13cmos5l_inv_1_0.Y 0.16895f
C1020 VDD a_25862_13722# 0.53201f
C1021 sg13cmos5l_buf_1_10.X a_7888_14726# 0.01264f
C1022 sg13cmos5l_or3_1_1.B sg13cmos5l_o21ai_1_2.Y 0.01359f
C1023 VDD a_6891_14495# 0.20627f
C1024 sg13cmos5l_or3_1_1.B sg13cmos5l_nand4_1_0.Y 0.01086f
C1025 a_16068_14040# a_16485_13701# 0.28324f
C1026 a_15782_13722# a_16587_13844# 0.07916f
C1027 a_2528_15366# sg13cmos5l_and2_1_0.X 0.03662f
C1028 a_2916_15552# sg13cmos5l_dfrbpq_1_2.CLK 0.07118f
C1029 a_21060_14488# sg13cmos5l_buf_8_2.X 0.06778f
C1030 sg13cmos5l_dlygate4sd3_1_8.A a_11752_15366# 0.03099f
C1031 sg13cmos5l_or3_1_1.A a_24824_15238# 0.02528f
C1032 sg13cmos5l_dfrbpq_1_2.RESET_B clock_i 0.18083f
C1033 a_22025_16334# a_21946_16237# 0.08889f
C1034 sg13cmos5l_a21oi_1_0.A2 sg13cmos5l_a21oi_1_3.B1 0.02675f
C1035 a_18586_15455# a_18665_15180# 0.08889f
C1036 a_25206_15302# VDD 0.16099f
C1037 sg13cmos5l_a21oi_1_3.A1 a_25109_12972# 0.02752f
C1038 a_18202_15202# a_18586_15455# 0.01303f
C1039 sg13cmos5l_dfrbpq_1_2.Q sg13cmos5l_dfrbpq_1_6.D 0.01319f
C1040 VDD a_8685_14832# 0.28623f
C1041 sg13cmos5l_o21ai_1_2.B1 VDD 0.449f
C1042 a_12232_16082# counter_value_o[2] 0.02116f
C1043 a_16587_13844# a_17584_13942# 0.03412f
C1044 a_15782_13722# a_16356_13735# 0.18486f
C1045 sg13cmos5l_dfrbpq_1_7.Q sg13cmos5l_dfrbpq_1_5.RESET_B 0.02776f
C1046 a_10703_15311# a_10609_15311# 0.16704f
C1047 sg13cmos5l_o21ai_1_3.Y sg13cmos5l_or3_1_2.B 0.05035f
C1048 a_2824_16082# a_2540_15960# 0.01225f
C1049 sg13cmos5l_or3_1_1.A a_24841_13726# 0.20349f
C1050 sg13cmos5l_xor2_1_0.B a_2916_15552# 0.01285f
C1051 sg13cmos5l_a21oi_1_3.B1 sg13cmos5l_dfrbpq_1_2.D 0.08258f
C1052 sg13cmos5l_buf_1_10.X a_10618_14448# 0.01712f
C1053 VDD a_10222_14751# 0.16191f
C1054 sg13cmos5l_and2_1_2.X VDD 0.32197f
C1055 a_9444_15552# a_10609_15311# 0.25046f
C1056 a_9963_15356# a_9732_15247# 0.07823f
C1057 sg13cmos5l_dlygate4sd3_1_4.X sg13cmos5l_a21oi_1_0.A2 0.04461f
C1058 a_21166_16263# a_21281_16262# 0.3854f
C1059 a_19816_15366# sg13cmos5l_dfrbpq_1_3.Q 0.05363f
C1060 a_17126_15238# a_17238_15302# 0.3854f
C1061 a_3130_16237# sg13cmos5l_dfrbpq_1_0.RESET_B 0.05105f
C1062 sg13cmos5l_a21oi_1_3.Y a_25670_14922# 0.04949f
C1063 sg13cmos5l_or3_1_1.B sg13cmos5l_a21oi_1_3.A1 0.01717f
C1064 a_16068_14040# VDD 0.08143f
C1065 sg13cmos5l_or3_1_2.B a_16140_15424# 0.23811f
C1066 a_18665_15180# VDD 0.0736f
C1067 a_18202_15202# VDD 0.26193f
C1068 a_25774_15423# sg13cmos5l_or3_1_1.A 0.01031f
C1069 a_3333_16033# a_3209_16334# 0.08186f
C1070 sg13cmos5l_or3_1_2.B a_21477_14495# 0.01108f
C1071 sg13cmos5l_or3_1_2.C sg13cmos5l_dfrbpq_1_6.RESET_B 0.02463f
C1072 sg13cmos5l_dlygate4sd3_1_4.X a_18789_15277# 0.03893f
C1073 sg13cmos5l_or3_1_1.X a_25206_15302# 0.05682f
C1074 sg13cmos5l_dlygate4sd3_1_8.X a_7888_14726# 0.01017f
C1075 a_17994_14020# VDD 0.28402f
C1076 sg13cmos5l_dlygate4sd3_1_4.X sg13cmos5l_inv_1_0.Y 0.90342f
C1077 sg13cmos5l_or3_1_1.X sg13cmos5l_o21ai_1_2.B1 0.01824f
C1078 sg13cmos5l_a21oi_1_3.B1 sg13cmos5l_a21oi_1_0.Y 0.43231f
C1079 a_23168_15366# VDD 0.10558f
C1080 a_17126_15238# VDD 0.20971f
C1081 sg13cmos5l_a21oi_1_3.B1 sg13cmos5l_dlygate4sd3_1_17.A 0.24924f
C1082 sg13cmos5l_o21ai_1_2.A2 sg13cmos5l_dfrbpq_1_6.Q 0.19177f
C1083 a_3008_16082# VDD 0.06559f
C1084 sg13cmos5l_buf_1_10.X a_5504_14570# 0.02387f
C1085 a_6086_14922# VDD 0.52224f
C1086 a_26753_15424# sg13cmos5l_dfrbpq_1_6.Q 0.01045f
C1087 a_3209_16334# VDD 0.10631f
C1088 a_16485_13701# a_16042_13945# 0.02241f
C1089 a_16175_15238# sg13cmos5l_nor2_1_0.B 0.0301f
C1090 sg13cmos5l_dfrbpq_1_1.RESET_B a_7888_14726# 0.09622f
C1091 sg13cmos5l_or3_1_1.B a_16587_13844# 0.03034f
C1092 a_22986_14484# sg13cmos5l_buf_8_2.X 0.01572f
C1093 sg13cmos5l_xnor2_1_2.B VDD 0.63659f
C1094 sg13cmos5l_dfrbpq_1_2.RESET_B sg13cmos5l_dfrbpq_1_2.D 0.3532f
C1095 sg13cmos5l_buf_1_10.X a_1192_9948# 0.15509f
C1096 sg13cmos5l_buf_1_10.X VDD 2.54445f
C1097 sg13cmos5l_dlygate4sd3_1_8.A a_10960_15454# 0.01793f
C1098 a_15782_13722# sg13cmos5l_dfrbpq_1_2.RESET_B 0.11354f
C1099 a_38720_13058# VDD 0.09066f
C1100 sg13cmos5l_dfrbpq_1_6.Q VDD 0.92075f
C1101 sg13cmos5l_or3_1_1.B a_16356_13735# 0.01005f
C1102 sg13cmos5l_or3_1_2.B sg13cmos5l_dfrbpq_1_6.RESET_B 0.24505f
C1103 a_25206_14508# sg13cmos5l_dfrbpq_1_5.D 0.10738f
C1104 sg13cmos5l_inv_1_0.Y sg13cmos5l_dfrbpq_1_2.RESET_B 0.01813f
C1105 a_26667_13844# a_27407_13799# 0.17382f
C1106 sg13cmos5l_a21oi_1_3.B1 sg13cmos5l_or3_1_1.B 0.03473f
C1107 a_19530_14484# a_18863_14845# 0.09257f
C1108 sg13cmos5l_or3_1_1.C a_24408_15552# 0.01124f
C1109 a_17584_13942# sg13cmos5l_dfrbpq_1_2.RESET_B 0.09962f
C1110 a_26249_16334# sg13cmos5l_dfrbpq_1_7.RESET_B 0.01098f
C1111 sg13cmos5l_or3_1_2.C sg13cmos5l_o21ai_1_1.Y 0.03402f
C1112 sg13cmos5l_dlygate4sd3_1_9.X a_20705_15260# 0.01276f
C1113 sg13cmos5l_o21ai_1_3.Y a_26170_16237# 0.03498f
C1114 a_26554_16237# VDD 0.09431f
C1115 sg13cmos5l_or3_1_1.A a_26753_15424# 0.01592f
C1116 a_27500_15960# a_27296_16082# 0.01689f
C1117 sg13cmos5l_xnor2_1_2.B a_6401_13912# 0.03894f
C1118 sg13cmos5l_dfrbpq_1_7.D sg13cmos5l_o21ai_1_2.B1 0.02262f
C1119 sg13cmos5l_a21oi_1_3.A2 a_24841_13726# 0.06354f
C1120 sg13cmos5l_buf_8_2.X a_18123_14495# 0.02452f
C1121 a_16042_13945# VDD 0.09565f
C1122 a_6080_13854# VDD 0.07075f
C1123 a_21824_15366# sg13cmos5l_or3_1_2.A 0.01319f
C1124 sg13cmos5l_dlygate4sd3_1_9.X sg13cmos5l_dfrbpq_1_3.Q 0.01028f
C1125 sg13cmos5l_and2_1_1.X VDD 0.27664f
C1126 a_4474_14448# VDD 0.29254f
C1127 sg13cmos5l_or3_1_1.A VDD 0.48327f
C1128 a_26554_16237# a_26757_16033# 0.02453f
C1129 a_3333_15213# sg13cmos5l_dlygate4sd3_1_3.A 0.01794f
C1130 a_27500_15960# counter_value_o[5] 0.15495f
C1131 a_15671_15315# VDD 0.06777f
C1132 sg13cmos5l_dfrbpq_1_2.CLK a_10703_15311# 0.01174f
C1133 a_21579_14495# VDD 0.21266f
C1134 sg13cmos5l_dfrbpq_1_2.Q a_17578_14452# 0.01204f
C1135 sg13cmos5l_or3_1_1.X sg13cmos5l_dfrbpq_1_6.Q 0.01503f
C1136 a_18123_14495# a_17318_14922# 0.07916f
C1137 sg13cmos5l_buf_1_0.X sg13cmos5l_xnor2_1_2.B 0.22918f
C1138 sg13cmos5l_or3_1_2.B sg13cmos5l_o21ai_1_1.Y 0.1545f
C1139 a_23552_14570# sg13cmos5l_or3_1_2.B 0.0358f
C1140 sg13cmos5l_buf_1_0.X sg13cmos5l_buf_1_10.X 0.13688f
C1141 a_9444_15552# sg13cmos5l_dfrbpq_1_2.CLK 0.08307f
C1142 sg13cmos5l_dlygate4sd3_1_8.X VDD 0.35396f
C1143 sg13cmos5l_a21oi_1_2.A1 a_25390_16263# 0.10831f
C1144 a_23480_15242# sg13cmos5l_o21ai_1_2.A2 0.01468f
C1145 a_25206_14508# sg13cmos5l_a21oi_1_3.A1 0.03685f
C1146 a_20774_14922# a_21060_14488# 0.26205f
C1147 a_16969_16020# counter_value_o[3] 0.08229f
C1148 sg13cmos5l_dfrbpq_1_2.Q sg13cmos5l_buf_8_2.X 0.04395f
C1149 sg13cmos5l_a21oi_1_2.A1 VDD 0.17436f
C1150 sg13cmos5l_dfrbpq_1_0.RESET_B a_3435_15356# 0.28294f
C1151 a_25956_14488# a_26373_14495# 0.28418f
C1152 a_6286_13911# sg13cmos5l_dlygate4sd3_1_0.A 0.02097f
C1153 a_17578_14452# a_17604_14488# 0.24169f
C1154 sg13cmos5l_or3_1_2.X sg13cmos5l_or3_1_2.A 0.55116f
C1155 sg13cmos5l_o21ai_1_2.B1 sg13cmos5l_or3_1_1.C 0.46973f
C1156 a_16140_15424# sg13cmos5l_nor2_1_0.B 0.1273f
C1157 sg13cmos5l_a21oi_1_0.A1 sg13cmos5l_dfrbpq_1_2.Q 0.1004f
C1158 enable_i VDD 0.25464f
C1159 sg13cmos5l_dlygate4sd3_1_3.A a_4432_15454# 0.05808f
C1160 a_21946_16237# VDD 0.09557f
C1161 sg13cmos5l_or3_1_1.B sg13cmos5l_dfrbpq_1_2.RESET_B 0.15658f
C1162 a_26667_13844# a_26148_14040# 0.20773f
C1163 sg13cmos5l_dfrbpq_1_1.RESET_B VDD 1.16726f
C1164 a_21060_14488# a_21348_14909# 0.24435f
C1165 a_2490_14447# VDD 0.19284f
C1166 a_26373_14495# a_26475_14495# 0.3643f
C1167 sg13cmos5l_buf_8_2.X a_26373_14495# 0.23747f
C1168 a_17604_14488# sg13cmos5l_buf_8_2.X 0.05299f
C1169 a_18021_14495# a_17892_14909# 0.01562f
C1170 sg13cmos5l_dfrbpq_1_2.Q a_17318_14922# 0.02985f
C1171 sg13cmos5l_or3_1_1.X sg13cmos5l_or3_1_1.A 0.269f
C1172 a_15870_15486# sg13cmos5l_dfrbpq_1_2.RESET_B 0.06273f
C1173 a_15671_15315# a_15671_15549# 0.08186f
C1174 a_25094_14484# VDD 0.20607f
C1175 a_21579_14495# a_22576_14726# 0.03546f
C1176 a_21166_16263# sg13cmos5l_a21oi_1_1.Y 0.01491f
C1177 a_26436_13735# a_26148_14040# 0.24435f
C1178 sg13cmos5l_tiehi_1.L_HI a_10960_15454# 0.09962f
C1179 sg13cmos5l_a21oi_1_0.A1 a_17825_16262# 0.01004f
C1180 a_26475_14495# a_27472_14726# 0.03546f
C1181 a_23638_14862# sg13cmos5l_o21ai_1_2.A2 0.10051f
C1182 a_17604_14488# a_17318_14922# 0.26205f
C1183 sg13cmos5l_a21oi_1_3.B1 a_20603_15532# 0.03672f
C1184 a_26170_15202# sg13cmos5l_dfrbpq_1_5.RESET_B 0.02237f
C1185 sg13cmos5l_dfrbpq_1_2.Q a_22426_15202# 0.01343f
C1186 sg13cmos5l_a21oi_1_2.A1 sg13cmos5l_or3_1_1.X 0.23534f
C1187 a_2490_14447# a_2516_14484# 0.21976f
C1188 sg13cmos5l_buf_1_0.X sg13cmos5l_dlygate4sd3_1_8.X 0.15391f
C1189 sg13cmos5l_a21oi_1_0.A2 sg13cmos5l_dfrbpq_1_2.Q 0.02237f
C1190 a_1192_9948# reset_n_i 0.19796f
C1191 reset_n_i VDD 0.14588f
C1192 sg13cmos5l_or3_1_1.C a_24310_15230# 0.11145f
C1193 a_2890_15457# VDD 0.10858f
C1194 a_21185_15424# VDD 0.20696f
C1195 sg13cmos5l_xnor2_1_2.A VDD 0.73342f
C1196 a_24841_13726# a_25037_14020# 0.01485f
C1197 a_16485_13701# sg13cmos5l_dfrbpq_1_2.CLK 0.22095f
C1198 sg13cmos5l_buf_1_0.X enable_i 0.0337f
C1199 a_16168_15996# VDD 0.22709f
C1200 a_6346_14452# a_6789_14495# 0.02241f
C1201 a_25094_14484# sg13cmos5l_or3_1_1.X 0.03354f
C1202 a_18454_16374# sg13cmos5l_or3_1_2.B 0.0782f
C1203 sg13cmos5l_dfrbpq_1_1.RESET_B sg13cmos5l_buf_1_0.X 0.16585f
C1204 sg13cmos5l_buf_1_0.X a_2490_14447# 0.09015f
C1205 sg13cmos5l_o21ai_1_2.B1 sg13cmos5l_buf_8_2.X 0.22463f
C1206 sg13cmos5l_a21oi_1_3.A2 VDD 0.40843f
C1207 sg13cmos5l_or3_1_1.C sg13cmos5l_dfrbpq_1_6.Q 0.13093f
C1208 a_26122_13945# a_25862_13722# 0.45119f
C1209 sg13cmos5l_dfrbpq_1_2.Q sg13cmos5l_inv_1_0.Y 0.06528f
C1210 a_22508_15960# counter_value_o[4] 0.15504f
C1211 sg13cmos5l_dfrbpq_1_6.RESET_B sg13cmos5l_dfrbpq_1_3.Q 0.02561f
C1212 a_21946_16237# a_22149_16033# 0.02453f
C1213 a_6660_14909# a_6891_14495# 0.07823f
C1214 sg13cmos5l_xnor2_1_2.B a_6202_15238# 0.01843f
C1215 a_20278_14862# sg13cmos5l_o21ai_1_1.Y 0.06702f
C1216 a_2916_15552# a_3435_15356# 0.20773f
C1217 sg13cmos5l_dlygate4sd3_1_5.A a_18454_16374# 0.07345f
C1218 sg13cmos5l_or3_1_2.X a_21070_15423# 0.04119f
C1219 a_7631_14845# a_7537_14845# 0.16704f
C1220 a_32492_15960# VDD 0.22858f
C1221 a_17825_16262# sg13cmos5l_inv_1_0.Y 0.01405f
C1222 a_9418_15457# a_9444_15552# 0.24169f
C1223 sg13cmos5l_dfrbpq_1_2.CLK VDD 1.58512f
C1224 sg13cmos5l_tiehi_1.L_HI a_9158_15234# 0.08086f
C1225 a_26667_13844# VDD 0.20664f
C1226 a_25094_15238# a_25206_15302# 0.3854f
C1227 sg13cmos5l_dfrbpq_1_2.Q sg13cmos5l_a21oi_1_0.Y 0.01608f
C1228 sg13cmos5l_xnor2_1_0.Y VDD 0.31635f
C1229 sg13cmos5l_and2_1_2.B sg13cmos5l_nand4_1_0.Y 0.01346f
C1230 sg13cmos5l_or3_1_1.C sg13cmos5l_or3_1_1.A 0.19409f
C1231 sg13cmos5l_buf_1_0.X a_3204_15247# 0.01531f
C1232 sg13cmos5l_buf_1_0.X sg13cmos5l_xnor2_1_2.A 0.16524f
C1233 sg13cmos5l_buf_1_10.X sg13cmos5l_dlygate4sd3_1_8.A 0.03261f
C1234 a_6575_13342# a_6540_13238# 0.19075f
C1235 a_26170_15202# sg13cmos5l_a21oi_1_3.Y 0.28819f
C1236 sg13cmos5l_dfrbpq_1_5.Q VDD 2.16343f
C1237 a_12232_16082# VDD 0.16754f
C1238 sg13cmos5l_dfrbpq_1_5.RESET_B a_27407_13799# 0.10868f
C1239 a_3435_15356# a_4175_15311# 0.17382f
C1240 sg13cmos5l_xor2_1_0.B VDD 0.49614f
C1241 sg13cmos5l_a21oi_1_0.A1 a_17126_15238# 0.02337f
C1242 a_25930_14452# VDD 0.0966f
C1243 a_1965_14832# sg13cmos5l_and2_1_0.X 0.07702f
C1244 sg13cmos5l_a21oi_1_1.Y sg13cmos5l_a21oi_1_3.B1 0.23211f
C1245 sg13cmos5l_buf_1_10.X clock_i 0.01285f
C1246 sg13cmos5l_nand3_1_0.Y a_6680_15242# 0.01437f
C1247 sg13cmos5l_or3_1_1.B sg13cmos5l_dfrbpq_1_2.Q 0.01742f
C1248 a_27121_14845# a_25956_14488# 0.25046f
C1249 sg13cmos5l_buf_8_2.X sg13cmos5l_dfrbpq_1_6.Q 0.11448f
C1250 sg13cmos5l_dlygate4sd3_1_1.A a_7888_14726# 0.01306f
C1251 VDD a_20968_13854# 0.1724f
C1252 sg13cmos5l_tiehi_1.L_HI sg13cmos5l_and2_1_2.X 0.10137f
C1253 sg13cmos5l_or3_1_2.C VDD 0.6831f
C1254 a_6086_14922# a_6660_14909# 0.18486f
C1255 a_4175_15311# a_4842_15532# 0.09257f
C1256 sg13cmos5l_xor2_1_0.B a_2516_14484# 0.01121f
C1257 sg13cmos5l_buf_1_0.X sg13cmos5l_dfrbpq_1_2.CLK 0.05368f
C1258 a_27502_15423# sg13cmos5l_dfrbpq_1_7.Q 0.01894f
C1259 sg13cmos5l_o21ai_1_2.B1 a_24062_15242# 0.01812f
C1260 sg13cmos5l_or3_1_2.B sg13cmos5l_o21ai_1_2.A2 0.55335f
C1261 a_15782_13722# a_16068_14040# 0.26205f
C1262 sg13cmos5l_dlygate4sd3_1_8.A a_10609_15311# 0.0173f
C1263 sg13cmos5l_a21oi_1_0.A2 a_17126_15238# 0.0707f
C1264 a_21185_15424# a_21466_15202# 0.18796f
C1265 a_20376_14464# sg13cmos5l_o21ai_1_1.Y 0.01087f
C1266 a_15671_15315# clock_i 0.02493f
C1267 sg13cmos5l_xor2_1_0.X sg13cmos5l_and2_1_0.X 0.28573f
C1268 a_19054_15423# a_19169_15424# 0.3854f
C1269 a_18789_15277# a_18665_15180# 0.08186f
C1270 sg13cmos5l_dlygate4sd3_1_17.A sg13cmos5l_o21ai_1_2.B1 0.02204f
C1271 sg13cmos5l_buf_1_0.X sg13cmos5l_xor2_1_0.B 0.67613f
C1272 a_2540_15960# sg13cmos5l_dlygate4sd3_1_3.A 0.19598f
C1273 sg13cmos5l_or3_1_1.A sg13cmos5l_buf_8_2.X 0.02847f
C1274 a_21034_14452# sg13cmos5l_or3_1_2.C 0.01367f
C1275 sg13cmos5l_dfrbpq_1_5.RESET_B a_26148_14040# 0.28728f
C1276 a_8582_15238# sg13cmos5l_and2_1_2.B 0.01938f
C1277 a_22145_15424# VDD 0.21275f
C1278 a_22426_15202# sg13cmos5l_dfrbpq_1_6.Q 0.27955f
C1279 a_21579_14495# sg13cmos5l_buf_8_2.X 0.03908f
C1280 sg13cmos5l_or3_1_2.B VDD 2.19079f
C1281 VDD a_9536_14570# 0.10026f
C1282 sg13cmos5l_a21oi_1_3.B1 sg13cmos5l_or3_1_2.X 0.02158f
C1283 a_9444_15552# a_9732_15247# 0.24435f
C1284 a_17584_13942# a_17994_14020# 0.07015f
C1285 sg13cmos5l_a21oi_1_3.A2 sg13cmos5l_or3_1_1.C 0.14595f
C1286 sg13cmos5l_buf_1_10.X sg13cmos5l_tiehi_1.L_HI 0.03277f
C1287 a_7532_15960# a_7240_16082# 0.01635f
C1288 a_3130_16237# a_3333_16033# 0.02453f
C1289 a_2824_16082# a_3008_16082# 0.05762f
C1290 VDD a_15579_14854# 0.86798f
C1291 a_9418_15457# VDD 0.1001f
C1292 a_15680_13854# VDD 0.10463f
C1293 sg13cmos5l_dlygate4sd3_1_5.A VDD 0.30993f
C1294 sg13cmos5l_or3_1_1.B sg13cmos5l_o21ai_1_2.B1 0.03172f
C1295 a_19054_15423# VDD 0.15932f
C1296 a_25094_15238# sg13cmos5l_or3_1_1.A 0.04844f
C1297 a_21562_15960# sg13cmos5l_dfrbpq_1_6.RESET_B 0.04463f
C1298 sg13cmos5l_or3_1_2.B a_21034_14452# 0.03049f
C1299 sg13cmos5l_dlygate4sd3_1_4.X a_18106_15960# 0.01488f
C1300 sg13cmos5l_dfrbpq_1_2.Q counter_value_o[3] 0.01238f
C1301 a_17327_13799# VDD 0.18096f
C1302 a_25094_14484# sg13cmos5l_buf_8_2.X 0.01175f
C1303 sg13cmos5l_dlygate4sd3_1_1.A VDD 0.97447f
C1304 a_3130_16237# VDD 0.10639f
C1305 a_16175_15238# a_16140_15424# 0.19075f
C1306 a_19323_13726# VDD 0.94636f
C1307 a_15782_13722# a_16042_13945# 0.45119f
C1308 sg13cmos5l_or3_1_1.B a_16068_14040# 0.03267f
C1309 sg13cmos5l_or3_1_2.X a_21060_14488# 0.04034f
C1310 a_26633_16334# VDD 0.10189f
C1311 sg13cmos5l_dlygate4sd3_1_8.X a_9861_14521# 0.02311f
C1312 a_27898_15202# VDD 0.2847f
C1313 sg13cmos5l_dlygate4sd3_1_17.A sg13cmos5l_dfrbpq_1_6.Q 0.01411f
C1314 a_26753_15424# sg13cmos5l_dfrbpq_1_5.RESET_B 0.01144f
C1315 sg13cmos5l_or3_1_1.B a_17994_14020# 0.01534f
C1316 a_24169_14508# a_24263_14508# 0.02103f
C1317 sg13cmos5l_or3_1_2.B sg13cmos5l_dfrbpq_1_6.D 0.02411f
C1318 sg13cmos5l_dlygate4sd3_1_8.X sg13cmos5l_tiehi_1.L_HI 0.04348f
C1319 a_24169_14508# sg13cmos5l_o21ai_1_2.Y 0.05936f
C1320 a_24824_14525# a_24824_15238# 0.01163f
C1321 a_38536_3986# VDD 0.1399f
C1322 a_26633_16334# a_26757_16033# 0.08186f
C1323 sg13cmos5l_a21oi_1_3.B1 sg13cmos5l_dfrbpq_1_7.RESET_B 0.04148f
C1324 a_25786_15960# a_25505_16262# 0.18796f
C1325 sg13cmos5l_dfrbpq_1_5.RESET_B VDD 1.27461f
C1326 a_26170_16237# VDD 0.09144f
C1327 a_18021_14495# sg13cmos5l_buf_8_2.A 0.01317f
C1328 sg13cmos5l_a21oi_1_3.A2 sg13cmos5l_buf_8_2.X 0.01098f
C1329 a_32200_16082# VDD 0.1695f
C1330 sg13cmos5l_dfrbpq_1_6.Q counter_value_o[5] 0.01034f
C1331 a_26565_13701# a_27313_13799# 0.01058f
C1332 a_27407_13799# a_28074_14020# 0.09257f
C1333 sg13cmos5l_buf_1_10.X a_5613_14832# 0.09367f
C1334 sg13cmos5l_dlygate4sd3_1_8.A sg13cmos5l_dfrbpq_1_2.CLK 0.11676f
C1335 sg13cmos5l_dfrbpq_1_3.RESET_B sg13cmos5l_inv_1_0.A 0.03151f
C1336 a_20278_14862# VDD 0.01267f
C1337 a_7937_13912# VDD 0.21568f
C1338 a_25786_15960# sg13cmos5l_dfrbpq_1_7.RESET_B 0.03625f
C1339 a_16552_15996# VDD 0.18144f
C1340 a_6286_13911# VDD 0.15952f
C1341 sg13cmos5l_nand4_1_0.Y a_12010_15202# 0.04366f
C1342 sg13cmos5l_buf_1_0.X sg13cmos5l_dlygate4sd3_1_1.A 0.27666f
C1343 sg13cmos5l_dlygate4sd3_1_17.A sg13cmos5l_or3_1_1.A 0.15251f
C1344 a_26373_16033# a_26554_16237# 0.04141f
C1345 a_2630_15234# sg13cmos5l_dlygate4sd3_1_3.A 0.03756f
C1346 sg13cmos5l_nor2_1_0.B VDD 0.25674f
C1347 clock_i sg13cmos5l_dfrbpq_1_2.CLK 0.03525f
C1348 sg13cmos5l_nand3_1_0.Y VDD 0.70369f
C1349 a_17806_15423# sg13cmos5l_inv_1_0.A 0.12443f
C1350 sg13cmos5l_o21ai_1_2.A2 sg13cmos5l_dfrbpq_1_3.Q 0.12945f
C1351 a_21824_15366# a_22030_15423# 0.01604f
C1352 sg13cmos5l_dlygate4sd3_1_0.X VDD 0.44473f
C1353 sg13cmos5l_a21oi_1_3.B1 sg13cmos5l_inv_1_0.A 0.05318f
C1354 sg13cmos5l_buf_8_2.X a_26667_13844# 0.04348f
C1355 sg13cmos5l_nand4_1_0.Y a_7680_15549# 0.03194f
C1356 sg13cmos5l_or3_1_2.B a_21466_15202# 0.05836f
C1357 sg13cmos5l_a21oi_1_2.A1 sg13cmos5l_dlygate4sd3_1_17.A 0.07757f
C1358 sg13cmos5l_a21oi_1_0.A1 sg13cmos5l_dfrbpq_1_2.CLK 0.27031f
C1359 sg13cmos5l_or3_1_1.B a_16042_13945# 0.0385f
C1360 a_25930_14452# a_25956_14488# 0.24169f
C1361 sg13cmos5l_dfrbpq_1_0.RESET_B a_2916_15552# 0.28678f
C1362 a_6286_13911# a_6401_13912# 0.3854f
C1363 a_5896_13854# a_6080_13854# 0.05762f
C1364 a_5613_14832# sg13cmos5l_and2_1_1.X 0.08726f
C1365 sg13cmos5l_dfrbpq_1_2.Q a_20000_15366# 0.02435f
C1366 sg13cmos5l_or3_1_2.B sg13cmos5l_or3_1_1.C 0.39924f
C1367 sg13cmos5l_or3_1_1.B sg13cmos5l_or3_1_1.A 0.12822f
C1368 sg13cmos5l_dfrbpq_1_3.Q VDD 1.10993f
C1369 a_20960_16082# VDD 0.08507f
C1370 sg13cmos5l_buf_1_10.X a_1965_14832# 0.10177f
C1371 a_20774_14922# a_21579_14495# 0.07916f
C1372 a_26565_13701# a_25862_13722# 0.02453f
C1373 a_5600_15366# VDD 0.09581f
C1374 a_25956_14488# a_26244_14909# 0.24435f
C1375 sg13cmos5l_buf_8_2.X a_25930_14452# 0.01411f
C1376 a_3435_15356# VDD 0.20564f
C1377 a_15870_15486# a_15671_15315# 0.02453f
C1378 sg13cmos5l_and2_1_0.X sg13cmos5l_dlygate4sd3_1_3.A 0.01628f
C1379 a_21348_14909# a_21579_14495# 0.07823f
C1380 a_26244_14909# a_26475_14495# 0.07823f
C1381 a_16168_15996# sg13cmos5l_inv_1_0.Y 0.03785f
C1382 sg13cmos5l_dfrbpq_1_0.RESET_B a_4175_15311# 0.10904f
C1383 sg13cmos5l_a21oi_1_3.Y VDD 0.39493f
C1384 sg13cmos5l_xor2_1_0.B a_6660_14909# 0.023f
C1385 sg13cmos5l_a21oi_1_3.B1 sg13cmos5l_or3_1_2.A 0.01884f
C1386 sg13cmos5l_buf_1_0.X sg13cmos5l_nand3_1_0.Y 0.18201f
C1387 sg13cmos5l_or3_1_2.C sg13cmos5l_buf_8_2.X 0.15474f
C1388 a_9963_15356# a_10703_15311# 0.17382f
C1389 sg13cmos5l_dfrbpq_1_5.Q counter_value_o[7] 0.01279f
C1390 a_9861_15213# sg13cmos5l_nand4_1_0.Y 0.0176f
C1391 sg13cmos5l_dfrbpq_1_2.RESET_B sg13cmos5l_inv_1_0.A 0.01762f
C1392 a_17892_14909# a_17318_14922# 0.18486f
C1393 a_21477_14495# sg13cmos5l_dfrbpq_1_6.RESET_B 0.03611f
C1394 a_4842_15532# VDD 0.28434f
C1395 a_9444_15552# a_9963_15356# 0.20773f
C1396 a_25889_15424# sg13cmos5l_dfrbpq_1_7.RESET_B 0.08041f
C1397 sg13cmos5l_dfrbpq_1_3.RESET_B a_18863_14845# 0.10879f
C1398 a_20376_14464# VDD 0.01867f
C1399 sg13cmos5l_buf_1_10.X sg13cmos5l_xor2_1_0.X 0.14017f
C1400 sg13cmos5l_tiehi_1.L_HI sg13cmos5l_dfrbpq_1_2.CLK 0.04608f
C1401 a_17921_15424# sg13cmos5l_inv_1_0.A 0.01143f
C1402 sg13cmos5l_a21oi_1_3.A2 sg13cmos5l_dlygate4sd3_1_17.A 0.05288f
C1403 sg13cmos5l_a21oi_1_3.A1 sg13cmos5l_dfrbpq_1_5.D 0.10222f
C1404 sg13cmos5l_inv_1_0.Y sg13cmos5l_dfrbpq_1_2.CLK 0.01047f
C1405 counter_value_o[0] a_2248_16082# 0.02116f
C1406 sg13cmos5l_dfrbpq_1_7.Q a_27215_14845# 0.0476f
C1407 sg13cmos5l_or3_1_2.X sg13cmos5l_dfrbpq_1_2.Q 0.33145f
C1408 sg13cmos5l_a21oi_1_3.A2 a_25109_12972# 0.05791f
C1409 a_24824_14525# VDD 0.2598f
C1410 a_32492_15960# counter_value_o[6] 0.15504f
C1411 sg13cmos5l_or3_1_2.B sg13cmos5l_buf_8_2.X 0.10287f
C1412 sg13cmos5l_buf_1_0.X a_3435_15356# 0.01828f
C1413 a_22508_15960# a_22304_16082# 0.01689f
C1414 sg13cmos5l_or3_1_1.X sg13cmos5l_a21oi_1_3.Y 0.01332f
C1415 sg13cmos5l_dfrbpq_1_6.D sg13cmos5l_dfrbpq_1_3.Q 0.01666f
C1416 sg13cmos5l_dfrbpq_1_6.D a_20960_16082# 0.01243f
C1417 a_6789_14495# a_6891_14495# 0.3643f
C1418 a_21060_14488# sg13cmos5l_or3_1_2.A 0.03179f
C1419 sg13cmos5l_buf_8_2.A VDD 1.75883f
C1420 a_5687_15549# sg13cmos5l_dfrbpq_1_1.RESET_B 0.01133f
C1421 a_22225_14845# a_21477_14495# 0.01058f
C1422 a_1965_14832# a_2490_14447# 0.01705f
C1423 clock_i a_15579_14854# 0.3255f
C1424 a_2630_15234# a_3333_15213# 0.02453f
C1425 a_18106_15960# a_17825_16262# 0.18796f
C1426 a_16168_15996# sg13cmos5l_or3_1_1.B 0.18678f
C1427 sg13cmos5l_a21oi_1_0.Y sg13cmos5l_dfrbpq_1_2.CLK 0.1806f
C1428 a_7888_14726# a_8298_14484# 0.07015f
C1429 sg13cmos5l_a21oi_1_3.A2 sg13cmos5l_or3_1_1.B 0.10458f
C1430 a_8312_15238# VDD 0.27567f
C1431 a_18769_14845# a_18863_14845# 0.16704f
C1432 sg13cmos5l_dlygate4sd3_1_1.A clock_i 0.01208f
C1433 a_8582_15238# sg13cmos5l_nand4_1_0.Y 0.0177f
C1434 a_25206_14508# sg13cmos5l_or3_1_1.A 0.0186f
C1435 sg13cmos5l_buf_1_0.X a_4842_15532# 0.01204f
C1436 a_22145_15424# a_22426_15202# 0.18796f
C1437 a_28074_14020# VDD 0.28333f
C1438 a_37484_15960# VDD 0.22428f
C1439 sg13cmos5l_and2_1_2.B a_9158_15234# 0.02349f
C1440 a_2916_15552# a_4175_15311# 0.01412f
C1441 sg13cmos5l_xnor2_1_2.B a_6540_13238# 0.25625f
C1442 sg13cmos5l_a21oi_1_3.B1 sg13cmos5l_dfrbpq_1_5.D 0.19488f
C1443 a_25670_14922# VDD 0.52312f
C1444 a_19323_13726# sg13cmos5l_buf_8_2.X 0.66336f
C1445 sg13cmos5l_a21oi_1_3.B1 sg13cmos5l_o21ai_1_2.Y 0.01177f
C1446 a_38720_13854# VDD 0.05657f
C1447 sg13cmos5l_or3_1_1.B sg13cmos5l_dfrbpq_1_2.CLK 0.21155f
C1448 sg13cmos5l_dfrbpq_1_2.CLK a_5613_14832# 0.01227f
C1449 sg13cmos5l_dfrbpq_1_2.CLK a_4078_14751# 0.01392f
C1450 sg13cmos5l_xor2_1_0.X a_2490_14447# 0.14671f
C1451 a_3333_15213# a_4081_15311# 0.01058f
C1452 a_12010_15202# a_11752_15366# 0.01836f
C1453 sg13cmos5l_or3_1_1.C sg13cmos5l_dfrbpq_1_3.Q 0.09624f
C1454 sg13cmos5l_o21ai_1_1.Y sg13cmos5l_dfrbpq_1_6.RESET_B 0.02262f
C1455 a_16955_14484# VDD 0.20174f
C1456 sg13cmos5l_dfrbpq_1_5.RESET_B a_25956_14488# 0.01473f
C1457 sg13cmos5l_o21ai_1_3.Y a_24824_15238# 0.03926f
C1458 a_21562_15960# VDD 0.26426f
C1459 a_10618_14448# a_10337_14750# 0.18796f
C1460 VDD a_19048_13854# 0.14253f
C1461 sg13cmos5l_tiehi_1.L_HI a_9536_14570# 0.01076f
C1462 a_19816_15366# VDD 0.12937f
C1463 sg13cmos5l_dfrbpq_1_2.Q a_16856_15238# 0.01361f
C1464 a_6086_14922# a_6789_14495# 0.02431f
C1465 sg13cmos5l_xor2_1_0.B a_4078_14751# 0.11637f
C1466 sg13cmos5l_and2_1_2.B a_8685_14832# 0.17752f
C1467 sg13cmos5l_or3_1_2.B sg13cmos5l_inv_1_0.Y 0.96765f
C1468 a_25206_14508# a_25094_14484# 0.3854f
C1469 sg13cmos5l_dfrbpq_1_5.RESET_B a_26475_14495# 0.02481f
C1470 sg13cmos5l_buf_8_2.X sg13cmos5l_dfrbpq_1_5.RESET_B 0.10136f
C1471 sg13cmos5l_dfrbpq_1_7.RESET_B a_26373_14495# 0.03634f
C1472 sg13cmos5l_dlygate4sd3_1_8.X a_7262_15242# 0.01812f
C1473 a_9963_15356# VDD 0.20809f
C1474 sg13cmos5l_buf_1_0.X a_7160_15242# 0.01376f
C1475 a_15579_14854# sg13cmos5l_dfrbpq_1_2.D 0.09154f
C1476 VDD a_24704_13854# 0.06781f
C1477 sg13cmos5l_buf_1_10.X a_6789_14495# 0.01284f
C1478 sg13cmos5l_and2_1_2.B sg13cmos5l_and2_1_2.X 0.13511f
C1479 a_9418_15457# sg13cmos5l_tiehi_1.L_HI 0.17464f
C1480 a_15680_13854# sg13cmos5l_dfrbpq_1_2.D 0.03989f
C1481 VDD a_6372_14488# 0.07271f
C1482 a_22030_15423# sg13cmos5l_or3_1_2.A 0.10722f
C1483 sg13cmos5l_nor2_1_0.B clock_i 0.09977f
C1484 sg13cmos5l_nand3_1_0.Y clock_i 0.04233f
C1485 sg13cmos5l_dfrbpq_1_7.RESET_B a_27472_14726# 0.09622f
C1486 sg13cmos5l_a21oi_1_3.B1 sg13cmos5l_a21oi_1_3.A1 0.26386f
C1487 sg13cmos5l_inv_1_0.Y a_15579_14854# 0.02441f
C1488 sg13cmos5l_dfrbpq_1_2.Q sg13cmos5l_inv_1_0.A 0.70863f
C1489 a_19054_15423# a_18789_15277# 0.0144f
C1490 sg13cmos5l_dlygate4sd3_1_5.A sg13cmos5l_inv_1_0.Y 0.2384f
C1491 a_20774_14922# sg13cmos5l_or3_1_2.C 0.03077f
C1492 sg13cmos5l_dfrbpq_1_7.Q VDD 1.33022f
C1493 sg13cmos5l_or3_1_1.B sg13cmos5l_or3_1_2.C 0.09208f
C1494 sg13cmos5l_dfrbpq_1_5.RESET_B a_26122_13945# 0.20792f
C1495 sg13cmos5l_or3_1_2.B sg13cmos5l_a21oi_1_0.Y 0.01754f
C1496 VDD a_8298_14484# 0.27815f
C1497 a_22025_16334# sg13cmos5l_dfrbpq_1_6.RESET_B 0.01142f
C1498 a_22319_14845# sg13cmos5l_dfrbpq_1_6.RESET_B 0.10879f
C1499 VDD a_9658_14725# 0.10119f
C1500 a_17327_13799# a_17584_13942# 0.23043f
C1501 a_16068_14040# a_17233_13799# 0.25046f
C1502 a_16587_13844# a_16356_13735# 0.07823f
C1503 sg13cmos5l_a21oi_1_0.Y a_15579_14854# 0.03237f
C1504 sg13cmos5l_buf_1_10.X a_14344_14570# 0.03427f
C1505 sg13cmos5l_dfrbpq_1_3.RESET_B a_17806_15423# 0.05914f
C1506 VDD a_10337_14750# 0.20387f
C1507 sg13cmos5l_dfrbpq_1_3.Q sg13cmos5l_buf_8_2.X 0.02606f
C1508 a_17710_16263# VDD 0.16005f
C1509 VDD a_21251_13690# 0.28201f
C1510 sg13cmos5l_a21oi_1_3.B1 sg13cmos5l_dfrbpq_1_3.RESET_B 0.04636f
C1511 sg13cmos5l_o21ai_1_2.B1 sg13cmos5l_dfrbpq_1_7.RESET_B 0.02543f
C1512 sg13cmos5l_xnor2_1_2.B sg13cmos5l_dlygate4sd3_1_3.A 0.11793f
C1513 sg13cmos5l_a21oi_1_1.Y a_21946_16237# 0.03498f
C1514 sg13cmos5l_dlygate4sd3_1_4.X a_16969_16020# 0.2162f
C1515 sg13cmos5l_or3_1_2.B a_20774_14922# 0.04313f
C1516 sg13cmos5l_or3_1_1.B sg13cmos5l_or3_1_2.B 0.04606f
C1517 sg13cmos5l_buf_1_10.X sg13cmos5l_dlygate4sd3_1_3.A 0.02697f
C1518 sg13cmos5l_buf_1_10.X sg13cmos5l_and2_1_2.B 0.19757f
C1519 a_22319_14845# a_22225_14845# 0.16704f
C1520 a_17238_15302# sg13cmos5l_dfrbpq_1_3.D 0.12541f
C1521 sg13cmos5l_a21oi_1_3.Y a_25956_14488# 0.02684f
C1522 a_2248_16082# VDD 0.16554f
C1523 sg13cmos5l_dlygate4sd3_1_8.X a_6789_14495# 0.01594f
C1524 sg13cmos5l_dfrbpq_1_7.D a_25670_14922# 0.16976f
C1525 a_8694_15302# VDD 0.15959f
C1526 sg13cmos5l_dfrbpq_1_2.Q sg13cmos5l_or3_1_2.A 0.09838f
C1527 sg13cmos5l_dlygate4sd3_1_9.X VDD 0.18623f
C1528 a_18123_14495# a_18863_14845# 0.17382f
C1529 sg13cmos5l_or3_1_2.B a_21348_14909# 0.01476f
C1530 sg13cmos5l_dlygate4sd3_1_4.X sg13cmos5l_dfrbpq_1_3.RESET_B 0.01938f
C1531 sg13cmos5l_a21oi_1_3.Y sg13cmos5l_buf_8_2.X 0.07372f
C1532 sg13cmos5l_or3_1_1.B a_15579_14854# 0.05153f
C1533 sg13cmos5l_dlygate4sd3_1_8.X a_7537_14845# 0.02247f
C1534 sg13cmos5l_dfrbpq_1_1.RESET_B a_6789_14495# 0.03692f
C1535 sg13cmos5l_xor2_1_0.B sg13cmos5l_xor2_1_0.X 0.07025f
C1536 sg13cmos5l_dfrbpq_1_3.D VDD 0.20543f
C1537 sg13cmos5l_dfrbpq_1_0.RESET_B VDD 1.2525f
C1538 sg13cmos5l_xnor2_1_2.B a_6714_12972# 0.01001f
C1539 a_32200_16082# counter_value_o[6] 0.02116f
C1540 sg13cmos5l_nor2_1_0.B sg13cmos5l_dfrbpq_1_2.D 0.11174f
C1541 a_16552_15996# sg13cmos5l_inv_1_0.Y 0.01509f
C1542 a_27502_15423# VDD 0.16013f
C1543 sg13cmos5l_xnor2_1_2.A a_6540_13238# 0.12802f
C1544 a_27617_15424# sg13cmos5l_dfrbpq_1_6.Q 0.04727f
C1545 a_22426_15202# sg13cmos5l_dfrbpq_1_3.Q 0.03081f
C1546 sg13cmos5l_dlygate4sd3_1_3.A a_4474_14448# 0.28823f
C1547 sg13cmos5l_or3_1_1.B a_17327_13799# 0.01909f
C1548 sg13cmos5l_dlygate4sd3_1_1.A a_8218_13690# 0.30158f
C1549 sg13cmos5l_inv_1_0.Y sg13cmos5l_nor2_1_0.B 0.02795f
C1550 a_25390_16263# sg13cmos5l_o21ai_1_3.Y 0.01565f
C1551 a_26565_13701# a_26667_13844# 0.36168f
C1552 sg13cmos5l_a21oi_1_3.B1 a_18769_14845# 0.01028f
C1553 sg13cmos5l_o21ai_1_3.Y VDD 0.48036f
C1554 a_16587_13844# sg13cmos5l_dfrbpq_1_2.RESET_B 0.27963f
C1555 a_16969_16020# a_17063_16020# 0.02103f
C1556 a_26249_16334# a_26554_16237# 0.01055f
C1557 a_38720_10034# VDD 0.0583f
C1558 a_16856_15238# a_17126_15238# 0.18796f
C1559 sg13cmos5l_or3_1_1.B a_19323_13726# 0.05142f
C1560 a_17578_14452# sg13cmos5l_buf_8_2.A 0.01404f
C1561 a_24824_14525# sg13cmos5l_buf_8_2.X 0.01711f
C1562 clock_i sg13cmos5l_buf_8_2.A 0.02615f
C1563 a_26638_15423# sg13cmos5l_o21ai_1_2.B1 0.10722f
C1564 a_26565_13701# a_26436_13735# 0.01562f
C1565 a_10703_15311# a_11370_15532# 0.09257f
C1566 sg13cmos5l_dlygate4sd3_1_8.X sg13cmos5l_and2_1_2.B 0.03311f
C1567 a_17604_14488# a_18863_14845# 0.01412f
C1568 a_38536_3986# a_38720_3986# 0.05762f
C1569 sg13cmos5l_dlygate4sd3_1_0.A a_6280_13058# 0.01639f
C1570 sg13cmos5l_nand4_1_0.Y a_10960_15454# 0.0126f
C1571 a_1856_14570# VDD 0.08533f
C1572 sg13cmos5l_xnor2_1_2.A a_6789_14495# 0.02956f
C1573 a_24923_15996# VDD 0.16154f
C1574 sg13cmos5l_buf_8_2.X sg13cmos5l_buf_8_2.A 0.17028f
C1575 a_17921_15424# sg13cmos5l_dfrbpq_1_3.RESET_B 0.07437f
C1576 sg13cmos5l_dfrbpq_1_7.RESET_B sg13cmos5l_dfrbpq_1_6.Q 0.01935f
C1577 sg13cmos5l_a21oi_1_3.B1 sg13cmos5l_dfrbpq_1_2.RESET_B 0.03328f
C1578 a_26170_16237# a_26373_16033# 0.02453f
C1579 a_16140_15424# VDD 0.18406f
C1580 sg13cmos5l_or3_1_1.C a_24704_13854# 0.02884f
C1581 sg13cmos5l_dfrbpq_1_1.RESET_B sg13cmos5l_dlygate4sd3_1_3.A 0.14117f
C1582 a_21477_14495# VDD 0.24916f
C1583 a_17126_15238# sg13cmos5l_inv_1_0.A 0.01214f
C1584 sg13cmos5l_dlygate4sd3_1_0.A VDD 0.32455f
C1585 a_12524_15960# a_12232_16082# 0.01635f
C1586 a_3872_14570# VDD 0.08604f
C1587 sg13cmos5l_dlygate4sd3_1_9.X sg13cmos5l_dfrbpq_1_6.D 0.09017f
C1588 a_17921_15424# a_17806_15423# 0.3854f
C1589 sg13cmos5l_buf_1_0.X sg13cmos5l_dfrbpq_1_0.RESET_B 0.05907f
C1590 sg13cmos5l_or3_1_2.B counter_value_o[3] 0.48267f
C1591 sg13cmos5l_buf_8_2.A a_17318_14922# 0.02999f
C1592 sg13cmos5l_or3_1_1.X sg13cmos5l_o21ai_1_3.Y 0.04258f
C1593 counter_value_o[7] VSS 2.33359f
C1594 counter_value_o[6] VSS 1.63261f
C1595 counter_value_o[5] VSS 1.92698f
C1596 counter_value_o[4] VSS 1.56945f
C1597 counter_value_o[3] VSS 1.53899f
C1598 counter_value_o[2] VSS 1.74775f
C1599 counter_value_o[1] VSS 1.5799f
C1600 counter_value_o[0] VSS 1.63892f
C1601 a_38720_3986# VSS 0.07631f ; **FLOATING
C1602 a_38536_3986# VSS 0.10768f ; **FLOATING
C1603 a_38720_10034# VSS 0.07628f ; **FLOATING
C1604 a_38536_10034# VSS 0.10768f ; **FLOATING
C1605 a_38720_13058# VSS 0.08763f ; **FLOATING
C1606 a_25109_12972# VSS 0.25522f
C1607 a_25203_13320# VSS 0.45994f
C1608 a_6575_13342# VSS 0.20137f
C1609 a_6280_13058# VSS 0.09809f ; **FLOATING
C1610 a_38720_13854# VSS 0.07452f ; **FLOATING
C1611 a_38536_13854# VSS 0.10767f ; **FLOATING
C1612 a_27826_13722# VSS 0.39632f
C1613 a_27313_13799# VSS 0.06782f
C1614 a_26374_13735# VSS 0.53262f
C1615 a_26436_13735# VSS 0.53884f
C1616 a_27609_14037# VSS 0.29831f
C1617 a_25956_13722# VSS 0.06121f
C1618 a_26505_14113# VSS 0.13109f
C1619 a_25862_13722# VSS 0.30589f
C1620 a_25037_14020# VSS 0.26318f
C1621 a_24704_13854# VSS 0.0401f ; **FLOATING
C1622 a_24520_13854# VSS 0.1039f ; **FLOATING
C1623 a_24841_13726# VSS 0.15095f
C1624 a_21549_14020# VSS 0.28251f
C1625 a_21460_14020# VSS 0.52082f
C1626 a_20968_13854# VSS 0.09008f ; **FLOATING
C1627 a_19232_13854# VSS 0.03773f ; **FLOATING
C1628 a_19048_13854# VSS 0.09994f ; **FLOATING
C1629 a_21251_13690# VSS 0.03834f
C1630 a_17233_13799# VSS 0.20929f
C1631 a_16356_13735# VSS 0.13271f
C1632 a_17529_14037# VSS 0.07696f
C1633 a_16425_14113# VSS 0.50217f
C1634 a_16068_14040# VSS 0.20049f
C1635 a_15782_13722# VSS 1.15951f
C1636 a_15680_13854# VSS 0.04657f ; **FLOATING
C1637 a_6080_13854# VSS 0.03878f ; **FLOATING
C1638 a_5896_13854# VSS 0.10286f ; **FLOATING
C1639 a_6286_13911# VSS 0.14189f
C1640 a_38720_14570# VSS 0.08673f ; **FLOATING
C1641 a_27417_14607# VSS 0.12686f
C1642 a_26313_14531# VSS 0.09521f
C1643 a_27634_14922# VSS 0.04455f
C1644 a_27121_14845# VSS 0.0678f
C1645 a_27472_14726# VSS 0.02568f
C1646 a_26244_14909# VSS 0.55965f
C1647 a_26182_14909# VSS 0.79375f
C1648 a_24263_14508# VSS 0.59707f
C1649 a_23736_14464# VSS 0.04886f
C1650 a_25764_14922# VSS 0.16376f
C1651 a_25670_14922# VSS 0.72012f
C1652 a_25094_14484# VSS 0.18968f
C1653 a_23552_14570# VSS 0.03863f ; **FLOATING
C1654 a_23368_14570# VSS 0.08476f ; **FLOATING
C1655 a_23638_14862# VSS 0.16918f
C1656 a_21417_14531# VSS 0.57652f
C1657 a_20376_14464# VSS 0.24207f
C1658 a_22225_14845# VSS 0.28476f
C1659 a_21348_14909# VSS 0.03666f
C1660 a_20868_14922# VSS 0.17329f
C1661 a_20774_14922# VSS 0.50797f
C1662 a_20278_14862# VSS 0.18479f
C1663 a_17961_14531# VSS 0.07346f
C1664 a_18769_14845# VSS 0.30331f
C1665 a_17892_14909# VSS 0.54013f
C1666 a_17830_14909# VSS 0.50346f
C1667 a_16955_14484# VSS 0.16646f
C1668 a_15338_14484# VSS 0.31827f
C1669 a_17412_14922# VSS 0.19118f
C1670 a_17057_14832# VSS 0.25488f
C1671 a_17318_14922# VSS 0.55406f
C1672 a_14344_14570# VSS 0.11656f ; **FLOATING
C1673 a_10016_14570# VSS 0.0411f ; **FLOATING
C1674 a_10618_14448# VSS 0.09765f
C1675 a_10222_14751# VSS 0.16058f
C1676 a_9536_14570# VSS 0.04987f ; **FLOATING
C1677 a_7833_14607# VSS 0.21642f
C1678 a_9658_14725# VSS 0.08137f
C1679 a_8779_14832# VSS 2.05795f
C1680 a_6729_14531# VSS 0.50345f
C1681 a_8050_14922# VSS 0.43618f
C1682 a_7537_14845# VSS 0.14418f
C1683 a_6660_14909# VSS 0.35245f
C1684 a_6598_14909# VSS 0.31578f
C1685 a_6180_14922# VSS 0.18831f
C1686 a_5707_14832# VSS 0.04721f
C1687 a_5504_14570# VSS 0.06581f ; **FLOATING
C1688 a_6086_14922# VSS 0.60611f
C1689 sg13cmos5l_dlygate4sd3_1_0.X VSS 0.04225f
C1690 a_3872_14570# VSS 0.06949f ; **FLOATING
C1691 a_2516_14484# VSS 0.22627f
C1692 a_2646_14842# VSS 0.0482f
C1693 a_2059_14832# VSS 0.62272f
C1694 a_1856_14570# VSS 0.06669f ; **FLOATING
C1695 a_1965_14832# VSS 0.07071f
C1696 a_38720_15366# VSS 0.08766f ; **FLOATING
C1697 a_27502_15423# VSS 0.16892f
C1698 a_24310_15230# VSS 1.57381f
C1699 a_24062_15242# VSS 0.06305f
C1700 a_23858_15242# VSS 0.01275f
C1701 a_23480_15242# VSS 0.09203f
C1702 a_23378_15242# VSS 0.04678f
C1703 a_25094_15238# VSS 0.18921f
C1704 sg13cmos5l_o21ai_1_2.Y VSS 0.11754f
C1705 a_24408_15552# VSS 0.41208f
C1706 a_23168_15366# VSS 0.05136f ; **FLOATING
C1707 a_21824_15366# VSS 0.04409f ; **FLOATING
C1708 a_20705_15260# VSS 0.09764f
C1709 a_20603_15532# VSS 0.32519f
C1710 a_20000_15366# VSS 0.03804f ; **FLOATING
C1711 a_19816_15366# VSS 0.08226f ; **FLOATING
C1712 a_21070_15423# VSS 0.03026f
C1713 sg13cmos5l_dlygate4sd3_1_9.X VSS 0.09206f
C1714 a_18665_15180# VSS 0.05051f
C1715 a_16175_15238# VSS 0.37281f
C1716 a_17238_15302# VSS 0.19906f
C1717 sg13cmos5l_a21oi_1_0.Y VSS 0.0238f
C1718 a_15870_15486# VSS 0.0567f
C1719 a_11752_15366# VSS 0.08325f ; **FLOATING
C1720 a_10609_15311# VSS 0.14761f
C1721 a_9670_15247# VSS 0.07864f
C1722 a_9732_15247# VSS 0.1153f
C1723 a_10905_15549# VSS 0.09938f
C1724 a_9252_15234# VSS 0.20127f
C1725 a_7829_15238# VSS 0.09487f
C1726 a_9801_15625# VSS 0.50347f
C1727 a_9158_15234# VSS 1.45711f
C1728 a_9418_15457# VSS 0.0195f
C1729 a_8582_15238# VSS 0.3273f
C1730 a_7058_15242# VSS 0.49023f
C1731 a_6578_15242# VSS 0.56482f
C1732 a_7923_15532# VSS 0.30095f
C1733 sg13cmos5l_nand4_1_0.Y VSS 0.03957f
C1734 a_5600_15366# VSS 0.04738f ; **FLOATING
C1735 a_5886_15486# VSS 0.0851f
C1736 a_4081_15311# VSS 0.14662f
C1737 a_3142_15247# VSS 0.97322f
C1738 a_3204_15247# VSS 0.72225f
C1739 a_3273_15625# VSS 0.02173f
C1740 a_2630_15234# VSS 0.4784f
C1741 sg13cmos5l_and2_1_0.X VSS 0.09449f
C1742 a_2528_15366# VSS 0.06282f ; **FLOATING
C1743 a_2890_15457# VSS 0.09289f
C1744 a_37192_16082# VSS 0.09909f ; **FLOATING
C1745 a_37484_15960# VSS 0.01239f
C1746 a_32200_16082# VSS 0.09676f ; **FLOATING
C1747 a_27296_16082# VSS 0.05227f ; **FLOATING
C1748 a_24923_15996# VSS 0.22259f
C1749 a_26170_16237# VSS 0.08239f
C1750 a_25025_16344# VSS 0.25926f
C1751 sg13cmos5l_dlygate4sd3_1_17.A VSS 0.15997f
C1752 a_26633_16334# VSS 0.07084f
C1753 a_25786_15960# VSS 0.41618f
C1754 a_25390_16263# VSS 0.06506f
C1755 a_22304_16082# VSS 0.04037f ; **FLOATING
C1756 a_21946_16237# VSS 0.05753f
C1757 a_20960_16082# VSS 0.06776f ; **FLOATING
C1758 a_17165_16020# VSS 0.1776f
C1759 sg13cmos5l_dfrbpq_1_6.D VSS 0.18416f
C1760 a_22025_16334# VSS 0.04998f
C1761 a_18454_16374# VSS 0.15119f
C1762 a_16969_16020# VSS 0.10779f
C1763 sg13cmos5l_inv_1_0.Y VSS 0.2253f
C1764 a_12232_16082# VSS 0.09383f ; **FLOATING
C1765 sg13cmos5l_dlygate4sd3_1_1.A VSS 0.09828f
C1766 a_7240_16082# VSS 0.09487f ; **FLOATING
C1767 a_3008_16082# VSS 0.03902f ; **FLOATING
C1768 a_2824_16082# VSS 0.07953f ; **FLOATING
C1769 a_3130_16237# VSS 0.09764f
C1770 a_2248_16082# VSS 0.10237f ; **FLOATING
C1771 VSS.t15 VSS 1.45961f
C1772 VSS.t30 VSS 0.20008f
C1773 VSS.t18 VSS 0.09764f
C1774 VSS.t2930 VSS 0.01995f
C1775 VSS.t2945 VSS 0.17545f
C1776 VSS.t2950 VSS 0.06052f
C1777 VSS.t2965 VSS 0.09964f
C1778 VSS.t2985 VSS 0.04589f
C1779 VSS.t2680 VSS 0.05735f
C1780 VSS.t2679 VSS 0.05735f
C1781 VSS.t136 VSS 0.50171f
C1782 VSS.t265 VSS 0.08544f
C1783 VSS.t11 VSS 0.64105f
C1784 VSS.t38 VSS 0.02525f
C1785 VSS.t6 VSS 0.30151f
C1786 VSS.t73 VSS 0.06244f
C1787 VSS.t124 VSS 0.55463f
C1788 VSS.t4 VSS 0.48365f
C1789 VSS.t187 VSS 0.37156f
C1790 VSS.t570 VSS 0.04725f
C1791 VSS.t557 VSS 0.01802f
C1792 VSS.t560 VSS 0.01924f
C1793 VSS.t555 VSS 0.01802f
C1794 VSS.t550 VSS 0.03919f
C1795 VSS.t545 VSS 0.03373f
C1796 VSS.t537 VSS 0.17154f
C1797 VSS.t540 VSS 0.06046f
C1798 VSS.t142 VSS 0.08634f
C1799 VSS.t534 VSS 0.0238f
C1800 VSS.t535 VSS 0.19534f
C1801 VSS.t170 VSS 0.52453f
C1802 VSS.t528 VSS 0.01177f
C1803 VSS.t518 VSS 0.10502f
C1804 VSS.t580 VSS 0.22302f
C1805 VSS.t584 VSS 0.26578f
C1806 VSS.t691 VSS 0.26578f
C1807 VSS.t79 VSS 0.20049f
C1808 VSS.t81 VSS 0.3123f
C1809 VSS.t587 VSS 0.15031f
C1810 VSS.t715 VSS 0.03782f
C1811 VSS.t591 VSS 0.02505f
C1812 VSS.t172 VSS 0.03834f
C1813 VSS.t593 VSS 0.02505f
C1814 VSS.t157 VSS 0.78513f
C1815 VSS.t729 VSS 0.0722f
C1816 VSS.t736 VSS 0.32579f
C1817 VSS.t735 VSS 0.32579f
C1818 VSS.t740 VSS 0.64302f
C1819 VSS.t1016 VSS 0.10671f
C1820 VSS.t1003 VSS 0.01276f
C1821 VSS.t1006 VSS 0.09974f
C1822 VSS.t1001 VSS 0.01276f
C1823 VSS.t995 VSS 0.11646f
C1824 VSS.t996 VSS 0.11646f
C1825 VSS.t986 VSS 0.06261f
C1826 VSS.t973 VSS 0.13302f
C1827 VSS.t971 VSS 0.13302f
C1828 VSS.t966 VSS 0.03542f
C1829 VSS.t960 VSS 0.04799f
C1830 VSS.t961 VSS 0.04799f
C1831 VSS.t956 VSS 0.05104f
C1832 VSS.t951 VSS 0.30723f
C1833 VSS.t945 VSS 0.0647f
C1834 VSS.t946 VSS 0.20536f
C1835 VSS.t926 VSS 0.21343f
C1836 VSS.t901 VSS 0.01475f
C1837 VSS.t895 VSS 0.03536f
C1838 VSS.t896 VSS 0.03536f
C1839 VSS.t881 VSS 0.18356f
C1840 VSS.t870 VSS 0.14291f
C1841 VSS.t871 VSS 0.23889f
C1842 VSS.t861 VSS 0.29837p
C1843 VSS.t851 VSS 0.0696f
C1844 VSS.t845 VSS 0.05691f
C1845 VSS.t846 VSS 0.26304f
C1846 VSS.t823 VSS 0.0658f
C1847 VSS.t821 VSS 0.0658f
C1848 VSS.t801 VSS 0.06676f
C1849 VSS.t795 VSS 0.17453f
C1850 VSS.t796 VSS 0.33818f
C1851 VSS.t1180 VSS 0.1862f
C1852 VSS.t1186 VSS 0.25677f
C1853 VSS.t1188 VSS 0.86786f
C1854 VSS.t1203 VSS 0.0736f
C1855 VSS.t1356 VSS 0.04579f
C1856 VSS.t1205 VSS 0.18317f
C1857 VSS.t1206 VSS 0.18317f
C1858 VSS.t1209 VSS 0.0786f
C1859 VSS.t1208 VSS 0.04651f
C1860 VSS.t1210 VSS 0.0321f
C1861 VSS.t1545 VSS 0.02111f
C1862 VSS.t1540 VSS 0.79077f
C1863 VSS.t1520 VSS 0.08773f
C1864 VSS.t1510 VSS 0.20053f
C1865 VSS.t1500 VSS 0.28211f
C1866 VSS.t1495 VSS 0.07204f
C1867 VSS.t1490 VSS 0.02567f
C1868 VSS.t1485 VSS 0.08206f
C1869 VSS.t1480 VSS 0.28211f
C1870 VSS.t1475 VSS 0.26268f
C1871 VSS.t1470 VSS 0.63743f
C1872 VSS.t1560 VSS 0.11959f
C1873 VSS.t1574 VSS 0.19097f
C1874 VSS.t1575 VSS 0.86215f
C1875 VSS.t1580 VSS 0.02994f
C1876 VSS.t1590 VSS 0.03848f
C1877 VSS.t1595 VSS 0.11899f
C1878 VSS.t1610 VSS 0.50367f
C1879 VSS.t1614 VSS 0.08801f
C1880 VSS.t1615 VSS 0.08801f
C1881 VSS.t353 VSS 0.05949f
C1882 VSS.t24 VSS 0.15287f
C1883 VSS.t273 VSS 0.04333f
C1884 VSS.t381 VSS 0.05798f
C1885 VSS.t378 VSS 0.05798f
C1886 VSS.t358 VSS 0.02098f
C1887 VSS.t222 VSS 0.53349f
C1888 VSS.t335 VSS 0.08338f
C1889 VSS.t128 VSS 0.62967f
C1890 VSS.t67 VSS 0.21698f
C1891 VSS.t60 VSS 0.04148f
C1892 VSS.t409 VSS 0.04148f
C1893 VSS.t27 VSS 0.07668f
C1894 VSS.t3212 VSS 0.21743f
C1895 VSS.t22 VSS 0.20865f
C1896 VSS.t204 VSS 0.44774f
C1897 VSS.t43 VSS 0.4511f
C1898 VSS.t64 VSS 0.83323f
C1899 VSS.t3275 VSS 0.03386f
C1900 VSS.t3195 VSS 0.4583f
C1901 VSS.t174 VSS 1.46641f
C1902 VSS.t66 VSS 0.12232f
C1903 VSS.t41 VSS 1.08206f
C1904 VSS.t28 VSS 0.76825f
C1905 VSS.t417 VSS 0.04604f
C1906 VSS.t416 VSS 0.04604f
C1907 VSS.t429 VSS 0.20178f
C1908 VSS.t432 VSS 0.10749f
C1909 VSS.t431 VSS 0.10749f
C1910 VSS.t435 VSS 0.38334f
C1911 VSS.t444 VSS 0.14106f
C1912 VSS.t443 VSS 0.14106f
C1913 VSS.t447 VSS 0.05338f
C1914 VSS.t57 VSS 0.18968f
C1915 VSS.t1281 VSS 0.04169f
C1916 VSS.t1279 VSS 0.06847f
C1917 VSS.t1284 VSS 0.02133f
C1918 VSS.t1416 VSS 0.04951f
C1919 VSS.t1282 VSS 0.04169f
C1920 VSS.t1285 VSS 0.07083f
C1921 VSS.t1288 VSS 0.08443f
C1922 VSS.t1427 VSS 0.0159f
C1923 VSS.t1300 VSS 0.0159f
C1924 VSS.t1312 VSS 0.11248f
C1925 VSS.t1311 VSS 0.02581f
C1926 VSS.t1321 VSS 0.03044f
C1927 VSS.t1322 VSS 0.03044f
C1928 VSS.t1323 VSS 0.10974f
C1929 VSS.t1324 VSS 0.10974f
C1930 VSS.t1326 VSS 0.16935f
C1931 VSS.t1451 VSS 0.28826f
C1932 VSS.t1310 VSS 0.08667f
C1933 VSS.t1309 VSS 0.22199f
C1934 VSS.t1255 VSS 0.04215f
C1935 VSS.t1251 VSS 0.16113f
C1936 VSS.t1250 VSS 0.16113f
C1937 VSS.t1237 VSS 0.09962f
C1938 VSS.t1226 VSS 0.11638f
C1939 VSS.t1225 VSS 0.11638f
C1940 VSS.t2012 VSS 0.59675p
C1941 VSS.t2017 VSS 0.93458f
C1942 VSS.t2016 VSS 0.93458f
C1943 VSS.t2021 VSS 0.02101f
C1944 VSS.t2022 VSS 0.069f
C1945 VSS.t2027 VSS 0.12567f
C1946 VSS.t2024 VSS 0.04799f
C1947 VSS.t2037 VSS 0.43393f
C1948 VSS.t2077 VSS 0.08623f
C1949 VSS.t2081 VSS 0.04311f
C1950 VSS.t2082 VSS 0.04311f
C1951 VSS.t2092 VSS 0.28197f
C1952 VSS.t2107 VSS 0.02669f
C1953 VSS.t2106 VSS 0.02669f
C1954 VSS.t2122 VSS 0.02111f
C1955 VSS.t2124 VSS 0.02111f
C1956 VSS.t1695 VSS 0.26241f
C1957 VSS.t1685 VSS 0.21696f
C1958 VSS.t1680 VSS 0.19277f
C1959 VSS.t1674 VSS 0.08182f
C1960 VSS.t1675 VSS 0.22455f
C1961 VSS.t1670 VSS 0.07033f
C1962 VSS.t1665 VSS 0.11685f
C1963 VSS.t1655 VSS 0.05899f
C1964 VSS.t1645 VSS 0.27388f
C1965 VSS.t1637 VSS 0.02568f
C1966 VSS.t1635 VSS 0.1554f
C1967 VSS.t1630 VSS 0.01971f
C1968 VSS.t1690 VSS 0.25691f
C1969 VSS.t1700 VSS 0.07668f
C1970 VSS.t1710 VSS 0.08438f
C1971 VSS.t1715 VSS 0.19179f
C1972 VSS.t1725 VSS 0.05162f
C1973 VSS.t1730 VSS 0.02975f
C1974 VSS.t1729 VSS 0.02975f
C1975 VSS.t2892 VSS 0.04951f
C1976 VSS.t2776 VSS 0.04951f
C1977 VSS.t2789 VSS 0.06319f
C1978 VSS.t2767 VSS 0.0598f
C1979 VSS.t2766 VSS 0.0598f
C1980 VSS.t2758 VSS 0.01055f
C1981 VSS.t2757 VSS 0.01055f
C1982 VSS.t2751 VSS 0.21563f
C1983 VSS.t2745 VSS 0.10259f
C1984 VSS.t2733 VSS 0.01657f
C1985 VSS.t2727 VSS 0.11233f
C1986 VSS.t3042 VSS 0.144f
C1987 VSS.t3037 VSS 0.03516f
C1988 VSS.t3040 VSS 0.144f
C1989 VSS.t3035 VSS 0.03516f
C1990 VSS.t3020 VSS 0.14658f
C1991 VSS.t3015 VSS 0.0317f
C1992 VSS.t3009 VSS 0.03026f
C1993 VSS.t3010 VSS 0.04523f
C1994 VSS.t2999 VSS 0.14918p
C1995 VSS.t3000 VSS 0.14918p
C1996 VSS.t3065 VSS 0.17977f
C1997 VSS.t3160 VSS 0.14412f
C1998 VSS.t2719 VSS 0.38479f
C1999 VSS.t2717 VSS 0.38479f
C2000 VSS.t2713 VSS 0.46886f
C2001 VSS.t2710 VSS 0.16135f
C2002 VSS.t2704 VSS 0.09598f
C2003 VSS.t2698 VSS 0.08782f
C2004 VSS.t2697 VSS 0.08782f
C2005 VSS.t2692 VSS 0.02266f
C2006 VSS.t2479 VSS 0.05336f
C2007 VSS.t2463 VSS 0.44886f
C2008 VSS.t2464 VSS 0.48348f
C2009 VSS.t2454 VSS 0.1936f
C2010 VSS.t2446 VSS 0.05073f
C2011 VSS.t2444 VSS 0.05073f
C2012 VSS.t2439 VSS 0.06925f
C2013 VSS.t2433 VSS 0.03205f
C2014 VSS.t2434 VSS 0.03205f
C2015 VSS.t2429 VSS 0.07206f
C2016 VSS.t2424 VSS 0.05992f
C2017 VSS.t2419 VSS 0.06771f
C2018 VSS.t2394 VSS 0.36388f
C2019 VSS.t2379 VSS 0.50347f
C2020 VSS.t2374 VSS 0.20184f
C2021 VSS.t2359 VSS 0.25173f
C2022 VSS.t2353 VSS 1.63396f
C2023 VSS.t2354 VSS 1.63396f
C2024 VSS.t2346 VSS 0.02552f
C2025 VSS.t2349 VSS 0.12129f
C2026 VSS.t2344 VSS 0.51192f
C2027 VSS.t2339 VSS 0.26967f
C2028 VSS.t2334 VSS 0.49836f
C2029 VSS.t2324 VSS 0.16676f
C2030 VSS.t2318 VSS 0.08269f
C2031 VSS.t2319 VSS 0.08269f
C2032 VSS.t2314 VSS 0.14609f
C2033 VSS.t2308 VSS 0.22939f
C2034 VSS.t2309 VSS 0.26542f
C2035 VSS.t2296 VSS 0.08667f
C2036 VSS.t2298 VSS 0.14106f
C2037 VSS.t2299 VSS 0.14106f
C2038 VSS.t2294 VSS 0.08667f
C2039 VSS.t2286 VSS 0.17661f
C2040 VSS.t2284 VSS 0.57558f
C2041 VSS.t2279 VSS 0.93251f
C2042 VSS.t2271 VSS 0.50347f
C2043 VSS.t2274 VSS 0.11469f
C2044 VSS.t2269 VSS 0.50347f
C2045 VSS.t2264 VSS 0.23443f
C2046 VSS.t1847 VSS 0.04202f
C2047 VSS.t1867 VSS 0.32028f
C2048 VSS.t1872 VSS 0.10324f
C2049 VSS.t1876 VSS 0.17341f
C2050 VSS.t1877 VSS 0.17341f
C2051 VSS.t1886 VSS 0.01585f
C2052 VSS.t1887 VSS 0.01585f
C2053 VSS.t1892 VSS 0.03386f
C2054 VSS.t1891 VSS 0.03386f
C2055 VSS.t1907 VSS 1.52005f
C2056 VSS.t1909 VSS 1.52005f
C2057 VSS.t1917 VSS 0.14098f
C2058 VSS.t1922 VSS 0.06261f
C2059 VSS.t1919 VSS 0.14098f
C2060 VSS.t1927 VSS 0.1061f
C2061 VSS.t1929 VSS 0.1061f
C2062 VSS.t1936 VSS 0.13296f
C2063 VSS.t1937 VSS 0.13296f
C2064 VSS.t1942 VSS 0.07552f
C2065 VSS.t1952 VSS 0.0888f
C2066 VSS.t1957 VSS 0.04195f
C2067 VSS.t1967 VSS 0.07838f
C2068 VSS.t1976 VSS 0.01001f
C2069 VSS.t1977 VSS 0.01001f
C2070 VSS.t1982 VSS 0.03942f
C2071 VSS.t1992 VSS 0.01771f
C2072 VSS.t1997 VSS 0.12504f
C2073 VSS.t2007 VSS 0.12093f
C2074 VSS.t1944 VSS 0.07552f
C2075 VSS.t1924 VSS 0.06261f
C2076 VSS.t2244 VSS 0.02295f
C2077 VSS.t2238 VSS 0.09005f
C2078 VSS.t2239 VSS 0.09005f
C2079 VSS.t2474 VSS 0.19927f
C2080 VSS.t2484 VSS 0.10848f
C2081 VSS.t2481 VSS 0.05336f
C2082 VSS.t2483 VSS 0.10848f
C2083 VSS.t2494 VSS 0.07787f
C2084 VSS.t2493 VSS 0.07787f
C2085 VSS.t2499 VSS 0.27378f
C2086 VSS.t2508 VSS 0.04219f
C2087 VSS.t2509 VSS 0.05959f
C2088 VSS.t2514 VSS 0.04172f
C2089 VSS.t2511 VSS 0.0174f
C2090 VSS.t2087 VSS 0.08526f
C2091 VSS.t1612 VSS 0.35526f
C2092 VSS.t1178 VSS 0.06283f
C2093 VSS.t791 VSS 0.11609f
C2094 VSS.t866 VSS 0.32477f
C2095 VSS.t1008 VSS 0.09974f
C2096 VSS.t1011 VSS 0.09639f
C2097 VSS.t1021 VSS 0.04005f
C2098 VSS.t1025 VSS 0.04501f
C2099 VSS.t1026 VSS 0.04501f
C2100 VSS.t1036 VSS 0.23946f
C2101 VSS.t1046 VSS 0.2162f
C2102 VSS.t1051 VSS 0.18907f
C2103 VSS.t633 VSS 0.20188f
C2104 VSS.t636 VSS 0.32185f
C2105 VSS.t639 VSS 0.0238f
C2106 VSS.t642 VSS 0.0238f
C2107 VSS.t2632 VSS 0.02098f
C2108 VSS.t2635 VSS 0.0238f
C2109 VSS.t2643 VSS 0.01239f
C2110 VSS.t2657 VSS 0.04333f
C2111 VSS.t2658 VSS 0.04333f
C2112 VSS.t2664 VSS 0.06747f
C2113 VSS.t2670 VSS 0.29777f
C2114 VSS.t2671 VSS 0.29777f
C2115 VSS.t2665 VSS 0.34772f
.ends
