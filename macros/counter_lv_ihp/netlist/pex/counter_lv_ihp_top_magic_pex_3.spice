* PEX produced on Sat Nov  7 03:30:57 PM CET 2026 using /foss/tools/sak/sak-pex.sh with m=3 and s=1 (extresist threshold=10000 mOhm, minres=1000 mOhm, mindelay=1 ps)
* NGSPICE file created from counter_lv_ihp_top_pex.ext - technology: ihp-sg13cmos5l

.subckt counter_lv_ihp_top_pex VDD VSS clock_i reset_n_i enable_i
+ counter_value_o[0] counter_value_o[1] counter_value_o[2] counter_value_o[3]
+ counter_value_o[4] counter_value_o[5] counter_value_o[6] counter_value_o[7]
X0 VSS.t328 VDD VSS.t327 VSS.t326 sg13_lv_nmos ad=0.1428p pd=1.52u as=0 ps=0 w=0.42u l=1u
X1 VDD VSS.t884 VDD VDD sg13_lv_pmos ad=0.19p pd=1.38u as=3.17039n ps=0.01237 w=1u l=1u
X2 VDD enable_i a_1192_3900# VDD sg13_lv_pmos ad=0.2114p pd=1.54u as=0.2856p ps=2.36u w=0.84u l=0.13u
X3 VDD VSS.t2623 VDD VDD sg13_lv_pmos ad=0.19p pd=1.38u as=0 ps=0 w=1u l=1u
X4 VDD a_15790_15238# sg13cmos5l_buf_16_2.A VDD sg13_lv_pmos ad=0.2128p pd=1.5u as=0.2128p ps=1.5u w=1.12u l=0.13u
X5 VSS.t577 VDD VSS.t579 VSS.t578 sg13_lv_nmos ad=79.8f pd=0.8u as=0 ps=0 w=0.42u l=1u
X6 VDD VSS.t1715 VDD VDD sg13_lv_pmos ad=0.34p pd=2.68u as=0 ps=0 w=1u l=1u
X7 VSS.t2003 VDD VSS.t2005 VSS.t2004 sg13_lv_nmos ad=79.8f pd=0.8u as=0 ps=0 w=0.42u l=1u
X8 VDD VSS.t201 VDD VDD sg13_lv_pmos ad=0.34p pd=2.68u as=0 ps=0 w=1u l=1u
X9 VSS.t1566 VDD VSS.t1568 VSS.t1567 sg13_lv_nmos ad=79.8f pd=0.8u as=0 ps=0 w=0.42u l=1u
X10 VSS.t3097 VDD VSS.t3099 VSS.t3098 sg13_lv_nmos ad=79.8f pd=0.8u as=0 ps=0 w=0.42u l=1u
X11 VSS.t555 VDD VSS.t555 VSS.t669 sg13_lv_nmos ad=0.1428p pd=1.52u as=0 ps=0 w=0.42u l=1u
X12 VDD VSS.t1168 VDD VDD sg13_lv_pmos ad=0.34p pd=2.68u as=0 ps=0 w=1u l=1u
X13 VSS.t1958 VDD VSS.t1957 VSS.t1956 sg13_lv_nmos ad=0.1428p pd=1.52u as=0 ps=0 w=0.42u l=1u
X14 VDD VSS.t821 VDD VDD sg13_lv_pmos ad=0.34p pd=2.68u as=0 ps=0 w=1u l=1u
X15 VSS.t2633 VDD VSS.t2634 VSS.t2620 sg13_lv_nmos ad=79.8f pd=0.8u as=0 ps=0 w=0.42u l=1u
X16 VSS.t77 sg13cmos5l_dlygate4sd3_1_5.A a_6296_15238# VSS.t3274 sg13_lv_nmos ad=79.8f pd=0.8u as=0.1428p ps=1.52u w=0.42u l=0.13u
X17 VDD a_22330_15202# a_22049_15424# VDD sg13_lv_pmos ad=0.1523p pd=1.38u as=0.34p ps=2.68u w=1u l=0.5u
X18 VSS.t1310 VDD VSS.t1309 VSS.t224 sg13_lv_nmos ad=0.1428p pd=1.52u as=0 ps=0 w=0.42u l=1u
X19 VDD VSS.t2404 VDD VDD sg13_lv_pmos ad=0.34p pd=2.68u as=0 ps=0 w=1u l=1u
X20 VDD VSS.t2062 VDD VDD sg13_lv_pmos ad=0.34p pd=2.68u as=0 ps=0 w=1u l=1u
X21 sg13cmos5l_buf_16_2.A a_15790_15238# VSS.t21 VSS.t24 sg13_lv_nmos ad=0.1406p pd=1.12u as=0.1406p ps=1.12u w=0.74u l=0.13u
X22 VDD VSS.t1837 VDD VDD sg13_lv_pmos ad=0.34p pd=2.68u as=0 ps=0 w=1u l=1u
X23 VDD VSS.t2634 VDD VDD sg13_lv_pmos ad=0.34p pd=2.68u as=0 ps=0 w=1u l=1u
X24 a_25402_14448# sg13cmos5l_o21ai_1_2.Y VDD VDD sg13_lv_pmos ad=0.1428p pd=1.52u as=0.1523p ps=1.38u w=0.42u l=0.13u
X25 VSS.t942 VDD VSS.t941 VSS.t940 sg13_lv_nmos ad=0.1428p pd=1.52u as=0 ps=0 w=0.42u l=1u
X26 a_3626_14484# sg13cmos5l_inv_1_0.Y VDD VDD sg13_lv_pmos ad=0.1176p pd=1.33u as=0.4032p ps=2.96u w=1.12u l=0.13u
X27 VSS.t987 VDD VSS.t986 VSS.t985 sg13_lv_nmos ad=0.1428p pd=1.52u as=0 ps=0 w=0.42u l=1u
X28 VDD VSS.t1177 VDD VDD sg13_lv_pmos ad=0.34p pd=2.68u as=0 ps=0 w=1u l=1u
X29 a_27500_15960# sg13cmos5l_dfrbpq_1_6.Q VSS.t12 VSS.t11 sg13_lv_nmos ad=0.187p pd=1.78u as=0.14875p ps=1.16u w=0.55u l=0.13u
X30 VDD a_18767_14845# a_19024_14726# VDD sg13_lv_pmos ad=2.42015p pd=15.68u as=79.8f ps=0.8u w=0.42u l=0.13u
X31 VDD VSS.t1039 VDD VDD sg13_lv_pmos ad=0.19p pd=1.38u as=0 ps=0 w=1u l=1u
X32 VDD VSS.t1287 VDD VDD sg13_lv_pmos ad=0.19p pd=1.38u as=0 ps=0 w=1u l=1u
X33 VDD VSS.t851 VDD VDD sg13_lv_pmos ad=0.34p pd=2.68u as=0 ps=0 w=1u l=1u
X34 VSS.t2687 VDD VSS.t2686 VSS.t2620 sg13_lv_nmos ad=0.1428p pd=1.52u as=0 ps=0 w=0.42u l=1u
X35 sg13cmos5l_or3_1_2.B a_14549_15238# VDD VDD sg13_lv_pmos ad=0.2128p pd=1.5u as=0.2128p ps=1.5u w=1.12u l=0.13u
X36 VSS.t2490 VDD VSS.t2492 VSS.t2491 sg13_lv_nmos ad=79.8f pd=0.8u as=0 ps=0 w=0.42u l=1u
X37 VDD VSS.t1558 VDD VDD sg13_lv_pmos ad=0.19p pd=1.38u as=0 ps=0 w=1u l=1u
X38 VDD VSS.t3031 VDD VDD sg13_lv_pmos ad=0.34p pd=2.68u as=0 ps=0 w=1u l=1u
X39 VSS.t2763 VDD VSS.t2762 VSS.t2620 sg13_lv_nmos ad=0.1428p pd=1.52u as=0 ps=0 w=0.42u l=1u
X40 VDD VSS.t1892 VDD VDD sg13_lv_pmos ad=0.34p pd=2.68u as=0 ps=0 w=1u l=1u
X41 VDD clock_i a_15790_15238# VDD sg13_lv_pmos ad=0.2128p pd=1.5u as=0.2128p ps=1.5u w=1.12u l=0.13u
X42 VDD sg13cmos5l_dlygate4sd3_1_13.X a_20507_15532# VDD sg13_lv_pmos ad=0.2128p pd=1.5u as=0.2128p ps=1.5u w=1.12u l=0.13u
X43 VSS.t907 VDD VSS.t909 VSS.t908 sg13_lv_nmos ad=79.8f pd=0.8u as=0 ps=0 w=0.42u l=1u
X44 VSS.t1988 VDD VSS.t1990 VSS.t1989 sg13_lv_nmos ad=79.8f pd=0.8u as=0 ps=0 w=0.42u l=1u
X45 VDD VSS.t1563 VDD VDD sg13_lv_pmos ad=0.19p pd=1.38u as=0 ps=0 w=1u l=1u
X46 VSS.t1442 VDD VSS.t1322 VSS.t224 sg13_lv_nmos ad=0.1428p pd=1.52u as=0 ps=0 w=0.42u l=1u
X47 VSS.t2624 VDD VSS.t2625 VSS.t2620 sg13_lv_nmos ad=79.8f pd=0.8u as=0 ps=0 w=0.42u l=1u
X48 VDD VSS.t914 VDD VDD sg13_lv_pmos ad=0.19p pd=1.38u as=0 ps=0 w=1u l=1u
X49 VSS.t957 VDD VSS.t956 VSS.t955 sg13_lv_nmos ad=0.1428p pd=1.52u as=0 ps=0 w=0.42u l=1u
X50 VSS.t2360 VDD VSS.t2362 VSS.t2361 sg13_lv_nmos ad=79.8f pd=0.8u as=0 ps=0 w=0.42u l=1u
X51 VSS.t1908 VDD VSS.t1907 VSS.t1906 sg13_lv_nmos ad=0.1428p pd=1.52u as=0 ps=0 w=0.42u l=1u
X52 a_20280_14464# sg13cmos5l_o21ai_1_2.A1 VDD VDD sg13_lv_pmos ad=0.2128p pd=1.5u as=0.3808p ps=2.92u w=1.12u l=0.15u
X53 a_25006_14751# a_25121_14750# VDD VDD sg13_lv_pmos ad=0.34p pd=2.68u as=0.2254p ps=1.53u w=1u l=0.5u
X54 VDD VSS.t1905 VDD VDD sg13_lv_pmos ad=0.19p pd=1.38u as=0 ps=0 w=1u l=1u
X55 VSS.t450 VDD VSS.t450 VSS.t2 sg13_lv_nmos ad=79.8f pd=0.8u as=0 ps=0 w=0.42u l=1u
X56 VSS.t782 VDD VSS.t784 VSS.t783 sg13_lv_nmos ad=79.8f pd=0.8u as=0 ps=0 w=0.42u l=1u
X57 VDD VSS.t841 VDD VDD sg13_lv_pmos ad=0.34p pd=2.68u as=0 ps=0 w=1u l=1u
X58 VDD VSS.t2030 VDD VDD sg13_lv_pmos ad=0.19p pd=1.38u as=0 ps=0 w=1u l=1u
X59 a_27310_15423# a_27425_15424# VSS.t1 VSS.t2 sg13_lv_nmos ad=0.1428p pd=1.52u as=0.1426p ps=1.16u w=0.42u l=0.5u
X60 VSS.t1451 VDD VSS.t1450 VSS.t1449 sg13_lv_nmos ad=0.1428p pd=1.52u as=0 ps=0 w=0.42u l=1u
X61 VDD VSS.t350 VDD VDD sg13_lv_pmos ad=0.19p pd=1.38u as=0 ps=0 w=1u l=1u
X62 VDD VSS.t1267 VDD VDD sg13_lv_pmos ad=0.34p pd=2.68u as=0 ps=0 w=1u l=1u
X63 VDD VSS.t3146 VDD VDD sg13_lv_pmos ad=0.34p pd=2.68u as=0 ps=0 w=1u l=1u
X64 VSS.t2640 VDD VSS.t2640 VSS.t2620 sg13_lv_nmos ad=0.1428p pd=1.52u as=0 ps=0 w=0.42u l=1u
X65 VSS.t1017 VDD VSS.t1019 VSS.t1018 sg13_lv_nmos ad=79.8f pd=0.8u as=0 ps=0 w=0.42u l=1u
X66 VSS.t2705 VDD VSS.t2706 VSS.t2620 sg13_lv_nmos ad=79.8f pd=0.8u as=0 ps=0 w=0.42u l=1u
X67 a_10020_15247# a_9732_15552# a_9958_15247# VSS.t64 sg13_lv_nmos ad=0.1428p pd=1.52u as=37.8f ps=0.6u w=0.42u l=0.13u
X68 VDD VSS.t1713 VDD VDD sg13_lv_pmos ad=0.19p pd=1.38u as=0 ps=0 w=1u l=1u
X69 a_4624_15454# sg13cmos5l_dfrbpq_1_0.RESET_B VDD VDD sg13_lv_pmos ad=79.8f pd=0.8u as=2.8961p ps=18.25u w=0.42u l=0.13u
X70 VSS.t877 VDD VSS.t876 VSS.t875 sg13_lv_nmos ad=0.1428p pd=1.52u as=0 ps=0 w=0.42u l=1u
X71 VDD VSS.t1543 VDD VDD sg13_lv_pmos ad=0.19p pd=1.38u as=0 ps=0 w=1u l=1u
X72 VSS.t412 VDD VSS.t411 VSS.t410 sg13_lv_nmos ad=0.1428p pd=1.52u as=0 ps=0 w=0.42u l=1u
X73 a_12212_15202# sg13cmos5l_buf_16_2.A VDD VDD sg13_lv_pmos ad=0.2128p pd=1.5u as=0.2128p ps=1.5u w=1.12u l=0.13u
X74 VDD VSS.t201 VDD VDD sg13_lv_pmos ad=0.34p pd=2.68u as=0 ps=0 w=1u l=1u
X75 VSS.t1210 VDD VSS.t1211 VSS.t224 sg13_lv_nmos ad=79.8f pd=0.8u as=0 ps=0 w=0.42u l=1u
X76 VDD VSS.t1305 VDD VDD sg13_lv_pmos ad=0.19p pd=1.38u as=0 ps=0 w=1u l=1u
X77 VSS.t2653 VDD VSS.t2653 VSS.t2620 sg13_lv_nmos ad=0.1428p pd=1.52u as=0 ps=0 w=0.42u l=1u
X78 VDD VSS.t2457 VDD VDD sg13_lv_pmos ad=0.19p pd=1.38u as=0 ps=0 w=1u l=1u
X79 a_7358_12972# sg13cmos5l_xor2_1_1.B a_6906_12935# VDD sg13_lv_pmos ad=0.1225p pd=1.245u as=0.34p ps=2.68u w=1u l=0.13u
X80 VSS.t1943 VDD VSS.t1942 VSS.t1941 sg13_lv_nmos ad=0.1428p pd=1.52u as=0 ps=0 w=0.42u l=1u
X81 VSS.t3037 VDD VSS.t3036 VSS.t3035 sg13_lv_nmos ad=0.1428p pd=1.52u as=0 ps=0 w=0.42u l=1u
X82 VSS.t438 VDD VSS.t438 VSS.t2 sg13_lv_nmos ad=0.1428p pd=1.52u as=0 ps=0 w=0.42u l=1u
X83 VDD VSS.t2244 VDD VDD sg13_lv_pmos ad=0.34p pd=2.68u as=0 ps=0 w=1u l=1u
X84 a_25978_15202# sg13cmos5l_o21ai_1_3.Y VDD VDD sg13_lv_pmos ad=0.1428p pd=1.52u as=0.1523p ps=1.38u w=0.42u l=0.13u
X85 VDD VSS.t804 VDD VDD sg13_lv_pmos ad=0.19p pd=1.38u as=0 ps=0 w=1u l=1u
X86 VDD VSS.t1508 VDD VDD sg13_lv_pmos ad=0.19p pd=1.38u as=0 ps=0 w=1u l=1u
X87 VDD VSS.t2417 VDD VDD sg13_lv_pmos ad=0.19p pd=1.38u as=0 ps=0 w=1u l=1u
X88 VSS.t2475 VDD VSS.t2477 VSS.t2476 sg13_lv_nmos ad=79.8f pd=0.8u as=0 ps=0 w=0.42u l=1u
X89 sg13cmos5l_buf_16_2.A a_15790_15238# VDD VDD sg13_lv_pmos ad=0.2128p pd=1.5u as=0.2128p ps=1.5u w=1.12u l=0.13u
X90 VDD VSS.t535 VDD VDD sg13_lv_pmos ad=0.34p pd=2.68u as=0 ps=0 w=1u l=1u
X91 VSS.t987 VDD VSS.t986 VSS.t985 sg13_lv_nmos ad=0.1428p pd=1.52u as=0 ps=0 w=0.42u l=1u
X92 VSS.t1853 VDD VSS.t1852 VSS.t1851 sg13_lv_nmos ad=0.1428p pd=1.52u as=0 ps=0 w=0.42u l=1u
X93 VSS.t1641 VDD VSS.t1643 VSS.t1642 sg13_lv_nmos ad=79.8f pd=0.8u as=0 ps=0 w=0.42u l=1u
X94 VSS.t2023 VDD VSS.t2025 VSS.t2024 sg13_lv_nmos ad=79.8f pd=0.8u as=0 ps=0 w=0.42u l=1u
X95 a_22480_14726# sg13cmos5l_dfrbpq_1_6.RESET_B VDD VDD sg13_lv_pmos ad=79.8f pd=0.8u as=2.42015p ps=15.68u w=0.42u l=0.13u
X96 VSS.t1193 VDD VSS.t1194 VSS.t224 sg13_lv_nmos ad=79.8f pd=0.8u as=0 ps=0 w=0.42u l=1u
X97 VDD VSS.t1952 VDD VDD sg13_lv_pmos ad=0.34p pd=2.68u as=0 ps=0 w=1u l=1u
X98 VDD VSS.t1314 VDD VDD sg13_lv_pmos ad=0.19p pd=1.38u as=0 ps=0 w=1u l=1u
X99 VDD a_22223_14845# a_22890_14484# VDD sg13_lv_pmos ad=0.2128p pd=1.5u as=0.3864p ps=2.93u w=1.12u l=0.13u
X100 VSS.t2678 VDD VSS.t2676 VSS.t2620 sg13_lv_nmos ad=0.1428p pd=1.52u as=0 ps=0 w=0.42u l=1u
X101 VSS.t284 VDD VSS.t284 VSS.t360 sg13_lv_nmos ad=0.1428p pd=1.52u as=0 ps=0 w=0.42u l=1u
X102 VDD VSS.t641 VDD VDD sg13_lv_pmos ad=0.19p pd=1.38u as=0 ps=0 w=1u l=1u
X103 VSS.t907 VDD VSS.t909 VSS.t908 sg13_lv_nmos ad=79.8f pd=0.8u as=0 ps=0 w=0.42u l=1u
X104 VDD VSS.t896 VDD VDD sg13_lv_pmos ad=0.34p pd=2.68u as=0 ps=0 w=1u l=1u
X105 VDD a_25978_15202# a_25697_15424# VDD sg13_lv_pmos ad=0.1523p pd=1.38u as=0.34p ps=2.68u w=1u l=0.5u
X106 VSS.t641 VDD VSS.t641 VSS.t764 sg13_lv_nmos ad=0.1428p pd=1.52u as=0 ps=0 w=0.42u l=1u
X107 VDD VSS.t1720 VDD VDD sg13_lv_pmos ad=0.34p pd=2.68u as=0 ps=0 w=1u l=1u
X108 VSS.t1571 VDD VSS.t1573 VSS.t1572 sg13_lv_nmos ad=79.8f pd=0.8u as=0 ps=0 w=0.42u l=1u
X109 VSS.t3102 VDD VSS.t3104 VSS.t3103 sg13_lv_nmos ad=79.8f pd=0.8u as=0 ps=0 w=0.42u l=1u
X110 sg13cmos5l_dfrbpq_1_2.CLK a_12212_15202# VDD VDD sg13_lv_pmos ad=0.2128p pd=1.5u as=0.2128p ps=1.5u w=1.12u l=0.13u
X111 VDD VSS.t595 VDD VDD sg13_lv_pmos ad=0.34p pd=2.68u as=0 ps=0 w=1u l=1u
X112 VDD a_27503_13799# a_27760_13942# VDD sg13_lv_pmos ad=2.42015p pd=15.68u as=79.8f ps=0.8u w=0.42u l=0.13u
X113 VDD VSS.t1021 VDD VDD sg13_lv_pmos ad=0.34p pd=2.68u as=0 ps=0 w=1u l=1u
X114 VSS.t86 sg13cmos5l_nor2_1_3.B sg13cmos5l_dfrbpq_1_2.D VSS.t3180 sg13_lv_nmos ad=0.2516p pd=2.16u as=0.1406p ps=1.12u w=0.74u l=0.13u
X115 a_25223_14020# sg13cmos5l_o21ai_1_3.A2 a_25129_13726# VDD sg13_lv_pmos ad=0.19p pd=1.38u as=0.34p ps=2.68u w=1u l=0.13u
X116 a_6932_12972# a_6906_12935# sg13cmos5l_dlygate4sd3_1_1.A VDD sg13_lv_pmos ad=0.2128p pd=1.5u as=0.3808p ps=2.92u w=1.12u l=0.13u
X117 VSS.t2345 VDD VSS.t2347 VSS.t2346 sg13_lv_nmos ad=79.8f pd=0.8u as=0 ps=0 w=0.42u l=1u
X118 VDD VSS.t2409 VDD VDD sg13_lv_pmos ad=0.34p pd=2.68u as=0 ps=0 w=1u l=1u
X119 VSS.t782 VDD VSS.t784 VSS.t783 sg13_lv_nmos ad=79.8f pd=0.8u as=0 ps=0 w=0.42u l=1u
X120 VDD VSS.t771 VDD VDD sg13_lv_pmos ad=0.34p pd=2.68u as=0 ps=0 w=1u l=1u
X121 VDD VSS.t959 VDD VDD sg13_lv_pmos ad=0.19p pd=1.38u as=0 ps=0 w=1u l=1u
X122 VDD VSS.t2067 VDD VDD sg13_lv_pmos ad=0.34p pd=2.68u as=0 ps=0 w=1u l=1u
X123 VDD VSS.t395 VDD VDD sg13_lv_pmos ad=0.34p pd=2.68u as=0 ps=0 w=1u l=1u
X124 VDD VSS.t426 VDD VDD sg13_lv_pmos ad=0.34p pd=2.68u as=0 ps=0 w=1u l=1u
X125 VSS.t338 VDD VSS.t340 VSS.t339 sg13_lv_nmos ad=79.8f pd=0.8u as=0 ps=0 w=0.42u l=1u
X126 VSS.t469 VDD VSS.t471 VSS.t470 sg13_lv_nmos ad=79.8f pd=0.8u as=0 ps=0 w=0.42u l=1u
X127 VDD VSS.t1235 VDD VDD sg13_lv_pmos ad=0.19p pd=1.38u as=0 ps=0 w=1u l=1u
X128 VDD VSS.t2739 VDD VDD sg13_lv_pmos ad=0.19p pd=1.38u as=0 ps=0 w=1u l=1u
X129 VDD a_4367_15311# a_5034_15532# VDD sg13_lv_pmos ad=0.2128p pd=1.5u as=0.3864p ps=2.93u w=1.12u l=0.13u
X130 VSS.t2430 VDD VSS.t2429 VSS.t2428 sg13_lv_nmos ad=0.1428p pd=1.52u as=0 ps=0 w=0.42u l=1u
X131 VSS.t2043 VDD VSS.t2045 VSS.t2044 sg13_lv_nmos ad=79.8f pd=0.8u as=0 ps=0 w=0.42u l=1u
X132 VDD a_15287_15315# a_15287_15549# VDD sg13_lv_pmos ad=2.8961p pd=18.25u as=0.2442p ps=2.06u w=0.66u l=0.13u
X133 VSS.t543 VDD VSS.t543 VSS.t658 sg13_lv_nmos ad=0.1428p pd=1.52u as=0 ps=0 w=0.42u l=1u
X134 VDD VSS.t549 VDD VDD sg13_lv_pmos ad=0.19p pd=1.38u as=0 ps=0 w=1u l=1u
X135 VSS.t877 VDD VSS.t876 VSS.t875 sg13_lv_nmos ad=0.1428p pd=1.52u as=0 ps=0 w=0.42u l=1u
X136 VSS.t1171 VDD VSS.t1172 VSS.t224 sg13_lv_nmos ad=79.8f pd=0.8u as=0 ps=0 w=0.42u l=1u
X137 VDD VSS.t2110 VDD VDD sg13_lv_pmos ad=0.19p pd=1.38u as=0 ps=0 w=1u l=1u
X138 VSS.t2669 VDD VSS.t2668 VSS.t2620 sg13_lv_nmos ad=0.1428p pd=1.52u as=0 ps=0 w=0.42u l=1u
X139 VDD VSS.t387 VDD VDD sg13_lv_pmos ad=0.19p pd=1.38u as=0 ps=0 w=1u l=1u
X140 VSS.t922 VDD VSS.t921 VSS.t920 sg13_lv_nmos ad=0.1428p pd=1.52u as=0 ps=0 w=0.42u l=1u
X141 VSS.t2495 VDD VSS.t2497 VSS.t2496 sg13_lv_nmos ad=79.8f pd=0.8u as=0 ps=0 w=0.42u l=1u
X142 VDD VSS.t3001 VDD VDD sg13_lv_pmos ad=0.34p pd=2.68u as=0 ps=0 w=1u l=1u
X143 VDD VSS.t1897 VDD VDD sg13_lv_pmos ad=0.34p pd=2.68u as=0 ps=0 w=1u l=1u
X144 VDD VSS.t1528 VDD VDD sg13_lv_pmos ad=0.19p pd=1.38u as=0 ps=0 w=1u l=1u
X145 VDD VSS.t1705 VDD VDD sg13_lv_pmos ad=0.34p pd=2.68u as=0 ps=0 w=1u l=1u
X146 VSS.t1993 VDD VSS.t1995 VSS.t1994 sg13_lv_nmos ad=79.8f pd=0.8u as=0 ps=0 w=0.42u l=1u
X147 sg13cmos5l_dfrbpq_1_2.CLK a_12212_15202# VDD VDD sg13_lv_pmos ad=0.2128p pd=1.5u as=0.3976p ps=2.95u w=1.12u l=0.13u
X148 VDD VSS.t1568 VDD VDD sg13_lv_pmos ad=0.19p pd=1.38u as=0 ps=0 w=1u l=1u
X149 VSS.t2644 VDD VSS.t2644 VSS.t2620 sg13_lv_nmos ad=0.1428p pd=1.52u as=0 ps=0 w=0.42u l=1u
X150 VDD VSS.t1219 VDD VDD sg13_lv_pmos ad=0.34p pd=2.68u as=0 ps=0 w=1u l=1u
X151 VDD VSS.t2698 VDD VDD sg13_lv_pmos ad=0.19p pd=1.38u as=0 ps=0 w=1u l=1u
X152 VDD VSS.t926 VDD VDD sg13_lv_pmos ad=0.34p pd=2.68u as=0 ps=0 w=1u l=1u
X153 VDD VSS.t168 VDD VDD sg13_lv_pmos ad=0.34p pd=2.68u as=0 ps=0 w=1u l=1u
X154 VSS.t577 VDD VSS.t579 VSS.t578 sg13_lv_nmos ad=79.8f pd=0.8u as=0 ps=0 w=0.42u l=1u
X155 sg13cmos5l_dfrbpq_1_0.RESET_B a_3294_15934# VDD VDD sg13_lv_pmos ad=0.3927p pd=2.99u as=2.8961p ps=18.25u w=1.155u l=0.13u
X156 VSS.t18 sg13cmos5l_xnor2_1_1.A a_16596_14832# VSS.t217 sg13_lv_nmos ad=0.2272p pd=1.99u as=78.39999f ps=0.885u w=0.64u l=0.13u
X157 VSS.t1256 VDD VSS.t1257 VSS.t224 sg13_lv_nmos ad=79.8f pd=0.8u as=0 ps=0 w=0.42u l=1u
X158 VDD VSS.t2229 VDD VDD sg13_lv_pmos ad=0.34p pd=2.68u as=0 ps=0 w=1u l=1u
X159 VDD a_10318_14751# sg13cmos5l_dlygate4sd3_1_11.X VDD sg13_lv_pmos ad=0.2254p pd=1.53u as=0.4256p ps=3u w=1.12u l=0.13u
X160 VDD a_18767_14845# a_19434_14484# VDD sg13_lv_pmos ad=0.2128p pd=1.5u as=0.3864p ps=2.93u w=1.12u l=0.13u
X161 VSS.t2290 VDD VSS.t2292 VSS.t2291 sg13_lv_nmos ad=79.8f pd=0.8u as=0 ps=0 w=0.42u l=1u
X162 VSS.t1838 VDD VSS.t1837 VSS.t1836 sg13_lv_nmos ad=0.1428p pd=1.52u as=0 ps=0 w=0.42u l=1u
X163 a_16425_14113# a_16068_14040# VDD VDD sg13_lv_pmos ad=63f pd=0.72u as=0.1563p ps=1.22u w=0.42u l=0.13u
X164 VSS.t614 VDD VSS.t614 VSS.t613 sg13_lv_nmos ad=0.1428p pd=1.52u as=0 ps=0 w=0.42u l=1u
X165 VSS.t2643 VDD VSS.t2642 VSS.t2620 sg13_lv_nmos ad=0.1428p pd=1.52u as=0 ps=0 w=0.42u l=1u
X166 a_17222_14922# a_18027_14495# a_17482_14452# VDD sg13_lv_pmos ad=0.1428p pd=1.52u as=79.8f ps=0.8u w=0.42u l=0.13u
X167 VSS.t1261 VDD VSS.t1262 VSS.t224 sg13_lv_nmos ad=79.8f pd=0.8u as=0 ps=0 w=0.42u l=1u
X168 VSS.t2745 VDD VSS.t2746 VSS.t2620 sg13_lv_nmos ad=79.8f pd=0.8u as=0 ps=0 w=0.42u l=1u
X169 VDD a_17584_13942# a_17529_14037# VDD sg13_lv_pmos ad=2.42015p pd=15.68u as=93.45f ps=0.865u w=0.42u l=0.13u
X170 VSS.t1581 VDD VSS.t1580 VSS.t1579 sg13_lv_nmos ad=0.1428p pd=1.52u as=0 ps=0 w=0.42u l=1u
X171 VDD VSS.t3069 VDD VDD sg13_lv_pmos ad=0.19p pd=1.38u as=0 ps=0 w=1u l=1u
X172 VSS.t2330 VDD VSS.t2332 VSS.t2331 sg13_lv_nmos ad=79.8f pd=0.8u as=0 ps=0 w=0.42u l=1u
X173 VDD VSS.t2272 VDD VDD sg13_lv_pmos ad=0.19p pd=1.38u as=0 ps=0 w=1u l=1u
X174 VSS.t122 a_22223_14845# a_22890_14484# VSS.t7 sg13_lv_nmos ad=0.1406p pd=1.12u as=0.2516p ps=2.16u w=0.74u l=0.13u
X175 VDD VSS.t941 VDD VDD sg13_lv_pmos ad=0.34p pd=2.68u as=0 ps=0 w=1u l=1u
X176 VDD VSS.t1241 VDD VDD sg13_lv_pmos ad=0.34p pd=2.68u as=0 ps=0 w=1u l=1u
X177 VDD VSS.t2746 VDD VDD sg13_lv_pmos ad=0.34p pd=2.68u as=0 ps=0 w=1u l=1u
X178 VDD VSS.t595 VDD VDD sg13_lv_pmos ad=0.34p pd=2.68u as=0 ps=0 w=1u l=1u
X179 VSS.t1556 VDD VSS.t1558 VSS.t1557 sg13_lv_nmos ad=79.8f pd=0.8u as=0 ps=0 w=0.42u l=1u
X180 VDD VSS.t1197 VDD VDD sg13_lv_pmos ad=0.19p pd=1.38u as=0 ps=0 w=1u l=1u
X181 VSS.t1948 VDD VSS.t1947 VSS.t1946 sg13_lv_nmos ad=0.1428p pd=1.52u as=0 ps=0 w=0.42u l=1u
X182 VDD VSS.t1004 VDD VDD sg13_lv_pmos ad=0.19p pd=1.38u as=0 ps=0 w=1u l=1u
X183 VSS.t1270 VDD VSS.t1271 VSS.t224 sg13_lv_nmos ad=79.8f pd=0.8u as=0 ps=0 w=0.42u l=1u
X184 VDD VSS.t1575 VDD VDD sg13_lv_pmos ad=0.34p pd=2.68u as=0 ps=0 w=1u l=1u
X185 VDD VSS.t446 VDD VDD sg13_lv_pmos ad=0.34p pd=2.68u as=0 ps=0 w=1u l=1u
X186 a_21959_14020# sg13cmos5l_or3_1_2.C a_21865_13726# VDD sg13_lv_pmos ad=0.19p pd=1.38u as=0.34p ps=2.68u w=1u l=0.13u
X187 VDD VSS.t2422 VDD VDD sg13_lv_pmos ad=0.19p pd=1.38u as=0 ps=0 w=1u l=1u
X188 VSS.t2480 VDD VSS.t2482 VSS.t2481 sg13_lv_nmos ad=79.8f pd=0.8u as=0 ps=0 w=0.42u l=1u
X189 a_21934_15423# a_22049_15424# VDD VDD sg13_lv_pmos ad=0.34p pd=2.68u as=0.2254p ps=1.53u w=1u l=0.5u
X190 VSS.t1646 VDD VSS.t1648 VSS.t1647 sg13_lv_nmos ad=79.8f pd=0.8u as=0 ps=0 w=0.42u l=1u
X191 VSS.t2028 VDD VSS.t2030 VSS.t2029 sg13_lv_nmos ad=79.8f pd=0.8u as=0 ps=0 w=0.42u l=1u
X192 VSS.t1037 VDD VSS.t1039 VSS.t1038 sg13_lv_nmos ad=79.8f pd=0.8u as=0 ps=0 w=0.42u l=1u
X193 VDD a_10991_15311# a_11248_15454# VDD sg13_lv_pmos ad=2.8961p pd=18.25u as=79.8f ps=0.8u w=0.42u l=0.13u
X194 VSS.t922 VDD VSS.t921 VSS.t920 sg13_lv_nmos ad=0.1428p pd=1.52u as=0 ps=0 w=0.42u l=1u
X195 VDD VSS.t1922 VDD VDD sg13_lv_pmos ad=0.34p pd=2.68u as=0 ps=0 w=1u l=1u
X196 sg13cmos5l_o21ai_1_1.Y sg13cmos5l_or3_1_2.A a_20182_14862# VSS.t39 sg13_lv_nmos ad=0.2516p pd=2.16u as=0.1406p ps=1.12u w=0.74u l=0.15u
X197 VDD VSS.t904 VDD VDD sg13_lv_pmos ad=0.19p pd=1.38u as=0 ps=0 w=1u l=1u
X198 VDD VSS.t3054 VDD VDD sg13_lv_pmos ad=0.19p pd=1.38u as=0 ps=0 w=1u l=1u
X199 VDD VSS.t2257 VDD VDD sg13_lv_pmos ad=0.19p pd=1.38u as=0 ps=0 w=1u l=1u
X200 VDD VSS.t2095 VDD VDD sg13_lv_pmos ad=0.19p pd=1.38u as=0 ps=0 w=1u l=1u
X201 sg13cmos5l_buf_16_2.X a_19534_13726# VDD VDD sg13_lv_pmos ad=0.2128p pd=1.5u as=0.2128p ps=1.5u w=1.12u l=0.13u
X202 VSS.t2659 VDD VSS.t2659 VSS.t2620 sg13_lv_nmos ad=0.1428p pd=1.52u as=0 ps=0 w=0.42u l=1u
X203 VDD VSS.t2047 VDD VDD sg13_lv_pmos ad=0.34p pd=2.68u as=0 ps=0 w=1u l=1u
X204 VSS.t629 VDD VSS.t629 VSS.t630 sg13_lv_nmos ad=0.1428p pd=1.52u as=0 ps=0 w=0.42u l=1u
X205 VDD VSS.t1179 VDD VDD sg13_lv_pmos ad=0.34p pd=2.68u as=0 ps=0 w=1u l=1u
X206 VDD VSS.t1882 VDD VDD sg13_lv_pmos ad=0.34p pd=2.68u as=0 ps=0 w=1u l=1u
X207 VDD VSS.t1690 VDD VDD sg13_lv_pmos ad=0.34p pd=2.68u as=0 ps=0 w=1u l=1u
X208 VSS.t2275 VDD VSS.t2277 VSS.t2276 sg13_lv_nmos ad=79.8f pd=0.8u as=0 ps=0 w=0.42u l=1u
X209 VSS.t1978 VDD VSS.t1980 VSS.t1979 sg13_lv_nmos ad=79.8f pd=0.8u as=0 ps=0 w=0.42u l=1u
X210 VDD VSS.t535 VDD VDD sg13_lv_pmos ad=0.19p pd=1.38u as=0 ps=0 w=1u l=1u
X211 VSS.t1541 VDD VSS.t1543 VSS.t1542 sg13_lv_nmos ad=79.8f pd=0.8u as=0 ps=0 w=0.42u l=1u
X212 VSS.t3072 VDD VSS.t3074 VSS.t3073 sg13_lv_nmos ad=79.8f pd=0.8u as=0 ps=0 w=0.42u l=1u
X213 a_7354_13690# sg13cmos5l_dlygate4sd3_1_1.A VDD VDD sg13_lv_pmos ad=0.1428p pd=1.52u as=0.1523p ps=1.38u w=0.42u l=0.13u
X214 sg13cmos5l_inv_1_0.Y sg13cmos5l_buf_1_10.X VDD VDD sg13_lv_pmos ad=0.3808p pd=2.92u as=0.3808p ps=2.92u w=1.12u l=0.13u
X215 VSS.t737 VDD VSS.t126 VSS.t736 sg13_lv_nmos ad=0.1428p pd=1.52u as=0 ps=0 w=0.42u l=1u
X216 VDD VSS.t1246 VDD VDD sg13_lv_pmos ad=0.34p pd=2.68u as=0 ps=0 w=1u l=1u
X217 VSS.t1238 VDD VSS.t1239 VSS.t224 sg13_lv_nmos ad=79.8f pd=0.8u as=0 ps=0 w=0.42u l=1u
X218 VDD VSS.t1553 VDD VDD sg13_lv_pmos ad=0.19p pd=1.38u as=0 ps=0 w=1u l=1u
X219 VDD VSS.t779 VDD VDD sg13_lv_pmos ad=0.19p pd=1.38u as=0 ps=0 w=1u l=1u
X220 VSS.t2350 VDD VSS.t2352 VSS.t2351 sg13_lv_nmos ad=79.8f pd=0.8u as=0 ps=0 w=0.42u l=1u
X221 VDD VSS.t2414 VDD VDD sg13_lv_pmos ad=0.34p pd=2.68u as=0 ps=0 w=1u l=1u
X222 VDD VSS.t236 VDD VDD sg13_lv_pmos ad=0.34p pd=2.68u as=0 ps=0 w=1u l=1u
X223 VDD VSS.t609 VDD VDD sg13_lv_pmos ad=0.19p pd=1.38u as=0 ps=0 w=1u l=1u
X224 VDD VSS.t2624 VDD VDD sg13_lv_pmos ad=0.34p pd=2.68u as=0 ps=0 w=1u l=1u
X225 VSS.t40 a_18767_14845# a_19434_14484# VSS.t39 sg13_lv_nmos ad=0.1406p pd=1.12u as=0.2516p ps=2.16u w=0.74u l=0.13u
X226 VDD a_21370_15202# a_21089_15424# VDD sg13_lv_pmos ad=0.1523p pd=1.38u as=0.34p ps=2.68u w=1u l=0.5u
X227 sg13cmos5l_buf_16_2.X a_19534_13726# VSS.t712 VSS.t3298 sg13_lv_nmos ad=0.1406p pd=1.12u as=0.1406p ps=1.12u w=0.74u l=0.13u
X228 VDD VSS.t1187 VDD VDD sg13_lv_pmos ad=0.34p pd=2.68u as=0 ps=0 w=1u l=1u
X229 VSS.t1288 VDD VSS.t1289 VSS.t224 sg13_lv_nmos ad=79.8f pd=0.8u as=0 ps=0 w=0.42u l=1u
X230 VSS.t2636 VDD VSS.t2635 VSS.t2620 sg13_lv_nmos ad=0.1428p pd=1.52u as=0 ps=0 w=0.42u l=1u
X231 VSS.t284 VDD VSS.t356 VSS.t355 sg13_lv_nmos ad=0.1428p pd=1.52u as=0 ps=0 w=0.42u l=1u
X232 VDD VSS.t442 VDD VDD sg13_lv_pmos ad=0.34p pd=2.68u as=0 ps=0 w=1u l=1u
X233 VDD VSS.t849 VDD VDD sg13_lv_pmos ad=0.19p pd=1.38u as=0 ps=0 w=1u l=1u
X234 VDD VSS.t1274 VDD VDD sg13_lv_pmos ad=0.19p pd=1.38u as=0 ps=0 w=1u l=1u
X235 VDD VSS.t2776 VDD VDD sg13_lv_pmos ad=0.19p pd=1.38u as=0 ps=0 w=1u l=1u
X236 VDD VSS.t2080 VDD VDD sg13_lv_pmos ad=0.19p pd=1.38u as=0 ps=0 w=1u l=1u
X237 VDD VSS.t185 VDD VDD sg13_lv_pmos ad=0.34p pd=2.68u as=0 ps=0 w=1u l=1u
X238 VSS.t2671 VDD VSS.t2671 VSS.t2620 sg13_lv_nmos ad=0.1428p pd=1.52u as=0 ps=0 w=0.42u l=1u
X239 VSS.t2495 VDD VSS.t2494 VSS.t2493 sg13_lv_nmos ad=0.1428p pd=1.52u as=0 ps=0 w=0.42u l=1u
X240 VSS.t2315 VDD VSS.t2317 VSS.t2316 sg13_lv_nmos ad=79.8f pd=0.8u as=0 ps=0 w=0.42u l=1u
X241 a_15486_15486# a_15287_15549# VSS.t2 VSS.t160 sg13_lv_nmos ad=0.27427p pd=2.28u as=5.4903p ps=35.61u w=0.795u l=0.13u
X242 VDD VSS.t3006 VDD VDD sg13_lv_pmos ad=0.34p pd=2.68u as=0 ps=0 w=1u l=1u
X243 VSS.t2748 VDD VSS.t2747 VSS.t2620 sg13_lv_nmos ad=0.1428p pd=1.52u as=0 ps=0 w=0.42u l=1u
X244 a_15818_14484# sg13cmos5l_inv_1_0.Y VDD VDD sg13_lv_pmos ad=0.1176p pd=1.33u as=0.4032p ps=2.96u w=1.12u l=0.13u
X245 VDD VSS.t1867 VDD VDD sg13_lv_pmos ad=0.34p pd=2.68u as=0 ps=0 w=1u l=1u
X246 VDD VSS.t934 VDD VDD sg13_lv_pmos ad=0.19p pd=1.38u as=0 ps=0 w=1u l=1u
X247 VSS.t1721 VDD VSS.t1720 VSS.t1719 sg13_lv_nmos ad=0.1428p pd=1.52u as=0 ps=0 w=0.42u l=1u
X248 VDD VSS.t1573 VDD VDD sg13_lv_pmos ad=0.19p pd=1.38u as=0 ps=0 w=1u l=1u
X249 VDD VSS.t2447 VDD VDD sg13_lv_pmos ad=0.19p pd=1.38u as=0 ps=0 w=1u l=1u
X250 a_26469_14495# sg13cmos5l_buf_16_2.X VSS.t2 VSS.t55 sg13_lv_nmos ad=0.2516p pd=2.16u as=5.06795p ps=32.87u w=0.74u l=0.13u
X251 VSS.t3027 VDD VSS.t3026 VSS.t3025 sg13_lv_nmos ad=0.1428p pd=1.52u as=0 ps=0 w=0.42u l=1u
X252 VSS.t362 VDD VSS.t79 VSS.t363 sg13_lv_nmos ad=79.8f pd=0.8u as=0 ps=0 w=0.42u l=1u
X253 VSS.t219 a_22508_15960# counter_value_o[4] VSS.t218 sg13_lv_nmos ad=0.14875p pd=1.16u as=0.2886p ps=2.26u w=0.74u l=0.13u
X254 VDD VSS.t625 VDD VDD sg13_lv_pmos ad=0.19p pd=1.38u as=0 ps=0 w=1u l=1u
X255 VDD VSS.t2737 VDD VDD sg13_lv_pmos ad=0.19p pd=1.38u as=0 ps=0 w=1u l=1u
X256 VSS.t2465 VDD VSS.t2467 VSS.t2466 sg13_lv_nmos ad=79.8f pd=0.8u as=0 ps=0 w=0.42u l=1u
X257 VSS.t620 VDD VSS.t620 VSS.t749 sg13_lv_nmos ad=0.1428p pd=1.52u as=0 ps=0 w=0.42u l=1u
X258 VSS.t1037 VDD VSS.t1039 VSS.t1038 sg13_lv_nmos ad=79.8f pd=0.8u as=0 ps=0 w=0.42u l=1u
X259 VDD VSS.t1279 VDD VDD sg13_lv_pmos ad=0.34p pd=2.68u as=0 ps=0 w=1u l=1u
X260 VDD VSS.t581 VDD VDD sg13_lv_pmos ad=0.34p pd=2.68u as=0 ps=0 w=1u l=1u
X261 VSS.t2627 VDD VSS.t2626 VSS.t2620 sg13_lv_nmos ad=0.1428p pd=1.52u as=0 ps=0 w=0.42u l=1u
X262 a_16372_16020# sg13cmos5l_xnor2_1_1.A VDD VDD sg13_lv_pmos ad=0.1575p pd=1.315u as=0.3822p ps=1.84u w=1u l=0.13u
X263 sg13cmos5l_buf_16_2.X a_19534_13726# VSS.t710 VSS.t3294 sg13_lv_nmos ad=0.1406p pd=1.12u as=0.1406p ps=1.12u w=0.74u l=0.13u
X264 VSS.t1229 VDD VSS.t1228 VSS.t224 sg13_lv_nmos ad=0.1428p pd=1.52u as=0 ps=0 w=0.42u l=1u
X265 VDD VSS.t2502 VDD VDD sg13_lv_pmos ad=0.19p pd=1.38u as=0 ps=0 w=1u l=1u
X266 VDD VSS.t1907 VDD VDD sg13_lv_pmos ad=0.34p pd=2.68u as=0 ps=0 w=1u l=1u
X267 VSS.t897 VDD VSS.t896 VSS.t895 sg13_lv_nmos ad=0.1428p pd=1.52u as=0 ps=0 w=0.42u l=1u
X268 VSS.t2335 VDD VSS.t2337 VSS.t2336 sg13_lv_nmos ad=79.8f pd=0.8u as=0 ps=0 w=0.42u l=1u
X269 VDD VSS.t2242 VDD VDD sg13_lv_pmos ad=0.19p pd=1.38u as=0 ps=0 w=1u l=1u
X270 sg13cmos5l_nor2_1_0.B a_3894_16020# VDD VDD sg13_lv_pmos ad=0.4256p pd=3u as=0.2254p ps=1.53u w=1.12u l=0.13u
X271 VSS.t1222 VDD VSS.t1223 VSS.t224 sg13_lv_nmos ad=79.8f pd=0.8u as=0 ps=0 w=0.42u l=1u
X272 VSS.t2108 VDD VSS.t2110 VSS.t2109 sg13_lv_nmos ad=79.8f pd=0.8u as=0 ps=0 w=0.42u l=1u
X273 VSS.t81 sg13cmos5l_nand4_1_0.Y a_14549_15238# VSS.t244 sg13_lv_nmos ad=0.3293p pd=1.63u as=0.2516p ps=2.16u w=0.74u l=0.13u
X274 VDD VSS.t2032 VDD VDD sg13_lv_pmos ad=0.34p pd=2.68u as=0 ps=0 w=1u l=1u
X275 VDD a_27022_13239# sg13cmos5l_o21ai_1_3.B1 VDD sg13_lv_pmos ad=0.2254p pd=1.53u as=0.4256p ps=3u w=1.12u l=0.13u
X276 VDD VSS.t1316 VDD VDD sg13_lv_pmos ad=0.19p pd=1.38u as=0 ps=0 w=1u l=1u
X277 VSS.t1706 VDD VSS.t1705 VSS.t1704 sg13_lv_nmos ad=0.1428p pd=1.52u as=0 ps=0 w=0.42u l=1u
X278 VDD VSS.t1715 VDD VDD sg13_lv_pmos ad=0.34p pd=2.68u as=0 ps=0 w=1u l=1u
X279 VSS.t772 VDD VSS.t771 VSS.t770 sg13_lv_nmos ad=0.1428p pd=1.52u as=0 ps=0 w=0.42u l=1u
X280 VSS.t957 VDD VSS.t959 VSS.t958 sg13_lv_nmos ad=79.8f pd=0.8u as=0 ps=0 w=0.42u l=1u
X281 a_25582_15423# a_25697_15424# VDD VDD sg13_lv_pmos ad=0.34p pd=2.68u as=0.2254p ps=1.53u w=1u l=0.5u
X282 VDD VSS.t537 VDD VDD sg13_lv_pmos ad=0.34p pd=2.68u as=0 ps=0 w=1u l=1u
X283 VDD VSS.t632 VDD VDD sg13_lv_pmos ad=0.19p pd=1.38u as=0 ps=0 w=1u l=1u
X284 VDD VSS.t2399 VDD VDD sg13_lv_pmos ad=0.34p pd=2.68u as=0 ps=0 w=1u l=1u
X285 VDD VSS.t337 VDD VDD sg13_lv_pmos ad=0.34p pd=2.68u as=0 ps=0 w=1u l=1u
X286 a_16042_13945# a_16485_13701# a_15782_13722# VSS.t3185 sg13_lv_nmos ad=79.8f pd=0.8u as=0.1296p ps=1.52u w=0.42u l=0.13u
X287 VDD VSS.t1545 VDD VDD sg13_lv_pmos ad=0.34p pd=2.68u as=0 ps=0 w=1u l=1u
X288 VSS.t2450 VDD VSS.t2452 VSS.t2451 sg13_lv_nmos ad=79.8f pd=0.8u as=0 ps=0 w=0.42u l=1u
X289 sg13cmos5l_buf_16_2.A a_15790_15238# VDD VDD sg13_lv_pmos ad=0.2128p pd=1.5u as=0.2128p ps=1.5u w=1.12u l=0.13u
X290 VDD sg13cmos5l_dfrbpq_1_7.Q sg13cmos5l_o21ai_1_3.A2 VDD sg13_lv_pmos ad=0.3808p pd=2.92u as=0.2128p ps=1.5u w=1.12u l=0.13u
X291 a_25402_14448# sg13cmos5l_o21ai_1_2.Y VSS.t202 VSS.t7 sg13_lv_nmos ad=0.1428p pd=1.52u as=79.8f ps=0.8u w=0.42u l=0.13u
X292 a_9732_15552# a_10251_15356# a_10991_15311# VSS.t207 sg13_lv_nmos ad=0.3473p pd=2.71u as=0.12665p ps=1.145u w=0.74u l=0.13u
X293 VSS.t1616 VDD VSS.t1618 VSS.t1617 sg13_lv_nmos ad=79.8f pd=0.8u as=0 ps=0 w=0.42u l=1u
X294 VSS.t257 sg13cmos5l_o21ai_1_2.A1 a_20182_14862# VSS.t39 sg13_lv_nmos ad=0.1406p pd=1.12u as=0.2516p ps=2.16u w=0.74u l=0.15u
X295 VDD VSS.t398 VDD VDD sg13_lv_pmos ad=0.19p pd=1.38u as=0 ps=0 w=1u l=1u
X296 VDD VSS.t1164 VDD VDD sg13_lv_pmos ad=0.34p pd=2.68u as=0 ps=0 w=1u l=1u
X297 VDD VSS.t1927 VDD VDD sg13_lv_pmos ad=0.34p pd=2.68u as=0 ps=0 w=1u l=1u
X298 a_17710_16263# a_17825_16262# VDD VDD sg13_lv_pmos ad=0.34p pd=2.68u as=0.2254p ps=1.53u w=1u l=0.5u
X299 VSS.t473 VDD VSS.t128 VSS.t474 sg13_lv_nmos ad=79.8f pd=0.8u as=0 ps=0 w=0.42u l=1u
X300 VSS.t1203 VDD VSS.t1203 VSS.t224 sg13_lv_nmos ad=0.1428p pd=1.52u as=0 ps=0 w=0.42u l=1u
X301 VDD VSS.t1265 VDD VDD sg13_lv_pmos ad=0.19p pd=1.38u as=0 ps=0 w=1u l=1u
X302 VDD VSS.t2768 VDD VDD sg13_lv_pmos ad=0.19p pd=1.38u as=0 ps=0 w=1u l=1u
X303 VDD VSS.t284 VDD VDD sg13_lv_pmos ad=0.34p pd=2.68u as=0 ps=0 w=1u l=1u
X304 a_9958_15247# sg13cmos5l_tiehi_0.L_HI VSS.t4 VSS.t3215 sg13_lv_nmos ad=37.8f pd=0.6u as=0.1701p ps=1.65u w=0.42u l=0.13u
X305 VDD sg13cmos5l_o21ai_1_2.B1 a_24461_14508# VDD sg13_lv_pmos ad=0.3822p pd=1.84u as=0.1575p ps=1.315u w=1u l=0.13u
X306 VDD VSS.t1297 VDD VDD sg13_lv_pmos ad=0.34p pd=2.68u as=0 ps=0 w=1u l=1u
X307 VSS.t2663 VDD VSS.t2662 VSS.t2620 sg13_lv_nmos ad=0.1428p pd=1.52u as=0 ps=0 w=0.42u l=1u
X308 VSS.t2480 VDD VSS.t2479 VSS.t2478 sg13_lv_nmos ad=0.1428p pd=1.52u as=0 ps=0 w=0.42u l=1u
X309 VSS.t2093 VDD VSS.t2095 VSS.t2094 sg13_lv_nmos ad=79.8f pd=0.8u as=0 ps=0 w=0.42u l=1u
X310 VSS.t546 VDD VSS.t549 VSS.t661 sg13_lv_nmos ad=79.8f pd=0.8u as=0 ps=0 w=0.42u l=1u
X311 VDD VSS.t1041 VDD VDD sg13_lv_pmos ad=0.34p pd=2.68u as=0 ps=0 w=1u l=1u
X312 VDD a_18970_16237# sg13cmos5l_dfrbpq_1_3.RESET_B VDD sg13_lv_pmos ad=2.8961p pd=18.25u as=0.3927p ps=2.99u w=1.155u l=0.13u
X313 VSS.t1247 VDD VSS.t1246 VSS.t224 sg13_lv_nmos ad=0.1428p pd=1.52u as=0 ps=0 w=0.42u l=1u
X314 VSS.t2280 VDD VSS.t2282 VSS.t2281 sg13_lv_nmos ad=79.8f pd=0.8u as=0 ps=0 w=0.42u l=1u
X315 VSS.t1983 VDD VSS.t1985 VSS.t1984 sg13_lv_nmos ad=79.8f pd=0.8u as=0 ps=0 w=0.42u l=1u
X316 VSS.t398 VDD VSS.t398 VSS.t400 sg13_lv_nmos ad=0.1428p pd=1.52u as=0 ps=0 w=0.42u l=1u
X317 a_12212_15202# sg13cmos5l_buf_16_2.A VSS.t147 VSS.t3309 sg13_lv_nmos ad=0.1406p pd=1.12u as=0.1406p ps=1.12u w=0.74u l=0.13u
X318 VSS.t3077 VDD VSS.t3079 VSS.t3078 sg13_lv_nmos ad=79.8f pd=0.8u as=0 ps=0 w=0.42u l=1u
X319 VSS.t927 VDD VSS.t926 VSS.t925 sg13_lv_nmos ad=0.1428p pd=1.52u as=0 ps=0 w=0.42u l=1u
X320 VDD VSS.t1558 VDD VDD sg13_lv_pmos ad=0.19p pd=1.38u as=0 ps=0 w=1u l=1u
X321 VDD VSS.t614 VDD VDD sg13_lv_pmos ad=0.34p pd=2.68u as=0 ps=0 w=1u l=1u
X322 sg13cmos5l_dlygate4sd3_1_1.A a_6906_12935# VSS.t69 VSS.t75 sg13_lv_nmos ad=0.1628p pd=1.18u as=0.3108p ps=2.32u w=0.74u l=0.13u
X323 VDD VSS.t979 VDD VDD sg13_lv_pmos ad=0.19p pd=1.38u as=0 ps=0 w=1u l=1u
X324 VDD VSS.t1613 VDD VDD sg13_lv_pmos ad=0.19p pd=1.38u as=0 ps=0 w=1u l=1u
X325 sg13cmos5l_inv_1_0.Y sg13cmos5l_buf_1_10.X VSS.t532 VSS.t3192 sg13_lv_nmos ad=0.2516p pd=2.16u as=0.2516p ps=2.16u w=0.74u l=0.13u
X326 VSS.t2355 VDD VSS.t2357 VSS.t2356 sg13_lv_nmos ad=79.8f pd=0.8u as=0 ps=0 w=0.42u l=1u
X327 VSS.t2661 VDD VSS.t2659 VSS.t2620 sg13_lv_nmos ad=0.1428p pd=1.52u as=0 ps=0 w=0.42u l=1u
X328 VDD VSS.t2384 VDD VDD sg13_lv_pmos ad=0.34p pd=2.68u as=0 ps=0 w=1u l=1u
X329 VSS.t481 VDD VSS.t483 VSS.t482 sg13_lv_nmos ad=79.8f pd=0.8u as=0 ps=0 w=0.42u l=1u
X330 VDD VSS.t1895 VDD VDD sg13_lv_pmos ad=0.19p pd=1.38u as=0 ps=0 w=1u l=1u
X331 VDD VSS.t2728 VDD VDD sg13_lv_pmos ad=0.19p pd=1.38u as=0 ps=0 w=1u l=1u
X332 VDD VSS.t581 VDD VDD sg13_lv_pmos ad=0.34p pd=2.68u as=0 ps=0 w=1u l=1u
X333 VSS.t1576 VDD VSS.t1575 VSS.t1574 sg13_lv_nmos ad=0.1428p pd=1.52u as=0 ps=0 w=0.42u l=1u
X334 VSS.t3107 VDD VSS.t3106 VSS.t3105 sg13_lv_nmos ad=0.1428p pd=1.52u as=0 ps=0 w=0.42u l=1u
X335 VDD VSS.t2302 VDD VDD sg13_lv_pmos ad=0.19p pd=1.38u as=0 ps=0 w=1u l=1u
X336 VDD VSS.t2699 VDD VDD sg13_lv_pmos ad=0.34p pd=2.68u as=0 ps=0 w=1u l=1u
X337 VDD VSS.t854 VDD VDD sg13_lv_pmos ad=0.19p pd=1.38u as=0 ps=0 w=1u l=1u
X338 VSS.t897 VDD VSS.t896 VSS.t895 sg13_lv_nmos ad=0.1428p pd=1.52u as=0 ps=0 w=0.42u l=1u
X339 VDD VSS.t2487 VDD VDD sg13_lv_pmos ad=0.19p pd=1.38u as=0 ps=0 w=1u l=1u
X340 VDD VSS.t1277 VDD VDD sg13_lv_pmos ad=0.19p pd=1.38u as=0 ps=0 w=1u l=1u
X341 VSS.t1571 VDD VSS.t1570 VSS.t1569 sg13_lv_nmos ad=0.1428p pd=1.52u as=0 ps=0 w=0.42u l=1u
X342 VDD VSS.t2779 VDD VDD sg13_lv_pmos ad=0.19p pd=1.38u as=0 ps=0 w=1u l=1u
X343 VDD VSS.t2085 VDD VDD sg13_lv_pmos ad=0.19p pd=1.38u as=0 ps=0 w=1u l=1u
X344 VDD VSS.t2439 VDD VDD sg13_lv_pmos ad=0.34p pd=2.68u as=0 ps=0 w=1u l=1u
X345 VSS.t2500 VDD VSS.t2499 VSS.t2498 sg13_lv_nmos ad=0.1428p pd=1.52u as=0 ps=0 w=0.42u l=1u
X346 VSS.t2320 VDD VSS.t2322 VSS.t2321 sg13_lv_nmos ad=79.8f pd=0.8u as=0 ps=0 w=0.42u l=1u
X347 VDD VSS.t430 VDD VDD sg13_lv_pmos ad=0.34p pd=2.68u as=0 ps=0 w=1u l=1u
X348 VDD VSS.t3011 VDD VDD sg13_lv_pmos ad=0.34p pd=2.68u as=0 ps=0 w=1u l=1u
X349 VSS.t450 VDD VSS.t450 VSS.t2 sg13_lv_nmos ad=0.1428p pd=1.52u as=0 ps=0 w=0.42u l=1u
X350 VSS.t2048 VDD VSS.t2047 VSS.t2046 sg13_lv_nmos ad=0.1428p pd=1.52u as=0 ps=0 w=0.42u l=1u
X351 VDD VSS.t1231 VDD VDD sg13_lv_pmos ad=0.34p pd=2.68u as=0 ps=0 w=1u l=1u
X352 VDD VSS.t2045 VDD VDD sg13_lv_pmos ad=0.19p pd=1.38u as=0 ps=0 w=1u l=1u
X353 sg13cmos5l_dfrbpq_1_2.CLK a_12212_15202# VSS.t142 VSS.t143 sg13_lv_nmos ad=0.1406p pd=1.12u as=0.1406p ps=1.12u w=0.74u l=0.13u
X354 a_7077_14495# sg13cmos5l_dfrbpq_1_2.CLK VDD VDD sg13_lv_pmos ad=0.4088p pd=2.97u as=2.3367p ps=15.135u w=1.12u l=0.13u
X355 VSS.t772 VDD VSS.t771 VSS.t770 sg13_lv_nmos ad=0.1428p pd=1.52u as=0 ps=0 w=0.42u l=1u
X356 VSS.t957 VDD VSS.t959 VSS.t958 sg13_lv_nmos ad=79.8f pd=0.8u as=0 ps=0 w=0.42u l=1u
X357 VDD VSS.t1543 VDD VDD sg13_lv_pmos ad=0.19p pd=1.38u as=0 ps=0 w=1u l=1u
X358 VSS.t689 VDD VSS.t691 VSS.t690 sg13_lv_nmos ad=79.8f pd=0.8u as=0 ps=0 w=0.42u l=1u
X359 VDD VSS.t1598 VDD VDD sg13_lv_pmos ad=0.19p pd=1.38u as=0 ps=0 w=1u l=1u
X360 a_26532_13735# a_26763_13844# a_26218_13945# VSS.t3190 sg13_lv_nmos ad=0.2373p pd=1.97u as=79.8f ps=0.8u w=0.42u l=0.13u
X361 a_26470_13735# sg13cmos5l_dfrbpq_1_5.RESET_B VSS.t297 VSS.t3213 sg13_lv_nmos ad=37.8f pd=0.6u as=0.1701p ps=1.65u w=0.42u l=0.13u
X362 sg13cmos5l_dfrbpq_1_2.Q a_17994_14020# VDD VDD sg13_lv_pmos ad=0.3808p pd=2.92u as=0.2128p ps=1.5u w=1.12u l=0.13u
X363 VDD VSS.t185 VDD VDD sg13_lv_pmos ad=0.19p pd=1.38u as=0 ps=0 w=1u l=1u
X364 VDD VSS.t886 VDD VDD sg13_lv_pmos ad=0.34p pd=2.68u as=0 ps=0 w=1u l=1u
X365 VDD VSS.t2658 VDD VDD sg13_lv_pmos ad=0.19p pd=1.38u as=0 ps=0 w=1u l=1u
X366 VDD VSS.t2740 VDD VDD sg13_lv_pmos ad=0.19p pd=1.38u as=0 ps=0 w=1u l=1u
X367 VSS.t1998 VDD VSS.t1997 VSS.t1996 sg13_lv_nmos ad=0.1428p pd=1.52u as=0 ps=0 w=0.42u l=1u
X368 VSS.t1 a_27568_14726# a_27217_14845# VSS.t2 sg13_lv_nmos ad=79.8f pd=0.8u as=0.1428p ps=1.52u w=0.42u l=0.13u
X369 VSS.t552 VDD VSS.t552 VSS.t663 sg13_lv_nmos ad=0.1428p pd=1.52u as=0 ps=0 w=0.42u l=1u
X370 VSS.t3092 VDD VSS.t3091 VSS.t3090 sg13_lv_nmos ad=0.1428p pd=1.52u as=0 ps=0 w=0.42u l=1u
X371 VSS.t2295 VDD VSS.t2294 VSS.t2293 sg13_lv_nmos ad=0.1428p pd=1.52u as=0 ps=0 w=0.42u l=1u
X372 VSS.t2630 VDD VSS.t2629 VSS.t2620 sg13_lv_nmos ad=0.1428p pd=1.52u as=0 ps=0 w=0.42u l=1u
X373 VDD sg13cmos5l_dlygate4sd3_1_11.X a_8156_15532# VDD sg13_lv_pmos ad=0.2128p pd=1.5u as=0.3808p ps=2.92u w=1.12u l=0.13u
X374 VDD VSS.t446 VDD VDD sg13_lv_pmos ad=0.34p pd=2.68u as=0 ps=0 w=1u l=1u
X375 VSS.t2730 VDD VSS.t2731 VSS.t2620 sg13_lv_nmos ad=79.8f pd=0.8u as=0 ps=0 w=0.42u l=1u
X376 VDD VSS.t2472 VDD VDD sg13_lv_pmos ad=0.19p pd=1.38u as=0 ps=0 w=1u l=1u
X377 VDD VSS.t1912 VDD VDD sg13_lv_pmos ad=0.34p pd=2.68u as=0 ps=0 w=1u l=1u
X378 VDD VSS.t2247 VDD VDD sg13_lv_pmos ad=0.19p pd=1.38u as=0 ps=0 w=1u l=1u
X379 VSS.t106 sg13cmos5l_nor2_1_1.B sg13cmos5l_nor2_1_1.Y VSS.t105 sg13_lv_nmos ad=0.2516p pd=2.16u as=0.1406p ps=1.12u w=0.74u l=0.13u
X380 VDD VSS.t3044 VDD VDD sg13_lv_pmos ad=0.19p pd=1.38u as=0 ps=0 w=1u l=1u
X381 VSS.t2078 VDD VSS.t2080 VSS.t2079 sg13_lv_nmos ad=79.8f pd=0.8u as=0 ps=0 w=0.42u l=1u
X382 VDD VSS.t2037 VDD VDD sg13_lv_pmos ad=0.34p pd=2.68u as=0 ps=0 w=1u l=1u
X383 a_21929_16334# a_22053_16033# VDD VDD sg13_lv_pmos ad=0.2442p pd=2.06u as=2.8961p ps=18.25u w=0.66u l=0.13u
X384 VDD sg13cmos5l_tiehi_0.L_HI a_9706_15457# VDD sg13_lv_pmos ad=0.1563p pd=1.22u as=0.147p ps=1.54u w=0.42u l=0.13u
X385 VSS.t1306 VDD VSS.t1305 VSS.t224 sg13_lv_nmos ad=0.1428p pd=1.52u as=0 ps=0 w=0.42u l=1u
X386 VSS.t313 VDD VSS.t315 VSS.t314 sg13_lv_nmos ad=79.8f pd=0.8u as=0 ps=0 w=0.42u l=1u
X387 VSS.t382 VDD VSS.t382 VSS.t385 sg13_lv_nmos ad=79.8f pd=0.8u as=0 ps=0 w=0.42u l=1u
X388 VSS.t927 VDD VSS.t926 VSS.t925 sg13_lv_nmos ad=0.1428p pd=1.52u as=0 ps=0 w=0.42u l=1u
X389 VSS.t3062 VDD VSS.t3064 VSS.t3063 sg13_lv_nmos ad=79.8f pd=0.8u as=0 ps=0 w=0.42u l=1u
X390 VSS.t2265 VDD VSS.t2267 VSS.t2266 sg13_lv_nmos ad=79.8f pd=0.8u as=0 ps=0 w=0.42u l=1u
X391 VDD VSS.t1720 VDD VDD sg13_lv_pmos ad=0.34p pd=2.68u as=0 ps=0 w=1u l=1u
X392 sg13cmos5l_dfrbpq_1_2.CLK a_12212_15202# VSS.t135 VSS.t138 sg13_lv_nmos ad=0.1406p pd=1.12u as=0.1406p ps=1.12u w=0.74u l=0.13u
X393 VDD VSS.t450 VDD VDD sg13_lv_pmos ad=0.34p pd=2.68u as=0 ps=0 w=1u l=1u
X394 a_26218_13945# a_26661_13701# a_26601_14113# VDD sg13_lv_pmos ad=79.8f pd=0.8u as=63f ps=0.72u w=0.42u l=0.13u
X395 VSS.t1626 VDD VSS.t1628 VSS.t1627 sg13_lv_nmos ad=79.8f pd=0.8u as=0 ps=0 w=0.42u l=1u
X396 VSS.t2340 VDD VSS.t2342 VSS.t2341 sg13_lv_nmos ad=79.8f pd=0.8u as=0 ps=0 w=0.42u l=1u
X397 a_27513_14607# a_26571_14495# a_27311_14845# VDD sg13_lv_pmos ad=93.45f pd=0.865u as=0.2048p ps=1.63u w=0.42u l=0.13u
X398 VDD VSS.t609 VDD VDD sg13_lv_pmos ad=0.19p pd=1.38u as=0 ps=0 w=1u l=1u
X399 VDD VSS.t1550 VDD VDD sg13_lv_pmos ad=0.34p pd=2.68u as=0 ps=0 w=1u l=1u
X400 VSS.t708 VDD VSS.t710 VSS.t709 sg13_lv_nmos ad=79.8f pd=0.8u as=0 ps=0 w=0.42u l=1u
X401 VSS.t1621 VDD VSS.t1623 VSS.t1622 sg13_lv_nmos ad=79.8f pd=0.8u as=0 ps=0 w=0.42u l=1u
X402 VDD VSS.t2690 VDD VDD sg13_lv_pmos ad=0.34p pd=2.68u as=0 ps=0 w=1u l=1u
X403 VDD VSS.t2464 VDD VDD sg13_lv_pmos ad=0.34p pd=2.68u as=0 ps=0 w=1u l=1u
X404 VSS.t847 VDD VSS.t849 VSS.t848 sg13_lv_nmos ad=79.8f pd=0.8u as=0 ps=0 w=0.42u l=1u
X405 VSS.t2742 VDD VSS.t2743 VSS.t2620 sg13_lv_nmos ad=79.8f pd=0.8u as=0 ps=0 w=0.42u l=1u
X406 a_9706_15457# a_10149_15213# a_9446_15234# VSS.t237 sg13_lv_nmos ad=79.8f pd=0.8u as=0.1296p ps=1.52u w=0.42u l=0.13u
X407 VDD VSS.t1166 VDD VDD sg13_lv_pmos ad=0.34p pd=2.68u as=0 ps=0 w=1u l=1u
X408 VDD VSS.t1268 VDD VDD sg13_lv_pmos ad=0.19p pd=1.38u as=0 ps=0 w=1u l=1u
X409 VDD VSS.t2771 VDD VDD sg13_lv_pmos ad=0.19p pd=1.38u as=0 ps=0 w=1u l=1u
X410 VDD VSS.t2070 VDD VDD sg13_lv_pmos ad=0.19p pd=1.38u as=0 ps=0 w=1u l=1u
X411 VSS.t641 VDD VSS.t641 VSS.t640 sg13_lv_nmos ad=0.1428p pd=1.52u as=0 ps=0 w=0.42u l=1u
X412 VDD VSS.t2424 VDD VDD sg13_lv_pmos ad=0.34p pd=2.68u as=0 ps=0 w=1u l=1u
X413 VSS.t2485 VDD VSS.t2484 VSS.t2483 sg13_lv_nmos ad=0.1428p pd=1.52u as=0 ps=0 w=0.42u l=1u
X414 a_20974_15423# a_21089_15424# VDD VDD sg13_lv_pmos ad=0.34p pd=2.68u as=0.2254p ps=1.53u w=1u l=0.5u
X415 VDD VSS.t2743 VDD VDD sg13_lv_pmos ad=0.34p pd=2.68u as=0 ps=0 w=1u l=1u
X416 VSS.t450 VDD VSS.t450 VSS.t2 sg13_lv_nmos ad=0.1428p pd=1.52u as=0 ps=0 w=0.42u l=1u
X417 VDD VSS.t546 VDD VDD sg13_lv_pmos ad=0.19p pd=1.38u as=0 ps=0 w=1u l=1u
X418 a_7985_15288# sg13cmos5l_xor2_1_0.B a_7953_15556# VDD sg13_lv_pmos ad=0.34p pd=2.68u as=0.1225p ps=1.245u w=1u l=0.13u
X419 VSS.t1651 VDD VSS.t1650 VSS.t1649 sg13_lv_nmos ad=0.1428p pd=1.52u as=0 ps=0 w=0.42u l=1u
X420 VDD VSS.t2996 VDD VDD sg13_lv_pmos ad=0.34p pd=2.68u as=0 ps=0 w=1u l=1u
X421 VDD VSS.t104 VDD VDD sg13_lv_pmos ad=0.34p pd=2.68u as=0 ps=0 w=1u l=1u
X422 VDD VSS.t1940 VDD VDD sg13_lv_pmos ad=0.19p pd=1.38u as=0 ps=0 w=1u l=1u
X423 a_17584_13942# sg13cmos5l_dfrbpq_1_2.RESET_B VDD VDD sg13_lv_pmos ad=79.8f pd=0.8u as=2.42015p ps=15.68u w=0.42u l=0.13u
X424 VDD VSS.t1528 VDD VDD sg13_lv_pmos ad=0.19p pd=1.38u as=0 ps=0 w=1u l=1u
X425 VDD VSS.t1705 VDD VDD sg13_lv_pmos ad=0.34p pd=2.68u as=0 ps=0 w=1u l=1u
X426 VSS.t2325 VDD VSS.t2327 VSS.t2326 sg13_lv_nmos ad=79.8f pd=0.8u as=0 ps=0 w=0.42u l=1u
X427 VSS.t1177 VDD VSS.t1178 VSS.t224 sg13_lv_nmos ad=79.8f pd=0.8u as=0 ps=0 w=0.42u l=1u
X428 VDD VSS.t2649 VDD VDD sg13_lv_pmos ad=0.19p pd=1.38u as=0 ps=0 w=1u l=1u
X429 VSS.t1546 VDD VSS.t1545 VSS.t1544 sg13_lv_nmos ad=0.1428p pd=1.52u as=0 ps=0 w=0.42u l=1u
X430 VSS.t3077 VDD VSS.t3076 VSS.t3075 sg13_lv_nmos ad=0.1428p pd=1.52u as=0 ps=0 w=0.42u l=1u
X431 VSS.t2280 VDD VSS.t2279 VSS.t2278 sg13_lv_nmos ad=0.1428p pd=1.52u as=0 ps=0 w=0.42u l=1u
X432 VDD VSS.t2307 VDD VDD sg13_lv_pmos ad=0.19p pd=1.38u as=0 ps=0 w=1u l=1u
X433 VDD VSS.t450 VDD VDD sg13_lv_pmos ad=0.34p pd=2.68u as=0 ps=0 w=1u l=1u
X434 VSS.t77 a_6566_15238# a_6678_15302# VSS.t226 sg13_lv_nmos ad=0.1426p pd=1.16u as=0.1428p ps=1.52u w=0.42u l=0.5u
X435 VSS.t2622 VDD VSS.t2621 VSS.t2620 sg13_lv_nmos ad=0.1428p pd=1.52u as=0 ps=0 w=0.42u l=1u
X436 VDD VSS.t755 VDD VDD sg13_lv_pmos ad=0.19p pd=1.38u as=0 ps=0 w=1u l=1u
X437 a_2843_14832# sg13cmos5l_xnor2_1_0.A VSS.t419 VSS.t3228 sg13_lv_nmos ad=78.39999f pd=0.885u as=0.2272p ps=1.99u w=0.64u l=0.13u
X438 VDD VSS.t2763 VDD VDD sg13_lv_pmos ad=0.19p pd=1.38u as=0 ps=0 w=1u l=1u
X439 VDD VSS.t2090 VDD VDD sg13_lv_pmos ad=0.19p pd=1.38u as=0 ps=0 w=1u l=1u
X440 VDD VSS.t522 VDD VDD sg13_lv_pmos ad=0.34p pd=2.68u as=0 ps=0 w=1u l=1u
X441 VDD VSS.t806 VDD VDD sg13_lv_pmos ad=0.34p pd=2.68u as=0 ps=0 w=1u l=1u
X442 VSS.t1232 VDD VSS.t1231 VSS.t224 sg13_lv_nmos ad=0.1428p pd=1.52u as=0 ps=0 w=0.42u l=1u
X443 VSS.t1636 VDD VSS.t1635 VSS.t1634 sg13_lv_nmos ad=0.1428p pd=1.52u as=0 ps=0 w=0.42u l=1u
X444 a_15707_15996# sg13cmos5l_a21oi_1_0.A2 VDD VDD sg13_lv_pmos ad=0.3808p pd=2.92u as=0.2128p ps=1.5u w=1.12u l=0.13u
X445 VSS.t1185 VDD VSS.t1186 VSS.t224 sg13_lv_nmos ad=79.8f pd=0.8u as=0 ps=0 w=0.42u l=1u
X446 VSS.t426 VDD VSS.t426 VSS.t2 sg13_lv_nmos ad=0.1428p pd=1.52u as=0 ps=0 w=0.42u l=1u
X447 VDD VSS.t636 VDD VDD sg13_lv_pmos ad=0.19p pd=1.38u as=0 ps=0 w=1u l=1u
X448 VSS.t2505 VDD VSS.t2504 VSS.t2503 sg13_lv_nmos ad=0.1428p pd=1.52u as=0 ps=0 w=0.42u l=1u
X449 VSS.t632 VDD VSS.t632 VSS.t758 sg13_lv_nmos ad=0.1428p pd=1.52u as=0 ps=0 w=0.42u l=1u
X450 VSS.t1347 VDD VSS.t1191 VSS.t224 sg13_lv_nmos ad=79.8f pd=0.8u as=0 ps=0 w=0.42u l=1u
X451 VSS.t1611 VDD VSS.t1613 VSS.t1612 sg13_lv_nmos ad=79.8f pd=0.8u as=0 ps=0 w=0.42u l=1u
X452 VDD VSS.t2287 VDD VDD sg13_lv_pmos ad=0.19p pd=1.38u as=0 ps=0 w=1u l=1u
X453 VDD VSS.t1885 VDD VDD sg13_lv_pmos ad=0.19p pd=1.38u as=0 ps=0 w=1u l=1u
X454 VDD VSS.t2722 VDD VDD sg13_lv_pmos ad=0.19p pd=1.38u as=0 ps=0 w=1u l=1u
X455 VSS.t2003 VDD VSS.t2002 VSS.t2001 sg13_lv_nmos ad=0.1428p pd=1.52u as=0 ps=0 w=0.42u l=1u
X456 VSS.t2 a_10149_15213# a_10251_15356# VSS.t163 sg13_lv_nmos ad=5.4903p pd=35.61u as=0.2516p ps=2.16u w=0.74u l=0.13u
X457 sg13cmos5l_a21oi_1_2.Y sg13cmos5l_inv_1_0.Y a_24821_15532# VDD sg13_lv_pmos ad=0.3808p pd=2.92u as=0.2128p ps=1.5u w=1.12u l=0.13u
X458 VSS.t1566 VDD VSS.t1565 VSS.t1564 sg13_lv_nmos ad=0.1428p pd=1.52u as=0 ps=0 w=0.42u l=1u
X459 VSS.t3097 VDD VSS.t3096 VSS.t3095 sg13_lv_nmos ad=0.1428p pd=1.52u as=0 ps=0 w=0.42u l=1u
X460 VSS.t847 VDD VSS.t849 VSS.t848 sg13_lv_nmos ad=79.8f pd=0.8u as=0 ps=0 w=0.42u l=1u
X461 VDD VSS.t1575 VDD VDD sg13_lv_pmos ad=0.34p pd=2.68u as=0 ps=0 w=1u l=1u
X462 VSS.t1606 VDD VSS.t1608 VSS.t1607 sg13_lv_nmos ad=79.8f pd=0.8u as=0 ps=0 w=0.42u l=1u
X463 VDD VSS.t2449 VDD VDD sg13_lv_pmos ad=0.34p pd=2.68u as=0 ps=0 w=1u l=1u
X464 VSS.t2733 VDD VSS.t2734 VSS.t2620 sg13_lv_nmos ad=79.8f pd=0.8u as=0 ps=0 w=0.42u l=1u
X465 VDD VSS.t2477 VDD VDD sg13_lv_pmos ad=0.19p pd=1.38u as=0 ps=0 w=1u l=1u
X466 VDD VSS.t1917 VDD VDD sg13_lv_pmos ad=0.34p pd=2.68u as=0 ps=0 w=1u l=1u
X467 VSS.t2310 VDD VSS.t2312 VSS.t2311 sg13_lv_nmos ad=79.8f pd=0.8u as=0 ps=0 w=0.42u l=1u
X468 VDD VSS.t2252 VDD VDD sg13_lv_pmos ad=0.19p pd=1.38u as=0 ps=0 w=1u l=1u
X469 VDD VSS.t961 VDD VDD sg13_lv_pmos ad=0.34p pd=2.68u as=0 ps=0 w=1u l=1u
X470 VDD VSS.t3049 VDD VDD sg13_lv_pmos ad=0.19p pd=1.38u as=0 ps=0 w=1u l=1u
X471 VSS.t2083 VDD VSS.t2085 VSS.t2084 sg13_lv_nmos ad=79.8f pd=0.8u as=0 ps=0 w=0.42u l=1u
X472 VDD sg13cmos5l_dfrbpq_1_0.RESET_B a_3082_15457# VDD sg13_lv_pmos ad=0.1563p pd=1.22u as=0.147p ps=1.54u w=0.42u l=0.13u
X473 VDD VSS.t1203 VDD VDD sg13_lv_pmos ad=0.19p pd=1.38u as=0 ps=0 w=1u l=1u
X474 VSS.t1277 VDD VSS.t1278 VSS.t224 sg13_lv_nmos ad=79.8f pd=0.8u as=0 ps=0 w=0.42u l=1u
X475 VDD VSS.t1230 VDD VDD sg13_lv_pmos ad=0.34p pd=2.68u as=0 ps=0 w=1u l=1u
X476 VDD VSS.t2734 VDD VDD sg13_lv_pmos ad=0.34p pd=2.68u as=0 ps=0 w=1u l=1u
X477 VSS.t343 VDD VSS.t342 VSS.t341 sg13_lv_nmos ad=0.1428p pd=1.52u as=0 ps=0 w=0.42u l=1u
X478 VDD sg13cmos5l_dlygate4sd3_1_0.A sg13cmos5l_xor2_1_0.B VDD sg13_lv_pmos ad=0.2128p pd=1.5u as=0.2128p ps=1.5u w=1.12u l=0.13u
X479 sg13cmos5l_o21ai_1_2.Y sg13cmos5l_o21ai_1_2.B1 a_24502_13718# VSS.t50 sg13_lv_nmos ad=0.2516p pd=2.16u as=0.1406p ps=1.12u w=0.74u l=0.15u
X480 VDD VSS.t2102 VDD VDD sg13_lv_pmos ad=0.34p pd=2.68u as=0 ps=0 w=1u l=1u
X481 VDD VSS.t1925 VDD VDD sg13_lv_pmos ad=0.19p pd=1.38u as=0 ps=0 w=1u l=1u
X482 a_19546_15202# sg13cmos5l_dfrbpq_1_3.Q VSS.t40 VSS.t65 sg13_lv_nmos ad=0.1428p pd=1.52u as=79.8f ps=0.8u w=0.42u l=0.13u
X483 a_21321_14531# a_20964_14488# VDD VDD sg13_lv_pmos ad=63f pd=0.72u as=0.1563p ps=1.22u w=0.42u l=0.13u
X484 VDD VSS.t641 VDD VDD sg13_lv_pmos ad=0.19p pd=1.38u as=0 ps=0 w=1u l=1u
X485 VDD VSS.t620 VDD VDD sg13_lv_pmos ad=0.34p pd=2.68u as=0 ps=0 w=1u l=1u
X486 VDD VSS.t1690 VDD VDD sg13_lv_pmos ad=0.34p pd=2.68u as=0 ps=0 w=1u l=1u
X487 VSS.t2490 VDD VSS.t2489 VSS.t2488 sg13_lv_nmos ad=0.1428p pd=1.52u as=0 ps=0 w=0.42u l=1u
X488 VSS.t1596 VDD VSS.t1598 VSS.t1597 sg13_lv_nmos ad=79.8f pd=0.8u as=0 ps=0 w=0.42u l=1u
X489 VSS.t3127 VDD VSS.t3129 VSS.t3128 sg13_lv_nmos ad=79.8f pd=0.8u as=0 ps=0 w=0.42u l=1u
X490 VDD VSS.t1555 VDD VDD sg13_lv_pmos ad=0.34p pd=2.68u as=0 ps=0 w=1u l=1u
X491 VSS.t2898 VDD VSS.t2782 VSS.t2620 sg13_lv_nmos ad=79.8f pd=0.8u as=0 ps=0 w=0.42u l=1u
X492 a_7448_15242# sg13cmos5l_dlygate4sd3_1_11.X a_7346_15242# VSS.t298 sg13_lv_nmos ad=0.1406p pd=1.12u as=0.1406p ps=1.12u w=0.74u l=0.13u
X493 VSS.t438 VDD VSS.t438 VSS.t2 sg13_lv_nmos ad=0.1428p pd=1.52u as=0 ps=0 w=0.42u l=1u
X494 VDD VSS.t976 VDD VDD sg13_lv_pmos ad=0.34p pd=2.68u as=0 ps=0 w=1u l=1u
X495 VDD VSS.t2693 VDD VDD sg13_lv_pmos ad=0.34p pd=2.68u as=0 ps=0 w=1u l=1u
X496 VDD VSS.t2469 VDD VDD sg13_lv_pmos ad=0.34p pd=2.68u as=0 ps=0 w=1u l=1u
X497 a_9098_14484# sg13cmos5l_inv_1_0.Y VDD VDD sg13_lv_pmos ad=0.1176p pd=1.33u as=0.4032p ps=2.96u w=1.12u l=0.13u
X498 VDD VSS.t522 VDD VDD sg13_lv_pmos ad=0.34p pd=2.68u as=0 ps=0 w=1u l=1u
X499 VDD VSS.t1271 VDD VDD sg13_lv_pmos ad=0.19p pd=1.38u as=0 ps=0 w=1u l=1u
X500 VDD VSS.t2075 VDD VDD sg13_lv_pmos ad=0.19p pd=1.38u as=0 ps=0 w=1u l=1u
X501 VSS.t546 VDD VSS.t546 VSS.t547 sg13_lv_nmos ad=79.8f pd=0.8u as=0 ps=0 w=0.42u l=1u
X502 VDD VSS.t2754 VDD VDD sg13_lv_pmos ad=0.19p pd=1.38u as=0 ps=0 w=1u l=1u
X503 VDD VSS.t2429 VDD VDD sg13_lv_pmos ad=0.34p pd=2.68u as=0 ps=0 w=1u l=1u
X504 VSS.t2455 VDD VSS.t2454 VSS.t2453 sg13_lv_nmos ad=0.1428p pd=1.52u as=0 ps=0 w=0.42u l=1u
X505 VSS.t1259 VDD VSS.t1258 VSS.t224 sg13_lv_nmos ad=0.1428p pd=1.52u as=0 ps=0 w=0.42u l=1u
X506 VSS.t2957 VDD VSS.t2959 VSS.t2958 sg13_lv_nmos ad=79.8f pd=0.8u as=0 ps=0 w=0.42u l=1u
X507 VSS.t2038 VDD VSS.t2037 VSS.t2036 sg13_lv_nmos ad=0.1428p pd=1.52u as=0 ps=0 w=0.42u l=1u
X508 VSS.t1252 VDD VSS.t1253 VSS.t224 sg13_lv_nmos ad=79.8f pd=0.8u as=0 ps=0 w=0.42u l=1u
X509 VSS.t1621 VDD VSS.t1620 VSS.t1619 sg13_lv_nmos ad=0.1428p pd=1.52u as=0 ps=0 w=0.42u l=1u
X510 VDD VSS.t625 VDD VDD sg13_lv_pmos ad=0.34p pd=2.68u as=0 ps=0 w=1u l=1u
X511 VDD VSS.t275 VDD VDD sg13_lv_pmos ad=0.34p pd=2.68u as=0 ps=0 w=1u l=1u
X512 VDD VSS.t434 VDD VDD sg13_lv_pmos ad=0.34p pd=2.68u as=0 ps=0 w=1u l=1u
X513 VSS.t712 a_19534_13726# sg13cmos5l_buf_16_2.X VSS.t3295 sg13_lv_nmos ad=0.1406p pd=1.12u as=0.1406p ps=1.12u w=0.74u l=0.13u
X514 VDD VSS.t799 VDD VDD sg13_lv_pmos ad=0.19p pd=1.38u as=0 ps=0 w=1u l=1u
X515 VDD VSS.t2264 VDD VDD sg13_lv_pmos ad=0.34p pd=2.68u as=0 ps=0 w=1u l=1u
X516 VDD VSS.t1588 VDD VDD sg13_lv_pmos ad=0.19p pd=1.38u as=0 ps=0 w=1u l=1u
X517 VDD VSS.t3061 VDD VDD sg13_lv_pmos ad=0.34p pd=2.68u as=0 ps=0 w=1u l=1u
X518 VDD a_21850_16237# sg13cmos5l_dfrbpq_1_6.RESET_B VDD sg13_lv_pmos ad=2.8961p pd=18.25u as=0.3927p ps=2.99u w=1.155u l=0.13u
X519 a_6566_15238# a_6296_15238# VDD VDD sg13_lv_pmos ad=0.34p pd=2.68u as=0.1523p ps=1.38u w=1u l=0.5u
X520 VDD VSS.t1236 VDD VDD sg13_lv_pmos ad=0.19p pd=1.38u as=0 ps=0 w=1u l=1u
X521 VSS.t1295 VDD VSS.t1295 VSS.t224 sg13_lv_nmos ad=79.8f pd=0.8u as=0 ps=0 w=0.42u l=1u
X522 VDD VSS.t693 VDD VDD sg13_lv_pmos ad=0.34p pd=2.68u as=0 ps=0 w=1u l=1u
X523 VDD VSS.t1870 VDD VDD sg13_lv_pmos ad=0.19p pd=1.38u as=0 ps=0 w=1u l=1u
X524 VDD VSS.t2652 VDD VDD sg13_lv_pmos ad=0.19p pd=1.38u as=0 ps=0 w=1u l=1u
X525 VDD VSS.t2713 VDD VDD sg13_lv_pmos ad=0.19p pd=1.38u as=0 ps=0 w=1u l=1u
X526 VSS.t1988 VDD VSS.t1987 VSS.t1986 sg13_lv_nmos ad=0.1428p pd=1.52u as=0 ps=0 w=0.42u l=1u
X527 VSS.t1551 VDD VSS.t1550 VSS.t1549 sg13_lv_nmos ad=0.1428p pd=1.52u as=0 ps=0 w=0.42u l=1u
X528 VSS.t3082 VDD VSS.t3081 VSS.t3080 sg13_lv_nmos ad=0.1428p pd=1.52u as=0 ps=0 w=0.42u l=1u
X529 VSS.t2285 VDD VSS.t2284 VSS.t2283 sg13_lv_nmos ad=0.1428p pd=1.52u as=0 ps=0 w=0.42u l=1u
X530 sg13cmos5l_buf_16_2.A a_15790_15238# VSS.t18 VSS.t19 sg13_lv_nmos ad=0.1406p pd=1.12u as=0.1406p ps=1.12u w=0.74u l=0.13u
X531 VSS.t412 VDD VSS.t414 VSS.t413 sg13_lv_nmos ad=79.8f pd=0.8u as=0 ps=0 w=0.42u l=1u
X532 sg13cmos5l_o21ai_1_1.Y sg13cmos5l_or3_1_2.C a_20280_14464# VDD sg13_lv_pmos ad=0.2128p pd=1.5u as=0.2128p ps=1.5u w=1.12u l=0.15u
X533 VDD VSS.t1198 VDD VDD sg13_lv_pmos ad=0.34p pd=2.68u as=0 ps=0 w=1u l=1u
X534 VSS.t2360 VDD VSS.t2359 VSS.t2358 sg13_lv_nmos ad=0.1428p pd=1.52u as=0 ps=0 w=0.42u l=1u
X535 VDD a_10149_15213# a_10251_15356# VDD sg13_lv_pmos ad=2.8961p pd=18.25u as=0.3864p ps=2.93u w=1.12u l=0.13u
X536 VDD VSS.t92 VDD VDD sg13_lv_pmos ad=0.34p pd=2.68u as=0 ps=0 w=1u l=1u
X537 VDD VSS.t1164 VDD VDD sg13_lv_pmos ad=0.19p pd=1.38u as=0 ps=0 w=1u l=1u
X538 VDD VSS.t2765 VDD VDD sg13_lv_pmos ad=0.19p pd=1.38u as=0 ps=0 w=1u l=1u
X539 VDD VSS.t2462 VDD VDD sg13_lv_pmos ad=0.19p pd=1.38u as=0 ps=0 w=1u l=1u
X540 VDD VSS.t2060 VDD VDD sg13_lv_pmos ad=0.19p pd=1.38u as=0 ps=0 w=1u l=1u
X541 sg13cmos5l_a21oi_1_0.Y sg13cmos5l_inv_1_0.Y VSS.t216 VSS.t270 sg13_lv_nmos ad=0.1406p pd=1.12u as=0.2516p ps=2.16u w=0.74u l=0.13u
X542 a_21865_13726# sg13cmos5l_or3_1_2.B VSS.t236 VSS.t282 sg13_lv_nmos ad=0.198p pd=1.27u as=0.1045p ps=0.93u w=0.55u l=0.13u
X543 VDD VSS.t1006 VDD VDD sg13_lv_pmos ad=0.34p pd=2.68u as=0 ps=0 w=1u l=1u
X544 VDD VSS.t1262 VDD VDD sg13_lv_pmos ad=0.19p pd=1.38u as=0 ps=0 w=1u l=1u
X545 VSS.t2475 VDD VSS.t2474 VSS.t2473 sg13_lv_nmos ad=0.1428p pd=1.52u as=0 ps=0 w=0.42u l=1u
X546 VSS.t2295 VDD VSS.t2297 VSS.t2296 sg13_lv_nmos ad=79.8f pd=0.8u as=0 ps=0 w=0.42u l=1u
X547 a_4366_14751# a_4481_14750# VDD VDD sg13_lv_pmos ad=0.34p pd=2.68u as=0.2254p ps=1.53u w=1u l=0.5u
X548 VDD VSS.t814 VDD VDD sg13_lv_pmos ad=0.19p pd=1.38u as=0 ps=0 w=1u l=1u
X549 VDD VSS.t2237 VDD VDD sg13_lv_pmos ad=0.19p pd=1.38u as=0 ps=0 w=1u l=1u
X550 VSS.t2779 VDD VSS.t2779 VSS.t2620 sg13_lv_nmos ad=79.8f pd=0.8u as=0 ps=0 w=0.42u l=1u
X551 VSS.t1641 VDD VSS.t1640 VSS.t1639 sg13_lv_nmos ad=0.1428p pd=1.52u as=0 ps=0 w=0.42u l=1u
X552 a_14549_15238# sg13cmos5l_nand4_1_0.Y VDD VDD sg13_lv_pmos ad=0.1596p pd=1.22u as=0.2856p ps=2.36u w=0.84u l=0.13u
X553 VDD VSS.t2332 VDD VDD sg13_lv_pmos ad=0.19p pd=1.38u as=0 ps=0 w=1u l=1u
X554 VDD VSS.t450 VDD VDD sg13_lv_pmos ad=0.19p pd=1.38u as=0 ps=0 w=1u l=1u
X555 VDD a_6958_13911# sg13cmos5l_dlygate4sd3_1_1.X VDD sg13_lv_pmos ad=0.2254p pd=1.53u as=0.4256p ps=3u w=1.12u l=0.13u
X556 VSS.t1042 VDD VSS.t1041 VSS.t1040 sg13_lv_nmos ad=0.1428p pd=1.52u as=0 ps=0 w=0.42u l=1u
X557 VDD VSS.t1278 VDD VDD sg13_lv_pmos ad=0.34p pd=2.68u as=0 ps=0 w=1u l=1u
X558 VDD VSS.t2779 VDD VDD sg13_lv_pmos ad=0.34p pd=2.68u as=0 ps=0 w=1u l=1u
X559 VDD VSS.t2087 VDD VDD sg13_lv_pmos ad=0.34p pd=2.68u as=0 ps=0 w=1u l=1u
X560 VDD a_37484_15960# counter_value_o[7] VDD sg13_lv_pmos ad=0.2114p pd=1.54u as=0.42p ps=2.99u w=1.12u l=0.13u
X561 VSS.t710 a_19534_13726# sg13cmos5l_buf_16_2.X VSS.t3291 sg13_lv_nmos ad=0.1406p pd=1.12u as=0.1406p ps=1.12u w=0.74u l=0.13u
X562 VSS.t1309 VDD VSS.t1310 VSS.t224 sg13_lv_nmos ad=79.8f pd=0.8u as=0 ps=0 w=0.42u l=1u
X563 VSS.t1938 VDD VSS.t1940 VSS.t1939 sg13_lv_nmos ad=79.8f pd=0.8u as=0 ps=0 w=0.42u l=1u
X564 VDD VSS.t2115 VDD VDD sg13_lv_pmos ad=0.19p pd=1.38u as=0 ps=0 w=1u l=1u
X565 VSS.t620 VDD VSS.t620 VSS.t622 sg13_lv_nmos ad=0.1428p pd=1.52u as=0 ps=0 w=0.42u l=1u
X566 VDD VSS.t1540 VDD VDD sg13_lv_pmos ad=0.34p pd=2.68u as=0 ps=0 w=1u l=1u
X567 VDD VSS.t1890 VDD VDD sg13_lv_pmos ad=0.19p pd=1.38u as=0 ps=0 w=1u l=1u
X568 VSS.t2890 VDD VSS.t2773 VSS.t2620 sg13_lv_nmos ad=79.8f pd=0.8u as=0 ps=0 w=0.42u l=1u
X569 VDD VSS.t2725 VDD VDD sg13_lv_pmos ad=0.19p pd=1.38u as=0 ps=0 w=1u l=1u
X570 VDD VSS.t423 VDD VDD sg13_lv_pmos ad=0.34p pd=2.68u as=0 ps=0 w=1u l=1u
X571 VSS.t1229 VDD VSS.t1230 VSS.t224 sg13_lv_nmos ad=79.8f pd=0.8u as=0 ps=0 w=0.42u l=1u
X572 sg13cmos5l_buf_16_2.A a_15790_15238# VSS.t14 VSS.t13 sg13_lv_nmos ad=0.1406p pd=1.12u as=0.1406p ps=1.12u w=0.74u l=0.13u
X573 VDD VSS.t1545 VDD VDD sg13_lv_pmos ad=0.34p pd=2.68u as=0 ps=0 w=1u l=1u
X574 VDD VSS.t2482 VDD VDD sg13_lv_pmos ad=0.19p pd=1.38u as=0 ps=0 w=1u l=1u
X575 a_19534_13726# sg13cmos5l_buf_16_2.A VSS.t707 VSS.t3319 sg13_lv_nmos ad=0.1406p pd=1.12u as=0.1406p ps=1.12u w=0.74u l=0.13u
X576 VDD VSS.t710 VDD VDD sg13_lv_pmos ad=0.34p pd=2.68u as=0 ps=0 w=1u l=1u
X577 VDD VSS.t969 VDD VDD sg13_lv_pmos ad=0.19p pd=1.38u as=0 ps=0 w=1u l=1u
X578 VSS.t1671 VDD VSS.t1673 VSS.t1672 sg13_lv_nmos ad=79.8f pd=0.8u as=0 ps=0 w=0.42u l=1u
X579 VDD VSS.t2741 VDD VDD sg13_lv_pmos ad=0.34p pd=2.68u as=0 ps=0 w=1u l=1u
X580 VSS.t2088 VDD VSS.t2090 VSS.t2089 sg13_lv_nmos ad=79.8f pd=0.8u as=0 ps=0 w=0.42u l=1u
X581 VSS.t2771 VDD VSS.t2771 VSS.t2620 sg13_lv_nmos ad=79.8f pd=0.8u as=0 ps=0 w=0.42u l=1u
X582 VSS.t852 VDD VSS.t854 VSS.t853 sg13_lv_nmos ad=79.8f pd=0.8u as=0 ps=0 w=0.42u l=1u
X583 VSS.t2942 VDD VSS.t2944 VSS.t2943 sg13_lv_nmos ad=79.8f pd=0.8u as=0 ps=0 w=0.42u l=1u
X584 VDD VSS.t434 VDD VDD sg13_lv_pmos ad=0.34p pd=2.68u as=0 ps=0 w=1u l=1u
X585 VSS.t201 sg13cmos5l_o21ai_1_2.A1 a_24502_13718# VSS.t261 sg13_lv_nmos ad=0.1406p pd=1.12u as=0.2516p ps=2.16u w=0.74u l=0.15u
X586 VSS.t1973 VDD VSS.t1975 VSS.t1974 sg13_lv_nmos ad=79.8f pd=0.8u as=0 ps=0 w=0.42u l=1u
X587 VDD VSS.t1930 VDD VDD sg13_lv_pmos ad=0.19p pd=1.38u as=0 ps=0 w=1u l=1u
X588 a_12212_15202# sg13cmos5l_buf_16_2.A VDD VDD sg13_lv_pmos ad=0.2128p pd=1.5u as=0.2128p ps=1.5u w=1.12u l=0.13u
X589 VDD VSS.t2667 VDD VDD sg13_lv_pmos ad=0.19p pd=1.38u as=0 ps=0 w=1u l=1u
X590 VSS.t2345 VDD VSS.t2344 VSS.t2343 sg13_lv_nmos ad=0.1428p pd=1.52u as=0 ps=0 w=0.42u l=1u
X591 VDD VSS.t3046 VDD VDD sg13_lv_pmos ad=0.34p pd=2.68u as=0 ps=0 w=1u l=1u
X592 VDD VSS.t2249 VDD VDD sg13_lv_pmos ad=0.34p pd=2.68u as=0 ps=0 w=1u l=1u
X593 VSS.t426 VDD VSS.t430 VSS.t2 sg13_lv_nmos ad=79.8f pd=0.8u as=0 ps=0 w=0.42u l=1u
X594 VSS.t1601 VDD VSS.t1603 VSS.t1602 sg13_lv_nmos ad=79.8f pd=0.8u as=0 ps=0 w=0.42u l=1u
X595 VSS.t3132 VDD VSS.t3134 VSS.t3133 sg13_lv_nmos ad=79.8f pd=0.8u as=0 ps=0 w=0.42u l=1u
X596 VDD VSS.t2277 VDD VDD sg13_lv_pmos ad=0.19p pd=1.38u as=0 ps=0 w=1u l=1u
X597 VDD VSS.t1613 VDD VDD sg13_lv_pmos ad=0.19p pd=1.38u as=0 ps=0 w=1u l=1u
X598 VSS.t1211 VDD VSS.t1210 VSS.t224 sg13_lv_nmos ad=0.1428p pd=1.52u as=0 ps=0 w=0.42u l=1u
X599 VSS.t1501 VDD VSS.t1503 VSS.t1502 sg13_lv_nmos ad=79.8f pd=0.8u as=0 ps=0 w=0.42u l=1u
X600 VSS.t2410 VDD VSS.t2412 VSS.t2411 sg13_lv_nmos ad=79.8f pd=0.8u as=0 ps=0 w=0.42u l=1u
X601 VSS.t1883 VDD VSS.t1885 VSS.t1884 sg13_lv_nmos ad=79.8f pd=0.8u as=0 ps=0 w=0.42u l=1u
X602 a_6468_14922# sg13cmos5l_dfrbpq_1_1.D a_6374_14922# VSS.t3284 sg13_lv_nmos ad=60.89999f pd=0.71u as=0.1428p ps=1.52u w=0.42u l=0.13u
X603 VDD VSS.t236 VDD VDD sg13_lv_pmos ad=0.34p pd=2.68u as=0 ps=0 w=1u l=1u
X604 VDD VSS.t936 VDD VDD sg13_lv_pmos ad=0.34p pd=2.68u as=0 ps=0 w=1u l=1u
X605 VSS.t387 VDD VSS.t387 VSS.t391 sg13_lv_nmos ad=0.1428p pd=1.52u as=0 ps=0 w=0.42u l=1u
X606 a_19534_13726# sg13cmos5l_buf_16_2.A VSS.t705 VSS.t3315 sg13_lv_nmos ad=0.1406p pd=1.12u as=0.2516p ps=2.16u w=0.74u l=0.13u
X607 VSS.t807 VDD VSS.t806 VSS.t805 sg13_lv_nmos ad=0.1428p pd=1.52u as=0 ps=0 w=0.42u l=1u
X608 VDD VSS.t1253 VDD VDD sg13_lv_pmos ad=0.19p pd=1.38u as=0 ps=0 w=1u l=1u
X609 VDD VSS.t1902 VDD VDD sg13_lv_pmos ad=0.34p pd=2.68u as=0 ps=0 w=1u l=1u
X610 VDD VSS.t2757 VDD VDD sg13_lv_pmos ad=0.19p pd=1.38u as=0 ps=0 w=1u l=1u
X611 VSS.t2696 VDD VSS.t2697 VSS.t2620 sg13_lv_nmos ad=79.8f pd=0.8u as=0 ps=0 w=0.42u l=1u
X612 VDD VSS.t2731 VDD VDD sg13_lv_pmos ad=0.34p pd=2.68u as=0 ps=0 w=1u l=1u
X613 VSS.t2460 VDD VSS.t2459 VSS.t2458 sg13_lv_nmos ad=0.1428p pd=1.52u as=0 ps=0 w=0.42u l=1u
X614 sg13cmos5l_dfrbpq_1_1.D sg13cmos5l_dlygate4sd3_1_1.X a_6026_15532# VDD sg13_lv_pmos ad=0.3808p pd=2.92u as=0.1176p ps=1.33u w=1.12u l=0.13u
X615 VDD a_7077_14495# a_7179_14495# VDD sg13_lv_pmos ad=2.42015p pd=15.68u as=0.3864p ps=2.93u w=1.12u l=0.13u
X616 VSS.t2927 VDD VSS.t2929 VSS.t2928 sg13_lv_nmos ad=79.8f pd=0.8u as=0 ps=0 w=0.42u l=1u
X617 VDD VSS.t999 VDD VDD sg13_lv_pmos ad=0.19p pd=1.38u as=0 ps=0 w=1u l=1u
X618 VSS.t1042 VDD VSS.t1041 VSS.t1040 sg13_lv_nmos ad=0.1428p pd=1.52u as=0 ps=0 w=0.42u l=1u
X619 VSS.t1626 VDD VSS.t1625 VSS.t1624 sg13_lv_nmos ad=0.1428p pd=1.52u as=0 ps=0 w=0.42u l=1u
X620 VSS.t2745 VDD VSS.t2743 VSS.t2620 sg13_lv_nmos ad=0.1428p pd=1.52u as=0 ps=0 w=0.42u l=1u
X621 VDD VSS.t2494 VDD VDD sg13_lv_pmos ad=0.34p pd=2.68u as=0 ps=0 w=1u l=1u
X622 VDD VSS.t2317 VDD VDD sg13_lv_pmos ad=0.19p pd=1.38u as=0 ps=0 w=1u l=1u
X623 VDD VSS.t185 VDD VDD sg13_lv_pmos ad=0.34p pd=2.68u as=0 ps=0 w=1u l=1u
X624 VSS.t54 a_10025_13668# a_9946_13943# VSS.t119 sg13_lv_nmos ad=10.4325p pd=68.31u as=0.27427p ps=2.28u w=0.795u l=0.13u
X625 VDD VSS.t2269 VDD VDD sg13_lv_pmos ad=0.34p pd=2.68u as=0 ps=0 w=1u l=1u
X626 sg13cmos5l_dfrbpq_1_2.CLK a_12212_15202# VDD VDD sg13_lv_pmos ad=0.2128p pd=1.5u as=0.2128p ps=1.5u w=1.12u l=0.13u
X627 VDD VSS.t1593 VDD VDD sg13_lv_pmos ad=0.19p pd=1.38u as=0 ps=0 w=1u l=1u
X628 VDD VSS.t3066 VDD VDD sg13_lv_pmos ad=0.34p pd=2.68u as=0 ps=0 w=1u l=1u
X629 VSS.t2103 VDD VSS.t2102 VSS.t2101 sg13_lv_nmos ad=0.1428p pd=1.52u as=0 ps=0 w=0.42u l=1u
X630 VSS.t1923 VDD VSS.t1925 VSS.t1924 sg13_lv_nmos ad=79.8f pd=0.8u as=0 ps=0 w=0.42u l=1u
X631 VDD VSS.t2442 VDD VDD sg13_lv_pmos ad=0.19p pd=1.38u as=0 ps=0 w=1u l=1u
X632 VDD VSS.t2100 VDD VDD sg13_lv_pmos ad=0.19p pd=1.38u as=0 ps=0 w=1u l=1u
X633 VSS.t1188 VDD VSS.t1189 VSS.t224 sg13_lv_nmos ad=79.8f pd=0.8u as=0 ps=0 w=0.42u l=1u
X634 VSS.t1225 VDD VSS.t1224 VSS.t224 sg13_lv_nmos ad=0.1428p pd=1.52u as=0 ps=0 w=0.42u l=1u
X635 VSS.t426 VDD VSS.t426 VSS.t2 sg13_lv_nmos ad=0.1428p pd=1.52u as=0 ps=0 w=0.42u l=1u
X636 VDD VSS.t1598 VDD VDD sg13_lv_pmos ad=0.19p pd=1.38u as=0 ps=0 w=1u l=1u
X637 VDD VSS.t1875 VDD VDD sg13_lv_pmos ad=0.19p pd=1.38u as=0 ps=0 w=1u l=1u
X638 VDD VSS.t2655 VDD VDD sg13_lv_pmos ad=0.19p pd=1.38u as=0 ps=0 w=1u l=1u
X639 VDD VSS.t2716 VDD VDD sg13_lv_pmos ad=0.19p pd=1.38u as=0 ps=0 w=1u l=1u
X640 VDD VSS.t1318 VDD VDD sg13_lv_pmos ad=0.34p pd=2.68u as=0 ps=0 w=1u l=1u
X641 VSS.t1556 VDD VSS.t1555 VSS.t1554 sg13_lv_nmos ad=0.1428p pd=1.52u as=0 ps=0 w=0.42u l=1u
X642 VSS.t3087 VDD VSS.t3086 VSS.t3085 sg13_lv_nmos ad=0.1428p pd=1.52u as=0 ps=0 w=0.42u l=1u
X643 VSS.t2290 VDD VSS.t2289 VSS.t2288 sg13_lv_nmos ad=0.1428p pd=1.52u as=0 ps=0 w=0.42u l=1u
X644 VDD VSS.t54 VDD VDD sg13_lv_pmos ad=0.19p pd=1.38u as=0 ps=0 w=1u l=1u
X645 a_24915_15260# sg13cmos5l_or3_1_3.X VSS.t49 VSS.t8 sg13_lv_nmos ad=0.1406p pd=1.12u as=0.2516p ps=2.16u w=0.74u l=0.13u
X646 VSS.t135 a_12212_15202# sg13cmos5l_dfrbpq_1_2.CLK VSS.t139 sg13_lv_nmos ad=0.1406p pd=1.12u as=0.1406p ps=1.12u w=0.74u l=0.13u
X647 VDD sg13cmos5l_dfrbpq_1_5.RESET_B a_26218_13945# VDD sg13_lv_pmos ad=0.1563p pd=1.22u as=0.147p ps=1.54u w=0.42u l=0.13u
X648 VDD VSS.t625 VDD VDD sg13_lv_pmos ad=0.19p pd=1.38u as=0 ps=0 w=1u l=1u
X649 VSS.t962 VDD VSS.t961 VSS.t960 sg13_lv_nmos ad=0.1428p pd=1.52u as=0 ps=0 w=0.42u l=1u
X650 VDD VSS.t2467 VDD VDD sg13_lv_pmos ad=0.19p pd=1.38u as=0 ps=0 w=1u l=1u
X651 VSS.t2330 VDD VSS.t2329 VSS.t2328 sg13_lv_nmos ad=0.1428p pd=1.52u as=0 ps=0 w=0.42u l=1u
X652 a_19049_16334# a_19173_16033# VDD VDD sg13_lv_pmos ad=0.2442p pd=2.06u as=2.8961p ps=18.25u w=0.66u l=0.13u
X653 VSS.t852 VDD VSS.t854 VSS.t853 sg13_lv_nmos ad=79.8f pd=0.8u as=0 ps=0 w=0.42u l=1u
X654 VDD VSS.t826 VDD VDD sg13_lv_pmos ad=0.34p pd=2.68u as=0 ps=0 w=1u l=1u
X655 VSS.t2687 VDD VSS.t2688 VSS.t2620 sg13_lv_nmos ad=79.8f pd=0.8u as=0 ps=0 w=0.42u l=1u
X656 VSS.t2073 VDD VSS.t2075 VSS.t2074 sg13_lv_nmos ad=79.8f pd=0.8u as=0 ps=0 w=0.42u l=1u
X657 VSS.t2763 VDD VSS.t2764 VSS.t2620 sg13_lv_nmos ad=79.8f pd=0.8u as=0 ps=0 w=0.42u l=1u
X658 VDD VSS.t109 VDD VDD sg13_lv_pmos ad=0.19p pd=1.38u as=0 ps=0 w=1u l=1u
X659 VDD VSS.t92 VDD VDD sg13_lv_pmos ad=0.19p pd=1.38u as=0 ps=0 w=1u l=1u
X660 a_10020_15247# a_10251_15356# a_9706_15457# VSS.t206 sg13_lv_nmos ad=0.2373p pd=1.97u as=79.8f ps=0.8u w=0.42u l=0.13u
X661 VDD VSS.t297 VDD VDD sg13_lv_pmos ad=0.34p pd=2.68u as=0 ps=0 w=1u l=1u
X662 VDD VSS.t647 VDD VDD sg13_lv_pmos ad=0.19p pd=1.38u as=0 ps=0 w=1u l=1u
X663 VDD VSS.t1281 VDD VDD sg13_lv_pmos ad=0.34p pd=2.68u as=0 ps=0 w=1u l=1u
X664 VDD VSS.t2092 VDD VDD sg13_lv_pmos ad=0.34p pd=2.68u as=0 ps=0 w=1u l=1u
X665 VDD VSS.t372 VDD VDD sg13_lv_pmos ad=0.19p pd=1.38u as=0 ps=0 w=1u l=1u
X666 VSS.t641 VDD VSS.t641 VSS.t766 sg13_lv_nmos ad=0.1428p pd=1.52u as=0 ps=0 w=0.42u l=1u
X667 VSS.t1172 VDD VSS.t1171 VSS.t224 sg13_lv_nmos ad=0.1428p pd=1.52u as=0 ps=0 w=0.42u l=1u
X668 VDD VSS.t2764 VDD VDD sg13_lv_pmos ad=0.34p pd=2.68u as=0 ps=0 w=1u l=1u
X669 VSS.t1943 VDD VSS.t1945 VSS.t1944 sg13_lv_nmos ad=79.8f pd=0.8u as=0 ps=0 w=0.42u l=1u
X670 sg13cmos5l_dfrbpq_1_2.CLK a_12212_15202# VDD VDD sg13_lv_pmos ad=0.2128p pd=1.5u as=0.2128p ps=1.5u w=1.12u l=0.13u
X671 sg13cmos5l_nor2_1_0.Y sg13cmos5l_nor2_1_0.B a_3626_14484# VDD sg13_lv_pmos ad=0.3808p pd=2.92u as=0.1176p ps=1.33u w=1.12u l=0.13u
X672 VDD VSS.t889 VDD VDD sg13_lv_pmos ad=0.19p pd=1.38u as=0 ps=0 w=1u l=1u
X673 VSS.t537 VDD VSS.t540 VSS.t655 sg13_lv_nmos ad=79.8f pd=0.8u as=0 ps=0 w=0.42u l=1u
X674 VSS.t977 VDD VSS.t976 VSS.t975 sg13_lv_nmos ad=0.1428p pd=1.52u as=0 ps=0 w=0.42u l=1u
X675 VSS.t1586 VDD VSS.t1588 VSS.t1587 sg13_lv_nmos ad=79.8f pd=0.8u as=0 ps=0 w=0.42u l=1u
X676 VSS.t3117 VDD VSS.t3119 VSS.t3118 sg13_lv_nmos ad=79.8f pd=0.8u as=0 ps=0 w=0.42u l=1u
X677 VDD VSS.t2262 VDD VDD sg13_lv_pmos ad=0.19p pd=1.38u as=0 ps=0 w=1u l=1u
X678 VDD VSS.t2646 VDD VDD sg13_lv_pmos ad=0.19p pd=1.38u as=0 ps=0 w=1u l=1u
X679 VSS.t1978 VDD VSS.t1977 VSS.t1976 sg13_lv_nmos ad=0.1428p pd=1.52u as=0 ps=0 w=0.42u l=1u
X680 a_8302_13911# a_8417_13912# VDD VDD sg13_lv_pmos ad=0.34p pd=2.68u as=0.2254p ps=1.53u w=1u l=0.5u
X681 VDD VSS.t647 VDD VDD sg13_lv_pmos ad=0.19p pd=1.38u as=0 ps=0 w=1u l=1u
X682 VSS.t3072 VDD VSS.t3071 VSS.t3070 sg13_lv_nmos ad=0.1428p pd=1.52u as=0 ps=0 w=0.42u l=1u
X683 VSS.t2275 VDD VSS.t2274 VSS.t2273 sg13_lv_nmos ad=0.1428p pd=1.52u as=0 ps=0 w=0.42u l=1u
X684 VDD VSS.t310 VDD VDD sg13_lv_pmos ad=0.19p pd=1.38u as=0 ps=0 w=1u l=1u
X685 VSS.t1486 VDD VSS.t1488 VSS.t1487 sg13_lv_nmos ad=79.8f pd=0.8u as=0 ps=0 w=0.42u l=1u
X686 VSS.t2395 VDD VSS.t2397 VSS.t2396 sg13_lv_nmos ad=79.8f pd=0.8u as=0 ps=0 w=0.42u l=1u
X687 VDD VSS.t1550 VDD VDD sg13_lv_pmos ad=0.34p pd=2.68u as=0 ps=0 w=1u l=1u
X688 VDD VSS.t1605 VDD VDD sg13_lv_pmos ad=0.34p pd=2.68u as=0 ps=0 w=1u l=1u
X689 VSS.t2350 VDD VSS.t2349 VSS.t2348 sg13_lv_nmos ad=0.1428p pd=1.52u as=0 ps=0 w=0.42u l=1u
X690 VSS.t807 VDD VSS.t806 VSS.t805 sg13_lv_nmos ad=0.1428p pd=1.52u as=0 ps=0 w=0.42u l=1u
X691 VDD VSS.t981 VDD VDD sg13_lv_pmos ad=0.34p pd=2.68u as=0 ps=0 w=1u l=1u
X692 VDD VSS.t2452 VDD VDD sg13_lv_pmos ad=0.19p pd=1.38u as=0 ps=0 w=1u l=1u
X693 sg13cmos5l_dfrbpq_1_1.RESET_B a_5694_15486# VDD VDD sg13_lv_pmos ad=0.3927p pd=2.99u as=2.8961p ps=18.25u w=1.155u l=0.13u
X694 VDD VSS.t1215 VDD VDD sg13_lv_pmos ad=0.19p pd=1.38u as=0 ps=0 w=1u l=1u
X695 VSS.t1676 VDD VSS.t1678 VSS.t1677 sg13_lv_nmos ad=79.8f pd=0.8u as=0 ps=0 w=0.42u l=1u
X696 VDD VSS.t1887 VDD VDD sg13_lv_pmos ad=0.34p pd=2.68u as=0 ps=0 w=1u l=1u
X697 VDD VSS.t2723 VDD VDD sg13_lv_pmos ad=0.34p pd=2.68u as=0 ps=0 w=1u l=1u
X698 VDD VSS.t919 VDD VDD sg13_lv_pmos ad=0.19p pd=1.38u as=0 ps=0 w=1u l=1u
X699 VSS.t2058 VDD VSS.t2060 VSS.t2059 sg13_lv_nmos ad=79.8f pd=0.8u as=0 ps=0 w=0.42u l=1u
X700 VDD sg13cmos5l_xor2_1_1.A a_7358_12972# VDD sg13_lv_pmos ad=0.36p pd=2.72u as=0.1225p ps=1.245u w=1u l=0.13u
X701 a_37484_15960# sg13cmos5l_dlygate4sd3_1_20.A VSS.t193 VSS.t192 sg13_lv_nmos ad=0.187p pd=1.78u as=0.14875p ps=1.16u w=0.55u l=0.13u
X702 VDD sg13cmos5l_dfrbpq_1_7.RESET_B a_26026_14452# VDD sg13_lv_pmos ad=0.1563p pd=1.22u as=0.147p ps=1.54u w=0.42u l=0.13u
X703 VDD VSS.t1301 VDD VDD sg13_lv_pmos ad=0.19p pd=1.38u as=0 ps=0 w=1u l=1u
X704 VSS.t2912 VDD VSS.t2914 VSS.t2913 sg13_lv_nmos ad=79.8f pd=0.8u as=0 ps=0 w=0.42u l=1u
X705 VSS.t552 VDD VSS.t552 VSS.t551 sg13_lv_nmos ad=0.1428p pd=1.52u as=0 ps=0 w=0.42u l=1u
X706 VDD a_18470_15238# a_18582_15302# VDD sg13_lv_pmos ad=0.2254p pd=1.53u as=0.34p ps=2.68u w=1u l=0.5u
X707 VSS.t1262 VDD VSS.t1261 VSS.t224 sg13_lv_nmos ad=0.1428p pd=1.52u as=0 ps=0 w=0.42u l=1u
X708 VSS.t1184 VDD VSS.t1184 VSS.t224 sg13_lv_nmos ad=0.1428p pd=1.52u as=0 ps=0 w=0.42u l=1u
X709 VDD VSS.t2479 VDD VDD sg13_lv_pmos ad=0.34p pd=2.68u as=0 ps=0 w=1u l=1u
X710 VDD VSS.t856 VDD VDD sg13_lv_pmos ad=0.34p pd=2.68u as=0 ps=0 w=1u l=1u
X711 VDD VSS.t2670 VDD VDD sg13_lv_pmos ad=0.19p pd=1.38u as=0 ps=0 w=1u l=1u
X712 VSS.t2315 VDD VSS.t2314 VSS.t2313 sg13_lv_nmos ad=0.1428p pd=1.52u as=0 ps=0 w=0.42u l=1u
X713 VDD VSS.t3051 VDD VDD sg13_lv_pmos ad=0.34p pd=2.68u as=0 ps=0 w=1u l=1u
X714 VDD VSS.t2254 VDD VDD sg13_lv_pmos ad=0.34p pd=2.68u as=0 ps=0 w=1u l=1u
X715 VDD VSS.t2282 VDD VDD sg13_lv_pmos ad=0.19p pd=1.38u as=0 ps=0 w=1u l=1u
X716 VSS.t2088 VDD VSS.t2087 VSS.t2086 sg13_lv_nmos ad=0.1428p pd=1.52u as=0 ps=0 w=0.42u l=1u
X717 VSS.t446 VDD VSS.t446 VSS.t2 sg13_lv_nmos ad=0.1428p pd=1.52u as=0 ps=0 w=0.42u l=1u
X718 a_6948_14909# a_6660_14488# a_6886_14909# VSS.t245 sg13_lv_nmos ad=0.1428p pd=1.52u as=37.8f ps=0.6u w=0.42u l=0.13u
X719 VSS.t426 VDD VSS.t426 VSS.t2 sg13_lv_nmos ad=0.1428p pd=1.52u as=0 ps=0 w=0.42u l=1u
X720 VSS.t1471 VDD VSS.t1473 VSS.t1472 sg13_lv_nmos ad=79.8f pd=0.8u as=0 ps=0 w=0.42u l=1u
X721 VSS.t2380 VDD VSS.t2382 VSS.t2381 sg13_lv_nmos ad=79.8f pd=0.8u as=0 ps=0 w=0.42u l=1u
X722 VSS.t1888 VDD VSS.t1890 VSS.t1889 sg13_lv_nmos ad=79.8f pd=0.8u as=0 ps=0 w=0.42u l=1u
X723 VDD VSS.t2444 VDD VDD sg13_lv_pmos ad=0.34p pd=2.68u as=0 ps=0 w=1u l=1u
X724 a_25006_14751# a_25121_14750# VSS.t113 VSS.t7 sg13_lv_nmos ad=0.1428p pd=1.52u as=0.1426p ps=1.16u w=0.42u l=0.5u
X725 VSS.t962 VDD VSS.t961 VSS.t960 sg13_lv_nmos ad=0.1428p pd=1.52u as=0 ps=0 w=0.42u l=1u
X726 VSS.t694 VDD VSS.t693 VSS.t692 sg13_lv_nmos ad=0.1428p pd=1.52u as=0 ps=0 w=0.42u l=1u
X727 VDD VSS.t48 VDD VDD sg13_lv_pmos ad=0.34p pd=2.68u as=0 ps=0 w=1u l=1u
X728 VSS.t1007 VDD VSS.t1006 VSS.t1005 sg13_lv_nmos ad=0.1428p pd=1.52u as=0 ps=0 w=0.42u l=1u
X729 VDD VSS.t1955 VDD VDD sg13_lv_pmos ad=0.19p pd=1.38u as=0 ps=0 w=1u l=1u
X730 VSS.t1271 VDD VSS.t1270 VSS.t224 sg13_lv_nmos ad=0.1428p pd=1.52u as=0 ps=0 w=0.42u l=1u
X731 VSS.t323 VDD VSS.t325 VSS.t324 sg13_lv_nmos ad=79.8f pd=0.8u as=0 ps=0 w=0.42u l=1u
X732 VSS.t417 VDD VSS.t419 VSS.t418 sg13_lv_nmos ad=79.8f pd=0.8u as=0 ps=0 w=0.42u l=1u
X733 VSS.t567 VDD VSS.t566 VSS.t565 sg13_lv_nmos ad=0.1428p pd=1.52u as=0 ps=0 w=0.42u l=1u
X734 VSS.t1838 VDD VSS.t1840 VSS.t1839 sg13_lv_nmos ad=79.8f pd=0.8u as=0 ps=0 w=0.42u l=1u
X735 VDD VSS.t426 VDD VDD sg13_lv_pmos ad=0.34p pd=2.68u as=0 ps=0 w=1u l=1u
X736 sg13cmos5l_buf_16_2.X a_19534_13726# VDD VDD sg13_lv_pmos ad=0.2128p pd=1.5u as=0.2128p ps=1.5u w=1.12u l=0.13u
X737 VDD VSS.t636 VDD VDD sg13_lv_pmos ad=0.34p pd=2.68u as=0 ps=0 w=1u l=1u
X738 VSS.t2932 VDD VSS.t2934 VSS.t2933 sg13_lv_nmos ad=79.8f pd=0.8u as=0 ps=0 w=0.42u l=1u
X739 VDD VSS.t442 VDD VDD sg13_lv_pmos ad=0.34p pd=2.68u as=0 ps=0 w=1u l=1u
X740 VSS.t1631 VDD VSS.t1630 VSS.t1629 sg13_lv_nmos ad=0.1428p pd=1.52u as=0 ps=0 w=0.42u l=1u
X741 VDD VSS.t2322 VDD VDD sg13_lv_pmos ad=0.19p pd=1.38u as=0 ps=0 w=1u l=1u
X742 sg13cmos5l_dfrbpq_1_3.D a_17142_16020# VDD VDD sg13_lv_pmos ad=0.4256p pd=3u as=0.2254p ps=1.53u w=1.12u l=0.13u
X743 a_26446_15423# a_26561_15424# VSS.t228 VSS.t3266 sg13_lv_nmos ad=0.1428p pd=1.52u as=0.1426p ps=1.16u w=0.42u l=0.5u
X744 VDD VSS.t819 VDD VDD sg13_lv_pmos ad=0.19p pd=1.38u as=0 ps=0 w=1u l=1u
X745 VSS.t977 VDD VSS.t976 VSS.t975 sg13_lv_nmos ad=0.1428p pd=1.52u as=0 ps=0 w=0.42u l=1u
X746 VSS.t1307 VDD VSS.t1308 VSS.t224 sg13_lv_nmos ad=79.8f pd=0.8u as=0 ps=0 w=0.42u l=1u
X747 VDD VSS.t1272 VDD VDD sg13_lv_pmos ad=0.34p pd=2.68u as=0 ps=0 w=1u l=1u
X748 VDD VSS.t2239 VDD VDD sg13_lv_pmos ad=0.34p pd=2.68u as=0 ps=0 w=1u l=1u
X749 VSS.t2108 VDD VSS.t2107 VSS.t2106 sg13_lv_nmos ad=0.1428p pd=1.52u as=0 ps=0 w=0.42u l=1u
X750 VSS.t1928 VDD VSS.t1930 VSS.t1929 sg13_lv_nmos ad=79.8f pd=0.8u as=0 ps=0 w=0.42u l=1u
X751 VDD VSS.t2105 VDD VDD sg13_lv_pmos ad=0.19p pd=1.38u as=0 ps=0 w=1u l=1u
X752 a_22053_16033# a_22053_16033# VSS.t73 VSS.t72 sg13_lv_nmos ad=0.111p pd=1.34u as=6.38822p ps=41.325u w=0.3u l=0.13u
X753 a_27922_13722# sg13cmos5l_dfrbpq_1_5.RESET_B VSS.t126 VSS.t3212 sg13_lv_nmos ad=37.8f pd=0.6u as=79.8f ps=0.8u w=0.42u l=0.13u
X754 VDD VSS.t2638 VDD VDD sg13_lv_pmos ad=0.19p pd=1.38u as=0 ps=0 w=1u l=1u
X755 VSS.t3057 VDD VSS.t3056 VSS.t3055 sg13_lv_nmos ad=0.1428p pd=1.52u as=0 ps=0 w=0.42u l=1u
X756 VSS.t2260 VDD VSS.t2259 VSS.t2258 sg13_lv_nmos ad=0.1428p pd=1.52u as=0 ps=0 w=0.42u l=1u
X757 sg13cmos5l_xor2_1_0.B sg13cmos5l_dlygate4sd3_1_5.A VDD VDD sg13_lv_pmos ad=0.3808p pd=2.92u as=0.2128p ps=1.5u w=1.12u l=0.13u
X758 sg13cmos5l_dlygate4sd3_1_11.A a_11658_15532# VDD VDD sg13_lv_pmos ad=0.3808p pd=2.92u as=0.2128p ps=1.5u w=1.12u l=0.13u
X759 VSS.t625 VDD VSS.t625 VSS.t626 sg13_lv_nmos ad=79.8f pd=0.8u as=0 ps=0 w=0.42u l=1u
X760 VDD VSS.t1176 VDD VDD sg13_lv_pmos ad=0.19p pd=1.38u as=0 ps=0 w=1u l=1u
X761 sg13cmos5l_nor2_1_0.B a_3894_16020# VSS.t307 VSS.t3235 sg13_lv_nmos ad=0.2516p pd=2.16u as=0.1426p ps=1.16u w=0.74u l=0.13u
X762 VDD VSS.t1026 VDD VDD sg13_lv_pmos ad=0.34p pd=2.68u as=0 ps=0 w=1u l=1u
X763 VDD VSS.t1590 VDD VDD sg13_lv_pmos ad=0.34p pd=2.68u as=0 ps=0 w=1u l=1u
X764 VDD VSS.t2755 VDD VDD sg13_lv_pmos ad=0.19p pd=1.38u as=0 ps=0 w=1u l=1u
X765 VSS.t2058 VDD VSS.t2057 VSS.t2056 sg13_lv_nmos ad=0.1428p pd=1.52u as=0 ps=0 w=0.42u l=1u
X766 VSS.t441 VDD VSS.t441 VSS.t2 sg13_lv_nmos ad=0.1428p pd=1.52u as=0 ps=0 w=0.42u l=1u
X767 VSS.t2972 VDD VSS.t2974 VSS.t2973 sg13_lv_nmos ad=79.8f pd=0.8u as=0 ps=0 w=0.42u l=1u
X768 VDD VSS.t2294 VDD VDD sg13_lv_pmos ad=0.34p pd=2.68u as=0 ps=0 w=1u l=1u
X769 VSS.t2335 VDD VSS.t2334 VSS.t2333 sg13_lv_nmos ad=0.1428p pd=1.52u as=0 ps=0 w=0.42u l=1u
X770 VSS.t2690 VDD VSS.t2691 VSS.t2620 sg13_lv_nmos ad=79.8f pd=0.8u as=0 ps=0 w=0.42u l=1u
X771 a_22223_14845# a_21381_14495# a_20964_14488# VDD sg13_lv_pmos ad=0.2048p pd=1.63u as=0.34p ps=2.68u w=1u l=0.13u
X772 VSS.t1661 VDD VSS.t1663 VSS.t1662 sg13_lv_nmos ad=79.8f pd=0.8u as=0 ps=0 w=0.42u l=1u
X773 VSS.t2765 VDD VSS.t2766 VSS.t2620 sg13_lv_nmos ad=79.8f pd=0.8u as=0 ps=0 w=0.42u l=1u
X774 VSS.t1903 VDD VSS.t1902 VSS.t1901 sg13_lv_nmos ad=0.1428p pd=1.52u as=0 ps=0 w=0.42u l=1u
X775 VDD VSS.t786 VDD VDD sg13_lv_pmos ad=0.34p pd=2.68u as=0 ps=0 w=1u l=1u
X776 VDD VSS.t3039 VDD VDD sg13_lv_pmos ad=0.19p pd=1.38u as=0 ps=0 w=1u l=1u
X777 VDD VSS.t1900 VDD VDD sg13_lv_pmos ad=0.19p pd=1.38u as=0 ps=0 w=1u l=1u
X778 VDD sg13cmos5l_dfrbpq_1_7.RESET_B a_25766_14922# VDD sg13_lv_pmos ad=0.36237p pd=2.605u as=79.8f ps=0.8u w=0.42u l=0.13u
X779 VSS.t1616 VDD VSS.t1615 VSS.t1614 sg13_lv_nmos ad=0.1428p pd=1.52u as=0 ps=0 w=0.42u l=1u
X780 a_23864_14850# sg13cmos5l_dfrbpq_1_3.Q a_23762_14850# VSS.t7 sg13_lv_nmos ad=0.1406p pd=1.12u as=0.1406p ps=1.12u w=0.74u l=0.13u
X781 sg13cmos5l_buf_16_2.X a_19534_13726# VDD VDD sg13_lv_pmos ad=0.2128p pd=1.5u as=0.2128p ps=1.5u w=1.12u l=0.13u
X782 VSS.t1289 VDD VSS.t1288 VSS.t224 sg13_lv_nmos ad=0.1428p pd=1.52u as=0 ps=0 w=0.42u l=1u
X783 VSS.t1439 VDD VSS.t1322 VSS.t224 sg13_lv_nmos ad=79.8f pd=0.8u as=0 ps=0 w=0.42u l=1u
X784 VDD VSS.t1263 VDD VDD sg13_lv_pmos ad=0.34p pd=2.68u as=0 ps=0 w=1u l=1u
X785 VDD VSS.t2766 VDD VDD sg13_lv_pmos ad=0.34p pd=2.68u as=0 ps=0 w=1u l=1u
X786 VDD VSS.t2062 VDD VDD sg13_lv_pmos ad=0.34p pd=2.68u as=0 ps=0 w=1u l=1u
X787 VSS.t307 a_3782_15996# a_3894_16020# VSS.t3225 sg13_lv_nmos ad=0.1426p pd=1.16u as=0.1428p ps=1.52u w=0.42u l=0.5u
X788 VSS.t446 VDD VSS.t446 VSS.t2 sg13_lv_nmos ad=0.1428p pd=1.52u as=0 ps=0 w=0.42u l=1u
X789 VSS.t1591 VDD VSS.t1593 VSS.t1592 sg13_lv_nmos ad=79.8f pd=0.8u as=0 ps=0 w=0.42u l=1u
X790 VDD VSS.t2267 VDD VDD sg13_lv_pmos ad=0.19p pd=1.38u as=0 ps=0 w=1u l=1u
X791 VDD VSS.t546 VDD VDD sg13_lv_pmos ad=0.34p pd=2.68u as=0 ps=0 w=1u l=1u
X792 VDD VSS.t839 VDD VDD sg13_lv_pmos ad=0.19p pd=1.38u as=0 ps=0 w=1u l=1u
X793 VSS.t1241 VDD VSS.t1241 VSS.t224 sg13_lv_nmos ad=79.8f pd=0.8u as=0 ps=0 w=0.42u l=1u
X794 VDD VSS.t1266 VDD VDD sg13_lv_pmos ad=0.19p pd=1.38u as=0 ps=0 w=1u l=1u
X795 VSS.t1456 VDD VSS.t1458 VSS.t1457 sg13_lv_nmos ad=79.8f pd=0.8u as=0 ps=0 w=0.42u l=1u
X796 VSS.t1873 VDD VSS.t1875 VSS.t1874 sg13_lv_nmos ad=79.8f pd=0.8u as=0 ps=0 w=0.42u l=1u
X797 VSS.t2 a_15287_15315# a_15287_15315# VSS.t3206 sg13_lv_nmos ad=5.4903p pd=35.61u as=0.111p ps=1.34u w=0.3u l=0.13u
X798 VSS.t1007 VDD VSS.t1006 VSS.t1005 sg13_lv_nmos ad=0.1428p pd=1.52u as=0 ps=0 w=0.42u l=1u
X799 VDD VSS.t1555 VDD VDD sg13_lv_pmos ad=0.34p pd=2.68u as=0 ps=0 w=1u l=1u
X800 a_8176_14726# sg13cmos5l_dfrbpq_1_1.RESET_B VDD VDD sg13_lv_pmos ad=79.8f pd=0.8u as=2.42015p ps=15.68u w=0.42u l=0.13u
X801 VDD VSS.t559 VDD VDD sg13_lv_pmos ad=0.19p pd=1.38u as=0 ps=0 w=1u l=1u
X802 VDD VSS.t609 VDD VDD sg13_lv_pmos ad=0.19p pd=1.38u as=0 ps=0 w=1u l=1u
X803 VDD VSS.t236 VDD VDD sg13_lv_pmos ad=0.34p pd=2.68u as=0 ps=0 w=1u l=1u
X804 VDD VSS.t1610 VDD VDD sg13_lv_pmos ad=0.34p pd=2.68u as=0 ps=0 w=1u l=1u
X805 VDD a_7919_14845# a_8586_14484# VDD sg13_lv_pmos ad=0.2128p pd=1.5u as=0.3864p ps=2.93u w=1.12u l=0.13u
X806 VSS.t1169 VDD VSS.t1170 VSS.t224 sg13_lv_nmos ad=79.8f pd=0.8u as=0 ps=0 w=0.42u l=1u
X807 VDD VSS.t1892 VDD VDD sg13_lv_pmos ad=0.34p pd=2.68u as=0 ps=0 w=1u l=1u
X808 VDD VSS.t2725 VDD VDD sg13_lv_pmos ad=0.34p pd=2.68u as=0 ps=0 w=1u l=1u
X809 VSS.t284 VDD VSS.t284 VSS.t358 sg13_lv_nmos ad=0.1428p pd=1.52u as=0 ps=0 w=0.42u l=1u
X810 a_20182_14862# sg13cmos5l_or3_1_2.C VSS.t257 VSS.t39 sg13_lv_nmos ad=0.1406p pd=1.12u as=0.1406p ps=1.12u w=0.74u l=0.15u
X811 VDD VSS.t442 VDD VDD sg13_lv_pmos ad=0.34p pd=2.68u as=0 ps=0 w=1u l=1u
X812 a_6374_14922# a_7179_14495# a_6634_14452# VDD sg13_lv_pmos ad=0.1428p pd=1.52u as=79.8f ps=0.8u w=0.42u l=0.13u
X813 VSS.t1303 VDD VSS.t1302 VSS.t224 sg13_lv_nmos ad=0.1428p pd=1.52u as=0 ps=0 w=0.42u l=1u
X814 VSS.t2919 VDD VSS.t2917 VSS.t2918 sg13_lv_nmos ad=79.8f pd=0.8u as=0 ps=0 w=0.42u l=1u
X815 VDD VSS.t620 VDD VDD sg13_lv_pmos ad=0.19p pd=1.38u as=0 ps=0 w=1u l=1u
X816 VSS.t614 VDD VSS.t618 VSS.t746 sg13_lv_nmos ad=79.8f pd=0.8u as=0 ps=0 w=0.42u l=1u
X817 VDD VSS.t1905 VDD VDD sg13_lv_pmos ad=0.19p pd=1.38u as=0 ps=0 w=1u l=1u
X818 VSS.t2739 VDD VSS.t2737 VSS.t2620 sg13_lv_nmos ad=0.1428p pd=1.52u as=0 ps=0 w=0.42u l=1u
X819 VDD VSS.t2484 VDD VDD sg13_lv_pmos ad=0.34p pd=2.68u as=0 ps=0 w=1u l=1u
X820 VDD VSS.t2673 VDD VDD sg13_lv_pmos ad=0.19p pd=1.38u as=0 ps=0 w=1u l=1u
X821 VSS.t2320 VDD VSS.t2319 VSS.t2318 sg13_lv_nmos ad=0.1428p pd=1.52u as=0 ps=0 w=0.42u l=1u
X822 VDD VSS.t791 VDD VDD sg13_lv_pmos ad=0.34p pd=2.68u as=0 ps=0 w=1u l=1u
X823 VSS.t1223 VDD VSS.t1222 VSS.t224 sg13_lv_nmos ad=0.1428p pd=1.52u as=0 ps=0 w=0.42u l=1u
X824 VSS.t2093 VDD VSS.t2092 VSS.t2091 sg13_lv_nmos ad=0.1428p pd=1.52u as=0 ps=0 w=0.42u l=1u
X825 VDD VSS.t1588 VDD VDD sg13_lv_pmos ad=0.19p pd=1.38u as=0 ps=0 w=1u l=1u
X826 VDD VSS.t956 VDD VDD sg13_lv_pmos ad=0.34p pd=2.68u as=0 ps=0 w=1u l=1u
X827 VSS.t1476 VDD VSS.t1478 VSS.t1477 sg13_lv_nmos ad=79.8f pd=0.8u as=0 ps=0 w=0.42u l=1u
X828 VSS.t2385 VDD VSS.t2387 VSS.t2386 sg13_lv_nmos ad=79.8f pd=0.8u as=0 ps=0 w=0.42u l=1u
X829 VDD VSS.t387 VDD VDD sg13_lv_pmos ad=0.34p pd=2.68u as=0 ps=0 w=1u l=1u
X830 sg13cmos5l_buf_16_2.A a_15790_15238# VDD VDD sg13_lv_pmos ad=0.2128p pd=1.5u as=0.2128p ps=1.5u w=1.12u l=0.13u
X831 VSS.t827 VDD VSS.t826 VSS.t825 sg13_lv_nmos ad=0.1428p pd=1.52u as=0 ps=0 w=0.42u l=1u
X832 VDD VSS.t1183 VDD VDD sg13_lv_pmos ad=0.19p pd=1.38u as=0 ps=0 w=1u l=1u
X833 VDD VSS.t1960 VDD VDD sg13_lv_pmos ad=0.19p pd=1.38u as=0 ps=0 w=1u l=1u
X834 VSS.t1340 VDD VSS.t1183 VSS.t224 sg13_lv_nmos ad=79.8f pd=0.8u as=0 ps=0 w=0.42u l=1u
X835 VSS.t1606 VDD VSS.t1605 VSS.t1604 sg13_lv_nmos ad=0.1428p pd=1.52u as=0 ps=0 w=0.42u l=1u
X836 VSS.t3137 VDD VSS.t3136 VSS.t3135 sg13_lv_nmos ad=0.1428p pd=1.52u as=0 ps=0 w=0.42u l=1u
X837 VDD VSS.t2279 VDD VDD sg13_lv_pmos ad=0.34p pd=2.68u as=0 ps=0 w=1u l=1u
X838 VDD VSS.t636 VDD VDD sg13_lv_pmos ad=0.34p pd=2.68u as=0 ps=0 w=1u l=1u
X839 VSS.t2681 VDD VSS.t2682 VSS.t2620 sg13_lv_nmos ad=79.8f pd=0.8u as=0 ps=0 w=0.42u l=1u
X840 VSS.t1888 VDD VSS.t1887 VSS.t1886 sg13_lv_nmos ad=0.1428p pd=1.52u as=0 ps=0 w=0.42u l=1u
X841 VDD VSS.t629 VDD VDD sg13_lv_pmos ad=0.19p pd=1.38u as=0 ps=0 w=1u l=1u
X842 VDD VSS.t1019 VDD VDD sg13_lv_pmos ad=0.19p pd=1.38u as=0 ps=0 w=1u l=1u
X843 a_10991_15311# a_10149_15213# a_10897_15311# VSS.t239 sg13_lv_nmos ad=0.12665p pd=1.145u as=0.1428p ps=1.52u w=0.42u l=0.13u
X844 VSS.t1601 VDD VSS.t1600 VSS.t1599 sg13_lv_nmos ad=0.1428p pd=1.52u as=0 ps=0 w=0.42u l=1u
X845 sg13cmos5l_xnor2_1_1.A sg13cmos5l_dlygate4sd3_1_8.X VDD VDD sg13_lv_pmos ad=0.3808p pd=2.92u as=0.3808p ps=2.92u w=1.12u l=0.13u
X846 VDD VSS.t73 VDD VDD sg13_lv_pmos ad=0.19p pd=1.38u as=0 ps=0 w=1u l=1u
X847 VDD VSS.t142 VDD VDD sg13_lv_pmos ad=0.19p pd=1.38u as=0 ps=0 w=1u l=1u
X848 VSS.t9 a_22330_15202# a_22049_15424# VSS.t8 sg13_lv_nmos ad=79.8f pd=0.8u as=0.1428p ps=1.52u w=0.42u l=0.5u
X849 VSS.t201 VDD VSS.t201 VSS.t727 sg13_lv_nmos ad=0.1428p pd=1.52u as=0 ps=0 w=0.42u l=1u
X850 VDD VSS.t946 VDD VDD sg13_lv_pmos ad=0.34p pd=2.68u as=0 ps=0 w=1u l=1u
X851 VSS.t1237 VDD VSS.t1236 VSS.t224 sg13_lv_nmos ad=0.1428p pd=1.52u as=0 ps=0 w=0.42u l=1u
X852 VSS.t1516 VDD VSS.t1518 VSS.t1517 sg13_lv_nmos ad=79.8f pd=0.8u as=0 ps=0 w=0.42u l=1u
X853 VDD VSS.t3041 VDD VDD sg13_lv_pmos ad=0.34p pd=2.68u as=0 ps=0 w=1u l=1u
X854 VDD VSS.t2244 VDD VDD sg13_lv_pmos ad=0.34p pd=2.68u as=0 ps=0 w=1u l=1u
X855 VDD sg13cmos5l_dfrbpq_1_2.RESET_B a_16042_13945# VDD sg13_lv_pmos ad=0.1563p pd=1.22u as=0.147p ps=1.54u w=0.42u l=0.13u
X856 VSS.t2679 VDD VSS.t2680 VSS.t2620 sg13_lv_nmos ad=79.8f pd=0.8u as=0 ps=0 w=0.42u l=1u
X857 VDD VSS.t2417 VDD VDD sg13_lv_pmos ad=0.19p pd=1.38u as=0 ps=0 w=1u l=1u
X858 VDD VSS.t2644 VDD VDD sg13_lv_pmos ad=0.19p pd=1.38u as=0 ps=0 w=1u l=1u
X859 VDD VSS.t268 VDD VDD sg13_lv_pmos ad=0.19p pd=1.38u as=0 ps=0 w=1u l=1u
X860 VDD VSS.t559 VDD VDD sg13_lv_pmos ad=0.19p pd=1.38u as=0 ps=0 w=1u l=1u
X861 VDD VSS.t1952 VDD VDD sg13_lv_pmos ad=0.34p pd=2.68u as=0 ps=0 w=1u l=1u
X862 VDD VSS.t540 VDD VDD sg13_lv_pmos ad=0.34p pd=2.68u as=0 ps=0 w=1u l=1u
X863 VSS.t982 VDD VSS.t981 VSS.t980 sg13_lv_nmos ad=0.1428p pd=1.52u as=0 ps=0 w=0.42u l=1u
X864 VDD VSS.t1540 VDD VDD sg13_lv_pmos ad=0.34p pd=2.68u as=0 ps=0 w=1u l=1u
X865 VDD sg13cmos5l_xnor2_1_0.A sg13cmos5l_nand4_1_0.Y VDD sg13_lv_pmos ad=0.3808p pd=2.92u as=0.2128p ps=1.5u w=1.12u l=0.13u
X866 VSS.t1165 VDD VSS.t1164 VSS.t224 sg13_lv_nmos ad=0.1428p pd=1.52u as=0 ps=0 w=0.42u l=1u
X867 VSS.t1273 VDD VSS.t1274 VSS.t224 sg13_lv_nmos ad=79.8f pd=0.8u as=0 ps=0 w=0.42u l=1u
X868 VDD VSS.t1595 VDD VDD sg13_lv_pmos ad=0.34p pd=2.68u as=0 ps=0 w=1u l=1u
X869 sg13cmos5l_buf_16_2.A a_15790_15238# VDD VDD sg13_lv_pmos ad=0.2128p pd=1.5u as=0.2128p ps=1.5u w=1.12u l=0.13u
X870 VSS.t2977 VDD VSS.t2979 VSS.t2978 sg13_lv_nmos ad=79.8f pd=0.8u as=0 ps=0 w=0.42u l=1u
X871 VSS.t2340 VDD VSS.t2339 VSS.t2338 sg13_lv_nmos ad=0.1428p pd=1.52u as=0 ps=0 w=0.42u l=1u
X872 VSS.t917 VDD VSS.t919 VSS.t918 sg13_lv_nmos ad=79.8f pd=0.8u as=0 ps=0 w=0.42u l=1u
X873 VSS.t2693 VDD VSS.t2694 VSS.t2620 sg13_lv_nmos ad=79.8f pd=0.8u as=0 ps=0 w=0.42u l=1u
X874 VDD VSS.t986 VDD VDD sg13_lv_pmos ad=0.34p pd=2.68u as=0 ps=0 w=1u l=1u
X875 VDD VSS.t2656 VDD VDD sg13_lv_pmos ad=0.34p pd=2.68u as=0 ps=0 w=1u l=1u
X876 VSS.t37 a_7919_14845# a_8586_14484# VSS.t36 sg13_lv_nmos ad=0.1406p pd=1.12u as=0.2516p ps=2.16u w=0.74u l=0.13u
X877 VSS.t2768 VDD VSS.t2769 VSS.t2620 sg13_lv_nmos ad=79.8f pd=0.8u as=0 ps=0 w=0.42u l=1u
X878 VDD a_19150_15423# sg13cmos5l_dlygate4sd3_1_10.X VDD sg13_lv_pmos ad=0.2254p pd=1.53u as=0.4256p ps=3u w=1.12u l=0.13u
X879 a_26661_13701# sg13cmos5l_buf_16_2.X VSS.t54 VSS.t53 sg13_lv_nmos ad=0.2516p pd=2.16u as=10.4325p ps=68.31u w=0.74u l=0.13u
X880 VDD VSS.t1218 VDD VDD sg13_lv_pmos ad=0.19p pd=1.38u as=0 ps=0 w=1u l=1u
X881 VSS.t3249 clock_i a_15790_15238# VSS.t3248 sg13_lv_nmos ad=0.1406p pd=1.12u as=0.1406p ps=1.12u w=0.74u l=0.13u
X882 VDD a_12524_15960# counter_value_o[2] VDD sg13_lv_pmos ad=0.2114p pd=1.54u as=0.42p ps=2.99u w=1.12u l=0.13u
X883 VSS.t537 VDD VSS.t537 VSS.t538 sg13_lv_nmos ad=79.8f pd=0.8u as=0 ps=0 w=0.42u l=1u
X884 VSS.t567 VDD VSS.t566 VSS.t565 sg13_lv_nmos ad=0.1428p pd=1.52u as=0 ps=0 w=0.42u l=1u
X885 VDD VSS.t909 VDD VDD sg13_lv_pmos ad=0.19p pd=1.38u as=0 ps=0 w=1u l=1u
X886 VDD VSS.t1266 VDD VDD sg13_lv_pmos ad=0.34p pd=2.68u as=0 ps=0 w=1u l=1u
X887 VDD VSS.t2664 VDD VDD sg13_lv_pmos ad=0.19p pd=1.38u as=0 ps=0 w=1u l=1u
X888 VDD VSS.t2769 VDD VDD sg13_lv_pmos ad=0.34p pd=2.68u as=0 ps=0 w=1u l=1u
X889 VSS.t2305 VDD VSS.t2304 VSS.t2303 sg13_lv_nmos ad=0.1428p pd=1.52u as=0 ps=0 w=0.42u l=1u
X890 VDD VSS.t2067 VDD VDD sg13_lv_pmos ad=0.34p pd=2.68u as=0 ps=0 w=1u l=1u
X891 VSS.t705 sg13cmos5l_buf_16_2.A a_19534_13726# VSS.t3316 sg13_lv_nmos ad=0.1406p pd=1.12u as=0.1406p ps=1.12u w=0.74u l=0.13u
X892 VSS.t1250 VDD VSS.t1249 VSS.t224 sg13_lv_nmos ad=0.1428p pd=1.52u as=0 ps=0 w=0.42u l=1u
X893 VSS.t1918 VDD VSS.t1920 VSS.t1919 sg13_lv_nmos ad=79.8f pd=0.8u as=0 ps=0 w=0.42u l=1u
X894 VDD VSS.t2637 VDD VDD sg13_lv_pmos ad=0.19p pd=1.38u as=0 ps=0 w=1u l=1u
X895 VSS.t1858 VDD VSS.t1857 VSS.t1856 sg13_lv_nmos ad=0.1428p pd=1.52u as=0 ps=0 w=0.42u l=1u
X896 sg13cmos5l_dlygate4sd3_1_8.X a_18582_15302# VSS.t66 VSS.t65 sg13_lv_nmos ad=0.2516p pd=2.16u as=0.1426p ps=1.16u w=0.74u l=0.13u
X897 a_7442_16362# sg13cmos5l_buf_1_0.X VSS.t168 VSS.t167 sg13_lv_nmos ad=0.1406p pd=1.12u as=0.2886p ps=2.26u w=0.74u l=0.13u
X898 VDD VSS.t620 VDD VDD sg13_lv_pmos ad=0.34p pd=2.68u as=0 ps=0 w=1u l=1u
X899 VSS.t609 VDD VSS.t609 VSS.t612 sg13_lv_nmos ad=79.8f pd=0.8u as=0 ps=0 w=0.42u l=1u
X900 VSS.t1461 VDD VSS.t1463 VSS.t1462 sg13_lv_nmos ad=79.8f pd=0.8u as=0 ps=0 w=0.42u l=1u
X901 VSS.t827 VDD VSS.t826 VSS.t825 sg13_lv_nmos ad=0.1428p pd=1.52u as=0 ps=0 w=0.42u l=1u
X902 VSS.t1255 VDD VSS.t1254 VSS.t224 sg13_lv_nmos ad=0.1428p pd=1.52u as=0 ps=0 w=0.42u l=1u
X903 VSS.t2646 VDD VSS.t2647 VSS.t2620 sg13_lv_nmos ad=79.8f pd=0.8u as=0 ps=0 w=0.42u l=1u
X904 VSS.t2370 VDD VSS.t2372 VSS.t2371 sg13_lv_nmos ad=79.8f pd=0.8u as=0 ps=0 w=0.42u l=1u
X905 VSS.t446 VDD VSS.t446 VSS.t2 sg13_lv_nmos ad=0.1428p pd=1.52u as=0 ps=0 w=0.42u l=1u
X906 VDD VSS.t784 VDD VDD sg13_lv_pmos ad=0.19p pd=1.38u as=0 ps=0 w=1u l=1u
X907 VDD VSS.t1227 VDD VDD sg13_lv_pmos ad=0.19p pd=1.38u as=0 ps=0 w=1u l=1u
X908 VDD VSS.t2904 VDD VDD sg13_lv_pmos ad=0.19p pd=1.38u as=0 ps=0 w=1u l=1u
X909 VDD VSS.t1945 VDD VDD sg13_lv_pmos ad=0.19p pd=1.38u as=0 ps=0 w=1u l=1u
X910 VSS.t596 VDD VSS.t598 VSS.t597 sg13_lv_nmos ad=79.8f pd=0.8u as=0 ps=0 w=0.42u l=1u
X911 VDD VSS.t1897 VDD VDD sg13_lv_pmos ad=0.34p pd=2.68u as=0 ps=0 w=1u l=1u
X912 VDD VSS.t2729 VDD VDD sg13_lv_pmos ad=0.34p pd=2.68u as=0 ps=0 w=1u l=1u
X913 VSS.t2778 VDD VSS.t2777 VSS.t2620 sg13_lv_nmos ad=0.1428p pd=1.52u as=0 ps=0 w=0.42u l=1u
X914 VDD VSS.t2647 VDD VDD sg13_lv_pmos ad=0.34p pd=2.68u as=0 ps=0 w=1u l=1u
X915 sg13cmos5l_buf_1_10.X a_1192_9948# VSS.t225 VSS.t224 sg13_lv_nmos ad=0.2886p pd=2.26u as=0.14875p ps=1.16u w=0.74u l=0.13u
X916 VDD VSS.t1190 VDD VDD sg13_lv_pmos ad=0.34p pd=2.68u as=0 ps=0 w=1u l=1u
X917 VSS.t2922 VDD VSS.t2924 VSS.t2923 sg13_lv_nmos ad=79.8f pd=0.8u as=0 ps=0 w=0.42u l=1u
X918 sg13cmos5l_a21oi_1_2.Y sg13cmos5l_dlygate4sd3_1_19.X a_24915_15260# VSS.t8 sg13_lv_nmos ad=0.1406p pd=1.12u as=0.1406p ps=1.12u w=0.74u l=0.13u
X919 VDD VSS.t876 VDD VDD sg13_lv_pmos ad=0.34p pd=2.68u as=0 ps=0 w=1u l=1u
X920 VSS.t1195 VDD VSS.t1194 VSS.t224 sg13_lv_nmos ad=0.1428p pd=1.52u as=0 ps=0 w=0.42u l=1u
X921 a_25115_15996# sg13cmos5l_or3_1_1.X VDD VDD sg13_lv_pmos ad=0.3808p pd=2.92u as=0.2128p ps=1.5u w=1.12u l=0.13u
X922 VSS.t572 VDD VSS.t571 VSS.t570 sg13_lv_nmos ad=0.1428p pd=1.52u as=0 ps=0 w=0.42u l=1u
X923 VDD VSS.t2454 VDD VDD sg13_lv_pmos ad=0.34p pd=2.68u as=0 ps=0 w=1u l=1u
X924 VDD VSS.t991 VDD VDD sg13_lv_pmos ad=0.34p pd=2.68u as=0 ps=0 w=1u l=1u
X925 VDD VSS.t2676 VDD VDD sg13_lv_pmos ad=0.19p pd=1.38u as=0 ps=0 w=1u l=1u
X926 VSS.t2702 VDD VSS.t2700 VSS.t2620 sg13_lv_nmos ad=0.1428p pd=1.52u as=0 ps=0 w=0.42u l=1u
X927 VSS.t2325 VDD VSS.t2324 VSS.t2323 sg13_lv_nmos ad=0.1428p pd=1.52u as=0 ps=0 w=0.42u l=1u
X928 VSS.t455 VDD VSS.t450 VSS.t2 sg13_lv_nmos ad=0.1428p pd=1.52u as=0 ps=0 w=0.42u l=1u
X929 VDD VSS.t2229 VDD VDD sg13_lv_pmos ad=0.34p pd=2.68u as=0 ps=0 w=1u l=1u
X930 VDD VSS.t442 VDD VDD sg13_lv_pmos ad=0.19p pd=1.38u as=0 ps=0 w=1u l=1u
X931 VSS.t1681 VDD VSS.t1680 VSS.t1679 sg13_lv_nmos ad=0.1428p pd=1.52u as=0 ps=0 w=0.42u l=1u
X932 VSS.t2063 VDD VSS.t2062 VSS.t2061 sg13_lv_nmos ad=0.1428p pd=1.52u as=0 ps=0 w=0.42u l=1u
X933 a_20964_14488# a_20938_14452# VDD VDD sg13_lv_pmos ad=0.34p pd=2.68u as=0.36237p ps=2.605u w=1u l=0.13u
X934 VDD VSS.t1583 VDD VDD sg13_lv_pmos ad=0.19p pd=1.38u as=0 ps=0 w=1u l=1u
X935 VSS.t2776 VDD VSS.t2775 VSS.t2620 sg13_lv_nmos ad=0.1428p pd=1.52u as=0 ps=0 w=0.42u l=1u
X936 VSS.t2670 VDD VSS.t2671 VSS.t2620 sg13_lv_nmos ad=79.8f pd=0.8u as=0 ps=0 w=0.42u l=1u
X937 VDD VSS.t1593 VDD VDD sg13_lv_pmos ad=0.19p pd=1.38u as=0 ps=0 w=1u l=1u
X938 VSS.t982 VDD VSS.t981 VSS.t980 sg13_lv_nmos ad=0.1428p pd=1.52u as=0 ps=0 w=0.42u l=1u
X939 VSS.t1027 VDD VSS.t1026 VSS.t1025 sg13_lv_nmos ad=0.1428p pd=1.52u as=0 ps=0 w=0.42u l=1u
X940 VDD sg13cmos5l_dfrbpq_1_3.RESET_B a_17222_14922# VDD sg13_lv_pmos ad=0.36237p pd=2.605u as=79.8f ps=0.8u w=0.42u l=0.13u
X941 VSS.t600 VDD VSS.t601 VSS.t703 sg13_lv_nmos ad=0.1428p pd=1.52u as=0 ps=0 w=0.42u l=1u
X942 VSS.t917 VDD VSS.t919 VSS.t918 sg13_lv_nmos ad=79.8f pd=0.8u as=0 ps=0 w=0.42u l=1u
X943 VDD VSS.t1207 VDD VDD sg13_lv_pmos ad=0.34p pd=2.68u as=0 ps=0 w=1u l=1u
X944 VSS.t1300 VDD VSS.t1301 VSS.t224 sg13_lv_nmos ad=79.8f pd=0.8u as=0 ps=0 w=0.42u l=1u
X945 VDD sg13cmos5l_o21ai_1_3.B1 sg13cmos5l_o21ai_1_3.Y VDD sg13_lv_pmos ad=0.3808p pd=2.92u as=0.2128p ps=1.5u w=1.12u l=0.15u
X946 VDD VSS.t1185 VDD VDD sg13_lv_pmos ad=0.19p pd=1.38u as=0 ps=0 w=1u l=1u
X947 VDD VSS.t2749 VDD VDD sg13_lv_pmos ad=0.19p pd=1.38u as=0 ps=0 w=1u l=1u
X948 VDD VSS.t1965 VDD VDD sg13_lv_pmos ad=0.19p pd=1.38u as=0 ps=0 w=1u l=1u
X949 VDD a_12212_15202# sg13cmos5l_dfrbpq_1_2.CLK VDD sg13_lv_pmos ad=0.2128p pd=1.5u as=0.2128p ps=1.5u w=1.12u l=0.13u
X950 VSS.t586 VDD VSS.t585 VSS.t584 sg13_lv_nmos ad=0.1428p pd=1.52u as=0 ps=0 w=0.42u l=1u
X951 VSS.t1611 VDD VSS.t1610 VSS.t1609 sg13_lv_nmos ad=0.1428p pd=1.52u as=0 ps=0 w=0.42u l=1u
X952 VSS.t3142 VDD VSS.t3141 VSS.t3140 sg13_lv_nmos ad=0.1428p pd=1.52u as=0 ps=0 w=0.42u l=1u
X953 VDD VSS.t2284 VDD VDD sg13_lv_pmos ad=0.34p pd=2.68u as=0 ps=0 w=1u l=1u
X954 VSS.t2684 VDD VSS.t2685 VSS.t2620 sg13_lv_nmos ad=79.8f pd=0.8u as=0 ps=0 w=0.42u l=1u
X955 VSS.t228 a_25978_15202# a_25697_15424# VSS.t280 sg13_lv_nmos ad=79.8f pd=0.8u as=0.1428p ps=1.52u w=0.42u l=0.5u
X956 VDD VSS.t1031 VDD VDD sg13_lv_pmos ad=0.34p pd=2.68u as=0 ps=0 w=1u l=1u
X957 VSS.t1893 VDD VSS.t1892 VSS.t1891 sg13_lv_nmos ad=0.1428p pd=1.52u as=0 ps=0 w=0.42u l=1u
X958 VSS.t2907 VDD VSS.t2909 VSS.t2908 sg13_lv_nmos ad=79.8f pd=0.8u as=0 ps=0 w=0.42u l=1u
X959 VSS.t2760 VDD VSS.t2760 VSS.t2620 sg13_lv_nmos ad=79.8f pd=0.8u as=0 ps=0 w=0.42u l=1u
X960 VDD VSS.t1244 VDD VDD sg13_lv_pmos ad=0.19p pd=1.38u as=0 ps=0 w=1u l=1u
X961 VSS.t1319 VDD VSS.t1319 VSS.t224 sg13_lv_nmos ad=79.8f pd=0.8u as=0 ps=0 w=0.42u l=1u
X962 VDD VSS.t2297 VDD VDD sg13_lv_pmos ad=0.19p pd=1.38u as=0 ps=0 w=1u l=1u
X963 VDD VSS.t954 VDD VDD sg13_lv_pmos ad=0.19p pd=1.38u as=0 ps=0 w=1u l=1u
X964 VDD VSS.t1257 VDD VDD sg13_lv_pmos ad=0.34p pd=2.68u as=0 ps=0 w=1u l=1u
X965 VSS.t1521 VDD VSS.t1523 VSS.t1522 sg13_lv_nmos ad=79.8f pd=0.8u as=0 ps=0 w=0.42u l=1u
X966 VDD VSS.t2760 VDD VDD sg13_lv_pmos ad=0.34p pd=2.68u as=0 ps=0 w=1u l=1u
X967 VSS.t2682 VDD VSS.t2682 VSS.t2620 sg13_lv_nmos ad=79.8f pd=0.8u as=0 ps=0 w=0.42u l=1u
X968 VDD VSS.t2422 VDD VDD sg13_lv_pmos ad=0.19p pd=1.38u as=0 ps=0 w=1u l=1u
X969 VSS.t2083 VDD VSS.t2082 VSS.t2081 sg13_lv_nmos ad=0.1428p pd=1.52u as=0 ps=0 w=0.42u l=1u
X970 VSS.t1903 VDD VSS.t1905 VSS.t1904 sg13_lv_nmos ad=79.8f pd=0.8u as=0 ps=0 w=0.42u l=1u
X971 VSS.t837 VDD VSS.t839 VSS.t838 sg13_lv_nmos ad=79.8f pd=0.8u as=0 ps=0 w=0.42u l=1u
X972 VDD VSS.t2628 VDD VDD sg13_lv_pmos ad=0.19p pd=1.38u as=0 ps=0 w=1u l=1u
X973 VSS.t1843 VDD VSS.t1842 VSS.t1841 sg13_lv_nmos ad=0.1428p pd=1.52u as=0 ps=0 w=0.42u l=1u
X974 VSS.t1442 VDD VSS.t1324 VSS.t224 sg13_lv_nmos ad=79.8f pd=0.8u as=0 ps=0 w=0.42u l=1u
X975 VSS.t2937 VDD VSS.t2936 VSS.t2935 sg13_lv_nmos ad=0.1428p pd=1.52u as=0 ps=0 w=0.42u l=1u
X976 VSS.t636 VDD VSS.t636 VSS.t637 sg13_lv_nmos ad=79.8f pd=0.8u as=0 ps=0 w=0.42u l=1u
X977 VDD VSS.t1314 VDD VDD sg13_lv_pmos ad=0.34p pd=2.68u as=0 ps=0 w=1u l=1u
X978 VSS.t446 VDD VSS.t446 VSS.t2 sg13_lv_nmos ad=0.1428p pd=1.52u as=0 ps=0 w=0.42u l=1u
X979 VDD VSS.t1046 VDD VDD sg13_lv_pmos ad=0.34p pd=2.68u as=0 ps=0 w=1u l=1u
X980 VDD VSS.t2682 VDD VDD sg13_lv_pmos ad=0.34p pd=2.68u as=0 ps=0 w=1u l=1u
X981 VDD VSS.t1922 VDD VDD sg13_lv_pmos ad=0.34p pd=2.68u as=0 ps=0 w=1u l=1u
X982 VDD VSS.t2107 VDD VDD sg13_lv_pmos ad=0.34p pd=2.68u as=0 ps=0 w=1u l=1u
X983 a_25129_13726# sg13cmos5l_o21ai_1_2.A1 VSS.t187 VSS.t262 sg13_lv_nmos ad=0.198p pd=1.27u as=0.1045p ps=0.93u w=0.55u l=0.13u
X984 VSS.t216 sg13cmos5l_dlygate4sd3_1_10.X a_16163_16265# VSS.t3201 sg13_lv_nmos ad=0.1045p pd=0.93u as=0.198p ps=1.27u w=0.55u l=0.13u
X985 VSS.t106 a_8870_15238# a_8982_15302# VSS.t243 sg13_lv_nmos ad=0.1426p pd=1.16u as=0.1428p ps=1.52u w=0.42u l=0.5u
X986 VDD VSS.t1605 VDD VDD sg13_lv_pmos ad=0.34p pd=2.68u as=0 ps=0 w=1u l=1u
X987 VDD VSS.t1882 VDD VDD sg13_lv_pmos ad=0.34p pd=2.68u as=0 ps=0 w=1u l=1u
X988 VDD VSS.t2719 VDD VDD sg13_lv_pmos ad=0.34p pd=2.68u as=0 ps=0 w=1u l=1u
X989 VSS.t236 VDD VSS.t236 VSS.t723 sg13_lv_nmos ad=0.1428p pd=1.52u as=0 ps=0 w=0.42u l=1u
X990 VSS.t2751 VDD VSS.t2751 VSS.t2620 sg13_lv_nmos ad=79.8f pd=0.8u as=0 ps=0 w=0.42u l=1u
X991 VDD sg13cmos5l_xor2_1_1.B a_6932_12972# VDD sg13_lv_pmos ad=0.2128p pd=1.5u as=0.2128p ps=1.5u w=1.12u l=0.13u
X992 VDD VSS.t921 VDD VDD sg13_lv_pmos ad=0.34p pd=2.68u as=0 ps=0 w=1u l=1u
X993 VSS.t729 VDD VSS.t731 VSS.t730 sg13_lv_nmos ad=79.8f pd=0.8u as=0 ps=0 w=0.42u l=1u
X994 VSS.t2693 VDD VSS.t2692 VSS.t2620 sg13_lv_nmos ad=0.1428p pd=1.52u as=0 ps=0 w=0.42u l=1u
X995 VSS.t2310 VDD VSS.t2309 VSS.t2308 sg13_lv_nmos ad=0.1428p pd=1.52u as=0 ps=0 w=0.42u l=1u
X996 a_21252_14909# a_21483_14495# a_20938_14452# VSS.t292 sg13_lv_nmos ad=0.2373p pd=1.97u as=79.8f ps=0.8u w=0.42u l=0.13u
X997 VSS.t620 VDD VSS.t620 VSS.t748 sg13_lv_nmos ad=79.8f pd=0.8u as=0 ps=0 w=0.42u l=1u
X998 VSS.t2768 VDD VSS.t2767 VSS.t2620 sg13_lv_nmos ad=0.1428p pd=1.52u as=0 ps=0 w=0.42u l=1u
X999 VSS.t2033 VDD VSS.t2035 VSS.t2034 sg13_lv_nmos ad=79.8f pd=0.8u as=0 ps=0 w=0.42u l=1u
X1000 a_20678_14922# sg13cmos5l_dfrbpq_1_6.D VDD VDD sg13_lv_pmos ad=79.8f pd=0.8u as=0.1428p ps=1.52u w=0.42u l=0.13u
X1001 VSS.t1027 VDD VSS.t1026 VSS.t1025 sg13_lv_nmos ad=0.1428p pd=1.52u as=0 ps=0 w=0.42u l=1u
X1002 VDD VSS.t579 VDD VDD sg13_lv_pmos ad=0.19p pd=1.38u as=0 ps=0 w=1u l=1u
X1003 VSS.t1466 VDD VSS.t1468 VSS.t1467 sg13_lv_nmos ad=79.8f pd=0.8u as=0 ps=0 w=0.42u l=1u
X1004 VDD VSS.t2344 VDD VDD sg13_lv_pmos ad=0.34p pd=2.68u as=0 ps=0 w=1u l=1u
X1005 VSS.t2649 VDD VSS.t2650 VSS.t2620 sg13_lv_nmos ad=79.8f pd=0.8u as=0 ps=0 w=0.42u l=1u
X1006 VSS.t2375 VDD VSS.t2377 VSS.t2376 sg13_lv_nmos ad=79.8f pd=0.8u as=0 ps=0 w=0.42u l=1u
X1007 VDD sg13cmos5l_xnor2_1_1.A a_16314_14484# VDD sg13_lv_pmos ad=0.2891p pd=1.695u as=0.1428p ps=1.375u w=1.12u l=0.13u
X1008 VDD VSS.t1585 VDD VDD sg13_lv_pmos ad=0.34p pd=2.68u as=0 ps=0 w=1u l=1u
X1009 VSS.t1953 VDD VSS.t1952 VSS.t1951 sg13_lv_nmos ad=0.1428p pd=1.52u as=0 ps=0 w=0.42u l=1u
X1010 a_27706_15202# sg13cmos5l_dfrbpq_1_7.Q VDD VDD sg13_lv_pmos ad=0.1428p pd=1.52u as=0.1523p ps=1.38u w=0.42u l=0.13u
X1011 VDD VSS.t1177 VDD VDD sg13_lv_pmos ad=0.19p pd=1.38u as=0 ps=0 w=1u l=1u
X1012 VDD VSS.t1950 VDD VDD sg13_lv_pmos ad=0.19p pd=1.38u as=0 ps=0 w=1u l=1u
X1013 VSS.t3240 sg13cmos5l_xnor2_1_0.Y a_3512_16037# VSS.t3239 sg13_lv_nmos ad=79.8f pd=0.8u as=0.1428p ps=1.52u w=0.42u l=0.13u
X1014 VSS.t1216 VDD VSS.t1367 VSS.t224 sg13_lv_nmos ad=0.1428p pd=1.52u as=0 ps=0 w=0.42u l=1u
X1015 VSS.t1596 VDD VSS.t1595 VSS.t1594 sg13_lv_nmos ad=0.1428p pd=1.52u as=0 ps=0 w=0.42u l=1u
X1016 VSS.t81 VDD VSS.t83 VSS.t485 sg13_lv_nmos ad=79.8f pd=0.8u as=0 ps=0 w=0.42u l=1u
X1017 VDD VSS.t1867 VDD VDD sg13_lv_pmos ad=0.34p pd=2.68u as=0 ps=0 w=1u l=1u
X1018 VDD VSS.t1309 VDD VDD sg13_lv_pmos ad=0.34p pd=2.68u as=0 ps=0 w=1u l=1u
X1019 VDD VSS.t2650 VDD VDD sg13_lv_pmos ad=0.34p pd=2.68u as=0 ps=0 w=1u l=1u
X1020 VDD VSS.t2711 VDD VDD sg13_lv_pmos ad=0.34p pd=2.68u as=0 ps=0 w=1u l=1u
X1021 VSS.t79 a_21466_15960# a_21185_16262# VSS.t3243 sg13_lv_nmos ad=79.8f pd=0.8u as=0.1428p ps=1.52u w=0.42u l=0.5u
X1022 a_12524_15960# sg13cmos5l_dlygate4sd3_1_11.A VSS.t275 VSS.t3238 sg13_lv_nmos ad=0.187p pd=1.78u as=0.14875p ps=1.16u w=0.55u l=0.13u
X1023 VDD VSS.t1289 VDD VDD sg13_lv_pmos ad=0.19p pd=1.38u as=0 ps=0 w=1u l=1u
X1024 VDD VSS.t2662 VDD VDD sg13_lv_pmos ad=0.19p pd=1.38u as=0 ps=0 w=1u l=1u
X1025 VSS.t947 VDD VSS.t946 VSS.t945 sg13_lv_nmos ad=0.1428p pd=1.52u as=0 ps=0 w=0.42u l=1u
X1026 VDD VSS.t2459 VDD VDD sg13_lv_pmos ad=0.34p pd=2.68u as=0 ps=0 w=1u l=1u
X1027 VSS.t837 VDD VSS.t839 VSS.t838 sg13_lv_nmos ad=79.8f pd=0.8u as=0 ps=0 w=0.42u l=1u
X1028 VSS.t1235 VDD VSS.t1234 VSS.t224 sg13_lv_nmos ad=0.1428p pd=1.52u as=0 ps=0 w=0.42u l=1u
X1029 VSS.t2 a_26469_14495# a_26571_14495# VSS.t181 sg13_lv_nmos ad=5.4903p pd=35.61u as=0.2516p ps=2.16u w=0.74u l=0.13u
X1030 a_19173_16033# a_19173_16033# VSS.t73 VSS.t3209 sg13_lv_nmos ad=0.111p pd=1.34u as=6.38822p ps=41.325u w=0.3u l=0.13u
X1031 VSS.t1686 VDD VSS.t1685 VSS.t1684 sg13_lv_nmos ad=0.1428p pd=1.52u as=0 ps=0 w=0.42u l=1u
X1032 VSS.t2673 VDD VSS.t2674 VSS.t2620 sg13_lv_nmos ad=79.8f pd=0.8u as=0 ps=0 w=0.42u l=1u
X1033 VSS.t2068 VDD VSS.t2067 VSS.t2066 sg13_lv_nmos ad=0.1428p pd=1.52u as=0 ps=0 w=0.42u l=1u
X1034 VSS.t2779 VDD VSS.t2778 VSS.t2620 sg13_lv_nmos ad=0.1428p pd=1.52u as=0 ps=0 w=0.42u l=1u
X1035 VSS.t193 VDD VSS.t193 VSS.t408 sg13_lv_nmos ad=79.8f pd=0.8u as=0 ps=0 w=0.42u l=1u
X1036 sg13cmos5l_o21ai_1_2.A2 sg13cmos5l_dfrbpq_1_2.Q a_23864_14850# VSS.t7 sg13_lv_nmos ad=0.2516p pd=2.16u as=0.1406p ps=1.12u w=0.74u l=0.13u
X1037 VDD a_19534_13726# sg13cmos5l_buf_16_2.X VDD sg13_lv_pmos ad=0.2128p pd=1.5u as=0.2128p ps=1.5u w=1.12u l=0.13u
X1038 VSS.t1451 VDD VSS.t1453 VSS.t1452 sg13_lv_nmos ad=79.8f pd=0.8u as=0 ps=0 w=0.42u l=1u
X1039 VDD VSS.t2502 VDD VDD sg13_lv_pmos ad=0.19p pd=1.38u as=0 ps=0 w=1u l=1u
X1040 VDD VSS.t109 VDD VDD sg13_lv_pmos ad=0.34p pd=2.68u as=0 ps=0 w=1u l=1u
X1041 VSS.t694 VDD VSS.t696 VSS.t695 sg13_lv_nmos ad=79.8f pd=0.8u as=0 ps=0 w=0.42u l=1u
X1042 a_25080_12952# sg13cmos5l_o21ai_1_2.A1 VDD VDD sg13_lv_pmos ad=0.2128p pd=1.5u as=0.3808p ps=2.92u w=1.12u l=0.15u
X1043 VSS.t1163 VDD VSS.t225 VSS.t224 sg13_lv_nmos ad=0.1428p pd=1.52u as=0 ps=0 w=0.42u l=1u
X1044 VDD VSS.t1907 VDD VDD sg13_lv_pmos ad=0.34p pd=2.68u as=0 ps=0 w=1u l=1u
X1045 VDD VSS.t2821 VDD VDD sg13_lv_pmos ad=0.34p pd=2.68u as=0 ps=0 w=1u l=1u
X1046 VSS.t1271 VDD VSS.t1272 VSS.t224 sg13_lv_nmos ad=79.8f pd=0.8u as=0 ps=0 w=0.42u l=1u
X1047 VSS.t1192 VDD VSS.t1193 VSS.t224 sg13_lv_nmos ad=79.8f pd=0.8u as=0 ps=0 w=0.42u l=1u
X1048 VDD VSS.t1935 VDD VDD sg13_lv_pmos ad=0.19p pd=1.38u as=0 ps=0 w=1u l=1u
X1049 VSS.t567 VDD VSS.t569 VSS.t568 sg13_lv_nmos ad=79.8f pd=0.8u as=0 ps=0 w=0.42u l=1u
X1050 VDD VSS.t1169 VDD VDD sg13_lv_pmos ad=0.19p pd=1.38u as=0 ps=0 w=1u l=1u
X1051 VDD VSS.t2289 VDD VDD sg13_lv_pmos ad=0.34p pd=2.68u as=0 ps=0 w=1u l=1u
X1052 VDD a_27310_15423# sg13cmos5l_o21ai_1_2.B1 VDD sg13_lv_pmos ad=0.2254p pd=1.53u as=0.4256p ps=3u w=1.12u l=0.13u
X1053 VDD a_7354_13690# a_7073_13912# VDD sg13_lv_pmos ad=0.1523p pd=1.38u as=0.34p ps=2.68u w=1u l=0.5u
X1054 VSS.t185 VDD VSS.t555 VSS.t554 sg13_lv_nmos ad=79.8f pd=0.8u as=0 ps=0 w=0.42u l=1u
X1055 VDD VSS.t54 VDD VDD sg13_lv_pmos ad=0.19p pd=1.38u as=0 ps=0 w=1u l=1u
X1056 VSS.t540 VDD VSS.t540 VSS.t656 sg13_lv_nmos ad=0.1428p pd=1.52u as=0 ps=0 w=0.42u l=1u
X1057 VDD VSS.t543 VDD VDD sg13_lv_pmos ad=0.34p pd=2.68u as=0 ps=0 w=1u l=1u
X1058 VDD VSS.t1039 VDD VDD sg13_lv_pmos ad=0.19p pd=1.38u as=0 ps=0 w=1u l=1u
X1059 VDD VSS.t1590 VDD VDD sg13_lv_pmos ad=0.34p pd=2.68u as=0 ps=0 w=1u l=1u
X1060 VSS.t1481 VDD VSS.t1480 VSS.t1479 sg13_lv_nmos ad=0.1428p pd=1.52u as=0 ps=0 w=0.42u l=1u
X1061 VSS.t1898 VDD VSS.t1897 VSS.t1896 sg13_lv_nmos ad=0.1428p pd=1.52u as=0 ps=0 w=0.42u l=1u
X1062 VSS.t398 VDD VSS.t398 VSS.t399 sg13_lv_nmos ad=79.8f pd=0.8u as=0 ps=0 w=0.42u l=1u
X1063 VDD VSS.t3034 VDD VDD sg13_lv_pmos ad=0.19p pd=1.38u as=0 ps=0 w=1u l=1u
X1064 VSS.t2658 VDD VSS.t2657 VSS.t2620 sg13_lv_nmos ad=0.1428p pd=1.52u as=0 ps=0 w=0.42u l=1u
X1065 VSS.t2390 VDD VSS.t2389 VSS.t2388 sg13_lv_nmos ad=0.1428p pd=1.52u as=0 ps=0 w=0.42u l=1u
X1066 VDD sg13cmos5l_dfrbpq_1_2.Q a_18200_15238# VDD sg13_lv_pmos ad=0.1523p pd=1.38u as=0.1428p ps=1.52u w=0.42u l=0.13u
X1067 VSS.t2723 VDD VSS.t2724 VSS.t2620 sg13_lv_nmos ad=79.8f pd=0.8u as=0 ps=0 w=0.42u l=1u
X1068 VSS.t77 sg13cmos5l_dlygate4sd3_1_1.X sg13cmos5l_dfrbpq_1_1.D VSS.t76 sg13_lv_nmos ad=0.2516p pd=2.16u as=0.1406p ps=1.12u w=0.74u l=0.13u
X1069 VDD VSS.t966 VDD VDD sg13_lv_pmos ad=0.34p pd=2.68u as=0 ps=0 w=1u l=1u
X1070 VSS.t434 VDD VSS.t434 VSS.t2 sg13_lv_nmos ad=0.1428p pd=1.52u as=0 ps=0 w=0.42u l=1u
X1071 a_22061_14020# sg13cmos5l_or3_1_2.B a_21959_14020# VDD sg13_lv_pmos ad=0.1575p pd=1.315u as=0.19p ps=1.38u w=1u l=0.13u
X1072 VDD VSS.t1448 VDD VDD sg13_lv_pmos ad=0.19p pd=1.38u as=0 ps=0 w=1u l=1u
X1073 VDD a_25006_14751# sg13cmos5l_dlygate4sd3_1_19.X VDD sg13_lv_pmos ad=0.2254p pd=1.53u as=0.4256p ps=3u w=1.12u l=0.13u
X1074 VSS.t596 VDD VSS.t598 VSS.t597 sg13_lv_nmos ad=79.8f pd=0.8u as=0 ps=0 w=0.42u l=1u
X1075 a_11410_15234# sg13cmos5l_tiehi_0.L_HI VSS.t469 VSS.t3216 sg13_lv_nmos ad=37.8f pd=0.6u as=79.8f ps=0.8u w=0.42u l=0.13u
X1076 VSS.t718 a_19534_13726# sg13cmos5l_buf_16_2.X VSS.t3303 sg13_lv_nmos ad=0.1406p pd=1.12u as=0.1406p ps=1.12u w=0.74u l=0.13u
X1077 VDD VSS.t2631 VDD VDD sg13_lv_pmos ad=0.19p pd=1.38u as=0 ps=0 w=1u l=1u
X1078 VSS.t2942 VDD VSS.t2941 VSS.t2940 sg13_lv_nmos ad=0.1428p pd=1.52u as=0 ps=0 w=0.42u l=1u
X1079 VSS.t288 a_21370_15202# a_21089_15424# VSS.t3269 sg13_lv_nmos ad=79.8f pd=0.8u as=0.1428p ps=1.52u w=0.42u l=0.5u
X1080 VSS.t572 VDD VSS.t571 VSS.t570 sg13_lv_nmos ad=0.1428p pd=1.52u as=0 ps=0 w=0.42u l=1u
X1081 VDD VSS.t579 VDD VDD sg13_lv_pmos ad=0.19p pd=1.38u as=0 ps=0 w=1u l=1u
X1082 VDD VSS.t1295 VDD VDD sg13_lv_pmos ad=0.34p pd=2.68u as=0 ps=0 w=1u l=1u
X1083 VSS.t1581 VDD VSS.t1583 VSS.t1582 sg13_lv_nmos ad=79.8f pd=0.8u as=0 ps=0 w=0.42u l=1u
X1084 VSS.t3112 VDD VSS.t3114 VSS.t3113 sg13_lv_nmos ad=79.8f pd=0.8u as=0 ps=0 w=0.42u l=1u
X1085 VSS.t1253 VDD VSS.t1252 VSS.t224 sg13_lv_nmos ad=0.1428p pd=1.52u as=0 ps=0 w=0.42u l=1u
X1086 VSS.t1176 VDD VSS.t1176 VSS.t224 sg13_lv_nmos ad=0.1428p pd=1.52u as=0 ps=0 w=0.42u l=1u
X1087 VSS.t1973 VDD VSS.t1972 VSS.t1971 sg13_lv_nmos ad=0.1428p pd=1.52u as=0 ps=0 w=0.42u l=1u
X1088 VDD a_19534_13726# sg13cmos5l_buf_16_2.X VDD sg13_lv_pmos ad=0.2128p pd=1.5u as=0.2128p ps=1.5u w=1.12u l=0.13u
X1089 VDD VSS.t841 VDD VDD sg13_lv_pmos ad=0.34p pd=2.68u as=0 ps=0 w=1u l=1u
X1090 VSS.t1285 VDD VSS.t1286 VSS.t224 sg13_lv_nmos ad=79.8f pd=0.8u as=0 ps=0 w=0.42u l=1u
X1091 VSS.t2640 VDD VSS.t2641 VSS.t2620 sg13_lv_nmos ad=79.8f pd=0.8u as=0 ps=0 w=0.42u l=1u
X1092 VDD VSS.t1927 VDD VDD sg13_lv_pmos ad=0.34p pd=2.68u as=0 ps=0 w=1u l=1u
X1093 VDD VSS.t2112 VDD VDD sg13_lv_pmos ad=0.34p pd=2.68u as=0 ps=0 w=1u l=1u
X1094 a_26278_14909# sg13cmos5l_dfrbpq_1_7.RESET_B VSS.t228 VSS.t230 sg13_lv_nmos ad=37.8f pd=0.6u as=0.1701p ps=1.65u w=0.42u l=0.13u
X1095 VSS.t2505 VDD VSS.t2507 VSS.t2506 sg13_lv_nmos ad=79.8f pd=0.8u as=0 ps=0 w=0.42u l=1u
X1096 VDD VSS.t430 VDD VDD sg13_lv_pmos ad=0.19p pd=1.38u as=0 ps=0 w=1u l=1u
X1097 VDD VSS.t1610 VDD VDD sg13_lv_pmos ad=0.34p pd=2.68u as=0 ps=0 w=1u l=1u
X1098 VDD VSS.t2641 VDD VDD sg13_lv_pmos ad=0.34p pd=2.68u as=0 ps=0 w=1u l=1u
X1099 VSS.t1883 VDD VSS.t1882 VSS.t1881 sg13_lv_nmos ad=0.1428p pd=1.52u as=0 ps=0 w=0.42u l=1u
X1100 VSS.t947 VDD VSS.t946 VSS.t945 sg13_lv_nmos ad=0.1428p pd=1.52u as=0 ps=0 w=0.42u l=1u
X1101 VSS.t549 VDD VSS.t549 VSS.t550 sg13_lv_nmos ad=79.8f pd=0.8u as=0 ps=0 w=0.42u l=1u
X1102 a_19534_13726# sg13cmos5l_buf_16_2.A VDD VDD sg13_lv_pmos ad=0.2128p pd=1.5u as=0.2128p ps=1.5u w=1.12u l=0.13u
X1103 VSS.t586 VDD VSS.t585 VSS.t584 sg13_lv_nmos ad=0.1428p pd=1.52u as=0 ps=0 w=0.42u l=1u
X1104 VDD VSS.t2759 VDD VDD sg13_lv_pmos ad=0.34p pd=2.68u as=0 ps=0 w=1u l=1u
X1105 VSS.t2696 VDD VSS.t2694 VSS.t2620 sg13_lv_nmos ad=0.1428p pd=1.52u as=0 ps=0 w=0.42u l=1u
X1106 a_24502_13718# sg13cmos5l_o21ai_1_2.A2 VSS.t201 VSS.t200 sg13_lv_nmos ad=0.1406p pd=1.12u as=0.1406p ps=1.12u w=0.74u l=0.15u
X1107 VSS.t715 a_19534_13726# sg13cmos5l_buf_16_2.X VSS.t3299 sg13_lv_nmos ad=0.1406p pd=1.12u as=0.1406p ps=1.12u w=0.74u l=0.13u
X1108 VSS.t2771 VDD VSS.t2770 VSS.t2620 sg13_lv_nmos ad=0.1428p pd=1.52u as=0 ps=0 w=0.42u l=1u
X1109 VSS.t2038 VDD VSS.t2040 VSS.t2039 sg13_lv_nmos ad=79.8f pd=0.8u as=0 ps=0 w=0.42u l=1u
X1110 VDD VSS.t356 VDD VDD sg13_lv_pmos ad=0.34p pd=2.68u as=0 ps=0 w=1u l=1u
X1111 VDD VSS.t996 VDD VDD sg13_lv_pmos ad=0.34p pd=2.68u as=0 ps=0 w=1u l=1u
X1112 VSS.t1267 VDD VSS.t1266 VSS.t224 sg13_lv_nmos ad=0.1428p pd=1.52u as=0 ps=0 w=0.42u l=1u
X1113 VDD VSS.t1202 VDD VDD sg13_lv_pmos ad=0.19p pd=1.38u as=0 ps=0 w=1u l=1u
X1114 VDD VSS.t2706 VDD VDD sg13_lv_pmos ad=0.19p pd=1.38u as=0 ps=0 w=1u l=1u
X1115 VSS.t2375 VDD VSS.t2374 VSS.t2373 sg13_lv_nmos ad=0.1428p pd=1.52u as=0 ps=0 w=0.42u l=1u
X1116 VDD VSS.t804 VDD VDD sg13_lv_pmos ad=0.19p pd=1.38u as=0 ps=0 w=1u l=1u
X1117 VDD VSS.t2314 VDD VDD sg13_lv_pmos ad=0.34p pd=2.68u as=0 ps=0 w=1u l=1u
X1118 VSS.t236 VDD VSS.t236 VSS.t722 sg13_lv_nmos ad=79.8f pd=0.8u as=0 ps=0 w=0.42u l=1u
X1119 VDD VSS.t2487 VDD VDD sg13_lv_pmos ad=0.19p pd=1.38u as=0 ps=0 w=1u l=1u
X1120 VSS.t86 a_14549_15238# sg13cmos5l_or3_1_2.B VSS.t85 sg13_lv_nmos ad=0.2516p pd=2.16u as=0.1406p ps=1.12u w=0.74u l=0.13u
X1121 VDD VSS.t1239 VDD VDD sg13_lv_pmos ad=0.19p pd=1.38u as=0 ps=0 w=1u l=1u
X1122 VDD VSS.t2439 VDD VDD sg13_lv_pmos ad=0.34p pd=2.68u as=0 ps=0 w=1u l=1u
X1123 VDD VSS.t1920 VDD VDD sg13_lv_pmos ad=0.19p pd=1.38u as=0 ps=0 w=1u l=1u
X1124 VSS.t1923 VDD VSS.t1922 VSS.t1921 sg13_lv_nmos ad=0.1428p pd=1.52u as=0 ps=0 w=0.42u l=1u
X1125 VDD VSS.t2097 VDD VDD sg13_lv_pmos ad=0.34p pd=2.68u as=0 ps=0 w=1u l=1u
X1126 a_15790_15238# clock_i VSS.t86 VSS.t3247 sg13_lv_nmos ad=0.1406p pd=1.12u as=0.1406p ps=1.12u w=0.74u l=0.13u
X1127 VDD VSS.t2274 VDD VDD sg13_lv_pmos ad=0.34p pd=2.68u as=0 ps=0 w=1u l=1u
X1128 VSS.t116 a_27503_13799# a_28170_14020# VSS.t190 sg13_lv_nmos ad=0.1406p pd=1.12u as=0.2516p ps=2.16u w=0.74u l=0.13u
X1129 VSS.t1032 VDD VSS.t1031 VSS.t1030 sg13_lv_nmos ad=0.1428p pd=1.52u as=0 ps=0 w=0.42u l=1u
X1130 VDD VSS.t2653 VDD VDD sg13_lv_pmos ad=0.34p pd=2.68u as=0 ps=0 w=1u l=1u
X1131 VSS.t1303 VDD VSS.t1304 VSS.t224 sg13_lv_nmos ad=79.8f pd=0.8u as=0 ps=0 w=0.42u l=1u
X1132 VDD VSS.t2045 VDD VDD sg13_lv_pmos ad=0.19p pd=1.38u as=0 ps=0 w=1u l=1u
X1133 VSS.t591 VDD VSS.t590 VSS.t589 sg13_lv_nmos ad=0.1428p pd=1.52u as=0 ps=0 w=0.42u l=1u
X1134 VSS.t614 VDD VSS.t618 VSS.t617 sg13_lv_nmos ad=79.8f pd=0.8u as=0 ps=0 w=0.42u l=1u
X1135 VSS.t185 VDD VSS.t555 VSS.t668 sg13_lv_nmos ad=79.8f pd=0.8u as=0 ps=0 w=0.42u l=1u
X1136 VDD VSS.t896 VDD VDD sg13_lv_pmos ad=0.34p pd=2.68u as=0 ps=0 w=1u l=1u
X1137 VDD VSS.t1166 VDD VDD sg13_lv_pmos ad=0.19p pd=1.38u as=0 ps=0 w=1u l=1u
X1138 VDD VSS.t874 VDD VDD sg13_lv_pmos ad=0.19p pd=1.38u as=0 ps=0 w=1u l=1u
X1139 VSS.t2649 VDD VSS.t2647 VSS.t2620 sg13_lv_nmos ad=0.1428p pd=1.52u as=0 ps=0 w=0.42u l=1u
X1140 VDD VSS.t2665 VDD VDD sg13_lv_pmos ad=0.19p pd=1.38u as=0 ps=0 w=1u l=1u
X1141 a_5694_15486# a_5495_15549# VSS.t2 VSS.t3230 sg13_lv_nmos ad=0.27427p pd=2.28u as=5.4903p ps=35.61u w=0.795u l=0.13u
X1142 VSS.t2713 VDD VSS.t2715 VSS.t2620 sg13_lv_nmos ad=79.8f pd=0.8u as=0 ps=0 w=0.42u l=1u
X1143 a_3782_15996# a_3512_16037# VDD VDD sg13_lv_pmos ad=0.34p pd=2.68u as=0.1523p ps=1.38u w=1u l=0.5u
X1144 a_19534_13726# sg13cmos5l_buf_16_2.A VDD VDD sg13_lv_pmos ad=0.2128p pd=1.5u as=0.3808p ps=2.92u w=1.12u l=0.13u
X1145 VDD VSS.t2906 VDD VDD sg13_lv_pmos ad=0.34p pd=2.68u as=0 ps=0 w=1u l=1u
X1146 a_20122_15238# sg13cmos5l_dfrbpq_1_3.Q VSS.t277 VSS.t65 sg13_lv_nmos ad=0.1406p pd=1.12u as=0.2516p ps=2.16u w=0.74u l=0.13u
X1147 VDD VSS.t126 VDD VDD sg13_lv_pmos ad=0.34p pd=2.68u as=0 ps=0 w=1u l=1u
X1148 VSS.t73 a_19049_16334# a_18970_16237# VSS.t3257 sg13_lv_nmos ad=6.38822p pd=41.325u as=0.27427p ps=2.28u w=0.795u l=0.13u
X1149 VDD VSS.t771 VDD VDD sg13_lv_pmos ad=0.34p pd=2.68u as=0 ps=0 w=1u l=1u
X1150 VDD VSS.t959 VDD VDD sg13_lv_pmos ad=0.19p pd=1.38u as=0 ps=0 w=1u l=1u
X1151 VSS.t2927 VDD VSS.t2926 VSS.t2925 sg13_lv_nmos ad=0.1428p pd=1.52u as=0 ps=0 w=0.42u l=1u
X1152 VSS.t1047 VDD VSS.t1046 VSS.t1045 sg13_lv_nmos ad=0.1428p pd=1.52u as=0 ps=0 w=0.42u l=1u
X1153 sg13cmos5l_o21ai_1_2.A1 a_15208_15996# VDD VDD sg13_lv_pmos ad=0.42p pd=2.99u as=0.2114p ps=1.54u w=1.12u l=0.13u
X1154 VSS.t1312 VDD VSS.t1313 VSS.t224 sg13_lv_nmos ad=79.8f pd=0.8u as=0 ps=0 w=0.42u l=1u
X1155 VDD VSS.t2472 VDD VDD sg13_lv_pmos ad=0.19p pd=1.38u as=0 ps=0 w=1u l=1u
X1156 VSS.t63 a_17710_16263# sg13cmos5l_a21oi_1_0.A1 VSS.t3308 sg13_lv_nmos ad=0.1426p pd=1.16u as=0.2516p ps=2.16u w=0.74u l=0.13u
X1157 VDD VSS.t1912 VDD VDD sg13_lv_pmos ad=0.34p pd=2.68u as=0 ps=0 w=1u l=1u
X1158 VDD VSS.t2676 VDD VDD sg13_lv_pmos ad=0.34p pd=2.68u as=0 ps=0 w=1u l=1u
X1159 VSS.t636 VDD VSS.t54 VSS.t639 sg13_lv_nmos ad=79.8f pd=0.8u as=0 ps=0 w=0.42u l=1u
X1160 VDD VSS.t1172 VDD VDD sg13_lv_pmos ad=0.19p pd=1.38u as=0 ps=0 w=1u l=1u
X1161 VSS.t483 sg13cmos5l_buf_16_2.A a_12212_15202# VSS.t3314 sg13_lv_nmos ad=0.2516p pd=2.16u as=0.1406p ps=1.12u w=0.74u l=0.13u
X1162 VSS.t1586 VDD VSS.t1585 VSS.t1584 sg13_lv_nmos ad=0.1428p pd=1.52u as=0 ps=0 w=0.42u l=1u
X1163 VSS.t3117 VDD VSS.t3116 VSS.t3115 sg13_lv_nmos ad=0.1428p pd=1.52u as=0 ps=0 w=0.42u l=1u
X1164 VDD VSS.t2259 VDD VDD sg13_lv_pmos ad=0.34p pd=2.68u as=0 ps=0 w=1u l=1u
X1165 VSS.t2490 VDD VSS.t2492 VSS.t2491 sg13_lv_nmos ad=79.8f pd=0.8u as=0 ps=0 w=0.42u l=1u
X1166 VDD VSS.t537 VDD VDD sg13_lv_pmos ad=0.34p pd=2.68u as=0 ps=0 w=1u l=1u
X1167 VDD VSS.t1595 VDD VDD sg13_lv_pmos ad=0.34p pd=2.68u as=0 ps=0 w=1u l=1u
X1168 VDD VSS.t1257 VDD VDD sg13_lv_pmos ad=0.19p pd=1.38u as=0 ps=0 w=1u l=1u
X1169 VSS.t1486 VDD VSS.t1485 VSS.t1484 sg13_lv_nmos ad=0.1428p pd=1.52u as=0 ps=0 w=0.42u l=1u
X1170 VSS.t2395 VDD VSS.t2394 VSS.t2393 sg13_lv_nmos ad=0.1428p pd=1.52u as=0 ps=0 w=0.42u l=1u
X1171 VSS.t1868 VDD VSS.t1867 VSS.t1866 sg13_lv_nmos ad=0.1428p pd=1.52u as=0 ps=0 w=0.42u l=1u
X1172 VSS.t1656 VDD VSS.t1658 VSS.t1657 sg13_lv_nmos ad=79.8f pd=0.8u as=0 ps=0 w=0.42u l=1u
X1173 VSS.t1205 VDD VSS.t1206 VSS.t224 sg13_lv_nmos ad=79.8f pd=0.8u as=0 ps=0 w=0.42u l=1u
X1174 VDD VSS.t1967 VDD VDD sg13_lv_pmos ad=0.34p pd=2.68u as=0 ps=0 w=1u l=1u
X1175 sg13cmos5l_nand4_1_0.Y sg13cmos5l_buf_1_0.X VDD VDD sg13_lv_pmos ad=0.2128p pd=1.5u as=0.3808p ps=2.92u w=1.12u l=0.13u
X1176 VDD VSS.t614 VDD VDD sg13_lv_pmos ad=0.34p pd=2.68u as=0 ps=0 w=1u l=1u
X1177 VDD VSS.t2749 VDD VDD sg13_lv_pmos ad=0.34p pd=2.68u as=0 ps=0 w=1u l=1u
X1178 VSS.t2360 VDD VSS.t2362 VSS.t2361 sg13_lv_nmos ad=79.8f pd=0.8u as=0 ps=0 w=0.42u l=1u
X1179 VDD clock_i a_15790_15238# VDD sg13_lv_pmos ad=0.2128p pd=1.5u as=0.2128p ps=1.5u w=1.12u l=0.13u
X1180 VSS.t21 a_15790_15238# sg13cmos5l_buf_16_2.A VSS.t31 sg13_lv_nmos ad=0.2516p pd=2.16u as=0.1406p ps=1.12u w=0.74u l=0.13u
X1181 VDD VSS.t3099 VDD VDD sg13_lv_pmos ad=0.19p pd=1.38u as=0 ps=0 w=1u l=1u
X1182 a_16485_13701# sg13cmos5l_dfrbpq_1_2.CLK VDD VDD sg13_lv_pmos ad=0.4088p pd=2.97u as=2.3367p ps=15.135u w=1.12u l=0.13u
X1183 VDD VSS.t926 VDD VDD sg13_lv_pmos ad=0.34p pd=2.68u as=0 ps=0 w=1u l=1u
X1184 VSS.t733 VDD VSS.t735 VSS.t734 sg13_lv_nmos ad=79.8f pd=0.8u as=0 ps=0 w=0.42u l=1u
X1185 VSS.t2667 VDD VSS.t2668 VSS.t2620 sg13_lv_nmos ad=79.8f pd=0.8u as=0 ps=0 w=0.42u l=1u
X1186 VDD VSS.t2634 VDD VDD sg13_lv_pmos ad=0.19p pd=1.38u as=0 ps=0 w=1u l=1u
X1187 VSS.t1294 VDD VSS.t1292 VSS.t224 sg13_lv_nmos ad=0.1428p pd=1.52u as=0 ps=0 w=0.42u l=1u
X1188 VSS.t2912 VDD VSS.t2911 VSS.t2910 sg13_lv_nmos ad=0.1428p pd=1.52u as=0 ps=0 w=0.42u l=1u
X1189 VDD VSS.t1298 VDD VDD sg13_lv_pmos ad=0.34p pd=2.68u as=0 ps=0 w=1u l=1u
X1190 VDD VSS.t2299 VDD VDD sg13_lv_pmos ad=0.34p pd=2.68u as=0 ps=0 w=1u l=1u
X1191 VDD VSS.t620 VDD VDD sg13_lv_pmos ad=0.34p pd=2.68u as=0 ps=0 w=1u l=1u
X1192 VDD VSS.t2668 VDD VDD sg13_lv_pmos ad=0.34p pd=2.68u as=0 ps=0 w=1u l=1u
X1193 VSS.t1032 VDD VSS.t1031 VSS.t1030 sg13_lv_nmos ad=0.1428p pd=1.52u as=0 ps=0 w=0.42u l=1u
X1194 VDD VSS.t2424 VDD VDD sg13_lv_pmos ad=0.34p pd=2.68u as=0 ps=0 w=1u l=1u
X1195 a_3123_14484# sg13cmos5l_xnor2_1_0.A VDD VDD sg13_lv_pmos ad=0.1428p pd=1.375u as=0.2891p ps=1.695u w=1.12u l=0.13u
X1196 VDD VSS.t2082 VDD VDD sg13_lv_pmos ad=0.34p pd=2.68u as=0 ps=0 w=1u l=1u
X1197 VSS.t135 a_12212_15202# sg13cmos5l_dfrbpq_1_2.CLK VSS.t134 sg13_lv_nmos ad=0.1406p pd=1.12u as=0.1406p ps=1.12u w=0.74u l=0.13u
X1198 VDD VSS.t2644 VDD VDD sg13_lv_pmos ad=0.34p pd=2.68u as=0 ps=0 w=1u l=1u
X1199 VDD VSS.t941 VDD VDD sg13_lv_pmos ad=0.34p pd=2.68u as=0 ps=0 w=1u l=1u
X1200 VSS.t92 VDD VSS.t92 VSS.t2 sg13_lv_nmos ad=79.8f pd=0.8u as=0 ps=0 w=0.42u l=1u
X1201 VSS.t567 VDD VSS.t569 VSS.t568 sg13_lv_nmos ad=79.8f pd=0.8u as=0 ps=0 w=0.42u l=1u
X1202 VDD VSS.t2762 VDD VDD sg13_lv_pmos ad=0.34p pd=2.68u as=0 ps=0 w=1u l=1u
X1203 VDD VSS.t1178 VDD VDD sg13_lv_pmos ad=0.34p pd=2.68u as=0 ps=0 w=1u l=1u
X1204 VSS.t2699 VDD VSS.t2698 VSS.t2620 sg13_lv_nmos ad=0.1428p pd=1.52u as=0 ps=0 w=0.42u l=1u
X1205 VSS.t629 VDD VSS.t632 VSS.t757 sg13_lv_nmos ad=79.8f pd=0.8u as=0 ps=0 w=0.42u l=1u
X1206 VSS.t1446 VDD VSS.t1448 VSS.t1447 sg13_lv_nmos ad=79.8f pd=0.8u as=0 ps=0 w=0.42u l=1u
X1207 VSS.t1047 VDD VSS.t1046 VSS.t1045 sg13_lv_nmos ad=0.1428p pd=1.52u as=0 ps=0 w=0.42u l=1u
X1208 VDD VSS.t1004 VDD VDD sg13_lv_pmos ad=0.19p pd=1.38u as=0 ps=0 w=1u l=1u
X1209 VSS.t952 VDD VSS.t954 VSS.t953 sg13_lv_nmos ad=79.8f pd=0.8u as=0 ps=0 w=0.42u l=1u
X1210 VDD reset_n_i a_1192_9948# VDD sg13_lv_pmos ad=0.2114p pd=1.54u as=0.2856p ps=2.36u w=0.84u l=0.13u
X1211 VDD VSS.t1578 VDD VDD sg13_lv_pmos ad=0.19p pd=1.38u as=0 ps=0 w=1u l=1u
X1212 VSS.t2754 VDD VSS.t2753 VSS.t2620 sg13_lv_nmos ad=0.1428p pd=1.52u as=0 ps=0 w=0.42u l=1u
X1213 VSS.t2008 VDD VSS.t2010 VSS.t2009 sg13_lv_nmos ad=79.8f pd=0.8u as=0 ps=0 w=0.42u l=1u
X1214 VDD VSS.t629 VDD VDD sg13_lv_pmos ad=0.34p pd=2.68u as=0 ps=0 w=1u l=1u
X1215 VDD VSS.t2319 VDD VDD sg13_lv_pmos ad=0.34p pd=2.68u as=0 ps=0 w=1u l=1u
X1216 VDD VSS.t73 VDD VDD sg13_lv_pmos ad=0.34p pd=2.68u as=0 ps=0 w=1u l=1u
X1217 VDD VSS.t1583 VDD VDD sg13_lv_pmos ad=0.19p pd=1.38u as=0 ps=0 w=1u l=1u
X1218 VDD VSS.t147 VDD VDD sg13_lv_pmos ad=0.34p pd=2.68u as=0 ps=0 w=1u l=1u
X1219 VSS.t1928 VDD VSS.t1927 VSS.t1926 sg13_lv_nmos ad=0.1428p pd=1.52u as=0 ps=0 w=0.42u l=1u
X1220 VDD VSS.t1321 VDD VDD sg13_lv_pmos ad=0.34p pd=2.68u as=0 ps=0 w=1u l=1u
X1221 VDD VSS.t2640 VDD VDD sg13_lv_pmos ad=0.34p pd=2.68u as=0 ps=0 w=1u l=1u
X1222 VSS.t128 a_12212_15202# sg13cmos5l_dfrbpq_1_2.CLK VSS.t129 sg13_lv_nmos ad=0.1406p pd=1.12u as=0.1406p ps=1.12u w=0.74u l=0.13u
X1223 sg13cmos5l_dfrbpq_1_3.D a_17142_16020# VSS.t63 VSS.t62 sg13_lv_nmos ad=0.2516p pd=2.16u as=0.1426p ps=1.16u w=0.74u l=0.13u
X1224 VSS.t382 VDD VSS.t382 VSS.t383 sg13_lv_nmos ad=79.8f pd=0.8u as=0 ps=0 w=0.42u l=1u
X1225 a_26052_14488# a_26026_14452# VSS.t228 VSS.t3286 sg13_lv_nmos ad=0.2516p pd=2.16u as=0.1626p ps=1.415u w=0.74u l=0.13u
X1226 VSS.t1666 VDD VSS.t1665 VSS.t1664 sg13_lv_nmos ad=0.1428p pd=1.52u as=0 ps=0 w=0.42u l=1u
X1227 VSS.t1471 VDD VSS.t1470 VSS.t1469 sg13_lv_nmos ad=0.1428p pd=1.52u as=0 ps=0 w=0.42u l=1u
X1228 VSS.t2380 VDD VSS.t2379 VSS.t2378 sg13_lv_nmos ad=0.1428p pd=1.52u as=0 ps=0 w=0.42u l=1u
X1229 VSS.t2652 VDD VSS.t2651 VSS.t2620 sg13_lv_nmos ad=0.1428p pd=1.52u as=0 ps=0 w=0.42u l=1u
X1230 VSS.t2717 VDD VSS.t2718 VSS.t2620 sg13_lv_nmos ad=79.8f pd=0.8u as=0 ps=0 w=0.42u l=1u
X1231 VSS.t2972 VDD VSS.t2971 VSS.t2970 sg13_lv_nmos ad=0.1428p pd=1.52u as=0 ps=0 w=0.42u l=1u
X1232 a_4366_14751# a_4481_14750# VSS.t158 VSS.t157 sg13_lv_nmos ad=0.1428p pd=1.52u as=0.1426p ps=1.16u w=0.42u l=0.5u
X1233 a_6958_13911# a_7073_13912# VDD VDD sg13_lv_pmos ad=0.34p pd=2.68u as=0.2254p ps=1.53u w=1u l=0.5u
X1234 VSS.t2345 VDD VSS.t2347 VSS.t2346 sg13_lv_nmos ad=79.8f pd=0.8u as=0 ps=0 w=0.42u l=1u
X1235 VDD VSS.t3084 VDD VDD sg13_lv_pmos ad=0.19p pd=1.38u as=0 ps=0 w=1u l=1u
X1236 VDD VSS.t2287 VDD VDD sg13_lv_pmos ad=0.19p pd=1.38u as=0 ps=0 w=1u l=1u
X1237 VSS.t1661 VDD VSS.t1660 VSS.t1659 sg13_lv_nmos ad=0.1428p pd=1.52u as=0 ps=0 w=0.42u l=1u
X1238 VDD VSS.t974 VDD VDD sg13_lv_pmos ad=0.19p pd=1.38u as=0 ps=0 w=1u l=1u
X1239 VDD VSS.t3036 VDD VDD sg13_lv_pmos ad=0.34p pd=2.68u as=0 ps=0 w=1u l=1u
X1240 VSS.t2765 VDD VSS.t2765 VSS.t2620 sg13_lv_nmos ad=0.1428p pd=1.52u as=0 ps=0 w=0.42u l=1u
X1241 VSS.t2658 VDD VSS.t2659 VSS.t2620 sg13_lv_nmos ad=79.8f pd=0.8u as=0 ps=0 w=0.42u l=1u
X1242 VDD VSS.t2625 VDD VDD sg13_lv_pmos ad=0.19p pd=1.38u as=0 ps=0 w=1u l=1u
X1243 VSS.t434 VDD VSS.t434 VSS.t2 sg13_lv_nmos ad=79.8f pd=0.8u as=0 ps=0 w=0.42u l=1u
X1244 sg13cmos5l_xor2_1_1.B sg13cmos5l_dlygate4sd3_1_3.X VDD VDD sg13_lv_pmos ad=0.2128p pd=1.5u as=0.3808p ps=2.92u w=1.12u l=0.13u
X1245 VSS.t600 VDD VSS.t705 VSS.t704 sg13_lv_nmos ad=79.8f pd=0.8u as=0 ps=0 w=0.42u l=1u
X1246 a_6932_12972# sg13cmos5l_xor2_1_1.A VDD VDD sg13_lv_pmos ad=0.3808p pd=2.92u as=0.2128p ps=1.5u w=1.12u l=0.13u
X1247 VDD VSS.t1209 VDD VDD sg13_lv_pmos ad=0.19p pd=1.38u as=0 ps=0 w=1u l=1u
X1248 VDD VSS.t1289 VDD VDD sg13_lv_pmos ad=0.34p pd=2.68u as=0 ps=0 w=1u l=1u
X1249 VSS.t142 VDD VSS.t135 VSS.t478 sg13_lv_nmos ad=0.1428p pd=1.52u as=0 ps=0 w=0.42u l=1u
X1250 VDD VSS.t2477 VDD VDD sg13_lv_pmos ad=0.19p pd=1.38u as=0 ps=0 w=1u l=1u
X1251 VDD VSS.t2659 VDD VDD sg13_lv_pmos ad=0.34p pd=2.68u as=0 ps=0 w=1u l=1u
X1252 VSS.t1963 VDD VSS.t1962 VSS.t1961 sg13_lv_nmos ad=0.1428p pd=1.52u as=0 ps=0 w=0.42u l=1u
X1253 VDD VSS.t1917 VDD VDD sg13_lv_pmos ad=0.34p pd=2.68u as=0 ps=0 w=1u l=1u
X1254 VSS.t540 VDD VSS.t537 VSS.t539 sg13_lv_nmos ad=0.1428p pd=1.52u as=0 ps=0 w=0.42u l=1u
X1255 VSS.t2495 VDD VSS.t2497 VSS.t2496 sg13_lv_nmos ad=79.8f pd=0.8u as=0 ps=0 w=0.42u l=1u
X1256 VDD VSS.t849 VDD VDD sg13_lv_pmos ad=0.19p pd=1.38u as=0 ps=0 w=1u l=1u
X1257 VDD VSS.t2437 VDD VDD sg13_lv_pmos ad=0.19p pd=1.38u as=0 ps=0 w=1u l=1u
X1258 VSS.t1246 VDD VSS.t1244 VSS.t224 sg13_lv_nmos ad=0.1428p pd=1.52u as=0 ps=0 w=0.42u l=1u
X1259 VSS.t1456 VDD VSS.t1455 VSS.t1454 sg13_lv_nmos ad=0.1428p pd=1.52u as=0 ps=0 w=0.42u l=1u
X1260 VDD sg13cmos5l_a21oi_1_2.Y a_25496_16037# VDD sg13_lv_pmos ad=0.1523p pd=1.38u as=0.1428p ps=1.52u w=0.42u l=0.13u
X1261 a_27022_13239# a_27137_13238# VSS.t3196 VSS.t3195 sg13_lv_nmos ad=0.1428p pd=1.52u as=0.1426p ps=1.16u w=0.42u l=0.5u
X1262 VDD VSS.t430 VDD VDD sg13_lv_pmos ad=0.19p pd=1.38u as=0 ps=0 w=1u l=1u
X1263 VSS.t2707 VDD VSS.t2709 VSS.t2620 sg13_lv_nmos ad=79.8f pd=0.8u as=0 ps=0 w=0.42u l=1u
X1264 VDD VSS.t1170 VDD VDD sg13_lv_pmos ad=0.34p pd=2.68u as=0 ps=0 w=1u l=1u
X1265 VDD VSS.t1937 VDD VDD sg13_lv_pmos ad=0.34p pd=2.68u as=0 ps=0 w=1u l=1u
X1266 VDD VSS.t1228 VDD VDD sg13_lv_pmos ad=0.34p pd=2.68u as=0 ps=0 w=1u l=1u
X1267 VDD VSS.t3104 VDD VDD sg13_lv_pmos ad=0.19p pd=1.38u as=0 ps=0 w=1u l=1u
X1268 VSS.t952 VDD VSS.t954 VSS.t953 sg13_lv_nmos ad=79.8f pd=0.8u as=0 ps=0 w=0.42u l=1u
X1269 VDD VSS.t691 VDD VDD sg13_lv_pmos ad=0.19p pd=1.38u as=0 ps=0 w=1u l=1u
X1270 VSS.t997 VDD VSS.t996 VSS.t995 sg13_lv_nmos ad=0.1428p pd=1.52u as=0 ps=0 w=0.42u l=1u
X1271 VSS.t591 VDD VSS.t590 VSS.t589 sg13_lv_nmos ad=0.1428p pd=1.52u as=0 ps=0 w=0.42u l=1u
X1272 VSS.t2917 VDD VSS.t2916 VSS.t2915 sg13_lv_nmos ad=0.1428p pd=1.52u as=0 ps=0 w=0.42u l=1u
X1273 VSS.t1187 VDD VSS.t1186 VSS.t224 sg13_lv_nmos ad=0.1428p pd=1.52u as=0 ps=0 w=0.42u l=1u
X1274 VSS.t3087 VDD VSS.t3089 VSS.t3088 sg13_lv_nmos ad=79.8f pd=0.8u as=0 ps=0 w=0.42u l=1u
X1275 VSS.t2290 VDD VSS.t2292 VSS.t2291 sg13_lv_nmos ad=79.8f pd=0.8u as=0 ps=0 w=0.42u l=1u
X1276 VSS.t557 VDD VSS.t555 VSS.t556 sg13_lv_nmos ad=0.1428p pd=1.52u as=0 ps=0 w=0.42u l=1u
X1277 VDD VSS.t2304 VDD VDD sg13_lv_pmos ad=0.34p pd=2.68u as=0 ps=0 w=1u l=1u
X1278 sg13cmos5l_dfrbpq_1_2.D sg13cmos5l_nor2_1_3.B a_15818_14484# VDD sg13_lv_pmos ad=0.3808p pd=2.92u as=0.1176p ps=1.33u w=1.12u l=0.13u
X1279 VDD VSS.t552 VDD VDD sg13_lv_pmos ad=0.34p pd=2.68u as=0 ps=0 w=1u l=1u
X1280 VDD VSS.t1450 VDD VDD sg13_lv_pmos ad=0.34p pd=2.68u as=0 ps=0 w=1u l=1u
X1281 a_17482_14452# a_17925_14495# a_17222_14922# VSS.t196 sg13_lv_nmos ad=79.8f pd=0.8u as=0.1296p ps=1.52u w=0.42u l=0.13u
X1282 a_3465_15625# a_3108_15552# VDD VDD sg13_lv_pmos ad=63f pd=0.72u as=0.1563p ps=1.22u w=0.42u l=0.13u
X1283 VDD VSS.t438 VDD VDD sg13_lv_pmos ad=0.19p pd=1.38u as=0 ps=0 w=1u l=1u
X1284 VSS.t4 a_10318_14751# sg13cmos5l_dlygate4sd3_1_11.X VSS.t38 sg13_lv_nmos ad=0.1426p pd=1.16u as=0.2516p ps=2.16u w=0.74u l=0.13u
X1285 VSS.t2365 VDD VSS.t2367 VSS.t2366 sg13_lv_nmos ad=79.8f pd=0.8u as=0 ps=0 w=0.42u l=1u
X1286 VDD VSS.t2429 VDD VDD sg13_lv_pmos ad=0.34p pd=2.68u as=0 ps=0 w=1u l=1u
X1287 VSS.t1913 VDD VSS.t1912 VSS.t1911 sg13_lv_nmos ad=0.1428p pd=1.52u as=0 ps=0 w=0.42u l=1u
X1288 VSS.t2688 VDD VSS.t2687 VSS.t2620 sg13_lv_nmos ad=0.1428p pd=1.52u as=0 ps=0 w=0.42u l=1u
X1289 VDD VSS.t2632 VDD VDD sg13_lv_pmos ad=0.34p pd=2.68u as=0 ps=0 w=1u l=1u
X1290 VDD a_19436_15960# counter_value_o[3] VDD sg13_lv_pmos ad=0.2114p pd=1.54u as=0.42p ps=2.99u w=1.12u l=0.13u
X1291 VSS.t236 VDD VSS.t236 VSS.t604 sg13_lv_nmos ad=0.1428p pd=1.52u as=0 ps=0 w=0.42u l=1u
X1292 VDD VSS.t1585 VDD VDD sg13_lv_pmos ad=0.34p pd=2.68u as=0 ps=0 w=1u l=1u
X1293 VSS.t370 VDD VSS.t369 VSS.t368 sg13_lv_nmos ad=0.1428p pd=1.52u as=0 ps=0 w=0.42u l=1u
X1294 VSS.t872 VDD VSS.t874 VSS.t873 sg13_lv_nmos ad=79.8f pd=0.8u as=0 ps=0 w=0.42u l=1u
X1295 VDD VSS.t2005 VDD VDD sg13_lv_pmos ad=0.19p pd=1.38u as=0 ps=0 w=1u l=1u
X1296 sg13cmos5l_dlygate4sd3_1_3.X a_6678_15302# VDD VDD sg13_lv_pmos ad=0.4256p pd=3u as=0.2254p ps=1.53u w=1.12u l=0.13u
X1297 a_24258_15242# sg13cmos5l_dfrbpq_1_6.Q a_24156_15242# VSS.t8 sg13_lv_nmos ad=0.1406p pd=1.12u as=0.1406p ps=1.12u w=0.74u l=0.13u
X1298 VDD VSS.t1181 VDD VDD sg13_lv_pmos ad=0.34p pd=2.68u as=0 ps=0 w=1u l=1u
X1299 VDD VSS.t555 VDD VDD sg13_lv_pmos ad=0.34p pd=2.68u as=0 ps=0 w=1u l=1u
X1300 VDD VSS.t1283 VDD VDD sg13_lv_pmos ad=0.19p pd=1.38u as=0 ps=0 w=1u l=1u
X1301 VSS.t620 VDD VSS.t620 VSS.t621 sg13_lv_nmos ad=79.8f pd=0.8u as=0 ps=0 w=0.42u l=1u
X1302 VSS.t2681 VDD VSS.t2680 VSS.t2620 sg13_lv_nmos ad=0.1428p pd=1.52u as=0 ps=0 w=0.42u l=1u
X1303 VDD a_26746_16237# sg13cmos5l_dfrbpq_1_5.RESET_B VDD sg13_lv_pmos ad=2.8961p pd=18.25u as=0.3927p ps=2.99u w=1.155u l=0.13u
X1304 VDD VSS.t1016 VDD VDD sg13_lv_pmos ad=0.34p pd=2.68u as=0 ps=0 w=1u l=1u
X1305 VSS.t434 VDD VSS.t438 VSS.t2 sg13_lv_nmos ad=79.8f pd=0.8u as=0 ps=0 w=0.42u l=1u
X1306 VDD VSS.t3021 VDD VDD sg13_lv_pmos ad=0.34p pd=2.68u as=0 ps=0 w=1u l=1u
X1307 VSS.t2757 VDD VSS.t2755 VSS.t2620 sg13_lv_nmos ad=0.1428p pd=1.52u as=0 ps=0 w=0.42u l=1u
X1308 VSS.t2013 VDD VSS.t2015 VSS.t2014 sg13_lv_nmos ad=79.8f pd=0.8u as=0 ps=0 w=0.42u l=1u
X1309 VSS.t96 a_17327_13799# a_17994_14020# VSS.t95 sg13_lv_nmos ad=0.1406p pd=1.12u as=0.2516p ps=2.16u w=0.74u l=0.13u
X1310 VSS.t3107 VDD VSS.t3109 VSS.t3108 sg13_lv_nmos ad=79.8f pd=0.8u as=0 ps=0 w=0.42u l=1u
X1311 VDD VSS.t2462 VDD VDD sg13_lv_pmos ad=0.19p pd=1.38u as=0 ps=0 w=1u l=1u
X1312 VSS.t1322 VDD VSS.t1321 VSS.t224 sg13_lv_nmos ad=0.1428p pd=1.52u as=0 ps=0 w=0.42u l=1u
X1313 VDD VSS.t1643 VDD VDD sg13_lv_pmos ad=0.19p pd=1.38u as=0 ps=0 w=1u l=1u
X1314 VDD VSS.t710 VDD VDD sg13_lv_pmos ad=0.19p pd=1.38u as=0 ps=0 w=1u l=1u
X1315 VSS.t1516 VDD VSS.t1515 VSS.t1514 sg13_lv_nmos ad=0.1428p pd=1.52u as=0 ps=0 w=0.42u l=1u
X1316 VSS.t1933 VDD VSS.t1932 VSS.t1931 sg13_lv_nmos ad=0.1428p pd=1.52u as=0 ps=0 w=0.42u l=1u
X1317 VDD VSS.t2642 VDD VDD sg13_lv_pmos ad=0.34p pd=2.68u as=0 ps=0 w=1u l=1u
X1318 VSS.t1315 VDD VSS.t1316 VSS.t224 sg13_lv_nmos ad=79.8f pd=0.8u as=0 ps=0 w=0.42u l=1u
X1319 VDD VSS.t2746 VDD VDD sg13_lv_pmos ad=0.19p pd=1.38u as=0 ps=0 w=1u l=1u
X1320 VSS.t2043 VDD VSS.t2042 VSS.t2041 sg13_lv_nmos ad=0.1428p pd=1.52u as=0 ps=0 w=0.42u l=1u
X1321 VSS.t168 sg13cmos5l_buf_1_0.X a_7066_16366# VSS.t169 sg13_lv_nmos ad=0.2516p pd=2.16u as=0.1406p ps=1.12u w=0.74u l=0.13u
X1322 VSS.t387 VDD VSS.t387 VSS.t389 sg13_lv_nmos ad=0.1428p pd=1.52u as=0 ps=0 w=0.42u l=1u
X1323 VSS.t842 VDD VSS.t841 VSS.t840 sg13_lv_nmos ad=0.1428p pd=1.52u as=0 ps=0 w=0.42u l=1u
X1324 VDD VSS.t894 VDD VDD sg13_lv_pmos ad=0.19p pd=1.38u as=0 ps=0 w=1u l=1u
X1325 VDD VSS.t2332 VDD VDD sg13_lv_pmos ad=0.19p pd=1.38u as=0 ps=0 w=1u l=1u
X1326 VDD VSS.t1990 VDD VDD sg13_lv_pmos ad=0.19p pd=1.38u as=0 ps=0 w=1u l=1u
X1327 VDD VSS.t434 VDD VDD sg13_lv_pmos ad=0.19p pd=1.38u as=0 ps=0 w=1u l=1u
X1328 VSS.t2655 VDD VSS.t2653 VSS.t2620 sg13_lv_nmos ad=0.1428p pd=1.52u as=0 ps=0 w=0.42u l=1u
X1329 VSS.t303 a_2540_15960# counter_value_o[0] VSS.t3242 sg13_lv_nmos ad=0.14875p pd=1.16u as=0.2886p ps=2.26u w=0.74u l=0.13u
X1330 VSS.t2350 VDD VSS.t2352 VSS.t2351 sg13_lv_nmos ad=79.8f pd=0.8u as=0 ps=0 w=0.42u l=1u
X1331 VDD VSS.t2115 VDD VDD sg13_lv_pmos ad=0.19p pd=1.38u as=0 ps=0 w=1u l=1u
X1332 VSS.t997 VDD VSS.t996 VSS.t995 sg13_lv_nmos ad=0.1428p pd=1.52u as=0 ps=0 w=0.42u l=1u
X1333 VDD VSS.t979 VDD VDD sg13_lv_pmos ad=0.19p pd=1.38u as=0 ps=0 w=1u l=1u
X1334 VSS.t2621 enable_i a_1192_3900# VSS.t2620 sg13_lv_nmos ad=0.14875p pd=1.16u as=0.187p ps=1.78u w=0.55u l=0.13u
X1335 a_20609_15260# sg13cmos5l_dlygate4sd3_1_13.X sg13cmos5l_a21oi_1_1.Y VSS.t65 sg13_lv_nmos ad=0.1406p pd=1.12u as=0.1406p ps=1.12u w=0.74u l=0.13u
X1336 VSS.t716 VDD VSS.t715 VSS.t714 sg13_lv_nmos ad=0.1428p pd=1.52u as=0 ps=0 w=0.42u l=1u
X1337 VSS.t1208 VDD VSS.t1209 VSS.t224 sg13_lv_nmos ad=79.8f pd=0.8u as=0 ps=0 w=0.42u l=1u
X1338 VDD VSS.t1448 VDD VDD sg13_lv_pmos ad=0.19p pd=1.38u as=0 ps=0 w=1u l=1u
X1339 VSS.t303 VDD VSS.t303 VSS.t302 sg13_lv_nmos ad=0.1428p pd=1.52u as=0 ps=0 w=0.42u l=1u
X1340 VSS.t2902 VDD VSS.t2901 VSS.t2900 sg13_lv_nmos ad=0.1428p pd=1.52u as=0 ps=0 w=0.42u l=1u
X1341 VDD VSS.t395 VDD VDD sg13_lv_pmos ad=0.19p pd=1.38u as=0 ps=0 w=1u l=1u
X1342 VDD VSS.t1292 VDD VDD sg13_lv_pmos ad=0.34p pd=2.68u as=0 ps=0 w=1u l=1u
X1343 VSS.t463 VDD VSS.t462 VSS.t461 sg13_lv_nmos ad=0.1428p pd=1.52u as=0 ps=0 w=0.42u l=1u
X1344 VDD VSS.t2482 VDD VDD sg13_lv_pmos ad=0.19p pd=1.38u as=0 ps=0 w=1u l=1u
X1345 VDD VSS.t2662 VDD VDD sg13_lv_pmos ad=0.34p pd=2.68u as=0 ps=0 w=1u l=1u
X1346 VSS.t73 a_21929_16334# a_21850_16237# VSS.t3283 sg13_lv_nmos ad=6.38822p pd=41.325u as=0.27427p ps=2.28u w=0.795u l=0.13u
X1347 VDD sg13cmos5l_dfrbpq_1_3.RESET_B a_17482_14452# VDD sg13_lv_pmos ad=0.1563p pd=1.22u as=0.147p ps=1.54u w=0.42u l=0.13u
X1348 a_24359_14508# sg13cmos5l_o21ai_1_2.A2 a_24265_14508# VDD sg13_lv_pmos ad=0.19p pd=1.38u as=0.34p ps=2.68u w=1u l=0.13u
X1349 VSS.t1466 VDD VSS.t1465 VSS.t1464 sg13_lv_nmos ad=0.1428p pd=1.52u as=0 ps=0 w=0.42u l=1u
X1350 VSS.t802 VDD VSS.t804 VSS.t803 sg13_lv_nmos ad=79.8f pd=0.8u as=0 ps=0 w=0.42u l=1u
X1351 VSS.t540 VDD VSS.t543 VSS.t657 sg13_lv_nmos ad=79.8f pd=0.8u as=0 ps=0 w=0.42u l=1u
X1352 VSS.t2028 VDD VSS.t2027 VSS.t2026 sg13_lv_nmos ad=0.1428p pd=1.52u as=0 ps=0 w=0.42u l=1u
X1353 sg13cmos5l_buf_16_2.X a_19534_13726# VSS.t715 VSS.t3300 sg13_lv_nmos ad=0.1406p pd=1.12u as=0.1406p ps=1.12u w=0.74u l=0.13u
X1354 VSS.t872 VDD VSS.t874 VSS.t873 sg13_lv_nmos ad=79.8f pd=0.8u as=0 ps=0 w=0.42u l=1u
X1355 VDD VSS.t861 VDD VDD sg13_lv_pmos ad=0.34p pd=2.68u as=0 ps=0 w=1u l=1u
X1356 VDD VSS.t564 VDD VDD sg13_lv_pmos ad=0.19p pd=1.38u as=0 ps=0 w=1u l=1u
X1357 VSS.t1461 VDD VSS.t1460 VSS.t1459 sg13_lv_nmos ad=0.1428p pd=1.52u as=0 ps=0 w=0.42u l=1u
X1358 VSS.t2370 VDD VSS.t2369 VSS.t2368 sg13_lv_nmos ad=0.1428p pd=1.52u as=0 ps=0 w=0.42u l=1u
X1359 VSS.t1631 VDD VSS.t1633 VSS.t1632 sg13_lv_nmos ad=79.8f pd=0.8u as=0 ps=0 w=0.42u l=1u
X1360 VSS.t2646 VDD VSS.t2645 VSS.t2620 sg13_lv_nmos ad=0.1428p pd=1.52u as=0 ps=0 w=0.42u l=1u
X1361 VDD VSS.t193 VDD VDD sg13_lv_pmos ad=0.19p pd=1.38u as=0 ps=0 w=1u l=1u
X1362 VDD VSS.t1332 VDD VDD sg13_lv_pmos ad=0.34p pd=2.68u as=0 ps=0 w=1u l=1u
X1363 VDD VSS.t1942 VDD VDD sg13_lv_pmos ad=0.34p pd=2.68u as=0 ps=0 w=1u l=1u
X1364 a_6566_15238# a_6296_15238# VSS.t77 VSS.t240 sg13_lv_nmos ad=0.1428p pd=1.52u as=79.8f ps=0.8u w=0.42u l=0.5u
X1365 VDD VSS.t3074 VDD VDD sg13_lv_pmos ad=0.19p pd=1.38u as=0 ps=0 w=1u l=1u
X1366 VDD VSS.t2277 VDD VDD sg13_lv_pmos ad=0.19p pd=1.38u as=0 ps=0 w=1u l=1u
X1367 VSS.t21 a_15790_15238# sg13cmos5l_buf_16_2.A VSS.t25 sg13_lv_nmos ad=0.1406p pd=1.12u as=0.1406p ps=1.12u w=0.74u l=0.13u
X1368 VDD VSS.t924 VDD VDD sg13_lv_pmos ad=0.19p pd=1.38u as=0 ps=0 w=1u l=1u
X1369 VSS.t1183 VDD VSS.t1182 VSS.t224 sg13_lv_nmos ad=0.1428p pd=1.52u as=0 ps=0 w=0.42u l=1u
X1370 VSS.t426 VDD VSS.t426 VSS.t2 sg13_lv_nmos ad=79.8f pd=0.8u as=0 ps=0 w=0.42u l=1u
X1371 sg13cmos5l_dlygate4sd3_1_20.A a_28170_14020# VSS.t116 VSS.t115 sg13_lv_nmos ad=0.2516p pd=2.16u as=0.1406p ps=1.12u w=0.74u l=0.13u
X1372 VDD VSS.t632 VDD VDD sg13_lv_pmos ad=0.34p pd=2.68u as=0 ps=0 w=1u l=1u
X1373 VSS.t3092 VDD VSS.t3094 VSS.t3093 sg13_lv_nmos ad=79.8f pd=0.8u as=0 ps=0 w=0.42u l=1u
X1374 VSS.t1998 VDD VSS.t2000 VSS.t1999 sg13_lv_nmos ad=79.8f pd=0.8u as=0 ps=0 w=0.42u l=1u
X1375 VSS.t2729 VDD VSS.t2728 VSS.t2620 sg13_lv_nmos ad=0.1428p pd=1.52u as=0 ps=0 w=0.42u l=1u
X1376 VDD VSS.t2309 VDD VDD sg13_lv_pmos ad=0.34p pd=2.68u as=0 ps=0 w=1u l=1u
X1377 a_7916_15960# sg13cmos5l_dlygate4sd3_1_0.A VSS.t253 VSS.t252 sg13_lv_nmos ad=0.187p pd=1.78u as=0.14875p ps=1.16u w=0.55u l=0.13u
X1378 VDD sg13cmos5l_buf_16_2.A a_19534_13726# VDD sg13_lv_pmos ad=0.2128p pd=1.5u as=0.2128p ps=1.5u w=1.12u l=0.13u
X1379 VDD VSS.t1628 VDD VDD sg13_lv_pmos ad=0.19p pd=1.38u as=0 ps=0 w=1u l=1u
X1380 VSS.t842 VDD VSS.t841 VSS.t840 sg13_lv_nmos ad=0.1428p pd=1.52u as=0 ps=0 w=0.42u l=1u
X1381 VDD VSS.t824 VDD VDD sg13_lv_pmos ad=0.19p pd=1.38u as=0 ps=0 w=1u l=1u
X1382 VSS.t1918 VDD VSS.t1917 VSS.t1916 sg13_lv_nmos ad=0.1428p pd=1.52u as=0 ps=0 w=0.42u l=1u
X1383 a_7953_15556# sg13cmos5l_dlygate4sd3_1_11.X VDD VDD sg13_lv_pmos ad=0.1225p pd=1.245u as=0.36p ps=2.72u w=1u l=0.13u
X1384 VDD a_14549_15238# sg13cmos5l_or3_1_2.B VDD sg13_lv_pmos ad=0.3808p pd=2.92u as=0.2128p ps=1.5u w=1.12u l=0.13u
X1385 VDD VSS.t1580 VDD VDD sg13_lv_pmos ad=0.34p pd=2.68u as=0 ps=0 w=1u l=1u
X1386 VSS.t2670 VDD VSS.t2669 VSS.t2620 sg13_lv_nmos ad=0.1428p pd=1.52u as=0 ps=0 w=0.42u l=1u
X1387 VDD VSS.t2635 VDD VDD sg13_lv_pmos ad=0.34p pd=2.68u as=0 ps=0 w=1u l=1u
X1388 VDD a_18106_15960# a_17825_16262# VDD sg13_lv_pmos ad=0.1523p pd=1.38u as=0.34p ps=2.68u w=1u l=0.5u
X1389 VDD VSS.t73 VDD VDD sg13_lv_pmos ad=0.34p pd=2.68u as=0 ps=0 w=1u l=1u
X1390 a_15790_15238# clock_i VDD VDD sg13_lv_pmos ad=0.2128p pd=1.5u as=0.2128p ps=1.5u w=1.12u l=0.13u
X1391 a_20507_15532# sg13cmos5l_or3_1_2.X VDD VDD sg13_lv_pmos ad=0.3808p pd=2.92u as=0.2128p ps=1.5u w=1.12u l=0.13u
X1392 VDD VSS.t939 VDD VDD sg13_lv_pmos ad=0.19p pd=1.38u as=0 ps=0 w=1u l=1u
X1393 VSS.t1231 VDD VSS.t1230 VSS.t224 sg13_lv_nmos ad=0.1428p pd=1.52u as=0 ps=0 w=0.42u l=1u
X1394 VDD VSS.t2494 VDD VDD sg13_lv_pmos ad=0.34p pd=2.68u as=0 ps=0 w=1u l=1u
X1395 VDD VSS.t2317 VDD VDD sg13_lv_pmos ad=0.19p pd=1.38u as=0 ps=0 w=1u l=1u
X1396 a_27311_14845# a_26469_14495# a_27217_14845# VSS.t2 sg13_lv_nmos ad=0.12665p pd=1.145u as=0.1428p ps=1.52u w=0.42u l=0.13u
X1397 VSS.t1651 VDD VSS.t1653 VSS.t1652 sg13_lv_nmos ad=79.8f pd=0.8u as=0 ps=0 w=0.42u l=1u
X1398 VDD VSS.t2747 VDD VDD sg13_lv_pmos ad=0.34p pd=2.68u as=0 ps=0 w=1u l=1u
X1399 VSS.t1274 VDD VSS.t1273 VSS.t224 sg13_lv_nmos ad=0.1428p pd=1.52u as=0 ps=0 w=0.42u l=1u
X1400 VDD VSS.t1286 VDD VDD sg13_lv_pmos ad=0.19p pd=1.38u as=0 ps=0 w=1u l=1u
X1401 VDD VSS.t2100 VDD VDD sg13_lv_pmos ad=0.19p pd=1.38u as=0 ps=0 w=1u l=1u
X1402 VSS.t972 VDD VSS.t974 VSS.t973 sg13_lv_nmos ad=79.8f pd=0.8u as=0 ps=0 w=0.42u l=1u
X1403 VDD a_3782_15996# a_3894_16020# VDD sg13_lv_pmos ad=0.2254p pd=1.53u as=0.34p ps=2.68u w=1u l=0.5u
X1404 sg13cmos5l_o21ai_1_3.Y sg13cmos5l_o21ai_1_3.B1 a_24982_13350# VSS.t188 sg13_lv_nmos ad=0.2516p pd=2.16u as=0.1406p ps=1.12u w=0.74u l=0.15u
X1405 sg13cmos5l_or3_1_2.C sg13cmos5l_dfrbpq_1_3.Q VDD VDD sg13_lv_pmos ad=0.2128p pd=1.5u as=0.3808p ps=2.92u w=1.12u l=0.13u
X1406 VDD VSS.t641 VDD VDD sg13_lv_pmos ad=0.34p pd=2.68u as=0 ps=0 w=1u l=1u
X1407 VDD VSS.t3026 VDD VDD sg13_lv_pmos ad=0.34p pd=2.68u as=0 ps=0 w=1u l=1u
X1408 VSS.t2230 VDD VSS.t2232 VSS.t2231 sg13_lv_nmos ad=79.8f pd=0.8u as=0 ps=0 w=0.42u l=1u
X1409 a_27022_13239# a_27137_13238# VDD VDD sg13_lv_pmos ad=0.34p pd=2.68u as=0.2254p ps=1.53u w=1u l=0.5u
X1410 VDD VSS.t2467 VDD VDD sg13_lv_pmos ad=0.19p pd=1.38u as=0 ps=0 w=1u l=1u
X1411 a_19436_15960# sg13cmos5l_dfrbpq_1_2.Q VSS.t104 VSS.t3203 sg13_lv_nmos ad=0.187p pd=1.78u as=0.14875p ps=1.16u w=0.55u l=0.13u
X1412 VSS.t802 VDD VSS.t804 VSS.t803 sg13_lv_nmos ad=79.8f pd=0.8u as=0 ps=0 w=0.42u l=1u
X1413 VDD VSS.t1648 VDD VDD sg13_lv_pmos ad=0.19p pd=1.38u as=0 ps=0 w=1u l=1u
X1414 VDD VSS.t707 VDD VDD sg13_lv_pmos ad=0.34p pd=2.68u as=0 ps=0 w=1u l=1u
X1415 VSS.t1451 VDD VSS.t1450 VSS.t1449 sg13_lv_nmos ad=0.1428p pd=1.52u as=0 ps=0 w=0.42u l=1u
X1416 VDD a_4367_15311# a_4624_15454# VDD sg13_lv_pmos ad=2.8961p pd=18.25u as=79.8f ps=0.8u w=0.42u l=0.13u
X1417 VSS.t1283 VDD VSS.t1282 VSS.t224 sg13_lv_nmos ad=0.1428p pd=1.52u as=0 ps=0 w=0.42u l=1u
X1418 VDD VSS.t2626 VDD VDD sg13_lv_pmos ad=0.34p pd=2.68u as=0 ps=0 w=1u l=1u
X1419 a_6634_14452# a_7077_14495# a_6374_14922# VSS.t247 sg13_lv_nmos ad=79.8f pd=0.8u as=0.1296p ps=1.52u w=0.42u l=0.13u
X1420 VSS.t557 VDD VSS.t555 VSS.t556 sg13_lv_nmos ad=0.1428p pd=1.52u as=0 ps=0 w=0.42u l=1u
X1421 VDD VSS.t564 VDD VDD sg13_lv_pmos ad=0.19p pd=1.38u as=0 ps=0 w=1u l=1u
X1422 VDD VSS.t1206 VDD VDD sg13_lv_pmos ad=0.34p pd=2.68u as=0 ps=0 w=1u l=1u
X1423 VSS.t2013 VDD VSS.t2012 VSS.t2011 sg13_lv_nmos ad=0.1428p pd=1.52u as=0 ps=0 w=0.42u l=1u
X1424 VDD sg13cmos5l_buf_16_2.A a_12212_15202# VDD sg13_lv_pmos ad=0.3808p pd=2.92u as=0.2128p ps=1.5u w=1.12u l=0.13u
X1425 VSS.t1446 VDD VSS.t1445 VSS.t1444 sg13_lv_nmos ad=0.1428p pd=1.52u as=0 ps=0 w=0.42u l=1u
X1426 VDD VSS.t1178 VDD VDD sg13_lv_pmos ad=0.19p pd=1.38u as=0 ps=0 w=1u l=1u
X1427 VSS.t2638 VDD VSS.t2638 VSS.t2620 sg13_lv_nmos ad=0.1428p pd=1.52u as=0 ps=0 w=0.42u l=1u
X1428 VSS.t1288 VDD VSS.t1287 VSS.t224 sg13_lv_nmos ad=0.1428p pd=1.52u as=0 ps=0 w=0.42u l=1u
X1429 VSS.t2702 VDD VSS.t2703 VSS.t2620 sg13_lv_nmos ad=79.8f pd=0.8u as=0 ps=0 w=0.42u l=1u
X1430 VSS.t2355 VDD VSS.t2357 VSS.t2356 sg13_lv_nmos ad=79.8f pd=0.8u as=0 ps=0 w=0.42u l=1u
X1431 VDD VSS.t3059 VDD VDD sg13_lv_pmos ad=0.19p pd=1.38u as=0 ps=0 w=1u l=1u
X1432 VSS.t2450 VDD VSS.t2449 VSS.t2448 sg13_lv_nmos ad=0.1428p pd=1.52u as=0 ps=0 w=0.42u l=1u
X1433 VDD VSS.t2262 VDD VDD sg13_lv_pmos ad=0.19p pd=1.38u as=0 ps=0 w=1u l=1u
X1434 VSS.t442 VDD VSS.t442 VSS.t2 sg13_lv_nmos ad=79.8f pd=0.8u as=0 ps=0 w=0.42u l=1u
X1435 VSS.t426 VDD VSS.t426 VSS.t2 sg13_lv_nmos ad=79.8f pd=0.8u as=0 ps=0 w=0.42u l=1u
X1436 VDD a_15790_15238# sg13cmos5l_buf_16_2.A VDD sg13_lv_pmos ad=0.3976p pd=2.95u as=0.2128p ps=1.5u w=1.12u l=0.13u
X1437 VDD a_22223_14845# a_22480_14726# VDD sg13_lv_pmos ad=2.42015p pd=15.68u as=79.8f ps=0.8u w=0.42u l=0.13u
X1438 VSS.t2719 VDD VSS.t2719 VSS.t2620 sg13_lv_nmos ad=0.1428p pd=1.52u as=0 ps=0 w=0.42u l=1u
X1439 VSS.t1002 VDD VSS.t1004 VSS.t1003 sg13_lv_nmos ad=79.8f pd=0.8u as=0 ps=0 w=0.42u l=1u
X1440 VDD VSS.t2452 VDD VDD sg13_lv_pmos ad=0.19p pd=1.38u as=0 ps=0 w=1u l=1u
X1441 VDD VSS.t1186 VDD VDD sg13_lv_pmos ad=0.19p pd=1.38u as=0 ps=0 w=1u l=1u
X1442 VSS.t1641 VDD VSS.t1643 VSS.t1642 sg13_lv_nmos ad=79.8f pd=0.8u as=0 ps=0 w=0.42u l=1u
X1443 VSS.t3172 VDD VSS.t3174 VSS.t3173 sg13_lv_nmos ad=79.8f pd=0.8u as=0 ps=0 w=0.42u l=1u
X1444 sg13cmos5l_buf_16_2.A a_15790_15238# VSS.t21 VSS.t28 sg13_lv_nmos ad=0.1406p pd=1.12u as=0.1406p ps=1.12u w=0.74u l=0.13u
X1445 VSS.t562 VDD VSS.t564 VSS.t563 sg13_lv_nmos ad=79.8f pd=0.8u as=0 ps=0 w=0.42u l=1u
X1446 VDD VSS.t1565 VDD VDD sg13_lv_pmos ad=0.34p pd=2.68u as=0 ps=0 w=1u l=1u
X1447 VSS.t2033 VDD VSS.t2032 VSS.t2031 sg13_lv_nmos ad=0.1428p pd=1.52u as=0 ps=0 w=0.42u l=1u
X1448 a_17327_13799# a_16485_13701# a_17233_13799# VSS.t3187 sg13_lv_nmos ad=0.12665p pd=1.145u as=0.1428p ps=1.52u w=0.42u l=0.13u
X1449 VDD a_12212_15202# sg13cmos5l_dfrbpq_1_2.CLK VDD sg13_lv_pmos ad=0.2128p pd=1.5u as=0.2128p ps=1.5u w=1.12u l=0.13u
X1450 VSS.t202 a_25582_15423# sg13cmos5l_dlygate4sd3_1_18.X VSS.t8 sg13_lv_nmos ad=0.1426p pd=1.16u as=0.2516p ps=2.16u w=0.74u l=0.13u
X1451 sg13cmos5l_or3_1_1.X a_25129_13726# VDD VDD sg13_lv_pmos ad=0.3808p pd=2.92u as=0.3822p ps=1.84u w=1.12u l=0.13u
X1452 VDD VSS.t2479 VDD VDD sg13_lv_pmos ad=0.34p pd=2.68u as=0 ps=0 w=1u l=1u
X1453 VDD VSS.t806 VDD VDD sg13_lv_pmos ad=0.34p pd=2.68u as=0 ps=0 w=1u l=1u
X1454 VSS.t1636 VDD VSS.t1638 VSS.t1637 sg13_lv_nmos ad=79.8f pd=0.8u as=0 ps=0 w=0.42u l=1u
X1455 VSS.t1301 VDD VSS.t1300 VSS.t224 sg13_lv_nmos ad=0.1428p pd=1.52u as=0 ps=0 w=0.42u l=1u
X1456 VDD VSS.t2507 VDD VDD sg13_lv_pmos ad=0.19p pd=1.38u as=0 ps=0 w=1u l=1u
X1457 a_25325_14020# sg13cmos5l_o21ai_1_2.A1 a_25223_14020# VDD sg13_lv_pmos ad=0.1575p pd=1.315u as=0.19p ps=1.38u w=1u l=0.13u
X1458 VSS.t972 VDD VSS.t974 VSS.t973 sg13_lv_nmos ad=79.8f pd=0.8u as=0 ps=0 w=0.42u l=1u
X1459 VDD VSS.t1176 VDD VDD sg13_lv_pmos ad=0.34p pd=2.68u as=0 ps=0 w=1u l=1u
X1460 VDD VSS.t1947 VDD VDD sg13_lv_pmos ad=0.34p pd=2.68u as=0 ps=0 w=1u l=1u
X1461 VSS.t375 VDD VSS.t374 VSS.t373 sg13_lv_nmos ad=0.1428p pd=1.52u as=0 ps=0 w=0.42u l=1u
X1462 VDD VSS.t3079 VDD VDD sg13_lv_pmos ad=0.19p pd=1.38u as=0 ps=0 w=1u l=1u
X1463 VDD VSS.t2282 VDD VDD sg13_lv_pmos ad=0.19p pd=1.38u as=0 ps=0 w=1u l=1u
X1464 VSS.t2113 VDD VSS.t2115 VSS.t2114 sg13_lv_nmos ad=79.8f pd=0.8u as=0 ps=0 w=0.42u l=1u
X1465 a_27568_14726# a_27311_14845# a_27730_14922# VSS.t2 sg13_lv_nmos ad=0.1428p pd=1.52u as=37.8f ps=0.6u w=0.42u l=0.13u
X1466 sg13cmos5l_dlygate4sd3_1_5.A a_5034_15532# VDD VDD sg13_lv_pmos ad=0.3808p pd=2.92u as=0.2128p ps=1.5u w=1.12u l=0.13u
X1467 VSS.t77 sg13cmos5l_dfrbpq_1_1.RESET_B a_6468_14922# VSS.t210 sg13_lv_nmos ad=0.1626p pd=1.415u as=60.89999f ps=0.71u w=0.42u l=0.13u
X1468 VDD VSS.t859 VDD VDD sg13_lv_pmos ad=0.19p pd=1.38u as=0 ps=0 w=1u l=1u
X1469 VSS.t2711 VDD VSS.t2710 VSS.t2620 sg13_lv_nmos ad=0.1428p pd=1.52u as=0 ps=0 w=0.42u l=1u
X1470 VSS.t12 a_27500_15960# counter_value_o[5] VSS.t3234 sg13_lv_nmos ad=0.14875p pd=1.16u as=0.2886p ps=2.26u w=0.74u l=0.13u
X1471 VDD VSS.t1024 VDD VDD sg13_lv_pmos ad=0.19p pd=1.38u as=0 ps=0 w=1u l=1u
X1472 VDD VSS.t1278 VDD VDD sg13_lv_pmos ad=0.19p pd=1.38u as=0 ps=0 w=1u l=1u
X1473 VDD VSS.t1578 VDD VDD sg13_lv_pmos ad=0.19p pd=1.38u as=0 ps=0 w=1u l=1u
X1474 VDD VSS.t1955 VDD VDD sg13_lv_pmos ad=0.19p pd=1.38u as=0 ps=0 w=1u l=1u
X1475 VSS.t438 VDD VSS.t438 VSS.t2 sg13_lv_nmos ad=79.8f pd=0.8u as=0 ps=0 w=0.42u l=1u
X1476 VDD VSS.t3106 VDD VDD sg13_lv_pmos ad=0.34p pd=2.68u as=0 ps=0 w=1u l=1u
X1477 VSS.t3157 VDD VSS.t3159 VSS.t3158 sg13_lv_nmos ad=79.8f pd=0.8u as=0 ps=0 w=0.42u l=1u
X1478 VSS.t2063 VDD VSS.t2065 VSS.t2064 sg13_lv_nmos ad=79.8f pd=0.8u as=0 ps=0 w=0.42u l=1u
X1479 sg13cmos5l_dfrbpq_1_7.D a_25878_16020# VSS.t98 VSS.t3223 sg13_lv_nmos ad=0.2516p pd=2.16u as=0.1426p ps=1.16u w=0.74u l=0.13u
X1480 VSS.t2673 VDD VSS.t2671 VSS.t2620 sg13_lv_nmos ad=0.1428p pd=1.52u as=0 ps=0 w=0.42u l=1u
X1481 VSS.t892 VDD VSS.t894 VSS.t893 sg13_lv_nmos ad=79.8f pd=0.8u as=0 ps=0 w=0.42u l=1u
X1482 VDD VSS.t961 VDD VDD sg13_lv_pmos ad=0.34p pd=2.68u as=0 ps=0 w=1u l=1u
X1483 VDD VSS.t2322 VDD VDD sg13_lv_pmos ad=0.19p pd=1.38u as=0 ps=0 w=1u l=1u
X1484 VSS.t1983 VDD VSS.t1982 VSS.t1981 sg13_lv_nmos ad=0.1428p pd=1.52u as=0 ps=0 w=0.42u l=1u
X1485 VDD a_12212_15202# sg13cmos5l_dfrbpq_1_2.CLK VDD sg13_lv_pmos ad=0.2128p pd=1.5u as=0.2128p ps=1.5u w=1.12u l=0.13u
X1486 VDD VSS.t1980 VDD VDD sg13_lv_pmos ad=0.19p pd=1.38u as=0 ps=0 w=1u l=1u
X1487 VSS.t1315 VDD VSS.t1314 VSS.t224 sg13_lv_nmos ad=0.1428p pd=1.52u as=0 ps=0 w=0.42u l=1u
X1488 VSS.t629 VDD VSS.t632 VSS.t631 sg13_lv_nmos ad=79.8f pd=0.8u as=0 ps=0 w=0.42u l=1u
X1489 VSS.t2340 VDD VSS.t2342 VSS.t2341 sg13_lv_nmos ad=79.8f pd=0.8u as=0 ps=0 w=0.42u l=1u
X1490 VDD VSS.t2105 VDD VDD sg13_lv_pmos ad=0.19p pd=1.38u as=0 ps=0 w=1u l=1u
X1491 VSS.t442 VDD VSS.t446 VSS.t2 sg13_lv_nmos ad=79.8f pd=0.8u as=0 ps=0 w=0.42u l=1u
X1492 VSS.t187 sg13cmos5l_o21ai_1_2.A1 a_24982_13350# VSS.t263 sg13_lv_nmos ad=0.1406p pd=1.12u as=0.2516p ps=2.16u w=0.74u l=0.15u
X1493 VSS.t1893 VDD VSS.t1895 VSS.t1894 sg13_lv_nmos ad=79.8f pd=0.8u as=0 ps=0 w=0.42u l=1u
X1494 sg13cmos5l_dfrbpq_1_3.Q a_19434_14484# VDD VDD sg13_lv_pmos ad=0.3808p pd=2.92u as=0.2128p ps=1.5u w=1.12u l=0.13u
X1495 VSS.t2749 VDD VSS.t2751 VSS.t2620 sg13_lv_nmos ad=79.8f pd=0.8u as=0 ps=0 w=0.42u l=1u
X1496 VDD VSS.t1258 VDD VDD sg13_lv_pmos ad=0.34p pd=2.68u as=0 ps=0 w=1u l=1u
X1497 VDD VSS.t73 VDD VDD sg13_lv_pmos ad=0.19p pd=1.38u as=0 ps=0 w=1u l=1u
X1498 VSS.t1002 VDD VSS.t1004 VSS.t1003 sg13_lv_nmos ad=79.8f pd=0.8u as=0 ps=0 w=0.42u l=1u
X1499 VDD VSS.t976 VDD VDD sg13_lv_pmos ad=0.34p pd=2.68u as=0 ps=0 w=1u l=1u
X1500 VDD VSS.t1618 VDD VDD sg13_lv_pmos ad=0.19p pd=1.38u as=0 ps=0 w=1u l=1u
X1501 VDD VSS.t3091 VDD VDD sg13_lv_pmos ad=0.34p pd=2.68u as=0 ps=0 w=1u l=1u
X1502 VDD VSS.t2294 VDD VDD sg13_lv_pmos ad=0.34p pd=2.68u as=0 ps=0 w=1u l=1u
X1503 VDD a_27568_14726# a_27513_14607# VDD sg13_lv_pmos ad=2.42015p pd=15.68u as=93.45f ps=0.865u w=0.42u l=0.13u
X1504 VSS.t862 VDD VSS.t861 VSS.t860 sg13_lv_nmos ad=0.1428p pd=1.52u as=0 ps=0 w=0.42u l=1u
X1505 VSS.t37 a_7985_15288# sg13cmos5l_xor2_1_0.X VSS.t107 sg13_lv_nmos ad=0.3108p pd=2.32u as=0.1628p ps=1.18u w=0.74u l=0.13u
X1506 VSS.t1356 VDD VSS.t1202 VSS.t224 sg13_lv_nmos ad=79.8f pd=0.8u as=0 ps=0 w=0.42u l=1u
X1507 VDD VSS.t2629 VDD VDD sg13_lv_pmos ad=0.34p pd=2.68u as=0 ps=0 w=1u l=1u
X1508 VSS.t44 VDD VSS.t466 VSS.t465 sg13_lv_nmos ad=79.8f pd=0.8u as=0 ps=0 w=0.42u l=1u
X1509 sg13cmos5l_o21ai_1_3.Y sg13cmos5l_o21ai_1_3.A2 a_25080_12952# VDD sg13_lv_pmos ad=0.2128p pd=1.5u as=0.2128p ps=1.5u w=1.12u l=0.15u
X1510 VDD VSS.t1295 VDD VDD sg13_lv_pmos ad=0.19p pd=1.38u as=0 ps=0 w=1u l=1u
X1511 VDD VSS.t1900 VDD VDD sg13_lv_pmos ad=0.19p pd=1.38u as=0 ps=0 w=1u l=1u
X1512 VDD VSS.t2731 VDD VDD sg13_lv_pmos ad=0.19p pd=1.38u as=0 ps=0 w=1u l=1u
X1513 VSS.t2018 VDD VSS.t2017 VSS.t2016 sg13_lv_nmos ad=0.1428p pd=1.52u as=0 ps=0 w=0.42u l=1u
X1514 a_4367_15311# a_3525_15213# a_3108_15552# VDD sg13_lv_pmos ad=0.2048p pd=1.63u as=0.34p ps=2.68u w=1u l=0.13u
X1515 VSS.t1581 VDD VSS.t1580 VSS.t1579 sg13_lv_nmos ad=0.1428p pd=1.52u as=0 ps=0 w=0.42u l=1u
X1516 VSS.t3112 VDD VSS.t3111 VSS.t3110 sg13_lv_nmos ad=0.1428p pd=1.52u as=0 ps=0 w=0.42u l=1u
X1517 a_26026_14452# a_26469_14495# a_26409_14531# VDD sg13_lv_pmos ad=79.8f pd=0.8u as=63f ps=0.72u w=0.42u l=0.13u
X1518 VDD VSS.t2492 VDD VDD sg13_lv_pmos ad=0.19p pd=1.38u as=0 ps=0 w=1u l=1u
X1519 VSS.t430 VDD VSS.t430 VSS.t2 sg13_lv_nmos ad=0.1428p pd=1.52u as=0 ps=0 w=0.42u l=1u
X1520 VSS.t922 VDD VSS.t924 VSS.t923 sg13_lv_nmos ad=79.8f pd=0.8u as=0 ps=0 w=0.42u l=1u
X1521 VDD VSS.t1932 VDD VDD sg13_lv_pmos ad=0.34p pd=2.68u as=0 ps=0 w=1u l=1u
X1522 VDD VSS.t789 VDD VDD sg13_lv_pmos ad=0.19p pd=1.38u as=0 ps=0 w=1u l=1u
X1523 VDD VSS.t3064 VDD VDD sg13_lv_pmos ad=0.19p pd=1.38u as=0 ps=0 w=1u l=1u
X1524 VSS.t2325 VDD VSS.t2327 VSS.t2326 sg13_lv_nmos ad=79.8f pd=0.8u as=0 ps=0 w=0.42u l=1u
X1525 VDD VSS.t2267 VDD VDD sg13_lv_pmos ad=0.19p pd=1.38u as=0 ps=0 w=1u l=1u
X1526 sg13cmos5l_nor2_1_1.Y sg13cmos5l_nor2_1_1.B a_9098_14484# VDD sg13_lv_pmos ad=0.3808p pd=2.92u as=0.1176p ps=1.33u w=1.12u l=0.13u
X1527 VSS.t1716 VDD VSS.t1718 VSS.t1717 sg13_lv_nmos ad=79.8f pd=0.8u as=0 ps=0 w=0.42u l=1u
X1528 VSS.t2098 VDD VSS.t2100 VSS.t2099 sg13_lv_nmos ad=79.8f pd=0.8u as=0 ps=0 w=0.42u l=1u
X1529 VDD VSS.t193 VDD VDD sg13_lv_pmos ad=0.19p pd=1.38u as=0 ps=0 w=1u l=1u
X1530 VSS.t423 VDD VSS.t10 VSS.t8 sg13_lv_nmos ad=0.1428p pd=1.52u as=0 ps=0 w=0.42u l=1u
X1531 a_8870_15238# a_8600_15238# VDD VDD sg13_lv_pmos ad=0.34p pd=2.68u as=0.1523p ps=1.38u w=1u l=0.5u
X1532 VSS.t620 VDD VSS.t620 VSS.t750 sg13_lv_nmos ad=79.8f pd=0.8u as=0 ps=0 w=0.42u l=1u
X1533 VSS.t822 VDD VSS.t824 VSS.t823 sg13_lv_nmos ad=79.8f pd=0.8u as=0 ps=0 w=0.42u l=1u
X1534 VSS.t1968 VDD VSS.t1970 VSS.t1969 sg13_lv_nmos ad=79.8f pd=0.8u as=0 ps=0 w=0.42u l=1u
X1535 VDD a_19534_13726# sg13cmos5l_buf_16_2.X VDD sg13_lv_pmos ad=0.2128p pd=1.5u as=0.2128p ps=1.5u w=1.12u l=0.13u
X1536 VSS.t892 VDD VSS.t894 VSS.t893 sg13_lv_nmos ad=79.8f pd=0.8u as=0 ps=0 w=0.42u l=1u
X1537 VDD VSS.t881 VDD VDD sg13_lv_pmos ad=0.34p pd=2.68u as=0 ps=0 w=1u l=1u
X1538 VSS.t1646 VDD VSS.t1648 VSS.t1647 sg13_lv_nmos ad=79.8f pd=0.8u as=0 ps=0 w=0.42u l=1u
X1539 VSS.t937 VDD VSS.t939 VSS.t938 sg13_lv_nmos ad=79.8f pd=0.8u as=0 ps=0 w=0.42u l=1u
X1540 VDD VSS.t1570 VDD VDD sg13_lv_pmos ad=0.34p pd=2.68u as=0 ps=0 w=1u l=1u
X1541 VDD VSS.t1450 VDD VDD sg13_lv_pmos ad=0.34p pd=2.68u as=0 ps=0 w=1u l=1u
X1542 VSS.t3142 VDD VSS.t3144 VSS.t3143 sg13_lv_nmos ad=79.8f pd=0.8u as=0 ps=0 w=0.42u l=1u
X1543 VSS.t2664 VDD VSS.t2663 VSS.t2620 sg13_lv_nmos ad=0.1428p pd=1.52u as=0 ps=0 w=0.42u l=1u
X1544 VDD a_4366_14751# sg13cmos5l_xnor2_1_0.A VDD sg13_lv_pmos ad=0.2254p pd=1.53u as=0.4256p ps=3u w=1.12u l=0.13u
X1545 a_16175_14854# a_16140_14750# sg13cmos5l_nor2_1_3.B VSS.t290 sg13_lv_nmos ad=0.1406p pd=1.12u as=0.2516p ps=2.16u w=0.74u l=0.13u
X1546 VDD VSS.t620 VDD VDD sg13_lv_pmos ad=0.34p pd=2.68u as=0 ps=0 w=1u l=1u
X1547 VDD VSS.t1006 VDD VDD sg13_lv_pmos ad=0.34p pd=2.68u as=0 ps=0 w=1u l=1u
X1548 VSS.t2250 VDD VSS.t2249 VSS.t2248 sg13_lv_nmos ad=0.1428p pd=1.52u as=0 ps=0 w=0.42u l=1u
X1549 a_4367_15311# a_3525_15213# a_4273_15311# VSS.t34 sg13_lv_nmos ad=0.12665p pd=1.145u as=0.1428p ps=1.52u w=0.42u l=0.13u
X1550 VDD VSS.t2484 VDD VDD sg13_lv_pmos ad=0.34p pd=2.68u as=0 ps=0 w=1u l=1u
X1551 VDD VSS.t102 VDD VDD sg13_lv_pmos ad=0.34p pd=2.68u as=0 ps=0 w=1u l=1u
X1552 a_22508_15960# sg13cmos5l_dfrbpq_1_3.Q VDD VDD sg13_lv_pmos ad=0.2856p pd=2.36u as=0.2114p ps=1.54u w=0.84u l=0.13u
X1553 VDD VSS.t944 VDD VDD sg13_lv_pmos ad=0.19p pd=1.38u as=0 ps=0 w=1u l=1u
X1554 VDD VSS.t1230 VDD VDD sg13_lv_pmos ad=0.19p pd=1.38u as=0 ps=0 w=1u l=1u
X1555 VSS.t1193 VDD VSS.t1193 VSS.t224 sg13_lv_nmos ad=0.1428p pd=1.52u as=0 ps=0 w=0.42u l=1u
X1556 VSS.t1234 VDD VSS.t1235 VSS.t224 sg13_lv_nmos ad=79.8f pd=0.8u as=0 ps=0 w=0.42u l=1u
X1557 VDD VSS.t1280 VDD VDD sg13_lv_pmos ad=0.19p pd=1.38u as=0 ps=0 w=1u l=1u
X1558 VDD VSS.t2782 VDD VDD sg13_lv_pmos ad=0.19p pd=1.38u as=0 ps=0 w=1u l=1u
X1559 a_22330_15202# sg13cmos5l_dfrbpq_1_6.Q VDD VDD sg13_lv_pmos ad=0.1428p pd=1.52u as=0.1523p ps=1.38u w=0.42u l=0.13u
X1560 VSS.t1701 VDD VSS.t1703 VSS.t1702 sg13_lv_nmos ad=79.8f pd=0.8u as=0 ps=0 w=0.42u l=1u
X1561 VSS.t2505 VDD VSS.t2504 VSS.t2503 sg13_lv_nmos ad=0.1428p pd=1.52u as=0 ps=0 w=0.42u l=1u
X1562 a_9706_15457# a_10149_15213# a_10089_15625# VDD sg13_lv_pmos ad=79.8f pd=0.8u as=63f ps=0.72u w=0.42u l=0.13u
X1563 VDD VSS.t641 VDD VDD sg13_lv_pmos ad=0.34p pd=2.68u as=0 ps=0 w=1u l=1u
X1564 VSS.t1878 VDD VSS.t1880 VSS.t1879 sg13_lv_nmos ad=79.8f pd=0.8u as=0 ps=0 w=0.42u l=1u
X1565 VDD VSS.t219 VDD VDD sg13_lv_pmos ad=0.34p pd=2.68u as=0 ps=0 w=1u l=1u
X1566 sg13cmos5l_dfrbpq_1_3.Q a_19434_14484# VSS.t40 VSS.t39 sg13_lv_nmos ad=0.2516p pd=2.16u as=0.1406p ps=1.12u w=0.74u l=0.13u
X1567 VSS.t1198 VDD VSS.t1197 VSS.t224 sg13_lv_nmos ad=0.1428p pd=1.52u as=0 ps=0 w=0.42u l=1u
X1568 VSS.t382 VDD VSS.t382 VSS.t384 sg13_lv_nmos ad=0.1428p pd=1.52u as=0 ps=0 w=0.42u l=1u
X1569 VDD VSS.t540 VDD VDD sg13_lv_pmos ad=0.19p pd=1.38u as=0 ps=0 w=1u l=1u
X1570 VSS.t2713 VDD VSS.t2713 VSS.t2620 sg13_lv_nmos ad=0.1428p pd=1.52u as=0 ps=0 w=0.42u l=1u
X1571 VSS.t535 VDD VSS.t535 VSS.t652 sg13_lv_nmos ad=0.1428p pd=1.52u as=0 ps=0 w=0.42u l=1u
X1572 VSS.t862 VDD VSS.t861 VSS.t860 sg13_lv_nmos ad=0.1428p pd=1.52u as=0 ps=0 w=0.42u l=1u
X1573 VSS.t977 VDD VSS.t979 VSS.t978 sg13_lv_nmos ad=79.8f pd=0.8u as=0 ps=0 w=0.42u l=1u
X1574 VDD VSS.t1960 VDD VDD sg13_lv_pmos ad=0.19p pd=1.38u as=0 ps=0 w=1u l=1u
X1575 VDD VSS.t3076 VDD VDD sg13_lv_pmos ad=0.34p pd=2.68u as=0 ps=0 w=1u l=1u
X1576 VDD VSS.t2279 VDD VDD sg13_lv_pmos ad=0.34p pd=2.68u as=0 ps=0 w=1u l=1u
X1577 a_26532_13735# a_26244_14040# a_26470_13735# VSS.t124 sg13_lv_nmos ad=0.1428p pd=1.52u as=37.8f ps=0.6u w=0.42u l=0.13u
X1578 VDD VSS.t1603 VDD VDD sg13_lv_pmos ad=0.19p pd=1.38u as=0 ps=0 w=1u l=1u
X1579 VSS.t2068 VDD VSS.t2070 VSS.t2069 sg13_lv_nmos ad=79.8f pd=0.8u as=0 ps=0 w=0.42u l=1u
X1580 VDD a_19534_13726# sg13cmos5l_buf_16_2.X VDD sg13_lv_pmos ad=0.2128p pd=1.5u as=0.2128p ps=1.5u w=1.12u l=0.13u
X1581 VSS.t2676 VDD VSS.t2675 VSS.t2620 sg13_lv_nmos ad=0.1428p pd=1.52u as=0 ps=0 w=0.42u l=1u
X1582 VSS.t430 VDD VSS.t430 VSS.t2 sg13_lv_nmos ad=79.8f pd=0.8u as=0 ps=0 w=0.42u l=1u
X1583 VDD VSS.t1643 VDD VDD sg13_lv_pmos ad=0.19p pd=1.38u as=0 ps=0 w=1u l=1u
X1584 VDD VSS.t2621 VDD VDD sg13_lv_pmos ad=0.34p pd=2.68u as=0 ps=0 w=1u l=1u
X1585 VSS.t708 VDD VSS.t707 VSS.t706 sg13_lv_nmos ad=0.1428p pd=1.52u as=0 ps=0 w=0.42u l=1u
X1586 VDD VSS.t1210 VDD VDD sg13_lv_pmos ad=0.34p pd=2.68u as=0 ps=0 w=1u l=1u
X1587 VDD VSS.t1985 VDD VDD sg13_lv_pmos ad=0.19p pd=1.38u as=0 ps=0 w=1u l=1u
X1588 VSS.t922 VDD VSS.t924 VSS.t923 sg13_lv_nmos ad=79.8f pd=0.8u as=0 ps=0 w=0.42u l=1u
X1589 VDD VSS.t911 VDD VDD sg13_lv_pmos ad=0.34p pd=2.68u as=0 ps=0 w=1u l=1u
X1590 VSS.t1286 VDD VSS.t1285 VSS.t224 sg13_lv_nmos ad=0.1428p pd=1.52u as=0 ps=0 w=0.42u l=1u
X1591 VSS.t528 VDD VSS.t527 VSS.t526 sg13_lv_nmos ad=0.1428p pd=1.52u as=0 ps=0 w=0.42u l=1u
X1592 VSS.t562 VDD VSS.t564 VSS.t563 sg13_lv_nmos ad=79.8f pd=0.8u as=0 ps=0 w=0.42u l=1u
X1593 VSS.t1247 VDD VSS.t1247 VSS.t224 sg13_lv_nmos ad=79.8f pd=0.8u as=0 ps=0 w=0.42u l=1u
X1594 VDD VSS.t2773 VDD VDD sg13_lv_pmos ad=0.19p pd=1.38u as=0 ps=0 w=1u l=1u
X1595 VSS.t2490 VDD VSS.t2489 VSS.t2488 sg13_lv_nmos ad=0.1428p pd=1.52u as=0 ps=0 w=0.42u l=1u
X1596 VDD VSS.t317 VDD VDD sg13_lv_pmos ad=0.34p pd=2.68u as=0 ps=0 w=1u l=1u
X1597 VDD VSS.t382 VDD VDD sg13_lv_pmos ad=0.34p pd=2.68u as=0 ps=0 w=1u l=1u
X1598 VDD VSS.t450 VDD VDD sg13_lv_pmos ad=0.19p pd=1.38u as=0 ps=0 w=1u l=1u
X1599 VSS.t1863 VDD VSS.t1865 VSS.t1864 sg13_lv_nmos ad=79.8f pd=0.8u as=0 ps=0 w=0.42u l=1u
X1600 a_6660_14488# a_6634_14452# VDD VDD sg13_lv_pmos ad=0.34p pd=2.68u as=0.36237p ps=2.605u w=1u l=0.13u
X1601 a_21466_15960# sg13cmos5l_a21oi_1_1.Y VDD VDD sg13_lv_pmos ad=0.1428p pd=1.52u as=0.1523p ps=1.38u w=0.42u l=0.13u
X1602 VSS.t1656 VDD VSS.t1655 VSS.t1654 sg13_lv_nmos ad=0.1428p pd=1.52u as=0 ps=0 w=0.42u l=1u
X1603 VSS.t118 a_19024_14726# a_18673_14845# VSS.t39 sg13_lv_nmos ad=79.8f pd=0.8u as=0.1428p ps=1.52u w=0.42u l=0.13u
X1604 VSS.t822 VDD VSS.t824 VSS.t823 sg13_lv_nmos ad=79.8f pd=0.8u as=0 ps=0 w=0.42u l=1u
X1605 VDD VSS.t2347 VDD VDD sg13_lv_pmos ad=0.19p pd=1.38u as=0 ps=0 w=1u l=1u
X1606 VDD VSS.t1287 VDD VDD sg13_lv_pmos ad=0.34p pd=2.68u as=0 ps=0 w=1u l=1u
X1607 VDD VSS.t1623 VDD VDD sg13_lv_pmos ad=0.19p pd=1.38u as=0 ps=0 w=1u l=1u
X1608 VDD a_26362_16237# sg13cmos5l_dfrbpq_1_7.RESET_B VDD sg13_lv_pmos ad=2.8961p pd=18.25u as=0.3927p ps=2.99u w=1.155u l=0.13u
X1609 VSS.t937 VDD VSS.t939 VSS.t938 sg13_lv_nmos ad=79.8f pd=0.8u as=0 ps=0 w=0.42u l=1u
X1610 VSS.t1953 VDD VSS.t1955 VSS.t1954 sg13_lv_nmos ad=79.8f pd=0.8u as=0 ps=0 w=0.42u l=1u
X1611 a_3082_15457# a_3525_15213# a_2822_15234# VSS.t32 sg13_lv_nmos ad=79.8f pd=0.8u as=0.1296p ps=1.52u w=0.42u l=0.13u
X1612 VDD VSS.t2734 VDD VDD sg13_lv_pmos ad=0.19p pd=1.38u as=0 ps=0 w=1u l=1u
X1613 VSS.t2023 VDD VSS.t2022 VSS.t2021 sg13_lv_nmos ad=0.1428p pd=1.52u as=0 ps=0 w=0.42u l=1u
X1614 VSS.t46 a_8302_13911# sg13cmos5l_xor2_1_1.A VSS.t45 sg13_lv_nmos ad=0.1426p pd=1.16u as=0.2516p ps=2.16u w=0.74u l=0.13u
X1615 VDD VSS.t1189 VDD VDD sg13_lv_pmos ad=0.19p pd=1.38u as=0 ps=0 w=1u l=1u
X1616 VSS.t2235 VDD VSS.t2234 VSS.t2233 sg13_lv_nmos ad=0.1428p pd=1.52u as=0 ps=0 w=0.42u l=1u
X1617 VDD VSS.t1650 VDD VDD sg13_lv_pmos ad=0.34p pd=2.68u as=0 ps=0 w=1u l=1u
X1618 VSS.t2632 VDD VSS.t2633 VSS.t2620 sg13_lv_nmos ad=79.8f pd=0.8u as=0 ps=0 w=0.42u l=1u
X1619 VDD VSS.t989 VDD VDD sg13_lv_pmos ad=0.19p pd=1.38u as=0 ps=0 w=1u l=1u
X1620 VDD VSS.t2497 VDD VDD sg13_lv_pmos ad=0.19p pd=1.38u as=0 ps=0 w=1u l=1u
X1621 a_3396_15247# a_3108_15552# a_3334_15247# VSS.t3193 sg13_lv_nmos ad=0.1428p pd=1.52u as=37.8f ps=0.6u w=0.42u l=0.13u
X1622 VDD VSS.t438 VDD VDD sg13_lv_pmos ad=0.34p pd=2.68u as=0 ps=0 w=1u l=1u
X1623 a_16356_13735# a_16587_13844# a_16042_13945# VSS.t294 sg13_lv_nmos ad=0.2373p pd=1.97u as=79.8f ps=0.8u w=0.42u l=0.13u
X1624 VSS.t1686 VDD VSS.t1688 VSS.t1687 sg13_lv_nmos ad=79.8f pd=0.8u as=0 ps=0 w=0.42u l=1u
X1625 VSS.t2103 VDD VSS.t2105 VSS.t2104 sg13_lv_nmos ad=79.8f pd=0.8u as=0 ps=0 w=0.42u l=1u
X1626 a_16294_13735# sg13cmos5l_dfrbpq_1_2.RESET_B VSS.t691 VSS.t3280 sg13_lv_nmos ad=37.8f pd=0.6u as=0.1701p ps=1.65u w=0.42u l=0.13u
X1627 VSS.t857 VDD VSS.t859 VSS.t858 sg13_lv_nmos ad=79.8f pd=0.8u as=0 ps=0 w=0.42u l=1u
X1628 VDD a_15790_15238# sg13cmos5l_buf_16_2.A VDD sg13_lv_pmos ad=0.2128p pd=1.5u as=0.2128p ps=1.5u w=1.12u l=0.13u
X1629 VSS.t977 VDD VSS.t979 VSS.t978 sg13_lv_nmos ad=79.8f pd=0.8u as=0 ps=0 w=0.42u l=1u
X1630 VDD VSS.t1997 VDD VDD sg13_lv_pmos ad=0.34p pd=2.68u as=0 ps=0 w=1u l=1u
X1631 VSS.t69 a_7354_13690# a_7073_13912# VSS.t93 sg13_lv_nmos ad=79.8f pd=0.8u as=0.1428p ps=1.52u w=0.42u l=0.5u
X1632 VSS.t1022 VDD VSS.t1024 VSS.t1023 sg13_lv_nmos ad=79.8f pd=0.8u as=0 ps=0 w=0.42u l=1u
X1633 VDD VSS.t3129 VDD VDD sg13_lv_pmos ad=0.19p pd=1.38u as=0 ps=0 w=1u l=1u
X1634 VSS.t2705 VDD VSS.t2704 VSS.t2620 sg13_lv_nmos ad=0.1428p pd=1.52u as=0 ps=0 w=0.42u l=1u
X1635 VDD VSS.t2697 VDD VDD sg13_lv_pmos ad=0.19p pd=1.38u as=0 ps=0 w=1u l=1u
X1636 VDD VSS.t1945 VDD VDD sg13_lv_pmos ad=0.19p pd=1.38u as=0 ps=0 w=1u l=1u
X1637 VSS.t333 VDD VSS.t332 VSS.t331 sg13_lv_nmos ad=0.1428p pd=1.52u as=0 ps=0 w=0.42u l=1u
X1638 VSS.t582 VDD VSS.t582 VSS.t583 sg13_lv_nmos ad=79.8f pd=0.8u as=0 ps=0 w=0.42u l=1u
X1639 VSS.t2360 VDD VSS.t2359 VSS.t2358 sg13_lv_nmos ad=0.1428p pd=1.52u as=0 ps=0 w=0.42u l=1u
X1640 VSS.t2053 VDD VSS.t2055 VSS.t2054 sg13_lv_nmos ad=79.8f pd=0.8u as=0 ps=0 w=0.42u l=1u
X1641 VSS.t430 VDD VSS.t430 VSS.t2 sg13_lv_nmos ad=79.8f pd=0.8u as=0 ps=0 w=0.42u l=1u
X1642 VSS.t1616 VDD VSS.t1618 VSS.t1617 sg13_lv_nmos ad=79.8f pd=0.8u as=0 ps=0 w=0.42u l=1u
X1643 VSS.t3147 VDD VSS.t3149 VSS.t3148 sg13_lv_nmos ad=79.8f pd=0.8u as=0 ps=0 w=0.42u l=1u
X1644 VSS.t2667 VDD VSS.t2665 VSS.t2620 sg13_lv_nmos ad=0.1428p pd=1.52u as=0 ps=0 w=0.42u l=1u
X1645 VDD VSS.t2292 VDD VDD sg13_lv_pmos ad=0.19p pd=1.38u as=0 ps=0 w=1u l=1u
X1646 VDD VSS.t1171 VDD VDD sg13_lv_pmos ad=0.34p pd=2.68u as=0 ps=0 w=1u l=1u
X1647 VDD VSS.t1628 VDD VDD sg13_lv_pmos ad=0.19p pd=1.38u as=0 ps=0 w=1u l=1u
X1648 VSS.t2008 VDD VSS.t2007 VSS.t2006 sg13_lv_nmos ad=0.1428p pd=1.52u as=0 ps=0 w=0.42u l=1u
X1649 sg13cmos5l_dlygate4sd3_1_3.X a_6678_15302# VSS.t77 VSS.t208 sg13_lv_nmos ad=0.2516p pd=2.16u as=0.1426p ps=1.16u w=0.74u l=0.13u
X1650 VDD VSS.t826 VDD VDD sg13_lv_pmos ad=0.34p pd=2.68u as=0 ps=0 w=1u l=1u
X1651 VSS.t481 sg13cmos5l_buf_16_2.A a_12212_15202# VSS.t3310 sg13_lv_nmos ad=0.1406p pd=1.12u as=0.1406p ps=1.12u w=0.74u l=0.13u
X1652 VDD VSS.t1580 VDD VDD sg13_lv_pmos ad=0.34p pd=2.68u as=0 ps=0 w=1u l=1u
X1653 VSS.t2425 VDD VSS.t2427 VSS.t2426 sg13_lv_nmos ad=79.8f pd=0.8u as=0 ps=0 w=0.42u l=1u
X1654 VSS.t1898 VDD VSS.t1900 VSS.t1899 sg13_lv_nmos ad=79.8f pd=0.8u as=0 ps=0 w=0.42u l=1u
X1655 a_10149_15213# sg13cmos5l_dfrbpq_1_2.CLK VSS.t2 VSS.t163 sg13_lv_nmos ad=0.2516p pd=2.16u as=5.06795p ps=32.87u w=0.74u l=0.13u
X1656 VSS.t1313 VDD VSS.t1312 VSS.t224 sg13_lv_nmos ad=0.1428p pd=1.52u as=0 ps=0 w=0.42u l=1u
X1657 VDD VSS.t1635 VDD VDD sg13_lv_pmos ad=0.34p pd=2.68u as=0 ps=0 w=1u l=1u
X1658 VDD VSS.t2454 VDD VDD sg13_lv_pmos ad=0.34p pd=2.68u as=0 ps=0 w=1u l=1u
X1659 a_7017_14531# a_6660_14488# VDD VDD sg13_lv_pmos ad=63f pd=0.72u as=0.1563p ps=1.22u w=0.42u l=0.13u
X1660 a_16042_13945# a_16485_13701# a_16425_14113# VDD sg13_lv_pmos ad=79.8f pd=0.8u as=63f ps=0.72u w=0.42u l=0.13u
X1661 VDD VSS.t879 VDD VDD sg13_lv_pmos ad=0.19p pd=1.38u as=0 ps=0 w=1u l=1u
X1662 VSS.t1436 VDD VSS.t1316 VSS.t224 sg13_lv_nmos ad=0.1428p pd=1.52u as=0 ps=0 w=0.42u l=1u
X1663 sg13cmos5l_o21ai_1_3.A2 sg13cmos5l_dfrbpq_1_2.Q VDD VDD sg13_lv_pmos ad=0.2128p pd=1.5u as=0.3808p ps=2.92u w=1.12u l=0.13u
X1664 VDD VSS.t430 VDD VDD sg13_lv_pmos ad=0.19p pd=1.38u as=0 ps=0 w=1u l=1u
X1665 VSS.t1848 VDD VSS.t1850 VSS.t1849 sg13_lv_nmos ad=79.8f pd=0.8u as=0 ps=0 w=0.42u l=1u
X1666 VDD VSS.t1319 VDD VDD sg13_lv_pmos ad=0.19p pd=1.38u as=0 ps=0 w=1u l=1u
X1667 a_6374_14922# sg13cmos5l_dfrbpq_1_1.D VDD VDD sg13_lv_pmos ad=79.8f pd=0.8u as=0.1428p ps=1.52u w=0.42u l=0.13u
X1668 VSS.t446 VDD VSS.t446 VSS.t2 sg13_lv_nmos ad=79.8f pd=0.8u as=0 ps=0 w=0.42u l=1u
X1669 VSS.t2717 VDD VSS.t2716 VSS.t2620 sg13_lv_nmos ad=0.1428p pd=1.52u as=0 ps=0 w=0.42u l=1u
X1670 VDD VSS.t193 VDD VDD sg13_lv_pmos ad=0.34p pd=2.68u as=0 ps=0 w=1u l=1u
X1671 VDD VSS.t2688 VDD VDD sg13_lv_pmos ad=0.19p pd=1.38u as=0 ps=0 w=1u l=1u
X1672 VDD VSS.t1965 VDD VDD sg13_lv_pmos ad=0.19p pd=1.38u as=0 ps=0 w=1u l=1u
X1673 a_27503_13799# a_26661_13701# a_26244_14040# VDD sg13_lv_pmos ad=0.2048p pd=1.63u as=0.34p ps=2.68u w=1u l=0.13u
X1674 VDD VSS.t3081 VDD VDD sg13_lv_pmos ad=0.34p pd=2.68u as=0 ps=0 w=1u l=1u
X1675 VDD VSS.t2284 VDD VDD sg13_lv_pmos ad=0.34p pd=2.68u as=0 ps=0 w=1u l=1u
X1676 VDD VSS.t1608 VDD VDD sg13_lv_pmos ad=0.19p pd=1.38u as=0 ps=0 w=1u l=1u
X1677 VSS.t1199 VDD VSS.t1200 VSS.t224 sg13_lv_nmos ad=79.8f pd=0.8u as=0 ps=0 w=0.42u l=1u
X1678 VDD VSS.t981 VDD VDD sg13_lv_pmos ad=0.34p pd=2.68u as=0 ps=0 w=1u l=1u
X1679 VDD VSS.t1648 VDD VDD sg13_lv_pmos ad=0.19p pd=1.38u as=0 ps=0 w=1u l=1u
X1680 VDD VSS.t416 VDD VDD sg13_lv_pmos ad=0.34p pd=2.68u as=0 ps=0 w=1u l=1u
X1681 VDD VSS.t919 VDD VDD sg13_lv_pmos ad=0.19p pd=1.38u as=0 ps=0 w=1u l=1u
X1682 VSS.t1571 VDD VSS.t1570 VSS.t1569 sg13_lv_nmos ad=0.1428p pd=1.52u as=0 ps=0 w=0.42u l=1u
X1683 VSS.t3102 VDD VSS.t3101 VSS.t3100 sg13_lv_nmos ad=0.1428p pd=1.52u as=0 ps=0 w=0.42u l=1u
X1684 VSS.t142 a_12212_15202# sg13cmos5l_dfrbpq_1_2.CLK VSS.t144 sg13_lv_nmos ad=0.1406p pd=1.12u as=0.1406p ps=1.12u w=0.74u l=0.13u
X1685 VDD VSS.t2297 VDD VDD sg13_lv_pmos ad=0.19p pd=1.38u as=0 ps=0 w=1u l=1u
X1686 VSS.t2623 VDD VSS.t2624 VSS.t2620 sg13_lv_nmos ad=79.8f pd=0.8u as=0 ps=0 w=0.42u l=1u
X1687 VSS.t450 VDD VSS.t450 VSS.t2 sg13_lv_nmos ad=79.8f pd=0.8u as=0 ps=0 w=0.42u l=1u
X1688 VSS.t787 VDD VSS.t789 VSS.t788 sg13_lv_nmos ad=79.8f pd=0.8u as=0 ps=0 w=0.42u l=1u
X1689 VDD VSS.t2779 VDD VDD sg13_lv_pmos ad=0.19p pd=1.38u as=0 ps=0 w=1u l=1u
X1690 VDD VSS.t618 VDD VDD sg13_lv_pmos ad=0.19p pd=1.38u as=0 ps=0 w=1u l=1u
X1691 VSS.t857 VDD VSS.t859 VSS.t858 sg13_lv_nmos ad=79.8f pd=0.8u as=0 ps=0 w=0.42u l=1u
X1692 VDD VSS.t846 VDD VDD sg13_lv_pmos ad=0.34p pd=2.68u as=0 ps=0 w=1u l=1u
X1693 VSS.t1868 VDD VSS.t1870 VSS.t1869 sg13_lv_nmos ad=79.8f pd=0.8u as=0 ps=0 w=0.42u l=1u
X1694 VDD a_26446_15423# sg13cmos5l_dfrbpq_1_5.D VDD sg13_lv_pmos ad=0.2254p pd=1.53u as=0.4256p ps=3u w=1.12u l=0.13u
X1695 VSS.t1022 VDD VSS.t1024 VSS.t1023 sg13_lv_nmos ad=79.8f pd=0.8u as=0 ps=0 w=0.42u l=1u
X1696 VDD VSS.t1270 VDD VDD sg13_lv_pmos ad=0.34p pd=2.68u as=0 ps=0 w=1u l=1u
X1697 a_27730_14922# sg13cmos5l_dfrbpq_1_7.RESET_B VSS.t1 VSS.t2 sg13_lv_nmos ad=37.8f pd=0.6u as=79.8f ps=0.8u w=0.42u l=0.13u
X1698 VDD VSS.t566 VDD VDD sg13_lv_pmos ad=0.34p pd=2.68u as=0 ps=0 w=1u l=1u
X1699 VSS.t2410 VDD VSS.t2412 VSS.t2411 sg13_lv_nmos ad=79.8f pd=0.8u as=0 ps=0 w=0.42u l=1u
X1700 VDD VSS.t1982 VDD VDD sg13_lv_pmos ad=0.34p pd=2.68u as=0 ps=0 w=1u l=1u
X1701 VDD VSS.t2352 VDD VDD sg13_lv_pmos ad=0.19p pd=1.38u as=0 ps=0 w=1u l=1u
X1702 a_8156_15532# sg13cmos5l_xor2_1_0.B VDD VDD sg13_lv_pmos ad=0.2128p pd=1.5u as=0.2128p ps=1.5u w=1.12u l=0.13u
X1703 VDD sg13cmos5l_xnor2_1_1.A a_18716_15976# VDD sg13_lv_pmos ad=0.3808p pd=2.92u as=0.2128p ps=1.5u w=1.12u l=0.15u
X1704 VSS.t882 VDD VSS.t881 VSS.t880 sg13_lv_nmos ad=0.1428p pd=1.52u as=0 ps=0 w=0.42u l=1u
X1705 VDD VSS.t2107 VDD VDD sg13_lv_pmos ad=0.34p pd=2.68u as=0 ps=0 w=1u l=1u
X1706 VDD VSS.t549 VDD VDD sg13_lv_pmos ad=0.34p pd=2.68u as=0 ps=0 w=1u l=1u
X1707 VSS.t1365 VDD VSS.t1214 VSS.t224 sg13_lv_nmos ad=79.8f pd=0.8u as=0 ps=0 w=0.42u l=1u
X1708 VSS.t1958 VDD VSS.t1960 VSS.t1959 sg13_lv_nmos ad=79.8f pd=0.8u as=0 ps=0 w=0.42u l=1u
X1709 VDD VSS.t420 VDD VDD sg13_lv_pmos ad=0.34p pd=2.68u as=0 ps=0 w=1u l=1u
X1710 VDD VSS.t1308 VDD VDD sg13_lv_pmos ad=0.19p pd=1.38u as=0 ps=0 w=1u l=1u
X1711 sg13cmos5l_buf_16_2.A a_15790_15238# VDD VDD sg13_lv_pmos ad=0.2128p pd=1.5u as=0.2128p ps=1.5u w=1.12u l=0.13u
X1712 VSS.t1993 VDD VSS.t1992 VSS.t1991 sg13_lv_nmos ad=0.1428p pd=1.52u as=0 ps=0 w=0.42u l=1u
X1713 VDD a_7916_15960# counter_value_o[1] VDD sg13_lv_pmos ad=0.2114p pd=1.54u as=0.42p ps=2.99u w=1.12u l=0.13u
X1714 a_16140_14750# sg13cmos5l_o21ai_1_2.A1 VDD VDD sg13_lv_pmos ad=0.1596p pd=1.22u as=0.2891p ps=1.695u w=0.84u l=0.13u
X1715 VSS.t1179 VDD VSS.t1178 VSS.t224 sg13_lv_nmos ad=0.1428p pd=1.52u as=0 ps=0 w=0.42u l=1u
X1716 VSS.t942 VDD VSS.t944 VSS.t943 sg13_lv_nmos ad=79.8f pd=0.8u as=0 ps=0 w=0.42u l=1u
X1717 VDD VSS.t1565 VDD VDD sg13_lv_pmos ad=0.34p pd=2.68u as=0 ps=0 w=1u l=1u
X1718 VDD VSS.t809 VDD VDD sg13_lv_pmos ad=0.19p pd=1.38u as=0 ps=0 w=1u l=1u
X1719 VDD VSS.t1620 VDD VDD sg13_lv_pmos ad=0.34p pd=2.68u as=0 ps=0 w=1u l=1u
X1720 VSS.t3002 VDD VSS.t3004 VSS.t3003 sg13_lv_nmos ad=79.8f pd=0.8u as=0 ps=0 w=0.42u l=1u
X1721 VSS.t2365 VDD VSS.t2364 VSS.t2363 sg13_lv_nmos ad=0.1428p pd=1.52u as=0 ps=0 w=0.42u l=1u
X1722 VSS.t1908 VDD VSS.t1910 VSS.t1909 sg13_lv_nmos ad=79.8f pd=0.8u as=0 ps=0 w=0.42u l=1u
X1723 VDD sg13cmos5l_nor2_1_1.Y a_9368_14525# VDD sg13_lv_pmos ad=0.1523p pd=1.38u as=0.1428p ps=1.52u w=0.42u l=0.13u
X1724 a_25958_13722# a_26763_13844# a_26218_13945# VDD sg13_lv_pmos ad=0.1428p pd=1.52u as=79.8f ps=0.8u w=0.42u l=0.13u
X1725 VDD VSS.t2944 VDD VDD sg13_lv_pmos ad=0.19p pd=1.38u as=0 ps=0 w=1u l=1u
X1726 a_10149_15213# sg13cmos5l_dfrbpq_1_2.CLK VDD VDD sg13_lv_pmos ad=0.4088p pd=2.97u as=2.77542p ps=17.49u w=1.12u l=0.13u
X1727 VSS.t1691 VDD VSS.t1693 VSS.t1692 sg13_lv_nmos ad=79.8f pd=0.8u as=0 ps=0 w=0.42u l=1u
X1728 a_18106_15960# sg13cmos5l_dlygate4sd3_1_7.A VDD VDD sg13_lv_pmos ad=0.1428p pd=1.52u as=0.1523p ps=1.38u w=0.42u l=0.13u
X1729 VDD VSS.t132 VDD VDD sg13_lv_pmos ad=0.34p pd=2.68u as=0 ps=0 w=1u l=1u
X1730 VSS.t2782 VDD VSS.t2783 VSS.t2620 sg13_lv_nmos ad=79.8f pd=0.8u as=0 ps=0 w=0.42u l=1u
X1731 VDD VSS.t2344 VDD VDD sg13_lv_pmos ad=0.34p pd=2.68u as=0 ps=0 w=1u l=1u
X1732 VDD VSS.t2002 VDD VDD sg13_lv_pmos ad=0.34p pd=2.68u as=0 ps=0 w=1u l=1u
X1733 VDD a_27760_13942# a_27705_14037# VDD sg13_lv_pmos ad=2.42015p pd=15.68u as=93.45f ps=0.865u w=0.42u l=0.13u
X1734 VDD VSS.t1310 VDD VDD sg13_lv_pmos ad=0.19p pd=1.38u as=0 ps=0 w=1u l=1u
X1735 VSS.t528 VDD VSS.t527 VSS.t526 sg13_lv_nmos ad=0.1428p pd=1.52u as=0 ps=0 w=0.42u l=1u
X1736 VSS.t2707 VDD VSS.t2707 VSS.t2620 sg13_lv_nmos ad=0.1428p pd=1.52u as=0 ps=0 w=0.42u l=1u
X1737 VSS.t1265 VDD VSS.t1264 VSS.t224 sg13_lv_nmos ad=0.1428p pd=1.52u as=0 ps=0 w=0.42u l=1u
X1738 VDD VSS.t2679 VDD VDD sg13_lv_pmos ad=0.19p pd=1.38u as=0 ps=0 w=1u l=1u
X1739 VDD VSS.t1950 VDD VDD sg13_lv_pmos ad=0.19p pd=1.38u as=0 ps=0 w=1u l=1u
X1740 VDD VSS.t1288 VDD VDD sg13_lv_pmos ad=0.34p pd=2.68u as=0 ps=0 w=1u l=1u
X1741 VSS.t2330 VDD VSS.t2329 VSS.t2328 sg13_lv_nmos ad=0.1428p pd=1.52u as=0 ps=0 w=0.42u l=1u
X1742 VDD VSS.t462 VDD VDD sg13_lv_pmos ad=0.34p pd=2.68u as=0 ps=0 w=1u l=1u
X1743 VDD VSS.t632 VDD VDD sg13_lv_pmos ad=0.34p pd=2.68u as=0 ps=0 w=1u l=1u
X1744 VDD VSS.t1026 VDD VDD sg13_lv_pmos ad=0.34p pd=2.68u as=0 ps=0 w=1u l=1u
X1745 VSS.t1621 VDD VSS.t1623 VSS.t1622 sg13_lv_nmos ad=79.8f pd=0.8u as=0 ps=0 w=0.42u l=1u
X1746 VSS.t3152 VDD VSS.t3154 VSS.t3153 sg13_lv_nmos ad=79.8f pd=0.8u as=0 ps=0 w=0.42u l=1u
X1747 VSS.t113 sg13cmos5l_inv_1_0.Y sg13cmos5l_a21oi_1_2.Y VSS.t8 sg13_lv_nmos ad=0.2516p pd=2.16u as=0.1406p ps=1.12u w=0.74u l=0.13u
X1748 VSS.t109 VDD VSS.t109 VSS.t392 sg13_lv_nmos ad=0.1428p pd=1.52u as=0 ps=0 w=0.42u l=1u
X1749 VDD VSS.t483 VDD VDD sg13_lv_pmos ad=0.34p pd=2.68u as=0 ps=0 w=1u l=1u
X1750 VSS.t912 VDD VSS.t911 VSS.t910 sg13_lv_nmos ad=0.1428p pd=1.52u as=0 ps=0 w=0.42u l=1u
X1751 VSS.t2430 VDD VSS.t2432 VSS.t2431 sg13_lv_nmos ad=79.8f pd=0.8u as=0 ps=0 w=0.42u l=1u
X1752 VSS.t787 VDD VSS.t789 VSS.t788 sg13_lv_nmos ad=79.8f pd=0.8u as=0 ps=0 w=0.42u l=1u
X1753 VDD VSS.t964 VDD VDD sg13_lv_pmos ad=0.19p pd=1.38u as=0 ps=0 w=1u l=1u
X1754 VDD VSS.t1241 VDD VDD sg13_lv_pmos ad=0.19p pd=1.38u as=0 ps=0 w=1u l=1u
X1755 VSS.t2706 VDD VSS.t2705 VSS.t2620 sg13_lv_nmos ad=0.1428p pd=1.52u as=0 ps=0 w=0.42u l=1u
X1756 VDD VSS.t2459 VDD VDD sg13_lv_pmos ad=0.34p pd=2.68u as=0 ps=0 w=1u l=1u
X1757 VSS.t430 VDD VSS.t430 VSS.t2 sg13_lv_nmos ad=79.8f pd=0.8u as=0 ps=0 w=0.42u l=1u
X1758 VDD a_17327_13799# a_17584_13942# VDD sg13_lv_pmos ad=2.42015p pd=15.68u as=79.8f ps=0.8u w=0.42u l=0.13u
X1759 VSS.t1651 VDD VSS.t1650 VSS.t1649 sg13_lv_nmos ad=0.1428p pd=1.52u as=0 ps=0 w=0.42u l=1u
X1760 VDD VSS.t2929 VDD VDD sg13_lv_pmos ad=0.19p pd=1.38u as=0 ps=0 w=1u l=1u
X1761 VDD VSS.t2771 VDD VDD sg13_lv_pmos ad=0.19p pd=1.38u as=0 ps=0 w=1u l=1u
X1762 VSS.t343 VDD VSS.t345 VSS.t344 sg13_lv_nmos ad=79.8f pd=0.8u as=0 ps=0 w=0.42u l=1u
X1763 a_10991_15311# a_10149_15213# a_9732_15552# VDD sg13_lv_pmos ad=0.2048p pd=1.63u as=0.34p ps=2.68u w=1u l=0.13u
X1764 a_16356_13735# a_16068_14040# a_16294_13735# VSS.t3289 sg13_lv_nmos ad=0.1428p pd=1.52u as=37.8f ps=0.6u w=0.42u l=0.13u
X1765 VDD VSS.t2743 VDD VDD sg13_lv_pmos ad=0.34p pd=2.68u as=0 ps=0 w=1u l=1u
X1766 VDD VSS.t566 VDD VDD sg13_lv_pmos ad=0.34p pd=2.68u as=0 ps=0 w=1u l=1u
X1767 VSS.t533 VDD VSS.t532 VSS.t531 sg13_lv_nmos ad=0.1428p pd=1.52u as=0 ps=0 w=0.42u l=1u
X1768 VSS.t555 VDD VSS.t555 VSS.t670 sg13_lv_nmos ad=79.8f pd=0.8u as=0 ps=0 w=0.42u l=1u
X1769 VSS.t2947 VDD VSS.t2949 VSS.t2948 sg13_lv_nmos ad=79.8f pd=0.8u as=0 ps=0 w=0.42u l=1u
X1770 VSS.t1853 VDD VSS.t1855 VSS.t1854 sg13_lv_nmos ad=79.8f pd=0.8u as=0 ps=0 w=0.42u l=1u
X1771 a_25766_14922# a_26571_14495# a_26026_14452# VDD sg13_lv_pmos ad=0.1428p pd=1.52u as=79.8f ps=0.8u w=0.42u l=0.13u
X1772 VDD VSS.t1170 VDD VDD sg13_lv_pmos ad=0.19p pd=1.38u as=0 ps=0 w=1u l=1u
X1773 VDD VSS.t1322 VDD VDD sg13_lv_pmos ad=0.19p pd=1.38u as=0 ps=0 w=1u l=1u
X1774 VSS.t1646 VDD VSS.t1645 VSS.t1644 sg13_lv_nmos ad=0.1428p pd=1.52u as=0 ps=0 w=0.42u l=1u
X1775 VDD VSS.t839 VDD VDD sg13_lv_pmos ad=0.19p pd=1.38u as=0 ps=0 w=1u l=1u
X1776 VSS.t882 VDD VSS.t881 VSS.t880 sg13_lv_nmos ad=0.1428p pd=1.52u as=0 ps=0 w=0.42u l=1u
X1777 VSS.t1279 VDD VSS.t1278 VSS.t224 sg13_lv_nmos ad=0.1428p pd=1.52u as=0 ps=0 w=0.42u l=1u
X1778 VDD VSS.t2337 VDD VDD sg13_lv_pmos ad=0.19p pd=1.38u as=0 ps=0 w=1u l=1u
X1779 VSS.t2395 VDD VSS.t2397 VSS.t2396 sg13_lv_nmos ad=79.8f pd=0.8u as=0 ps=0 w=0.42u l=1u
X1780 a_21370_15202# sg13cmos5l_o21ai_1_1.Y VDD VDD sg13_lv_pmos ad=0.1428p pd=1.52u as=0.1523p ps=1.38u w=0.42u l=0.13u
X1781 VDD VSS.t2691 VDD VDD sg13_lv_pmos ad=0.19p pd=1.38u as=0 ps=0 w=1u l=1u
X1782 VDD VSS.t1935 VDD VDD sg13_lv_pmos ad=0.19p pd=1.38u as=0 ps=0 w=1u l=1u
X1783 VDD VSS.t456 VDD VDD sg13_lv_pmos ad=0.19p pd=1.38u as=0 ps=0 w=1u l=1u
X1784 VDD VSS.t3086 VDD VDD sg13_lv_pmos ad=0.34p pd=2.68u as=0 ps=0 w=1u l=1u
X1785 VSS.t2350 VDD VSS.t2349 VSS.t2348 sg13_lv_nmos ad=0.1428p pd=1.52u as=0 ps=0 w=0.42u l=1u
X1786 VDD VSS.t2289 VDD VDD sg13_lv_pmos ad=0.34p pd=2.68u as=0 ps=0 w=1u l=1u
X1787 VSS.t438 VDD VSS.t438 VSS.t2 sg13_lv_nmos ad=79.8f pd=0.8u as=0 ps=0 w=0.42u l=1u
X1788 VDD VSS.t1618 VDD VDD sg13_lv_pmos ad=0.19p pd=1.38u as=0 ps=0 w=1u l=1u
X1789 VSS.t49 sg13cmos5l_o21ai_1_2.B1 a_24265_14508# VSS.t7 sg13_lv_nmos ad=0.13395p pd=1.12u as=0.198p ps=1.27u w=0.55u l=0.13u
X1790 VDD VSS.t1222 VDD VDD sg13_lv_pmos ad=0.34p pd=2.68u as=0 ps=0 w=1u l=1u
X1791 VSS.t942 VDD VSS.t944 VSS.t943 sg13_lv_nmos ad=79.8f pd=0.8u as=0 ps=0 w=0.42u l=1u
X1792 VDD VSS.t1673 VDD VDD sg13_lv_pmos ad=0.19p pd=1.38u as=0 ps=0 w=1u l=1u
X1793 VSS.t193 VDD VSS.t193 VSS.t73 sg13_lv_nmos ad=0.1428p pd=1.52u as=0 ps=0 w=0.42u l=1u
X1794 VSS.t543 VDD VSS.t540 VSS.t542 sg13_lv_nmos ad=0.1428p pd=1.52u as=0 ps=0 w=0.42u l=1u
X1795 VSS.t987 VDD VSS.t989 VSS.t988 sg13_lv_nmos ad=79.8f pd=0.8u as=0 ps=0 w=0.42u l=1u
X1796 a_8698_13690# sg13cmos5l_dlygate4sd3_1_0.A VSS.t185 VSS.t251 sg13_lv_nmos ad=0.1428p pd=1.52u as=79.8f ps=0.8u w=0.42u l=0.13u
X1797 VSS.t582 VDD VSS.t582 VSS.t583 sg13_lv_nmos ad=79.8f pd=0.8u as=0 ps=0 w=0.42u l=1u
X1798 VDD VSS.t1199 VDD VDD sg13_lv_pmos ad=0.19p pd=1.38u as=0 ps=0 w=1u l=1u
X1799 VDD VSS.t2764 VDD VDD sg13_lv_pmos ad=0.19p pd=1.38u as=0 ps=0 w=1u l=1u
X1800 VSS.t2073 VDD VSS.t2072 VSS.t2071 sg13_lv_nmos ad=0.1428p pd=1.52u as=0 ps=0 w=0.42u l=1u
X1801 VDD VSS.t303 VDD VDD sg13_lv_pmos ad=0.19p pd=1.38u as=0 ps=0 w=1u l=1u
X1802 VSS.t1636 VDD VSS.t1635 VSS.t1634 sg13_lv_nmos ad=0.1428p pd=1.52u as=0 ps=0 w=0.42u l=1u
X1803 VSS.t3167 VDD VSS.t3166 VSS.t3165 sg13_lv_nmos ad=0.1428p pd=1.52u as=0 ps=0 w=0.42u l=1u
X1804 VSS.t2987 VDD VSS.t2989 VSS.t2988 sg13_lv_nmos ad=79.8f pd=0.8u as=0 ps=0 w=0.42u l=1u
X1805 VSS.t2699 VDD VSS.t2700 VSS.t2620 sg13_lv_nmos ad=79.8f pd=0.8u as=0 ps=0 w=0.42u l=1u
X1806 VDD VSS.t354 VDD VDD sg13_lv_pmos ad=0.19p pd=1.38u as=0 ps=0 w=1u l=1u
X1807 sg13cmos5l_nor2_1_1.B a_8982_15302# VDD VDD sg13_lv_pmos ad=0.4256p pd=3u as=0.2254p ps=1.53u w=1.12u l=0.13u
X1808 VSS.t14 sg13cmos5l_o21ai_1_2.A1 a_16175_14854# VSS.t255 sg13_lv_nmos ad=0.1898p pd=1.36u as=0.1406p ps=1.12u w=0.74u l=0.13u
X1809 VDD VSS.t994 VDD VDD sg13_lv_pmos ad=0.19p pd=1.38u as=0 ps=0 w=1u l=1u
X1810 VSS.t2773 VDD VSS.t2774 VSS.t2620 sg13_lv_nmos ad=79.8f pd=0.8u as=0 ps=0 w=0.42u l=1u
X1811 VSS.t37 sg13cmos5l_xor2_1_0.B a_7985_15288# VSS.t241 sg13_lv_nmos ad=0.15245p pd=1.17u as=0.17462p ps=1.185u w=0.55u l=0.13u
X1812 VDD VSS.t791 VDD VDD sg13_lv_pmos ad=0.34p pd=2.68u as=0 ps=0 w=1u l=1u
X1813 VDD VSS.t1987 VDD VDD sg13_lv_pmos ad=0.34p pd=2.68u as=0 ps=0 w=1u l=1u
X1814 VDD sg13cmos5l_dlygate4sd3_1_5.A a_6296_15238# VDD sg13_lv_pmos ad=0.1523p pd=1.38u as=0.1428p ps=1.52u w=0.42u l=0.13u
X1815 a_9446_15234# sg13cmos5l_dlygate4sd3_1_6.X VDD VDD sg13_lv_pmos ad=79.8f pd=0.8u as=0.1428p ps=1.52u w=0.42u l=0.13u
X1816 VDD VSS.t3119 VDD VDD sg13_lv_pmos ad=0.19p pd=1.38u as=0 ps=0 w=1u l=1u
X1817 VDD VSS.t2357 VDD VDD sg13_lv_pmos ad=0.19p pd=1.38u as=0 ps=0 w=1u l=1u
X1818 VSS.t2380 VDD VSS.t2382 VSS.t2381 sg13_lv_nmos ad=79.8f pd=0.8u as=0 ps=0 w=0.42u l=1u
X1819 sg13cmos5l_dlygate4sd3_1_7.A sg13cmos5l_dlygate4sd3_1_10.X VDD VDD sg13_lv_pmos ad=0.2128p pd=1.5u as=0.3808p ps=2.92u w=1.12u l=0.15u
X1820 VDD VSS.t2112 VDD VDD sg13_lv_pmos ad=0.34p pd=2.68u as=0 ps=0 w=1u l=1u
X1821 VSS.t1546 VDD VSS.t1548 VSS.t1547 sg13_lv_nmos ad=79.8f pd=0.8u as=0 ps=0 w=0.42u l=1u
X1822 VDD VSS.t2774 VDD VDD sg13_lv_pmos ad=0.34p pd=2.68u as=0 ps=0 w=1u l=1u
X1823 VSS.t1963 VDD VSS.t1965 VSS.t1964 sg13_lv_nmos ad=79.8f pd=0.8u as=0 ps=0 w=0.42u l=1u
X1824 VDD VSS.t601 VDD VDD sg13_lv_pmos ad=0.34p pd=2.68u as=0 ps=0 w=1u l=1u
X1825 VSS.t2697 VDD VSS.t2698 VSS.t2620 sg13_lv_nmos ad=79.8f pd=0.8u as=0 ps=0 w=0.42u l=1u
X1826 a_9446_15234# a_10251_15356# a_9706_15457# VDD sg13_lv_pmos ad=0.1428p pd=1.52u as=79.8f ps=0.8u w=0.42u l=0.13u
X1827 VDD a_19546_15202# a_19265_15424# VDD sg13_lv_pmos ad=0.1523p pd=1.38u as=0.34p ps=2.68u w=1u l=0.5u
X1828 VSS.t1606 VDD VSS.t1608 VSS.t1607 sg13_lv_nmos ad=79.8f pd=0.8u as=0 ps=0 w=0.42u l=1u
X1829 VSS.t3137 VDD VSS.t3139 VSS.t3138 sg13_lv_nmos ad=79.8f pd=0.8u as=0 ps=0 w=0.42u l=1u
X1830 VSS.t912 VDD VSS.t911 VSS.t910 sg13_lv_nmos ad=0.1428p pd=1.52u as=0 ps=0 w=0.42u l=1u
X1831 VSS.t1297 VDD VSS.t1295 VSS.t224 sg13_lv_nmos ad=0.1428p pd=1.52u as=0 ps=0 w=0.42u l=1u
X1832 VDD VSS.t1009 VDD VDD sg13_lv_pmos ad=0.19p pd=1.38u as=0 ps=0 w=1u l=1u
X1833 VDD VSS.t1269 VDD VDD sg13_lv_pmos ad=0.19p pd=1.38u as=0 ps=0 w=1u l=1u
X1834 VSS.t193 VDD VSS.t193 VSS.t406 sg13_lv_nmos ad=0.1428p pd=1.52u as=0 ps=0 w=0.42u l=1u
X1835 VSS.t430 VDD VSS.t434 VSS.t2 sg13_lv_nmos ad=79.8f pd=0.8u as=0 ps=0 w=0.42u l=1u
X1836 VDD VSS.t1570 VDD VDD sg13_lv_pmos ad=0.34p pd=2.68u as=0 ps=0 w=1u l=1u
X1837 VDD VSS.t1625 VDD VDD sg13_lv_pmos ad=0.34p pd=2.68u as=0 ps=0 w=1u l=1u
X1838 VSS.t3007 VDD VSS.t3009 VSS.t3008 sg13_lv_nmos ad=79.8f pd=0.8u as=0 ps=0 w=0.42u l=1u
X1839 VSS.t1913 VDD VSS.t1915 VSS.t1914 sg13_lv_nmos ad=79.8f pd=0.8u as=0 ps=0 w=0.42u l=1u
X1840 VDD a_11248_15454# a_11193_15549# VDD sg13_lv_pmos ad=2.8961p pd=18.25u as=93.45f ps=0.865u w=0.42u l=0.13u
X1841 VDD VSS.t2914 VDD VDD sg13_lv_pmos ad=0.19p pd=1.38u as=0 ps=0 w=1u l=1u
X1842 sg13cmos5l_buf_16_2.X a_19534_13726# VDD VDD sg13_lv_pmos ad=0.2128p pd=1.5u as=0.2128p ps=1.5u w=1.12u l=0.13u
X1843 VSS.t1316 VDD VSS.t1315 VSS.t224 sg13_lv_nmos ad=0.1428p pd=1.52u as=0 ps=0 w=0.42u l=1u
X1844 VSS.t1696 VDD VSS.t1698 VSS.t1697 sg13_lv_nmos ad=79.8f pd=0.8u as=0 ps=0 w=0.42u l=1u
X1845 VDD VSS.t2735 VDD VDD sg13_lv_pmos ad=0.34p pd=2.68u as=0 ps=0 w=1u l=1u
X1846 a_7550_15242# sg13cmos5l_xor2_1_1.A a_7448_15242# VSS.t67 sg13_lv_nmos ad=0.1406p pd=1.12u as=0.1406p ps=1.12u w=0.74u l=0.13u
X1847 VDD VSS.t946 VDD VDD sg13_lv_pmos ad=0.34p pd=2.68u as=0 ps=0 w=1u l=1u
X1848 VSS.t121 a_21934_15423# sg13cmos5l_or3_1_2.A VSS.t3271 sg13_lv_nmos ad=0.1426p pd=1.16u as=0.2516p ps=2.16u w=0.74u l=0.13u
X1849 VDD VSS.t2314 VDD VDD sg13_lv_pmos ad=0.34p pd=2.68u as=0 ps=0 w=1u l=1u
X1850 VDD VSS.t1313 VDD VDD sg13_lv_pmos ad=0.19p pd=1.38u as=0 ps=0 w=1u l=1u
X1851 VSS.t313 VDD VSS.t312 VSS.t311 sg13_lv_nmos ad=0.1428p pd=1.52u as=0 ps=0 w=0.42u l=1u
X1852 VDD VSS.t2499 VDD VDD sg13_lv_pmos ad=0.34p pd=2.68u as=0 ps=0 w=1u l=1u
X1853 VDD VSS.t1284 VDD VDD sg13_lv_pmos ad=0.34p pd=2.68u as=0 ps=0 w=1u l=1u
X1854 VDD VSS.t2682 VDD VDD sg13_lv_pmos ad=0.19p pd=1.38u as=0 ps=0 w=1u l=1u
X1855 VDD VSS.t2097 VDD VDD sg13_lv_pmos ad=0.34p pd=2.68u as=0 ps=0 w=1u l=1u
X1856 VDD VSS.t1920 VDD VDD sg13_lv_pmos ad=0.19p pd=1.38u as=0 ps=0 w=1u l=1u
X1857 VSS.t632 VDD VSS.t632 VSS.t633 sg13_lv_nmos ad=0.1428p pd=1.52u as=0 ps=0 w=0.42u l=1u
X1858 VSS.t2335 VDD VSS.t2334 VSS.t2333 sg13_lv_nmos ad=0.1428p pd=1.52u as=0 ps=0 w=0.42u l=1u
X1859 VDD VSS.t2274 VDD VDD sg13_lv_pmos ad=0.34p pd=2.68u as=0 ps=0 w=1u l=1u
X1860 a_17508_14488# a_17482_14452# VSS.t21 VSS.t3181 sg13_lv_nmos ad=0.2516p pd=2.16u as=0.1626p ps=1.415u w=0.74u l=0.13u
X1861 VDD VSS.t3071 VDD VDD sg13_lv_pmos ad=0.34p pd=2.68u as=0 ps=0 w=1u l=1u
X1862 VDD VSS.t537 VDD VDD sg13_lv_pmos ad=0.19p pd=1.38u as=0 ps=0 w=1u l=1u
X1863 VSS.t3122 VDD VSS.t3124 VSS.t3123 sg13_lv_nmos ad=79.8f pd=0.8u as=0 ps=0 w=0.42u l=1u
X1864 a_7062_13330# sg13cmos5l_xor2_1_1.B sg13cmos5l_dlygate4sd3_1_1.A VSS.t110 sg13_lv_nmos ad=88.8f pd=0.98u as=0.1628p ps=1.18u w=0.74u l=0.13u
X1865 VSS.t609 VDD VSS.t116 VSS.t739 sg13_lv_nmos ad=0.1428p pd=1.52u as=0 ps=0 w=0.42u l=1u
X1866 VDD VSS.t1249 VDD VDD sg13_lv_pmos ad=0.34p pd=2.68u as=0 ps=0 w=1u l=1u
X1867 VSS.t987 VDD VSS.t989 VSS.t988 sg13_lv_nmos ad=79.8f pd=0.8u as=0 ps=0 w=0.42u l=1u
X1868 VSS.t1324 VDD VSS.t1324 VSS.t224 sg13_lv_nmos ad=0.1428p pd=1.52u as=0 ps=0 w=0.42u l=1u
X1869 VDD VSS.t1603 VDD VDD sg13_lv_pmos ad=0.19p pd=1.38u as=0 ps=0 w=1u l=1u
X1870 a_19186_14922# sg13cmos5l_dfrbpq_1_3.RESET_B VSS.t118 VSS.t39 sg13_lv_nmos ad=37.8f pd=0.6u as=79.8f ps=0.8u w=0.42u l=0.13u
X1871 VSS.t1491 VDD VSS.t1493 VSS.t1492 sg13_lv_nmos ad=79.8f pd=0.8u as=0 ps=0 w=0.42u l=1u
X1872 VSS.t2400 VDD VSS.t2402 VSS.t2401 sg13_lv_nmos ad=79.8f pd=0.8u as=0 ps=0 w=0.42u l=1u
X1873 sg13cmos5l_buf_16_2.X a_19534_13726# VSS.t712 VSS.t3296 sg13_lv_nmos ad=0.1406p pd=1.12u as=0.1406p ps=1.12u w=0.74u l=0.13u
X1874 VSS.t847 VDD VSS.t846 VSS.t845 sg13_lv_nmos ad=0.1428p pd=1.52u as=0 ps=0 w=0.42u l=1u
X1875 VDD VSS.t1191 VDD VDD sg13_lv_pmos ad=0.19p pd=1.38u as=0 ps=0 w=1u l=1u
X1876 VDD VSS.t1975 VDD VDD sg13_lv_pmos ad=0.19p pd=1.38u as=0 ps=0 w=1u l=1u
X1877 VDD VSS.t731 VDD VDD sg13_lv_pmos ad=0.19p pd=1.38u as=0 ps=0 w=1u l=1u
X1878 VSS.t1621 VDD VSS.t1620 VSS.t1619 sg13_lv_nmos ad=0.1428p pd=1.52u as=0 ps=0 w=0.42u l=1u
X1879 VSS.t3152 VDD VSS.t3151 VSS.t3150 sg13_lv_nmos ad=0.1428p pd=1.52u as=0 ps=0 w=0.42u l=1u
X1880 a_17327_13799# a_16485_13701# a_16068_14040# VDD sg13_lv_pmos ad=0.2048p pd=1.63u as=0.34p ps=2.68u w=1u l=0.13u
X1881 VSS.t641 VDD VSS.t641 VSS.t765 sg13_lv_nmos ad=79.8f pd=0.8u as=0 ps=0 w=0.42u l=1u
X1882 sg13cmos5l_or3_1_2.B a_14549_15238# VSS.t81 VSS.t80 sg13_lv_nmos ad=0.1406p pd=1.12u as=0.3293p ps=1.63u w=0.74u l=0.13u
X1883 VDD VSS.t598 VDD VDD sg13_lv_pmos ad=0.19p pd=1.38u as=0 ps=0 w=1u l=1u
X1884 VSS.t2952 VDD VSS.t2954 VSS.t2953 sg13_lv_nmos ad=79.8f pd=0.8u as=0 ps=0 w=0.42u l=1u
X1885 VSS.t1858 VDD VSS.t1860 VSS.t1859 sg13_lv_nmos ad=79.8f pd=0.8u as=0 ps=0 w=0.42u l=1u
X1886 VSS.t21 a_15790_15238# sg13cmos5l_buf_16_2.A VSS.t20 sg13_lv_nmos ad=0.1406p pd=1.12u as=0.1406p ps=1.12u w=0.74u l=0.13u
X1887 VDD VSS.t1304 VDD VDD sg13_lv_pmos ad=0.19p pd=1.38u as=0 ps=0 w=1u l=1u
X1888 VDD VSS.t2342 VDD VDD sg13_lv_pmos ad=0.19p pd=1.38u as=0 ps=0 w=1u l=1u
X1889 VDD VSS.t1488 VDD VDD sg13_lv_pmos ad=0.19p pd=1.38u as=0 ps=0 w=1u l=1u
X1890 a_15809_16344# sg13cmos5l_a21oi_1_0.A1 sg13cmos5l_a21oi_1_0.Y VSS.t3272 sg13_lv_nmos ad=0.1406p pd=1.12u as=0.1406p ps=1.12u w=0.74u l=0.13u
X1891 VDD VSS.t571 VDD VDD sg13_lv_pmos ad=0.34p pd=2.68u as=0 ps=0 w=1u l=1u
X1892 VSS.t1531 VDD VSS.t1533 VSS.t1532 sg13_lv_nmos ad=79.8f pd=0.8u as=0 ps=0 w=0.42u l=1u
X1893 VSS.t1711 VDD VSS.t1710 VSS.t1709 sg13_lv_nmos ad=0.1428p pd=1.52u as=0 ps=0 w=0.42u l=1u
X1894 VDD VSS.t3056 VDD VDD sg13_lv_pmos ad=0.34p pd=2.68u as=0 ps=0 w=1u l=1u
X1895 VDD VSS.t2259 VDD VDD sg13_lv_pmos ad=0.34p pd=2.68u as=0 ps=0 w=1u l=1u
X1896 VSS.t1948 VDD VSS.t1950 VSS.t1949 sg13_lv_nmos ad=79.8f pd=0.8u as=0 ps=0 w=0.42u l=1u
X1897 VDD VSS.t426 VDD VDD sg13_lv_pmos ad=0.19p pd=1.38u as=0 ps=0 w=1u l=1u
X1898 VSS.t2688 VDD VSS.t2688 VSS.t2620 sg13_lv_nmos ad=79.8f pd=0.8u as=0 ps=0 w=0.42u l=1u
X1899 VDD VSS.t2653 VDD VDD sg13_lv_pmos ad=0.19p pd=1.38u as=0 ps=0 w=1u l=1u
X1900 VDD VSS.t1623 VDD VDD sg13_lv_pmos ad=0.19p pd=1.38u as=0 ps=0 w=1u l=1u
X1901 VDD VSS.t2974 VDD VDD sg13_lv_pmos ad=0.19p pd=1.38u as=0 ps=0 w=1u l=1u
X1902 VSS.t102 a_10991_15311# a_11658_15532# VSS.t101 sg13_lv_nmos ad=0.1406p pd=1.12u as=0.2516p ps=2.16u w=0.74u l=0.13u
X1903 VDD sg13cmos5l_nand4_1_0.Y a_14549_15238# VDD sg13_lv_pmos ad=0.203p pd=1.5u as=0.1596p ps=1.22u w=0.84u l=0.13u
X1904 VDD VSS.t44 VDD VDD sg13_lv_pmos ad=0.34p pd=2.68u as=0 ps=0 w=1u l=1u
X1905 VDD VSS.t1967 VDD VDD sg13_lv_pmos ad=0.34p pd=2.68u as=0 ps=0 w=1u l=1u
X1906 VSS.t807 VDD VSS.t809 VSS.t808 sg13_lv_nmos ad=79.8f pd=0.8u as=0 ps=0 w=0.42u l=1u
X1907 sg13cmos5l_buf_16_2.X a_19534_13726# VSS.t710 VSS.t3292 sg13_lv_nmos ad=0.1406p pd=1.12u as=0.1406p ps=1.12u w=0.74u l=0.13u
X1908 VDD VSS.t866 VDD VDD sg13_lv_pmos ad=0.34p pd=2.68u as=0 ps=0 w=1u l=1u
X1909 VDD VSS.t2766 VDD VDD sg13_lv_pmos ad=0.19p pd=1.38u as=0 ps=0 w=1u l=1u
X1910 VSS.t2355 VDD VSS.t2354 VSS.t2353 sg13_lv_nmos ad=0.1428p pd=1.52u as=0 ps=0 w=0.42u l=1u
X1911 VSS.t2078 VDD VSS.t2077 VSS.t2076 sg13_lv_nmos ad=0.1428p pd=1.52u as=0 ps=0 w=0.42u l=1u
X1912 VSS.t625 VDD VSS.t620 VSS.t751 sg13_lv_nmos ad=0.1428p pd=1.52u as=0 ps=0 w=0.42u l=1u
X1913 VSS.t1641 VDD VSS.t1640 VSS.t1639 sg13_lv_nmos ad=0.1428p pd=1.52u as=0 ps=0 w=0.42u l=1u
X1914 VSS.t3172 VDD VSS.t3171 VSS.t3170 sg13_lv_nmos ad=0.1428p pd=1.52u as=0 ps=0 w=0.42u l=1u
X1915 VSS.t2992 VDD VSS.t2994 VSS.t2993 sg13_lv_nmos ad=79.8f pd=0.8u as=0 ps=0 w=0.42u l=1u
X1916 VDD a_16485_13701# a_16587_13844# VDD sg13_lv_pmos ad=2.42015p pd=15.68u as=0.3864p ps=2.93u w=1.12u l=0.13u
X1917 VDD VSS.t1650 VDD VDD sg13_lv_pmos ad=0.34p pd=2.68u as=0 ps=0 w=1u l=1u
X1918 VDD VSS.t585 VDD VDD sg13_lv_pmos ad=0.34p pd=2.68u as=0 ps=0 w=1u l=1u
X1919 VDD VSS.t991 VDD VDD sg13_lv_pmos ad=0.34p pd=2.68u as=0 ps=0 w=1u l=1u
X1920 VSS.t1681 VDD VSS.t1683 VSS.t1682 sg13_lv_nmos ad=79.8f pd=0.8u as=0 ps=0 w=0.42u l=1u
X1921 VSS.t2776 VDD VSS.t2777 VSS.t2620 sg13_lv_nmos ad=79.8f pd=0.8u as=0 ps=0 w=0.42u l=1u
X1922 VSS.t1843 VDD VSS.t1845 VSS.t1844 sg13_lv_nmos ad=79.8f pd=0.8u as=0 ps=0 w=0.42u l=1u
X1923 VDD VSS.t2299 VDD VDD sg13_lv_pmos ad=0.34p pd=2.68u as=0 ps=0 w=1u l=1u
X1924 VSS.t14 a_15790_15238# sg13cmos5l_buf_16_2.A VSS.t15 sg13_lv_nmos ad=0.1406p pd=1.12u as=0.1406p ps=1.12u w=0.74u l=0.13u
X1925 VDD VSS.t2327 VDD VDD sg13_lv_pmos ad=0.19p pd=1.38u as=0 ps=0 w=1u l=1u
X1926 VSS.t2385 VDD VSS.t2387 VSS.t2386 sg13_lv_nmos ad=79.8f pd=0.8u as=0 ps=0 w=0.42u l=1u
X1927 a_21070_16263# a_21185_16262# VSS.t79 VSS.t78 sg13_lv_nmos ad=0.1428p pd=1.52u as=0.1426p ps=1.16u w=0.42u l=0.5u
X1928 VDD VSS.t929 VDD VDD sg13_lv_pmos ad=0.19p pd=1.38u as=0 ps=0 w=1u l=1u
X1929 VSS.t1225 VDD VSS.t1226 VSS.t224 sg13_lv_nmos ad=79.8f pd=0.8u as=0 ps=0 w=0.42u l=1u
X1930 VDD VSS.t1473 VDD VDD sg13_lv_pmos ad=0.19p pd=1.38u as=0 ps=0 w=1u l=1u
X1931 VDD VSS.t2082 VDD VDD sg13_lv_pmos ad=0.34p pd=2.68u as=0 ps=0 w=1u l=1u
X1932 VDD VSS.t1319 VDD VDD sg13_lv_pmos ad=0.19p pd=1.38u as=0 ps=0 w=1u l=1u
X1933 VDD VSS.t1275 VDD VDD sg13_lv_pmos ad=0.34p pd=2.68u as=0 ps=0 w=1u l=1u
X1934 VSS.t1551 VDD VSS.t1553 VSS.t1552 sg13_lv_nmos ad=79.8f pd=0.8u as=0 ps=0 w=0.42u l=1u
X1935 VDD VSS.t2777 VDD VDD sg13_lv_pmos ad=0.34p pd=2.68u as=0 ps=0 w=1u l=1u
X1936 VSS.t1933 VDD VSS.t1935 VSS.t1934 sg13_lv_nmos ad=79.8f pd=0.8u as=0 ps=0 w=0.42u l=1u
X1937 VDD VSS.t696 VDD VDD sg13_lv_pmos ad=0.19p pd=1.38u as=0 ps=0 w=1u l=1u
X1938 VSS.t9 a_22480_14726# a_22129_14845# VSS.t7 sg13_lv_nmos ad=79.8f pd=0.8u as=0.1428p ps=1.52u w=0.42u l=0.13u
X1939 VSS.t1268 VDD VSS.t1269 VSS.t224 sg13_lv_nmos ad=79.8f pd=0.8u as=0 ps=0 w=0.42u l=1u
X1940 VSS.t2967 VDD VSS.t2966 VSS.t2965 sg13_lv_nmos ad=0.1428p pd=1.52u as=0 ps=0 w=0.42u l=1u
X1941 VSS.t1873 VDD VSS.t1872 VSS.t1871 sg13_lv_nmos ad=0.1428p pd=1.52u as=0 ps=0 w=0.42u l=1u
X1942 VDD sg13cmos5l_dfrbpq_1_3.Q sg13cmos5l_o21ai_1_3.A2 VDD sg13_lv_pmos ad=0.2128p pd=1.5u as=0.2128p ps=1.5u w=1.12u l=0.13u
X1943 a_26842_15202# sg13cmos5l_dlygate4sd3_1_15.A VSS.t1 VSS.t3231 sg13_lv_nmos ad=0.1428p pd=1.52u as=79.8f ps=0.8u w=0.42u l=0.13u
X1944 a_26469_14495# sg13cmos5l_buf_16_2.X VDD VDD sg13_lv_pmos ad=0.4088p pd=2.97u as=2.3367p ps=15.135u w=1.12u l=0.13u
X1945 VSS.t1347 VDD VSS.t1189 VSS.t224 sg13_lv_nmos ad=0.1428p pd=1.52u as=0 ps=0 w=0.42u l=1u
X1946 VSS.t12 VDD VSS.t12 VSS.t377 sg13_lv_nmos ad=0.1428p pd=1.52u as=0 ps=0 w=0.42u l=1u
X1947 VSS.t962 VDD VSS.t964 VSS.t963 sg13_lv_nmos ad=79.8f pd=0.8u as=0 ps=0 w=0.42u l=1u
X1948 VDD VSS.t426 VDD VDD sg13_lv_pmos ad=0.19p pd=1.38u as=0 ps=0 w=1u l=1u
X1949 VDD VSS.t636 VDD VDD sg13_lv_pmos ad=0.19p pd=1.38u as=0 ps=0 w=1u l=1u
X1950 VDD VSS.t1031 VDD VDD sg13_lv_pmos ad=0.34p pd=2.68u as=0 ps=0 w=1u l=1u
X1951 VSS.t847 VDD VSS.t846 VSS.t845 sg13_lv_nmos ad=0.1428p pd=1.52u as=0 ps=0 w=0.42u l=1u
X1952 VSS.t1671 VDD VSS.t1673 VSS.t1672 sg13_lv_nmos ad=79.8f pd=0.8u as=0 ps=0 w=0.42u l=1u
X1953 VSS.t2655 VDD VSS.t2656 VSS.t2620 sg13_lv_nmos ad=79.8f pd=0.8u as=0 ps=0 w=0.42u l=1u
X1954 VDD VSS.t327 VDD VDD sg13_lv_pmos ad=0.34p pd=2.68u as=0 ps=0 w=1u l=1u
X1955 VDD sg13cmos5l_buf_16_2.A a_12212_15202# VDD sg13_lv_pmos ad=0.2128p pd=1.5u as=0.2128p ps=1.5u w=1.12u l=0.13u
X1956 VDD VSS.t441 VDD VDD sg13_lv_pmos ad=0.19p pd=1.38u as=0 ps=0 w=1u l=1u
X1957 a_7919_14845# a_7077_14495# a_6660_14488# VDD sg13_lv_pmos ad=0.2048p pd=1.63u as=0.34p ps=2.68u w=1u l=0.13u
X1958 VDD VSS.t1630 VDD VDD sg13_lv_pmos ad=0.34p pd=2.68u as=0 ps=0 w=1u l=1u
X1959 VDD VSS.t2919 VDD VDD sg13_lv_pmos ad=0.19p pd=1.38u as=0 ps=0 w=1u l=1u
X1960 VSS.t153 a_10714_14448# a_10433_14750# VSS.t3 sg13_lv_nmos ad=79.8f pd=0.8u as=0.1428p ps=1.52u w=0.42u l=0.5u
X1961 VDD VSS.t1635 VDD VDD sg13_lv_pmos ad=0.34p pd=2.68u as=0 ps=0 w=1u l=1u
X1962 VDD VSS.t2737 VDD VDD sg13_lv_pmos ad=0.34p pd=2.68u as=0 ps=0 w=1u l=1u
X1963 VSS.t430 VDD VSS.t430 VSS.t2 sg13_lv_nmos ad=0.1428p pd=1.52u as=0 ps=0 w=0.42u l=1u
X1964 VDD VSS.t598 VDD VDD sg13_lv_pmos ad=0.19p pd=1.38u as=0 ps=0 w=1u l=1u
X1965 VSS.t1666 VDD VSS.t1668 VSS.t1667 sg13_lv_nmos ad=79.8f pd=0.8u as=0 ps=0 w=0.42u l=1u
X1966 VSS.t96 VDD VSS.t48 VSS.t699 sg13_lv_nmos ad=0.1428p pd=1.52u as=0 ps=0 w=0.42u l=1u
X1967 VDD VSS.t1201 VDD VDD sg13_lv_pmos ad=0.34p pd=2.68u as=0 ps=0 w=1u l=1u
X1968 VDD VSS.t2319 VDD VDD sg13_lv_pmos ad=0.34p pd=2.68u as=0 ps=0 w=1u l=1u
X1969 VDD VSS.t1977 VDD VDD sg13_lv_pmos ad=0.34p pd=2.68u as=0 ps=0 w=1u l=1u
X1970 VSS.t2937 VDD VSS.t2939 VSS.t2938 sg13_lv_nmos ad=79.8f pd=0.8u as=0 ps=0 w=0.42u l=1u
X1971 sg13cmos5l_dfrbpq_1_2.CLK a_12212_15202# VSS.t142 VSS.t145 sg13_lv_nmos ad=0.1406p pd=1.12u as=0.1406p ps=1.12u w=0.74u l=0.13u
X1972 VDD VSS.t1295 VDD VDD sg13_lv_pmos ad=0.19p pd=1.38u as=0 ps=0 w=1u l=1u
X1973 VDD VSS.t2504 VDD VDD sg13_lv_pmos ad=0.34p pd=2.68u as=0 ps=0 w=1u l=1u
X1974 VDD VSS.t2685 VDD VDD sg13_lv_pmos ad=0.19p pd=1.38u as=0 ps=0 w=1u l=1u
X1975 a_22425_14607# a_21483_14495# a_22223_14845# VDD sg13_lv_pmos ad=93.45f pd=0.865u as=0.2048p ps=1.63u w=0.42u l=0.13u
X1976 VDD VSS.t571 VDD VDD sg13_lv_pmos ad=0.34p pd=2.68u as=0 ps=0 w=1u l=1u
X1977 VDD VSS.t1046 VDD VDD sg13_lv_pmos ad=0.34p pd=2.68u as=0 ps=0 w=1u l=1u
X1978 VSS.t1501 VDD VSS.t1503 VSS.t1502 sg13_lv_nmos ad=79.8f pd=0.8u as=0 ps=0 w=0.42u l=1u
X1979 VSS.t2340 VDD VSS.t2339 VSS.t2338 sg13_lv_nmos ad=0.1428p pd=1.52u as=0 ps=0 w=0.42u l=1u
X1980 VDD VSS.t446 VDD VDD sg13_lv_pmos ad=0.19p pd=1.38u as=0 ps=0 w=1u l=1u
X1981 VSS.t1696 VDD VSS.t1695 VSS.t1694 sg13_lv_nmos ad=0.1428p pd=1.52u as=0 ps=0 w=0.42u l=1u
X1982 VSS.t2113 VDD VSS.t2112 VSS.t2111 sg13_lv_nmos ad=0.1428p pd=1.52u as=0 ps=0 w=0.42u l=1u
X1983 a_27760_13942# a_27503_13799# a_27922_13722# VSS.t189 sg13_lv_nmos ad=0.1428p pd=1.52u as=37.8f ps=0.6u w=0.42u l=0.13u
X1984 VSS.t193 VDD VSS.t398 VSS.t402 sg13_lv_nmos ad=0.1428p pd=1.52u as=0 ps=0 w=0.42u l=1u
X1985 VSS.t807 VDD VSS.t809 VSS.t808 sg13_lv_nmos ad=79.8f pd=0.8u as=0 ps=0 w=0.42u l=1u
X1986 VSS.t1243 VDD VSS.t1244 VSS.t224 sg13_lv_nmos ad=79.8f pd=0.8u as=0 ps=0 w=0.42u l=1u
X1987 VDD VSS.t1608 VDD VDD sg13_lv_pmos ad=0.19p pd=1.38u as=0 ps=0 w=1u l=1u
X1988 VDD VSS.t1663 VDD VDD sg13_lv_pmos ad=0.19p pd=1.38u as=0 ps=0 w=1u l=1u
X1989 VSS.t1496 VDD VSS.t1498 VSS.t1497 sg13_lv_nmos ad=79.8f pd=0.8u as=0 ps=0 w=0.42u l=1u
X1990 VDD VSS.t3136 VDD VDD sg13_lv_pmos ad=0.34p pd=2.68u as=0 ps=0 w=1u l=1u
X1991 VSS.t2405 VDD VSS.t2407 VSS.t2406 sg13_lv_nmos ad=79.8f pd=0.8u as=0 ps=0 w=0.42u l=1u
X1992 VDD VSS.t416 VDD VDD sg13_lv_pmos ad=0.34p pd=2.68u as=0 ps=0 w=1u l=1u
X1993 VDD a_12212_15202# sg13cmos5l_dfrbpq_1_2.CLK VDD sg13_lv_pmos ad=0.2128p pd=1.5u as=0.2128p ps=1.5u w=1.12u l=0.13u
X1994 VDD VSS.t1193 VDD VDD sg13_lv_pmos ad=0.19p pd=1.38u as=0 ps=0 w=1u l=1u
X1995 VDD VSS.t2758 VDD VDD sg13_lv_pmos ad=0.19p pd=1.38u as=0 ps=0 w=1u l=1u
X1996 VSS.t1626 VDD VSS.t1625 VSS.t1624 sg13_lv_nmos ad=0.1428p pd=1.52u as=0 ps=0 w=0.42u l=1u
X1997 sg13cmos5l_buf_1_0.X a_1192_3900# VDD VDD sg13_lv_pmos ad=0.42p pd=2.99u as=0.2114p ps=1.54u w=1.12u l=0.13u
X1998 VSS.t3157 VDD VSS.t3156 VSS.t3155 sg13_lv_nmos ad=0.1428p pd=1.52u as=0 ps=0 w=0.42u l=1u
X1999 VSS.t546 VDD VSS.t543 VSS.t545 sg13_lv_nmos ad=0.1428p pd=1.52u as=0 ps=0 w=0.42u l=1u
X2000 VDD VSS.t585 VDD VDD sg13_lv_pmos ad=0.34p pd=2.68u as=0 ps=0 w=1u l=1u
X2001 VSS.t992 VDD VSS.t994 VSS.t993 sg13_lv_nmos ad=79.8f pd=0.8u as=0 ps=0 w=0.42u l=1u
X2002 a_17925_14495# sg13cmos5l_buf_16_2.X VSS.t2 VSS.t56 sg13_lv_nmos ad=0.2516p pd=2.16u as=5.06795p ps=32.87u w=0.74u l=0.13u
X2003 VDD VSS.t1181 VDD VDD sg13_lv_pmos ad=0.19p pd=1.38u as=0 ps=0 w=1u l=1u
X2004 VSS.t2435 VDD VSS.t2434 VSS.t2433 sg13_lv_nmos ad=0.1428p pd=1.52u as=0 ps=0 w=0.42u l=1u
X2005 VDD VSS.t1307 VDD VDD sg13_lv_pmos ad=0.19p pd=1.38u as=0 ps=0 w=1u l=1u
X2006 VSS.t2628 VDD VSS.t2628 VSS.t2620 sg13_lv_nmos ad=0.1428p pd=1.52u as=0 ps=0 w=0.42u l=1u
X2007 a_24982_13350# sg13cmos5l_o21ai_1_3.A2 VSS.t187 VSS.t234 sg13_lv_nmos ad=0.1406p pd=1.12u as=0.1406p ps=1.12u w=0.74u l=0.15u
X2008 VDD VSS.t2680 VDD VDD sg13_lv_pmos ad=0.19p pd=1.38u as=0 ps=0 w=1u l=1u
X2009 VSS.t2370 VDD VSS.t2372 VSS.t2371 sg13_lv_nmos ad=79.8f pd=0.8u as=0 ps=0 w=0.42u l=1u
X2010 sg13cmos5l_dfrbpq_1_2.CLK a_12212_15202# VSS.t135 VSS.t140 sg13_lv_nmos ad=0.1406p pd=1.12u as=0.1406p ps=1.12u w=0.74u l=0.13u
X2011 a_4762_14448# sg13cmos5l_dlygate4sd3_1_5.A VDD VDD sg13_lv_pmos ad=0.1428p pd=1.52u as=0.1523p ps=1.38u w=0.42u l=0.13u
X2012 VDD VSS.t2489 VDD VDD sg13_lv_pmos ad=0.34p pd=2.68u as=0 ps=0 w=1u l=1u
X2013 VDD VSS.t2312 VDD VDD sg13_lv_pmos ad=0.19p pd=1.38u as=0 ps=0 w=1u l=1u
X2014 VDD a_27706_15202# a_27425_15424# VDD sg13_lv_pmos ad=0.1523p pd=1.38u as=0.34p ps=2.68u w=1u l=0.5u
X2015 VDD VSS.t1458 VDD VDD sg13_lv_pmos ad=0.19p pd=1.38u as=0 ps=0 w=1u l=1u
X2016 VDD VSS.t236 VDD VDD sg13_lv_pmos ad=0.19p pd=1.38u as=0 ps=0 w=1u l=1u
X2017 VSS.t1536 VDD VSS.t1538 VSS.t1537 sg13_lv_nmos ad=79.8f pd=0.8u as=0 ps=0 w=0.42u l=1u
X2018 VSS.t1716 VDD VSS.t1715 VSS.t1714 sg13_lv_nmos ad=0.1428p pd=1.52u as=0 ps=0 w=0.42u l=1u
X2019 VSS.t236 VDD VSS.t718 VSS.t719 sg13_lv_nmos ad=0.1428p pd=1.52u as=0 ps=0 w=0.42u l=1u
X2020 VSS.t2691 VDD VSS.t2692 VSS.t2620 sg13_lv_nmos ad=79.8f pd=0.8u as=0 ps=0 w=0.42u l=1u
X2021 VDD VSS.t2437 VDD VDD sg13_lv_pmos ad=0.19p pd=1.38u as=0 ps=0 w=1u l=1u
X2022 VSS.t2098 VDD VSS.t2097 VSS.t2096 sg13_lv_nmos ad=0.1428p pd=1.52u as=0 ps=0 w=0.42u l=1u
X2023 VSS.t962 VDD VSS.t964 VSS.t963 sg13_lv_nmos ad=79.8f pd=0.8u as=0 ps=0 w=0.42u l=1u
X2024 VDD VSS.t1234 VDD VDD sg13_lv_pmos ad=0.34p pd=2.68u as=0 ps=0 w=1u l=1u
X2025 VSS.t1295 VDD VSS.t1294 VSS.t224 sg13_lv_nmos ad=0.1428p pd=1.52u as=0 ps=0 w=0.42u l=1u
X2026 VSS.t365 VDD VSS.t367 VSS.t366 sg13_lv_nmos ad=79.8f pd=0.8u as=0 ps=0 w=0.42u l=1u
X2027 VSS.t44 a_4624_15454# a_4273_15311# VSS.t43 sg13_lv_nmos ad=79.8f pd=0.8u as=0.1428p ps=1.52u w=0.42u l=0.13u
X2028 a_20938_14452# a_21381_14495# a_21321_14531# VDD sg13_lv_pmos ad=79.8f pd=0.8u as=63f ps=0.72u w=0.42u l=0.13u
X2029 VDD VSS.t1322 VDD VDD sg13_lv_pmos ad=0.34p pd=2.68u as=0 ps=0 w=1u l=1u
X2030 VDD VSS.t2979 VDD VDD sg13_lv_pmos ad=0.19p pd=1.38u as=0 ps=0 w=1u l=1u
X2031 VSS.t2952 VDD VSS.t2951 VSS.t2950 sg13_lv_nmos ad=0.1428p pd=1.52u as=0 ps=0 w=0.42u l=1u
X2032 VDD VSS.t193 VDD VDD sg13_lv_pmos ad=0.34p pd=2.68u as=0 ps=0 w=1u l=1u
X2033 a_3525_15213# sg13cmos5l_dfrbpq_1_2.CLK VSS.t2 VSS.t33 sg13_lv_nmos ad=0.2516p pd=2.16u as=5.06795p ps=32.87u w=0.74u l=0.13u
X2034 VSS.t1007 VDD VSS.t1009 VSS.t1008 sg13_lv_nmos ad=79.8f pd=0.8u as=0 ps=0 w=0.42u l=1u
X2035 VDD VSS.t1840 VDD VDD sg13_lv_pmos ad=0.19p pd=1.38u as=0 ps=0 w=1u l=1u
X2036 VSS.t284 VDD VSS.t284 VSS.t357 sg13_lv_nmos ad=79.8f pd=0.8u as=0 ps=0 w=0.42u l=1u
X2037 VSS.t412 VDD VSS.t411 VSS.t410 sg13_lv_nmos ad=0.1428p pd=1.52u as=0 ps=0 w=0.42u l=1u
X2038 VDD VSS.t442 VDD VDD sg13_lv_pmos ad=0.19p pd=1.38u as=0 ps=0 w=1u l=1u
X2039 VDD VSS.t2692 VDD VDD sg13_lv_pmos ad=0.34p pd=2.68u as=0 ps=0 w=1u l=1u
X2040 VDD VSS.t1937 VDD VDD sg13_lv_pmos ad=0.34p pd=2.68u as=0 ps=0 w=1u l=1u
X2041 a_19150_15423# a_19265_15424# VDD VDD sg13_lv_pmos ad=0.34p pd=2.68u as=0.2254p ps=1.53u w=1u l=0.5u
X2042 VSS.t106 sg13cmos5l_nor2_1_1.Y a_9368_14525# VSS.t289 sg13_lv_nmos ad=79.8f pd=0.8u as=0.1428p ps=1.52u w=0.42u l=0.13u
X2043 VDD VSS.t555 VDD VDD sg13_lv_pmos ad=0.19p pd=1.38u as=0 ps=0 w=1u l=1u
X2044 VDD VSS.t1615 VDD VDD sg13_lv_pmos ad=0.34p pd=2.68u as=0 ps=0 w=1u l=1u
X2045 VDD VSS.t2769 VDD VDD sg13_lv_pmos ad=0.19p pd=1.38u as=0 ps=0 w=1u l=1u
X2046 VSS.t185 VDD VSS.t46 VSS.t665 sg13_lv_nmos ad=0.1428p pd=1.52u as=0 ps=0 w=0.42u l=1u
X2047 VDD VSS.t225 VDD VDD sg13_lv_pmos ad=0.34p pd=2.68u as=0 ps=0 w=1u l=1u
X2048 VDD VSS.t1272 VDD VDD sg13_lv_pmos ad=0.19p pd=1.38u as=0 ps=0 w=1u l=1u
X2049 VDD VSS.t569 VDD VDD sg13_lv_pmos ad=0.19p pd=1.38u as=0 ps=0 w=1u l=1u
X2050 VDD VSS.t1620 VDD VDD sg13_lv_pmos ad=0.34p pd=2.68u as=0 ps=0 w=1u l=1u
X2051 VSS.t201 VDD VSS.t201 VSS.t725 sg13_lv_nmos ad=0.1428p pd=1.52u as=0 ps=0 w=0.42u l=1u
X2052 VSS.t1220 VDD VSS.t1220 VSS.t224 sg13_lv_nmos ad=79.8f pd=0.8u as=0 ps=0 w=0.42u l=1u
X2053 VSS.t1511 VDD VSS.t1510 VSS.t1509 sg13_lv_nmos ad=0.1428p pd=1.52u as=0 ps=0 w=0.42u l=1u
X2054 VSS.t2420 VDD VSS.t2419 VSS.t2418 sg13_lv_nmos ad=0.1428p pd=1.52u as=0 ps=0 w=0.42u l=1u
X2055 VDD VSS.t2304 VDD VDD sg13_lv_pmos ad=0.34p pd=2.68u as=0 ps=0 w=1u l=1u
X2056 VSS.t1486 VDD VSS.t1488 VSS.t1487 sg13_lv_nmos ad=79.8f pd=0.8u as=0 ps=0 w=0.42u l=1u
X2057 VSS.t318 VDD VSS.t320 VSS.t319 sg13_lv_nmos ad=79.8f pd=0.8u as=0 ps=0 w=0.42u l=1u
X2058 VSS.t1309 VDD VSS.t1308 VSS.t224 sg13_lv_nmos ad=0.1428p pd=1.52u as=0 ps=0 w=0.42u l=1u
X2059 VSS.t106 sg13cmos5l_tiehi_0.L_HI a_9540_15234# VSS.t3214 sg13_lv_nmos ad=0.1626p pd=1.415u as=60.89999f ps=0.71u w=0.42u l=0.13u
X2060 VDD VSS.t2647 VDD VDD sg13_lv_pmos ad=0.19p pd=1.38u as=0 ps=0 w=1u l=1u
X2061 VSS.t1878 VDD VSS.t1877 VSS.t1876 sg13_lv_nmos ad=0.1428p pd=1.52u as=0 ps=0 w=0.42u l=1u
X2062 VSS.t2048 VDD VSS.t2050 VSS.t2049 sg13_lv_nmos ad=79.8f pd=0.8u as=0 ps=0 w=0.42u l=1u
X2063 VDD VSS.t2005 VDD VDD sg13_lv_pmos ad=0.19p pd=1.38u as=0 ps=0 w=1u l=1u
X2064 VDD a_21070_16263# sg13cmos5l_dfrbpq_1_6.D VDD sg13_lv_pmos ad=0.2254p pd=1.53u as=0.4256p ps=3u w=1.12u l=0.13u
X2065 VSS.t441 VDD VSS.t442 VSS.t2 sg13_lv_nmos ad=79.8f pd=0.8u as=0 ps=0 w=0.42u l=1u
X2066 VDD VSS.t430 VDD VDD sg13_lv_pmos ad=0.34p pd=2.68u as=0 ps=0 w=1u l=1u
X2067 VDD VSS.t1208 VDD VDD sg13_lv_pmos ad=0.19p pd=1.38u as=0 ps=0 w=1u l=1u
X2068 VDD VSS.t2359 VDD VDD sg13_lv_pmos ad=0.34p pd=2.68u as=0 ps=0 w=1u l=1u
X2069 VDD VSS.t193 VDD VDD sg13_lv_pmos ad=0.34p pd=2.68u as=0 ps=0 w=1u l=1u
X2070 VSS.t1481 VDD VSS.t1483 VSS.t1482 sg13_lv_nmos ad=79.8f pd=0.8u as=0 ps=0 w=0.42u l=1u
X2071 VDD VSS.t3121 VDD VDD sg13_lv_pmos ad=0.34p pd=2.68u as=0 ps=0 w=1u l=1u
X2072 VSS.t2390 VDD VSS.t2392 VSS.t2391 sg13_lv_nmos ad=79.8f pd=0.8u as=0 ps=0 w=0.42u l=1u
X2073 VSS.t1676 VDD VSS.t1678 VSS.t1677 sg13_lv_nmos ad=79.8f pd=0.8u as=0 ps=0 w=0.42u l=1u
X2074 VSS.t609 VDD VSS.t609 VSS.t741 sg13_lv_nmos ad=0.1428p pd=1.52u as=0 ps=0 w=0.42u l=1u
X2075 VDD VSS.t1600 VDD VDD sg13_lv_pmos ad=0.34p pd=2.68u as=0 ps=0 w=1u l=1u
X2076 VSS.t1968 VDD VSS.t1967 VSS.t1966 sg13_lv_nmos ad=0.1428p pd=1.52u as=0 ps=0 w=0.42u l=1u
X2077 VSS.t992 VDD VSS.t994 VSS.t993 sg13_lv_nmos ad=79.8f pd=0.8u as=0 ps=0 w=0.42u l=1u
X2078 VDD VSS.t1252 VDD VDD sg13_lv_pmos ad=0.34p pd=2.68u as=0 ps=0 w=1u l=1u
X2079 VDD VSS.t2924 VDD VDD sg13_lv_pmos ad=0.19p pd=1.38u as=0 ps=0 w=1u l=1u
X2080 VSS.t2982 VDD VSS.t2984 VSS.t2983 sg13_lv_nmos ad=79.8f pd=0.8u as=0 ps=0 w=0.42u l=1u
X2081 VDD VSS.t966 VDD VDD sg13_lv_pmos ad=0.34p pd=2.68u as=0 ps=0 w=1u l=1u
X2082 VSS.t1202 VDD VSS.t1201 VSS.t224 sg13_lv_nmos ad=0.1428p pd=1.52u as=0 ps=0 w=0.42u l=1u
X2083 VDD VSS.t1518 VDD VDD sg13_lv_pmos ad=0.19p pd=1.38u as=0 ps=0 w=1u l=1u
X2084 VDD VSS.t735 VDD VDD sg13_lv_pmos ad=0.19p pd=1.38u as=0 ps=0 w=1u l=1u
X2085 VSS.t641 VDD VSS.t641 VSS.t643 sg13_lv_nmos ad=0.1428p pd=1.52u as=0 ps=0 w=0.42u l=1u
X2086 VDD VSS.t1298 VDD VDD sg13_lv_pmos ad=0.19p pd=1.38u as=0 ps=0 w=1u l=1u
X2087 VDD VSS.t2775 VDD VDD sg13_lv_pmos ad=0.34p pd=2.68u as=0 ps=0 w=1u l=1u
X2088 VDD VSS.t2671 VDD VDD sg13_lv_pmos ad=0.19p pd=1.38u as=0 ps=0 w=1u l=1u
X2089 VDD VSS.t2474 VDD VDD sg13_lv_pmos ad=0.34p pd=2.68u as=0 ps=0 w=1u l=1u
X2090 VDD VSS.t549 VDD VDD sg13_lv_pmos ad=0.19p pd=1.38u as=0 ps=0 w=1u l=1u
X2091 VSS.t792 VDD VSS.t791 VSS.t790 sg13_lv_nmos ad=0.1428p pd=1.52u as=0 ps=0 w=0.42u l=1u
X2092 VDD VSS.t340 VDD VDD sg13_lv_pmos ad=0.19p pd=1.38u as=0 ps=0 w=1u l=1u
X2093 VSS.t1471 VDD VSS.t1473 VSS.t1472 sg13_lv_nmos ad=79.8f pd=0.8u as=0 ps=0 w=0.42u l=1u
X2094 VSS.t1701 VDD VSS.t1700 VSS.t1699 sg13_lv_nmos ad=0.1428p pd=1.52u as=0 ps=0 w=0.42u l=1u
X2095 VSS.t42 a_20974_15423# sg13cmos5l_dlygate4sd3_1_13.X VSS.t3264 sg13_lv_nmos ad=0.1426p pd=1.16u as=0.2516p ps=2.16u w=0.74u l=0.13u
X2096 VSS.t1007 VDD VSS.t1009 VSS.t1008 sg13_lv_nmos ad=79.8f pd=0.8u as=0 ps=0 w=0.42u l=1u
X2097 VDD VSS.t1261 VDD VDD sg13_lv_pmos ad=0.34p pd=2.68u as=0 ps=0 w=1u l=1u
X2098 VDD VSS.t1990 VDD VDD sg13_lv_pmos ad=0.19p pd=1.38u as=0 ps=0 w=1u l=1u
X2099 VDD VSS.t3141 VDD VDD sg13_lv_pmos ad=0.34p pd=2.68u as=0 ps=0 w=1u l=1u
X2100 VDD VSS.t1196 VDD VDD sg13_lv_pmos ad=0.19p pd=1.38u as=0 ps=0 w=1u l=1u
X2101 VDD VSS.t1673 VDD VDD sg13_lv_pmos ad=0.19p pd=1.38u as=0 ps=0 w=1u l=1u
X2102 VDD VSS.t2760 VDD VDD sg13_lv_pmos ad=0.19p pd=1.38u as=0 ps=0 w=1u l=1u
X2103 a_3525_15213# sg13cmos5l_dfrbpq_1_2.CLK VDD VDD sg13_lv_pmos ad=0.4088p pd=2.97u as=2.77542p ps=17.49u w=1.12u l=0.13u
X2104 VDD VSS.t1298 VDD VDD sg13_lv_pmos ad=0.19p pd=1.38u as=0 ps=0 w=1u l=1u
X2105 VSS.t1180 VDD VSS.t1181 VSS.t224 sg13_lv_nmos ad=79.8f pd=0.8u as=0 ps=0 w=0.42u l=1u
X2106 VSS.t1631 VDD VSS.t1630 VSS.t1629 sg13_lv_nmos ad=0.1428p pd=1.52u as=0 ps=0 w=0.42u l=1u
X2107 VSS.t3127 VDD VSS.t3126 VSS.t3125 sg13_lv_nmos ad=0.1428p pd=1.52u as=0 ps=0 w=0.42u l=1u
X2108 a_25958_13722# sg13cmos5l_dfrbpq_1_5.D VDD VDD sg13_lv_pmos ad=79.8f pd=0.8u as=0.1428p ps=1.52u w=0.42u l=0.13u
X2109 VDD VSS.t569 VDD VDD sg13_lv_pmos ad=0.19p pd=1.38u as=0 ps=0 w=1u l=1u
X2110 sg13cmos5l_dlygate4sd3_1_15.A sg13cmos5l_inv_1_0.Y VSS.t268 VSS.t267 sg13_lv_nmos ad=0.1406p pd=1.12u as=0.2516p ps=2.16u w=0.74u l=0.13u
X2111 VDD a_5495_15315# a_5495_15549# VDD sg13_lv_pmos ad=2.8961p pd=18.25u as=0.2442p ps=2.06u w=0.66u l=0.13u
X2112 sg13cmos5l_dfrbpq_1_7.D a_25878_16020# VDD VDD sg13_lv_pmos ad=0.4256p pd=3u as=0.2254p ps=1.53u w=1.12u l=0.13u
X2113 VDD VSS.t632 VDD VDD sg13_lv_pmos ad=0.19p pd=1.38u as=0 ps=0 w=1u l=1u
X2114 VSS.t1496 VDD VSS.t1495 VSS.t1494 sg13_lv_nmos ad=0.1428p pd=1.52u as=0 ps=0 w=0.42u l=1u
X2115 VSS.t2405 VDD VSS.t2404 VSS.t2403 sg13_lv_nmos ad=0.1428p pd=1.52u as=0 ps=0 w=0.42u l=1u
X2116 a_15707_15996# sg13cmos5l_inv_1_0.Y sg13cmos5l_a21oi_1_0.Y VDD sg13_lv_pmos ad=0.2128p pd=1.5u as=0.3808p ps=2.92u w=1.12u l=0.13u
X2117 VSS.t2731 VDD VSS.t2733 VSS.t2620 sg13_lv_nmos ad=79.8f pd=0.8u as=0 ps=0 w=0.42u l=1u
X2118 VSS.t2375 VDD VSS.t2377 VSS.t2376 sg13_lv_nmos ad=79.8f pd=0.8u as=0 ps=0 w=0.42u l=1u
X2119 VDD VSS.t590 VDD VDD sg13_lv_pmos ad=0.34p pd=2.68u as=0 ps=0 w=1u l=1u
X2120 VDD VSS.t618 VDD VDD sg13_lv_pmos ad=0.19p pd=1.38u as=0 ps=0 w=1u l=1u
X2121 VDD VSS.t996 VDD VDD sg13_lv_pmos ad=0.34p pd=2.68u as=0 ps=0 w=1u l=1u
X2122 VDD VSS.t2936 VDD VDD sg13_lv_pmos ad=0.34p pd=2.68u as=0 ps=0 w=1u l=1u
X2123 a_27705_14037# a_26763_13844# a_27503_13799# VDD sg13_lv_pmos ad=93.45f pd=0.865u as=0.2048p ps=1.63u w=0.42u l=0.13u
X2124 VSS.t69 sg13cmos5l_xor2_1_1.A a_6906_12935# VSS.t68 sg13_lv_nmos ad=0.374p pd=2.46u as=0.17462p ps=1.185u w=0.55u l=0.13u
X2125 VDD VSS.t811 VDD VDD sg13_lv_pmos ad=0.34p pd=2.68u as=0 ps=0 w=1u l=1u
X2126 VDD VSS.t1463 VDD VDD sg13_lv_pmos ad=0.19p pd=1.38u as=0 ps=0 w=1u l=1u
X2127 VSS.t73 a_26825_16334# a_26746_16237# VSS.t279 sg13_lv_nmos ad=6.38822p pd=41.325u as=0.27427p ps=2.28u w=0.795u l=0.13u
X2128 VSS.t446 VDD VSS.t446 VSS.t2 sg13_lv_nmos ad=79.8f pd=0.8u as=0 ps=0 w=0.42u l=1u
X2129 VSS.t2694 VDD VSS.t2694 VSS.t2620 sg13_lv_nmos ad=79.8f pd=0.8u as=0 ps=0 w=0.42u l=1u
X2130 VSS.t303 VDD VSS.t303 VSS.t305 sg13_lv_nmos ad=0.1428p pd=1.52u as=0 ps=0 w=0.42u l=1u
X2131 a_3029_14854# sg13cmos5l_buf_1_0.X VSS.t61 VSS.t171 sg13_lv_nmos ad=0.1406p pd=1.12u as=0.1898p ps=1.36u w=0.74u l=0.13u
X2132 VDD VSS.t2639 VDD VDD sg13_lv_pmos ad=0.19p pd=1.38u as=0 ps=0 w=1u l=1u
X2133 VSS.t1863 VDD VSS.t1862 VSS.t1861 sg13_lv_nmos ad=0.1428p pd=1.52u as=0 ps=0 w=0.42u l=1u
X2134 VSS.t2957 VDD VSS.t2956 VSS.t2955 sg13_lv_nmos ad=0.1428p pd=1.52u as=0 ps=0 w=0.42u l=1u
X2135 VDD VSS.t1305 VDD VDD sg13_lv_pmos ad=0.34p pd=2.68u as=0 ps=0 w=1u l=1u
X2136 VSS.t2018 VDD VSS.t2020 VSS.t2019 sg13_lv_nmos ad=79.8f pd=0.8u as=0 ps=0 w=0.42u l=1u
X2137 VDD VSS.t2694 VDD VDD sg13_lv_pmos ad=0.34p pd=2.68u as=0 ps=0 w=1u l=1u
X2138 VDD VSS.t1942 VDD VDD sg13_lv_pmos ad=0.34p pd=2.68u as=0 ps=0 w=1u l=1u
X2139 VSS.t636 VDD VSS.t636 VSS.t760 sg13_lv_nmos ad=0.1428p pd=1.52u as=0 ps=0 w=0.42u l=1u
X2140 VSS.t1661 VDD VSS.t1663 VSS.t1662 sg13_lv_nmos ad=79.8f pd=0.8u as=0 ps=0 w=0.42u l=1u
X2141 VSS.t37 sg13cmos5l_xor2_1_0.X a_8600_15238# VSS.t3321 sg13_lv_nmos ad=79.8f pd=0.8u as=0.1428p ps=1.52u w=0.42u l=0.13u
X2142 VDD VSS.t874 VDD VDD sg13_lv_pmos ad=0.19p pd=1.38u as=0 ps=0 w=1u l=1u
X2143 VDD VSS.t1188 VDD VDD sg13_lv_pmos ad=0.19p pd=1.38u as=0 ps=0 w=1u l=1u
X2144 VDD VSS.t2751 VDD VDD sg13_lv_pmos ad=0.19p pd=1.38u as=0 ps=0 w=1u l=1u
X2145 VSS.t2053 VDD VSS.t2052 VSS.t2051 sg13_lv_nmos ad=0.1428p pd=1.52u as=0 ps=0 w=0.42u l=1u
X2146 VSS.t1616 VDD VSS.t1615 VSS.t1614 sg13_lv_nmos ad=0.1428p pd=1.52u as=0 ps=0 w=0.42u l=1u
X2147 VDD VSS.t2909 VDD VDD sg13_lv_pmos ad=0.19p pd=1.38u as=0 ps=0 w=1u l=1u
X2148 VSS.t3147 VDD VSS.t3146 VSS.t3145 sg13_lv_nmos ad=0.1428p pd=1.52u as=0 ps=0 w=0.42u l=1u
X2149 VSS.t2967 VDD VSS.t2969 VSS.t2968 sg13_lv_nmos ad=79.8f pd=0.8u as=0 ps=0 w=0.42u l=1u
X2150 VSS.t450 VDD VSS.t450 VSS.t2 sg13_lv_nmos ad=79.8f pd=0.8u as=0 ps=0 w=0.42u l=1u
X2151 VDD VSS.t1625 VDD VDD sg13_lv_pmos ad=0.34p pd=2.68u as=0 ps=0 w=1u l=1u
X2152 VDD VSS.t1680 VDD VDD sg13_lv_pmos ad=0.34p pd=2.68u as=0 ps=0 w=1u l=1u
X2153 VSS.t2425 VDD VSS.t2424 VSS.t2423 sg13_lv_nmos ad=0.1428p pd=1.52u as=0 ps=0 w=0.42u l=1u
X2154 a_17796_14909# a_18027_14495# a_17482_14452# VSS.t112 sg13_lv_nmos ad=0.2373p pd=1.97u as=79.8f ps=0.8u w=0.42u l=0.13u
X2155 a_17865_14531# a_17508_14488# VDD VDD sg13_lv_pmos ad=63f pd=0.72u as=0.1563p ps=1.22u w=0.42u l=0.13u
X2156 VDD VSS.t2309 VDD VDD sg13_lv_pmos ad=0.34p pd=2.68u as=0 ps=0 w=1u l=1u
X2157 VDD VSS.t92 VDD VDD sg13_lv_pmos ad=0.34p pd=2.68u as=0 ps=0 w=1u l=1u
X2158 VDD a_7919_14845# a_8176_14726# VDD sg13_lv_pmos ad=2.42015p pd=15.68u as=79.8f ps=0.8u w=0.42u l=0.13u
X2159 VSS.t792 VDD VSS.t791 VSS.t790 sg13_lv_nmos ad=0.1428p pd=1.52u as=0 ps=0 w=0.42u l=1u
X2160 VDD VSS.t2767 VDD VDD sg13_lv_pmos ad=0.34p pd=2.68u as=0 ps=0 w=1u l=1u
X2161 VDD VSS.t705 VDD VDD sg13_lv_pmos ad=0.19p pd=1.38u as=0 ps=0 w=1u l=1u
X2162 VDD VSS.t1206 VDD VDD sg13_lv_pmos ad=0.19p pd=1.38u as=0 ps=0 w=1u l=1u
X2163 VSS.t1526 VDD VSS.t1528 VSS.t1527 sg13_lv_nmos ad=79.8f pd=0.8u as=0 ps=0 w=0.42u l=1u
X2164 sg13cmos5l_dlygate4sd3_1_0.A a_8586_14484# VDD VDD sg13_lv_pmos ad=0.3808p pd=2.92u as=0.2128p ps=1.5u w=1.12u l=0.13u
X2165 VSS.t1280 VDD VSS.t1281 VSS.t224 sg13_lv_nmos ad=79.8f pd=0.8u as=0 ps=0 w=0.42u l=1u
X2166 VSS.t1456 VDD VSS.t1458 VSS.t1457 sg13_lv_nmos ad=79.8f pd=0.8u as=0 ps=0 w=0.42u l=1u
X2167 VSS.t348 VDD VSS.t347 VSS.t346 sg13_lv_nmos ad=0.1428p pd=1.52u as=0 ps=0 w=0.42u l=1u
X2168 VDD VSS.t2650 VDD VDD sg13_lv_pmos ad=0.19p pd=1.38u as=0 ps=0 w=1u l=1u
X2169 VSS.t1848 VDD VSS.t1847 VSS.t1846 sg13_lv_nmos ad=0.1428p pd=1.52u as=0 ps=0 w=0.42u l=1u
X2170 VSS.t193 a_37484_15960# counter_value_o[7] VSS.t3277 sg13_lv_nmos ad=0.14875p pd=1.16u as=0.2886p ps=2.26u w=0.74u l=0.13u
X2171 VDD VSS.t1211 VDD VDD sg13_lv_pmos ad=0.19p pd=1.38u as=0 ps=0 w=1u l=1u
X2172 VDD VSS.t2715 VDD VDD sg13_lv_pmos ad=0.19p pd=1.38u as=0 ps=0 w=1u l=1u
X2173 VSS.t2390 VDD VSS.t2389 VSS.t2388 sg13_lv_nmos ad=0.1428p pd=1.52u as=0 ps=0 w=0.42u l=1u
X2174 VSS.t48 a_17584_13942# a_17233_13799# VSS.t47 sg13_lv_nmos ad=79.8f pd=0.8u as=0.1428p ps=1.52u w=0.42u l=0.13u
X2175 VDD VSS.t2329 VDD VDD sg13_lv_pmos ad=0.34p pd=2.68u as=0 ps=0 w=1u l=1u
X2176 VDD VSS.t446 VDD VDD sg13_lv_pmos ad=0.19p pd=1.38u as=0 ps=0 w=1u l=1u
X2177 a_16485_13701# sg13cmos5l_dfrbpq_1_2.CLK VSS.t54 VSS.t165 sg13_lv_nmos ad=0.2516p pd=2.16u as=10.4325p ps=68.31u w=0.74u l=0.13u
X2178 VSS.t193 VDD VSS.t193 VSS.t404 sg13_lv_nmos ad=0.1428p pd=1.52u as=0 ps=0 w=0.42u l=1u
X2179 VDD VSS.t1970 VDD VDD sg13_lv_pmos ad=0.19p pd=1.38u as=0 ps=0 w=1u l=1u
X2180 VSS.t1938 VDD VSS.t1937 VSS.t1936 sg13_lv_nmos ad=0.1428p pd=1.52u as=0 ps=0 w=0.42u l=1u
X2181 VSS.t438 VDD VSS.t438 VSS.t2 sg13_lv_nmos ad=0.1428p pd=1.52u as=0 ps=0 w=0.42u l=1u
X2182 VSS.t2455 VDD VSS.t2457 VSS.t2456 sg13_lv_nmos ad=79.8f pd=0.8u as=0 ps=0 w=0.42u l=1u
X2183 VDD VSS.t1523 VDD VDD sg13_lv_pmos ad=0.19p pd=1.38u as=0 ps=0 w=1u l=1u
X2184 sg13cmos5l_or3_1_2.B a_14549_15238# VDD VDD sg13_lv_pmos ad=0.2128p pd=1.5u as=0.203p ps=1.5u w=1.12u l=0.13u
X2185 a_17584_13942# a_17327_13799# a_17746_13722# VSS.t94 sg13_lv_nmos ad=0.1428p pd=1.52u as=37.8f ps=0.6u w=0.42u l=0.13u
X2186 VSS.t113 a_25006_14751# sg13cmos5l_dlygate4sd3_1_19.X VSS.t7 sg13_lv_nmos ad=0.1426p pd=1.16u as=0.2516p ps=2.16u w=0.74u l=0.13u
X2187 VSS.t2623 VDD VSS.t2623 VSS.t2620 sg13_lv_nmos ad=0.1428p pd=1.52u as=0 ps=0 w=0.42u l=1u
X2188 VDD VSS.t590 VDD VDD sg13_lv_pmos ad=0.34p pd=2.68u as=0 ps=0 w=1u l=1u
X2189 VSS.t992 VDD VSS.t991 VSS.t990 sg13_lv_nmos ad=0.1428p pd=1.52u as=0 ps=0 w=0.42u l=1u
X2190 VDD VSS.t2674 VDD VDD sg13_lv_pmos ad=0.19p pd=1.38u as=0 ps=0 w=1u l=1u
X2191 VDD a_15790_15238# sg13cmos5l_buf_16_2.A VDD sg13_lv_pmos ad=0.2128p pd=1.5u as=0.2128p ps=1.5u w=1.12u l=0.13u
X2192 VSS.t3017 VDD VSS.t3016 VSS.t3015 sg13_lv_nmos ad=0.1428p pd=1.52u as=0 ps=0 w=0.42u l=1u
X2193 VDD VSS.t1044 VDD VDD sg13_lv_pmos ad=0.19p pd=1.38u as=0 ps=0 w=1u l=1u
X2194 VDD VSS.t2921 VDD VDD sg13_lv_pmos ad=0.34p pd=2.68u as=0 ps=0 w=1u l=1u
X2195 VSS.t609 VDD VSS.t609 VSS.t608 sg13_lv_nmos ad=0.1428p pd=1.52u as=0 ps=0 w=0.42u l=1u
X2196 VSS.t609 VDD VSS.t609 VSS.t740 sg13_lv_nmos ad=79.8f pd=0.8u as=0 ps=0 w=0.42u l=1u
X2197 VSS.t1476 VDD VSS.t1478 VSS.t1477 sg13_lv_nmos ad=79.8f pd=0.8u as=0 ps=0 w=0.42u l=1u
X2198 VSS.t1671 VDD VSS.t1670 VSS.t1669 sg13_lv_nmos ad=0.1428p pd=1.52u as=0 ps=0 w=0.42u l=1u
X2199 VDD VSS.t1488 VDD VDD sg13_lv_pmos ad=0.19p pd=1.38u as=0 ps=0 w=1u l=1u
X2200 VSS.t2685 VDD VSS.t2686 VSS.t2620 sg13_lv_nmos ad=79.8f pd=0.8u as=0 ps=0 w=0.42u l=1u
X2201 VDD VSS.t2397 VDD VDD sg13_lv_pmos ad=0.19p pd=1.38u as=0 ps=0 w=1u l=1u
X2202 VDD VSS.t434 VDD VDD sg13_lv_pmos ad=0.34p pd=2.68u as=0 ps=0 w=1u l=1u
X2203 VSS.t2285 VDD VSS.t2287 VSS.t2286 sg13_lv_nmos ad=79.8f pd=0.8u as=0 ps=0 w=0.42u l=1u
X2204 a_27310_15423# a_27425_15424# VDD VDD sg13_lv_pmos ad=0.34p pd=2.68u as=0.2254p ps=1.53u w=1u l=0.5u
X2205 VSS.t2003 VDD VSS.t2005 VSS.t2004 sg13_lv_nmos ad=79.8f pd=0.8u as=0 ps=0 w=0.42u l=1u
X2206 sg13cmos5l_buf_16_2.A a_15790_15238# VSS.t14 VSS.t16 sg13_lv_nmos ad=0.1406p pd=1.12u as=0.1406p ps=1.12u w=0.74u l=0.13u
X2207 VSS.t1298 VDD VSS.t1298 VSS.t224 sg13_lv_nmos ad=79.8f pd=0.8u as=0 ps=0 w=0.42u l=1u
X2208 VDD VSS.t2686 VDD VDD sg13_lv_pmos ad=0.34p pd=2.68u as=0 ps=0 w=1u l=1u
X2209 VSS.t1958 VDD VSS.t1957 VSS.t1956 sg13_lv_nmos ad=0.1428p pd=1.52u as=0 ps=0 w=0.42u l=1u
X2210 VSS.t641 VDD VSS.t641 VSS.t642 sg13_lv_nmos ad=79.8f pd=0.8u as=0 ps=0 w=0.42u l=1u
X2211 VDD VSS.t1180 VDD VDD sg13_lv_pmos ad=0.19p pd=1.38u as=0 ps=0 w=1u l=1u
X2212 VSS.t1601 VDD VSS.t1600 VSS.t1599 sg13_lv_nmos ad=0.1428p pd=1.52u as=0 ps=0 w=0.42u l=1u
X2213 VSS.t3132 VDD VSS.t3131 VSS.t3130 sg13_lv_nmos ad=0.1428p pd=1.52u as=0 ps=0 w=0.42u l=1u
X2214 VDD VSS.t2657 VDD VDD sg13_lv_pmos ad=0.34p pd=2.68u as=0 ps=0 w=1u l=1u
X2215 VSS.t284 VDD VSS.t284 VSS.t359 sg13_lv_nmos ad=79.8f pd=0.8u as=0 ps=0 w=0.42u l=1u
X2216 a_18610_16374# sg13cmos5l_xnor2_1_1.A VSS.t63 VSS.t214 sg13_lv_nmos ad=0.2516p pd=2.16u as=0.1406p ps=1.12u w=0.74u l=0.15u
X2217 a_11193_15549# a_10251_15356# a_10991_15311# VDD sg13_lv_pmos ad=93.45f pd=0.865u as=0.2048p ps=1.63u w=0.42u l=0.13u
X2218 VDD VSS.t1665 VDD VDD sg13_lv_pmos ad=0.34p pd=2.68u as=0 ps=0 w=1u l=1u
X2219 VSS.t1501 VDD VSS.t1500 VSS.t1499 sg13_lv_nmos ad=0.1428p pd=1.52u as=0 ps=0 w=0.42u l=1u
X2220 VSS.t2410 VDD VSS.t2409 VSS.t2408 sg13_lv_nmos ad=0.1428p pd=1.52u as=0 ps=0 w=0.42u l=1u
X2221 VSS.t1516 VDD VSS.t1518 VSS.t1517 sg13_lv_nmos ad=79.8f pd=0.8u as=0 ps=0 w=0.42u l=1u
X2222 VDD VSS.t79 VDD VDD sg13_lv_pmos ad=0.19p pd=1.38u as=0 ps=0 w=1u l=1u
X2223 VDD VSS.t1011 VDD VDD sg13_lv_pmos ad=0.34p pd=2.68u as=0 ps=0 w=1u l=1u
X2224 VSS.t2735 VDD VSS.t2736 VSS.t2620 sg13_lv_nmos ad=79.8f pd=0.8u as=0 ps=0 w=0.42u l=1u
X2225 VSS.t1908 VDD VSS.t1907 VSS.t1906 sg13_lv_nmos ad=0.1428p pd=1.52u as=0 ps=0 w=0.42u l=1u
X2226 VSS.t434 VDD VSS.t434 VSS.t2 sg13_lv_nmos ad=0.1428p pd=1.52u as=0 ps=0 w=0.42u l=1u
X2227 VDD VSS.t1468 VDD VDD sg13_lv_pmos ad=0.19p pd=1.38u as=0 ps=0 w=1u l=1u
X2228 VDD VSS.t2941 VDD VDD sg13_lv_pmos ad=0.34p pd=2.68u as=0 ps=0 w=1u l=1u
X2229 VDD a_15790_15238# sg13cmos5l_buf_16_2.A VDD sg13_lv_pmos ad=0.2128p pd=1.5u as=0.2128p ps=1.5u w=1.12u l=0.13u
X2230 VDD VSS.t3114 VDD VDD sg13_lv_pmos ad=0.19p pd=1.38u as=0 ps=0 w=1u l=1u
X2231 VSS.t1511 VDD VSS.t1513 VSS.t1512 sg13_lv_nmos ad=79.8f pd=0.8u as=0 ps=0 w=0.42u l=1u
X2232 VSS.t1691 VDD VSS.t1690 VSS.t1689 sg13_lv_nmos ad=0.1428p pd=1.52u as=0 ps=0 w=0.42u l=1u
X2233 VDD VSS.t1473 VDD VDD sg13_lv_pmos ad=0.19p pd=1.38u as=0 ps=0 w=1u l=1u
X2234 sg13cmos5l_dlygate4sd3_1_0.A a_8586_14484# VSS.t37 VSS.t152 sg13_lv_nmos ad=0.2516p pd=2.16u as=0.1406p ps=1.12u w=0.74u l=0.13u
X2235 VSS.t2676 VDD VSS.t2676 VSS.t2620 sg13_lv_nmos ad=79.8f pd=0.8u as=0 ps=0 w=0.42u l=1u
X2236 VDD VSS.t2641 VDD VDD sg13_lv_pmos ad=0.19p pd=1.38u as=0 ps=0 w=1u l=1u
X2237 VDD VSS.t2382 VDD VDD sg13_lv_pmos ad=0.19p pd=1.38u as=0 ps=0 w=1u l=1u
X2238 VSS.t417 VDD VSS.t416 VSS.t415 sg13_lv_nmos ad=0.1428p pd=1.52u as=0 ps=0 w=0.42u l=1u
X2239 VDD VSS.t450 VDD VDD sg13_lv_pmos ad=0.19p pd=1.38u as=0 ps=0 w=1u l=1u
X2240 VSS.t2962 VDD VSS.t2961 VSS.t2960 sg13_lv_nmos ad=0.1428p pd=1.52u as=0 ps=0 w=0.42u l=1u
X2241 VSS.t63 a_17030_15996# a_17142_16020# VSS.t3210 sg13_lv_nmos ad=0.1426p pd=1.16u as=0.1428p ps=1.52u w=0.42u l=0.5u
X2242 VDD VSS.t1308 VDD VDD sg13_lv_pmos ad=0.34p pd=2.68u as=0 ps=0 w=1u l=1u
X2243 VSS.t1988 VDD VSS.t1990 VSS.t1989 sg13_lv_nmos ad=79.8f pd=0.8u as=0 ps=0 w=0.42u l=1u
X2244 VDD VSS.t2698 VDD VDD sg13_lv_pmos ad=0.34p pd=2.68u as=0 ps=0 w=1u l=1u
X2245 VDD VSS.t2507 VDD VDD sg13_lv_pmos ad=0.19p pd=1.38u as=0 ps=0 w=1u l=1u
X2246 VDD VSS.t1947 VDD VDD sg13_lv_pmos ad=0.34p pd=2.68u as=0 ps=0 w=1u l=1u
X2247 VSS.t216 a_16163_16265# sg13cmos5l_a21oi_1_0.A2 VSS.t3199 sg13_lv_nmos ad=0.13395p pd=1.12u as=0.2516p ps=2.16u w=0.74u l=0.13u
X2248 a_15790_15238# clock_i VSS.t3249 VSS.t3250 sg13_lv_nmos ad=0.1406p pd=1.12u as=0.1406p ps=1.12u w=0.74u l=0.13u
X2249 VSS.t625 VDD VSS.t620 VSS.t624 sg13_lv_nmos ad=0.1428p pd=1.52u as=0 ps=0 w=0.42u l=1u
X2250 VDD VSS.t1284 VDD VDD sg13_lv_pmos ad=0.19p pd=1.38u as=0 ps=0 w=1u l=1u
X2251 a_16461_16020# sg13cmos5l_dlygate4sd3_1_10.X a_16372_16020# VDD sg13_lv_pmos ad=0.19p pd=1.38u as=0.1575p ps=1.315u w=1u l=0.13u
X2252 VDD VSS.t588 VDD VDD sg13_lv_pmos ad=0.19p pd=1.38u as=0 ps=0 w=1u l=1u
X2253 a_19534_13726# sg13cmos5l_buf_16_2.A VSS.t705 VSS.t3317 sg13_lv_nmos ad=0.1406p pd=1.12u as=0.1406p ps=1.12u w=0.74u l=0.13u
X2254 VDD a_10714_14448# a_10433_14750# VDD sg13_lv_pmos ad=0.1523p pd=1.38u as=0.34p ps=2.68u w=1u l=0.5u
X2255 VSS.t1232 VDD VSS.t1233 VSS.t224 sg13_lv_nmos ad=79.8f pd=0.8u as=0 ps=0 w=0.42u l=1u
X2256 VDD VSS.t1630 VDD VDD sg13_lv_pmos ad=0.34p pd=2.68u as=0 ps=0 w=1u l=1u
X2257 sg13cmos5l_o21ai_1_2.A2 sg13cmos5l_dfrbpq_1_6.Q VDD VDD sg13_lv_pmos ad=0.2128p pd=1.5u as=0.3808p ps=2.92u w=1.12u l=0.13u
X2258 VDD VSS.t1685 VDD VDD sg13_lv_pmos ad=0.34p pd=2.68u as=0 ps=0 w=1u l=1u
X2259 VDD VSS.t1842 VDD VDD sg13_lv_pmos ad=0.34p pd=2.68u as=0 ps=0 w=1u l=1u
X2260 a_7544_16362# sg13cmos5l_dlygate4sd3_1_0.A a_7442_16362# VSS.t250 sg13_lv_nmos ad=0.1406p pd=1.12u as=0.1406p ps=1.12u w=0.74u l=0.13u
X2261 VSS.t992 VDD VSS.t991 VSS.t990 sg13_lv_nmos ad=0.1428p pd=1.52u as=0 ps=0 w=0.42u l=1u
X2262 VDD VSS.t715 VDD VDD sg13_lv_pmos ad=0.34p pd=2.68u as=0 ps=0 w=1u l=1u
X2263 VDD VSS.t974 VDD VDD sg13_lv_pmos ad=0.19p pd=1.38u as=0 ps=0 w=1u l=1u
X2264 VDD VSS.t2770 VDD VDD sg13_lv_pmos ad=0.34p pd=2.68u as=0 ps=0 w=1u l=1u
X2265 sg13cmos5l_dfrbpq_1_2.CLK a_12212_15202# VDD VDD sg13_lv_pmos ad=0.2128p pd=1.5u as=0.2128p ps=1.5u w=1.12u l=0.13u
X2266 VSS.t1439 VDD VSS.t1319 VSS.t224 sg13_lv_nmos ad=0.1428p pd=1.52u as=0 ps=0 w=0.42u l=1u
X2267 VDD VSS.t901 VDD VDD sg13_lv_pmos ad=0.34p pd=2.68u as=0 ps=0 w=1u l=1u
X2268 VSS.t1461 VDD VSS.t1463 VSS.t1462 sg13_lv_nmos ad=79.8f pd=0.8u as=0 ps=0 w=0.42u l=1u
X2269 VSS.t122 VDD VSS.t420 VSS.t8 sg13_lv_nmos ad=0.1428p pd=1.52u as=0 ps=0 w=0.42u l=1u
X2270 VDD VSS.t438 VDD VDD sg13_lv_pmos ad=0.34p pd=2.68u as=0 ps=0 w=1u l=1u
X2271 VSS.t1853 VDD VSS.t1852 VSS.t1851 sg13_lv_nmos ad=0.1428p pd=1.52u as=0 ps=0 w=0.42u l=1u
X2272 VSS.t2947 VDD VSS.t2946 VSS.t2945 sg13_lv_nmos ad=0.1428p pd=1.52u as=0 ps=0 w=0.42u l=1u
X2273 VSS.t2782 VDD VSS.t2781 VSS.t2620 sg13_lv_nmos ad=0.1428p pd=1.52u as=0 ps=0 w=0.42u l=1u
X2274 VSS.t2023 VDD VSS.t2025 VSS.t2024 sg13_lv_nmos ad=79.8f pd=0.8u as=0 ps=0 w=0.42u l=1u
X2275 VDD VSS.t1980 VDD VDD sg13_lv_pmos ad=0.19p pd=1.38u as=0 ps=0 w=1u l=1u
X2276 VDD VSS.t543 VDD VDD sg13_lv_pmos ad=0.19p pd=1.38u as=0 ps=0 w=1u l=1u
X2277 VDD VSS.t1214 VDD VDD sg13_lv_pmos ad=0.19p pd=1.38u as=0 ps=0 w=1u l=1u
X2278 VDD VSS.t2718 VDD VDD sg13_lv_pmos ad=0.19p pd=1.38u as=0 ps=0 w=1u l=1u
X2279 VSS.t2270 VDD VSS.t2272 VSS.t2271 sg13_lv_nmos ad=79.8f pd=0.8u as=0 ps=0 w=0.42u l=1u
X2280 VSS.t2395 VDD VSS.t2394 VSS.t2393 sg13_lv_nmos ad=0.1428p pd=1.52u as=0 ps=0 w=0.42u l=1u
X2281 VDD VSS.t2334 VDD VDD sg13_lv_pmos ad=0.34p pd=2.68u as=0 ps=0 w=1u l=1u
X2282 VDD VSS.t1480 VDD VDD sg13_lv_pmos ad=0.34p pd=2.68u as=0 ps=0 w=1u l=1u
X2283 VDD VSS.t555 VDD VDD sg13_lv_pmos ad=0.34p pd=2.68u as=0 ps=0 w=1u l=1u
X2284 VSS.t1561 VDD VSS.t1560 VSS.t1559 sg13_lv_nmos ad=0.1428p pd=1.52u as=0 ps=0 w=0.42u l=1u
X2285 VDD VSS.t776 VDD VDD sg13_lv_pmos ad=0.34p pd=2.68u as=0 ps=0 w=1u l=1u
X2286 VSS.t1214 VDD VSS.t1213 VSS.t224 sg13_lv_nmos ad=0.1428p pd=1.52u as=0 ps=0 w=0.42u l=1u
X2287 VDD VSS.t1663 VDD VDD sg13_lv_pmos ad=0.19p pd=1.38u as=0 ps=0 w=1u l=1u
X2288 VSS.t1943 VDD VSS.t1942 VSS.t1941 sg13_lv_nmos ad=0.1428p pd=1.52u as=0 ps=0 w=0.42u l=1u
X2289 VSS.t2 a_17925_14495# a_18027_14495# VSS.t197 sg13_lv_nmos ad=5.4903p pd=35.61u as=0.2516p ps=2.16u w=0.74u l=0.13u
X2290 VDD VSS.t2647 VDD VDD sg13_lv_pmos ad=0.34p pd=2.68u as=0 ps=0 w=1u l=1u
X2291 VSS.t2460 VDD VSS.t2462 VSS.t2461 sg13_lv_nmos ad=79.8f pd=0.8u as=0 ps=0 w=0.42u l=1u
X2292 VDD VSS.t398 VDD VDD sg13_lv_pmos ad=0.34p pd=2.68u as=0 ps=0 w=1u l=1u
X2293 VDD sg13cmos5l_dfrbpq_1_6.RESET_B a_20938_14452# VDD sg13_lv_pmos ad=0.1563p pd=1.22u as=0.147p ps=1.54u w=0.42u l=0.13u
X2294 a_4786_15234# sg13cmos5l_dfrbpq_1_0.RESET_B VSS.t44 VSS.t87 sg13_lv_nmos ad=37.8f pd=0.6u as=79.8f ps=0.8u w=0.42u l=0.13u
X2295 VDD VSS.t236 VDD VDD sg13_lv_pmos ad=0.34p pd=2.68u as=0 ps=0 w=1u l=1u
X2296 VDD VSS.t2035 VDD VDD sg13_lv_pmos ad=0.19p pd=1.38u as=0 ps=0 w=1u l=1u
X2297 VSS.t1681 VDD VSS.t1680 VSS.t1679 sg13_lv_nmos ad=0.1428p pd=1.52u as=0 ps=0 w=0.42u l=1u
X2298 VSS.t2626 VDD VSS.t2625 VSS.t2620 sg13_lv_nmos ad=0.1428p pd=1.52u as=0 ps=0 w=0.42u l=1u
X2299 a_4762_14448# sg13cmos5l_dlygate4sd3_1_5.A VSS.t44 VSS.t3273 sg13_lv_nmos ad=0.1428p pd=1.52u as=79.8f ps=0.8u w=0.42u l=0.13u
X2300 VSS.t2725 VDD VSS.t2727 VSS.t2620 sg13_lv_nmos ad=79.8f pd=0.8u as=0 ps=0 w=0.42u l=1u
X2301 VSS.t546 VDD VSS.t546 VSS.t660 sg13_lv_nmos ad=0.1428p pd=1.52u as=0 ps=0 w=0.42u l=1u
X2302 VSS.t614 VDD VSS.t614 VSS.t745 sg13_lv_nmos ad=0.1428p pd=1.52u as=0 ps=0 w=0.42u l=1u
X2303 VSS.t812 VDD VSS.t811 VSS.t810 sg13_lv_nmos ad=0.1428p pd=1.52u as=0 ps=0 w=0.42u l=1u
X2304 VSS.t1250 VDD VSS.t1251 VSS.t224 sg13_lv_nmos ad=79.8f pd=0.8u as=0 ps=0 w=0.42u l=1u
X2305 VSS.t2987 VDD VSS.t2986 VSS.t2985 sg13_lv_nmos ad=0.1428p pd=1.52u as=0 ps=0 w=0.42u l=1u
X2306 VSS.t1333 VDD VSS.t1175 VSS.t224 sg13_lv_nmos ad=79.8f pd=0.8u as=0 ps=0 w=0.42u l=1u
X2307 VDD VSS.t1453 VDD VDD sg13_lv_pmos ad=0.19p pd=1.38u as=0 ps=0 w=1u l=1u
X2308 VDD VSS.t2926 VDD VDD sg13_lv_pmos ad=0.34p pd=2.68u as=0 ps=0 w=1u l=1u
X2309 a_11248_15454# a_10991_15311# a_11410_15234# VSS.t100 sg13_lv_nmos ad=0.1428p pd=1.52u as=37.8f ps=0.6u w=0.42u l=0.13u
X2310 sg13cmos5l_dfrbpq_1_2.CLK a_12212_15202# VDD VDD sg13_lv_pmos ad=0.2128p pd=1.5u as=0.2128p ps=1.5u w=1.12u l=0.13u
X2311 VSS.t1676 VDD VSS.t1675 VSS.t1674 sg13_lv_nmos ad=0.1428p pd=1.52u as=0 ps=0 w=0.42u l=1u
X2312 VDD VSS.t620 VDD VDD sg13_lv_pmos ad=0.19p pd=1.38u as=0 ps=0 w=1u l=1u
X2313 VDD VSS.t1458 VDD VDD sg13_lv_pmos ad=0.19p pd=1.38u as=0 ps=0 w=1u l=1u
X2314 VSS.t2773 VDD VSS.t2773 VSS.t2620 sg13_lv_nmos ad=0.1428p pd=1.52u as=0 ps=0 w=0.42u l=1u
X2315 VSS.t2043 VDD VSS.t2045 VSS.t2044 sg13_lv_nmos ad=79.8f pd=0.8u as=0 ps=0 w=0.42u l=1u
X2316 VSS.t2255 VDD VSS.t2257 VSS.t2256 sg13_lv_nmos ad=79.8f pd=0.8u as=0 ps=0 w=0.42u l=1u
X2317 VDD VSS.t3116 VDD VDD sg13_lv_pmos ad=0.34p pd=2.68u as=0 ps=0 w=1u l=1u
X2318 VDD VSS.t471 VDD VDD sg13_lv_pmos ad=0.19p pd=1.38u as=0 ps=0 w=1u l=1u
X2319 VDD VSS.t2492 VDD VDD sg13_lv_pmos ad=0.19p pd=1.38u as=0 ps=0 w=1u l=1u
X2320 VDD VSS.t931 VDD VDD sg13_lv_pmos ad=0.34p pd=2.68u as=0 ps=0 w=1u l=1u
X2321 VSS.t1191 VDD VSS.t1192 VSS.t224 sg13_lv_nmos ad=79.8f pd=0.8u as=0 ps=0 w=0.42u l=1u
X2322 VSS.t1228 VDD VSS.t1227 VSS.t224 sg13_lv_nmos ad=0.1428p pd=1.52u as=0 ps=0 w=0.42u l=1u
X2323 VDD VSS.t1932 VDD VDD sg13_lv_pmos ad=0.34p pd=2.68u as=0 ps=0 w=1u l=1u
X2324 a_26340_14909# a_26052_14488# a_26278_14909# VSS.t203 sg13_lv_nmos ad=0.1428p pd=1.52u as=37.8f ps=0.6u w=0.42u l=0.13u
X2325 VDD VSS.t588 VDD VDD sg13_lv_pmos ad=0.19p pd=1.38u as=0 ps=0 w=1u l=1u
X2326 a_18610_16374# sg13cmos5l_dlygate4sd3_1_10.X sg13cmos5l_dlygate4sd3_1_7.A VSS.t3202 sg13_lv_nmos ad=0.1406p pd=1.12u as=0.2516p ps=2.16u w=0.74u l=0.15u
X2327 VSS.t1259 VDD VSS.t1260 VSS.t224 sg13_lv_nmos ad=79.8f pd=0.8u as=0 ps=0 w=0.42u l=1u
X2328 VDD VSS.t1615 VDD VDD sg13_lv_pmos ad=0.34p pd=2.68u as=0 ps=0 w=1u l=1u
X2329 a_19546_15202# sg13cmos5l_dfrbpq_1_3.Q VDD VDD sg13_lv_pmos ad=0.1428p pd=1.52u as=0.1523p ps=1.38u w=0.42u l=0.13u
X2330 VSS.t1506 VDD VSS.t1505 VSS.t1504 sg13_lv_nmos ad=0.1428p pd=1.52u as=0 ps=0 w=0.42u l=1u
X2331 VSS.t2415 VDD VSS.t2414 VSS.t2413 sg13_lv_nmos ad=0.1428p pd=1.52u as=0 ps=0 w=0.42u l=1u
X2332 VDD VSS.t1016 VDD VDD sg13_lv_pmos ad=0.34p pd=2.68u as=0 ps=0 w=1u l=1u
X2333 VSS.t967 VDD VSS.t966 VSS.t965 sg13_lv_nmos ad=0.1428p pd=1.52u as=0 ps=0 w=0.42u l=1u
X2334 VSS.t1521 VDD VSS.t1523 VSS.t1522 sg13_lv_nmos ad=79.8f pd=0.8u as=0 ps=0 w=0.42u l=1u
X2335 VSS.t2737 VDD VSS.t2739 VSS.t2620 sg13_lv_nmos ad=79.8f pd=0.8u as=0 ps=0 w=0.42u l=1u
X2336 VSS.t455 VDD VSS.t456 VSS.t2 sg13_lv_nmos ad=79.8f pd=0.8u as=0 ps=0 w=0.42u l=1u
X2337 VDD VSS.t831 VDD VDD sg13_lv_pmos ad=0.34p pd=2.68u as=0 ps=0 w=1u l=1u
X2338 VSS.t1264 VDD VSS.t1265 VSS.t224 sg13_lv_nmos ad=79.8f pd=0.8u as=0 ps=0 w=0.42u l=1u
X2339 VDD VSS.t1197 VDD VDD sg13_lv_pmos ad=0.34p pd=2.68u as=0 ps=0 w=1u l=1u
X2340 VDD VSS.t2911 VDD VDD sg13_lv_pmos ad=0.34p pd=2.68u as=0 ps=0 w=1u l=1u
X2341 a_21381_14495# sg13cmos5l_buf_16_2.X VSS.t2 VSS.t52 sg13_lv_nmos ad=0.2516p pd=2.16u as=5.06795p ps=32.87u w=0.74u l=0.13u
X2342 VDD VSS.t303 VDD VDD sg13_lv_pmos ad=0.34p pd=2.68u as=0 ps=0 w=1u l=1u
X2343 a_16163_16265# sg13cmos5l_o21ai_1_2.A1 VSS.t216 VSS.t259 sg13_lv_nmos ad=0.187p pd=1.78u as=0.1045p ps=0.93u w=0.55u l=0.13u
X2344 a_18716_15976# sg13cmos5l_o21ai_1_2.A1 sg13cmos5l_dlygate4sd3_1_7.A VDD sg13_lv_pmos ad=0.2128p pd=1.5u as=0.2128p ps=1.5u w=1.12u l=0.15u
X2345 VSS.t1838 VDD VSS.t1837 VSS.t1836 sg13_lv_nmos ad=0.1428p pd=1.52u as=0 ps=0 w=0.42u l=1u
X2346 VSS.t2932 VDD VSS.t2931 VSS.t2930 sg13_lv_nmos ad=0.1428p pd=1.52u as=0 ps=0 w=0.42u l=1u
X2347 VSS.t1027 VDD VSS.t1029 VSS.t1028 sg13_lv_nmos ad=79.8f pd=0.8u as=0 ps=0 w=0.42u l=1u
X2348 VDD VSS.t1205 VDD VDD sg13_lv_pmos ad=0.19p pd=1.38u as=0 ps=0 w=1u l=1u
X2349 VDD VSS.t1311 VDD VDD sg13_lv_pmos ad=0.34p pd=2.68u as=0 ps=0 w=1u l=1u
X2350 VDD VSS.t2709 VDD VDD sg13_lv_pmos ad=0.19p pd=1.38u as=0 ps=0 w=1u l=1u
X2351 VSS.t2380 VDD VSS.t2379 VSS.t2378 sg13_lv_nmos ad=0.1428p pd=1.52u as=0 ps=0 w=0.42u l=1u
X2352 VSS.t1993 VDD VSS.t1995 VSS.t1994 sg13_lv_nmos ad=79.8f pd=0.8u as=0 ps=0 w=0.42u l=1u
X2353 VSS.t1283 VDD VSS.t1284 VSS.t224 sg13_lv_nmos ad=79.8f pd=0.8u as=0 ps=0 w=0.42u l=1u
X2354 VSS.t523 VDD VSS.t525 VSS.t524 sg13_lv_nmos ad=79.8f pd=0.8u as=0 ps=0 w=0.42u l=1u
X2355 VSS.t586 VDD VSS.t588 VSS.t587 sg13_lv_nmos ad=79.8f pd=0.8u as=0 ps=0 w=0.42u l=1u
X2356 VDD VSS.t555 VDD VDD sg13_lv_pmos ad=0.34p pd=2.68u as=0 ps=0 w=1u l=1u
X2357 VDD VSS.t894 VDD VDD sg13_lv_pmos ad=0.19p pd=1.38u as=0 ps=0 w=1u l=1u
X2358 VDD VSS.t1465 VDD VDD sg13_lv_pmos ad=0.34p pd=2.68u as=0 ps=0 w=1u l=1u
X2359 VDD VSS.t2680 VDD VDD sg13_lv_pmos ad=0.34p pd=2.68u as=0 ps=0 w=1u l=1u
X2360 VSS.t2697 VDD VSS.t2696 VSS.t2620 sg13_lv_nmos ad=0.1428p pd=1.52u as=0 ps=0 w=0.42u l=1u
X2361 VDD VSS.t315 VDD VDD sg13_lv_pmos ad=0.19p pd=1.38u as=0 ps=0 w=1u l=1u
X2362 VDD VSS.t382 VDD VDD sg13_lv_pmos ad=0.19p pd=1.38u as=0 ps=0 w=1u l=1u
X2363 VDD VSS.t1600 VDD VDD sg13_lv_pmos ad=0.34p pd=2.68u as=0 ps=0 w=1u l=1u
X2364 VSS.t2445 VDD VSS.t2447 VSS.t2446 sg13_lv_nmos ad=79.8f pd=0.8u as=0 ps=0 w=0.42u l=1u
X2365 VDD sg13cmos5l_dfrbpq_1_6.RESET_B a_20678_14922# VDD sg13_lv_pmos ad=0.36237p pd=2.605u as=79.8f ps=0.8u w=0.42u l=0.13u
X2366 VSS.t1491 VDD VSS.t1490 VSS.t1489 sg13_lv_nmos ad=0.1428p pd=1.52u as=0 ps=0 w=0.42u l=1u
X2367 VSS.t812 VDD VSS.t811 VSS.t810 sg13_lv_nmos ad=0.1428p pd=1.52u as=0 ps=0 w=0.42u l=1u
X2368 VSS.t2400 VDD VSS.t2399 VSS.t2398 sg13_lv_nmos ad=0.1428p pd=1.52u as=0 ps=0 w=0.42u l=1u
X2369 VDD VSS.t2020 VDD VDD sg13_lv_pmos ad=0.19p pd=1.38u as=0 ps=0 w=1u l=1u
X2370 VSS.t442 VDD VSS.t442 VSS.t2 sg13_lv_nmos ad=0.1428p pd=1.52u as=0 ps=0 w=0.42u l=1u
X2371 VSS.t1042 VDD VSS.t1044 VSS.t1043 sg13_lv_nmos ad=79.8f pd=0.8u as=0 ps=0 w=0.42u l=1u
X2372 VDD VSS.t1518 VDD VDD sg13_lv_pmos ad=0.19p pd=1.38u as=0 ps=0 w=1u l=1u
X2373 VDD VSS.t1972 VDD VDD sg13_lv_pmos ad=0.34p pd=2.68u as=0 ps=0 w=1u l=1u
X2374 VDD VSS.t1189 VDD VDD sg13_lv_pmos ad=0.34p pd=2.68u as=0 ps=0 w=1u l=1u
X2375 VDD VSS.t2753 VDD VDD sg13_lv_pmos ad=0.34p pd=2.68u as=0 ps=0 w=1u l=1u
X2376 a_3782_15996# a_3512_16037# VSS.t3240 VSS.t3241 sg13_lv_nmos ad=0.1428p pd=1.52u as=79.8f ps=0.8u w=0.42u l=0.5u
X2377 VSS.t1466 VDD VSS.t1468 VSS.t1467 sg13_lv_nmos ad=79.8f pd=0.8u as=0 ps=0 w=0.42u l=1u
X2378 VSS.t2690 VDD VSS.t2688 VSS.t2620 sg13_lv_nmos ad=0.1428p pd=1.52u as=0 ps=0 w=0.42u l=1u
X2379 a_25217_16344# sg13cmos5l_dlygate4sd3_1_18.X sg13cmos5l_dlygate4sd3_1_15.A VSS.t3207 sg13_lv_nmos ad=0.1406p pd=1.12u as=0.1406p ps=1.12u w=0.74u l=0.13u
X2380 VSS.t225 reset_n_i a_1192_9948# VSS.t224 sg13_lv_nmos ad=0.14875p pd=1.16u as=0.187p ps=1.78u w=0.55u l=0.13u
X2381 VDD VSS.t1182 VDD VDD sg13_lv_pmos ad=0.34p pd=2.68u as=0 ps=0 w=1u l=1u
X2382 VSS.t2028 VDD VSS.t2030 VSS.t2029 sg13_lv_nmos ad=79.8f pd=0.8u as=0 ps=0 w=0.42u l=1u
X2383 VDD VSS.t1985 VDD VDD sg13_lv_pmos ad=0.19p pd=1.38u as=0 ps=0 w=1u l=1u
X2384 VDD VSS.t861 VDD VDD sg13_lv_pmos ad=0.34p pd=2.68u as=0 ps=0 w=1u l=1u
X2385 VDD VSS.t1049 VDD VDD sg13_lv_pmos ad=0.19p pd=1.38u as=0 ps=0 w=1u l=1u
X2386 VDD VSS.t1217 VDD VDD sg13_lv_pmos ad=0.19p pd=1.38u as=0 ps=0 w=1u l=1u
X2387 VSS.t2747 VDD VSS.t2746 VSS.t2620 sg13_lv_nmos ad=0.1428p pd=1.52u as=0 ps=0 w=0.42u l=1u
X2388 VSS.t2240 VDD VSS.t2242 VSS.t2241 sg13_lv_nmos ad=79.8f pd=0.8u as=0 ps=0 w=0.42u l=1u
X2389 VSS.t609 VDD VSS.t609 VSS.t611 sg13_lv_nmos ad=0.1428p pd=1.52u as=0 ps=0 w=0.42u l=1u
X2390 VDD VSS.t2339 VDD VDD sg13_lv_pmos ad=0.34p pd=2.68u as=0 ps=0 w=1u l=1u
X2391 VDD VSS.t1485 VDD VDD sg13_lv_pmos ad=0.34p pd=2.68u as=0 ps=0 w=1u l=1u
X2392 VDD VSS.t1658 VDD VDD sg13_lv_pmos ad=0.19p pd=1.38u as=0 ps=0 w=1u l=1u
X2393 VSS.t1531 VDD VSS.t1530 VSS.t1529 sg13_lv_nmos ad=0.1428p pd=1.52u as=0 ps=0 w=0.42u l=1u
X2394 VSS.t1948 VDD VSS.t1947 VSS.t1946 sg13_lv_nmos ad=0.1428p pd=1.52u as=0 ps=0 w=0.42u l=1u
X2395 VDD VSS.t2651 VDD VDD sg13_lv_pmos ad=0.34p pd=2.68u as=0 ps=0 w=1u l=1u
X2396 VSS.t967 VDD VSS.t966 VSS.t965 sg13_lv_nmos ad=0.1428p pd=1.52u as=0 ps=0 w=0.42u l=1u
X2397 VDD VSS.t924 VDD VDD sg13_lv_pmos ad=0.19p pd=1.38u as=0 ps=0 w=1u l=1u
X2398 VSS.t1012 VDD VSS.t1011 VSS.t1010 sg13_lv_nmos ad=0.1428p pd=1.52u as=0 ps=0 w=0.42u l=1u
X2399 VDD VSS.t2347 VDD VDD sg13_lv_pmos ad=0.19p pd=1.38u as=0 ps=0 w=1u l=1u
X2400 VDD VSS.t2040 VDD VDD sg13_lv_pmos ad=0.19p pd=1.38u as=0 ps=0 w=1u l=1u
X2401 sg13cmos5l_buf_16_2.X a_19534_13726# VDD VDD sg13_lv_pmos ad=0.2128p pd=1.5u as=0.2128p ps=1.5u w=1.12u l=0.13u
X2402 VSS.t1291 VDD VSS.t1292 VSS.t224 sg13_lv_nmos ad=79.8f pd=0.8u as=0 ps=0 w=0.42u l=1u
X2403 VSS.t1686 VDD VSS.t1685 VSS.t1684 sg13_lv_nmos ad=0.1428p pd=1.52u as=0 ps=0 w=0.42u l=1u
X2404 VSS.t2729 VDD VSS.t2730 VSS.t2620 sg13_lv_nmos ad=79.8f pd=0.8u as=0 ps=0 w=0.42u l=1u
X2405 VDD VSS.t2659 VDD VDD sg13_lv_pmos ad=0.19p pd=1.38u as=0 ps=0 w=1u l=1u
X2406 VSS.t328 VDD VSS.t330 VSS.t329 sg13_lv_nmos ad=79.8f pd=0.8u as=0 ps=0 w=0.42u l=1u
X2407 a_8870_15238# a_8600_15238# VSS.t37 VSS.t71 sg13_lv_nmos ad=0.1428p pd=1.52u as=79.8f ps=0.8u w=0.42u l=0.5u
X2408 a_10714_14448# sg13cmos5l_dlygate4sd3_1_11.A VDD VDD sg13_lv_pmos ad=0.1428p pd=1.52u as=0.1523p ps=1.38u w=0.42u l=0.13u
X2409 VDD a_27311_14845# a_27978_14484# VDD sg13_lv_pmos ad=0.2128p pd=1.5u as=0.3864p ps=2.93u w=1.12u l=0.13u
X2410 VSS.t2992 VDD VSS.t2991 VSS.t2990 sg13_lv_nmos ad=0.1428p pd=1.52u as=0 ps=0 w=0.42u l=1u
X2411 VSS.t2365 VDD VSS.t2367 VSS.t2366 sg13_lv_nmos ad=79.8f pd=0.8u as=0 ps=0 w=0.42u l=1u
X2412 VSS.t1451 VDD VSS.t1453 VSS.t1452 sg13_lv_nmos ad=79.8f pd=0.8u as=0 ps=0 w=0.42u l=1u
X2413 VSS.t1027 VDD VSS.t1029 VSS.t1028 sg13_lv_nmos ad=79.8f pd=0.8u as=0 ps=0 w=0.42u l=1u
X2414 VDD VSS.t1273 VDD VDD sg13_lv_pmos ad=0.34p pd=2.68u as=0 ps=0 w=1u l=1u
X2415 VSS.t1211 VDD VSS.t1212 VSS.t224 sg13_lv_nmos ad=79.8f pd=0.8u as=0 ps=0 w=0.42u l=1u
X2416 VDD VSS.t824 VDD VDD sg13_lv_pmos ad=0.19p pd=1.38u as=0 ps=0 w=1u l=1u
X2417 VDD VSS.t1463 VDD VDD sg13_lv_pmos ad=0.19p pd=1.38u as=0 ps=0 w=1u l=1u
X2418 VDD VSS.t2372 VDD VDD sg13_lv_pmos ad=0.19p pd=1.38u as=0 ps=0 w=1u l=1u
X2419 VSS.t2260 VDD VSS.t2262 VSS.t2261 sg13_lv_nmos ad=79.8f pd=0.8u as=0 ps=0 w=0.42u l=1u
X2420 VDD a_25582_15423# sg13cmos5l_dlygate4sd3_1_18.X VDD sg13_lv_pmos ad=0.2254p pd=1.53u as=0.4256p ps=3u w=1.12u l=0.13u
X2421 VSS.t1310 VDD VSS.t1311 VSS.t224 sg13_lv_nmos ad=79.8f pd=0.8u as=0 ps=0 w=0.42u l=1u
X2422 VDD VSS.t1302 VDD VDD sg13_lv_pmos ad=0.34p pd=2.68u as=0 ps=0 w=1u l=1u
X2423 VDD VSS.t236 VDD VDD sg13_lv_pmos ad=0.19p pd=1.38u as=0 ps=0 w=1u l=1u
X2424 VDD VSS.t939 VDD VDD sg13_lv_pmos ad=0.19p pd=1.38u as=0 ps=0 w=1u l=1u
X2425 VSS.t2727 VDD VSS.t2728 VSS.t2620 sg13_lv_nmos ad=79.8f pd=0.8u as=0 ps=0 w=0.42u l=1u
X2426 VDD VSS.t2497 VDD VDD sg13_lv_pmos ad=0.19p pd=1.38u as=0 ps=0 w=1u l=1u
X2427 VSS.t1978 VDD VSS.t1980 VSS.t1979 sg13_lv_nmos ad=79.8f pd=0.8u as=0 ps=0 w=0.42u l=1u
X2428 VDD VSS.t2671 VDD VDD sg13_lv_pmos ad=0.34p pd=2.68u as=0 ps=0 w=1u l=1u
X2429 VSS.t1481 VDD VSS.t1480 VSS.t1479 sg13_lv_nmos ad=0.1428p pd=1.52u as=0 ps=0 w=0.42u l=1u
X2430 sg13cmos5l_buf_16_2.X a_19534_13726# VSS.t718 VSS.t3304 sg13_lv_nmos ad=0.1406p pd=1.12u as=0.1406p ps=1.12u w=0.74u l=0.13u
X2431 VDD VSS.t1224 VDD VDD sg13_lv_pmos ad=0.34p pd=2.68u as=0 ps=0 w=1u l=1u
X2432 VDD VSS.t2728 VDD VDD sg13_lv_pmos ad=0.34p pd=2.68u as=0 ps=0 w=1u l=1u
X2433 VDD VSS.t1997 VDD VDD sg13_lv_pmos ad=0.34p pd=2.68u as=0 ps=0 w=1u l=1u
X2434 VSS.t1042 VDD VSS.t1044 VSS.t1043 sg13_lv_nmos ad=79.8f pd=0.8u as=0 ps=0 w=0.42u l=1u
X2435 VDD VSS.t1282 VDD VDD sg13_lv_pmos ad=0.34p pd=2.68u as=0 ps=0 w=1u l=1u
X2436 a_21934_15423# a_22049_15424# VSS.t121 VSS.t120 sg13_lv_nmos ad=0.1428p pd=1.52u as=0.1426p ps=1.16u w=0.42u l=0.5u
X2437 VSS.t442 VDD VSS.t442 VSS.t2 sg13_lv_nmos ad=0.1428p pd=1.52u as=0 ps=0 w=0.42u l=1u
X2438 a_17746_13722# sg13cmos5l_dfrbpq_1_2.RESET_B VSS.t48 VSS.t3281 sg13_lv_nmos ad=37.8f pd=0.6u as=79.8f ps=0.8u w=0.42u l=0.13u
X2439 VDD VSS.t116 VDD VDD sg13_lv_pmos ad=0.19p pd=1.38u as=0 ps=0 w=1u l=1u
X2440 VSS.t1476 VDD VSS.t1475 VSS.t1474 sg13_lv_nmos ad=0.1428p pd=1.52u as=0 ps=0 w=0.42u l=1u
X2441 VSS.t2385 VDD VSS.t2384 VSS.t2383 sg13_lv_nmos ad=0.1428p pd=1.52u as=0 ps=0 w=0.42u l=1u
X2442 VDD VSS.t555 VDD VDD sg13_lv_pmos ad=0.19p pd=1.38u as=0 ps=0 w=1u l=1u
X2443 sg13cmos5l_buf_16_2.X a_19534_13726# VDD VDD sg13_lv_pmos ad=0.2128p pd=1.5u as=0.2128p ps=1.5u w=1.12u l=0.13u
X2444 VDD VSS.t1680 VDD VDD sg13_lv_pmos ad=0.34p pd=2.68u as=0 ps=0 w=1u l=1u
X2445 VSS.t2719 VDD VSS.t2721 VSS.t2620 sg13_lv_nmos ad=79.8f pd=0.8u as=0 ps=0 w=0.42u l=1u
X2446 VDD VSS.t1957 VDD VDD sg13_lv_pmos ad=0.34p pd=2.68u as=0 ps=0 w=1u l=1u
X2447 VSS.t902 VDD VSS.t901 VSS.t900 sg13_lv_nmos ad=0.1428p pd=1.52u as=0 ps=0 w=0.42u l=1u
X2448 VDD VSS.t2916 VDD VDD sg13_lv_pmos ad=0.34p pd=2.68u as=0 ps=0 w=1u l=1u
X2449 VSS.t2300 VDD VSS.t2302 VSS.t2301 sg13_lv_nmos ad=79.8f pd=0.8u as=0 ps=0 w=0.42u l=1u
X2450 a_2822_15234# sg13cmos5l_nor2_1_0.Y VDD VDD sg13_lv_pmos ad=79.8f pd=0.8u as=0.1428p ps=1.52u w=0.42u l=0.13u
X2451 VSS.t199 sg13cmos5l_o21ai_1_2.A2 a_24265_14508# VSS.t7 sg13_lv_nmos ad=0.1045p pd=0.93u as=0.187p ps=1.78u w=0.55u l=0.13u
X2452 VDD VSS.t3089 VDD VDD sg13_lv_pmos ad=0.19p pd=1.38u as=0 ps=0 w=1u l=1u
X2453 VDD VSS.t2292 VDD VDD sg13_lv_pmos ad=0.19p pd=1.38u as=0 ps=0 w=1u l=1u
X2454 VSS.t426 VDD VSS.t426 VSS.t2 sg13_lv_nmos ad=79.8f pd=0.8u as=0 ps=0 w=0.42u l=1u
X2455 VDD a_9638_14484# a_9750_14508# VDD sg13_lv_pmos ad=0.2254p pd=1.53u as=0.34p ps=2.68u w=1u l=0.5u
X2456 VDD VSS.t414 VDD VDD sg13_lv_pmos ad=0.19p pd=1.38u as=0 ps=0 w=1u l=1u
X2457 VSS.t636 VDD VSS.t636 VSS.t635 sg13_lv_nmos ad=0.1428p pd=1.52u as=0 ps=0 w=0.42u l=1u
X2458 VSS.t2737 VDD VSS.t2737 VSS.t2620 sg13_lv_nmos ad=0.1428p pd=1.52u as=0 ps=0 w=0.42u l=1u
X2459 VDD VSS.t2687 VDD VDD sg13_lv_pmos ad=0.34p pd=2.68u as=0 ps=0 w=1u l=1u
X2460 VDD VSS.t906 VDD VDD sg13_lv_pmos ad=0.34p pd=2.68u as=0 ps=0 w=1u l=1u
X2461 VDD VSS.t2324 VDD VDD sg13_lv_pmos ad=0.34p pd=2.68u as=0 ps=0 w=1u l=1u
X2462 VSS.t73 a_26441_16334# a_26362_16237# VSS.t99 sg13_lv_nmos ad=6.38822p pd=41.325u as=0.27427p ps=2.28u w=0.795u l=0.13u
X2463 VSS.t777 VDD VSS.t776 VSS.t775 sg13_lv_nmos ad=0.1428p pd=1.52u as=0 ps=0 w=0.42u l=1u
X2464 VDD VSS.t1470 VDD VDD sg13_lv_pmos ad=0.34p pd=2.68u as=0 ps=0 w=1u l=1u
X2465 VSS.t2108 VDD VSS.t2110 VSS.t2109 sg13_lv_nmos ad=79.8f pd=0.8u as=0 ps=0 w=0.42u l=1u
X2466 VDD VSS.t829 VDD VDD sg13_lv_pmos ad=0.19p pd=1.38u as=0 ps=0 w=1u l=1u
X2467 VDD VSS.t342 VDD VDD sg13_lv_pmos ad=0.34p pd=2.68u as=0 ps=0 w=1u l=1u
X2468 VSS.t2679 VDD VSS.t2678 VSS.t2620 sg13_lv_nmos ad=0.1428p pd=1.52u as=0 ps=0 w=0.42u l=1u
X2469 VDD VSS.t382 VDD VDD sg13_lv_pmos ad=0.34p pd=2.68u as=0 ps=0 w=1u l=1u
X2470 VSS.t1012 VDD VSS.t1011 VSS.t1010 sg13_lv_nmos ad=0.1428p pd=1.52u as=0 ps=0 w=0.42u l=1u
X2471 VDD VSS.t1660 VDD VDD sg13_lv_pmos ad=0.34p pd=2.68u as=0 ps=0 w=1u l=1u
X2472 sg13cmos5l_xnor2_1_0.Y sg13cmos5l_buf_1_0.X a_3123_14484# VDD sg13_lv_pmos ad=0.2408p pd=1.55u as=0.1428p ps=1.375u w=1.12u l=0.13u
X2473 VDD VSS.t781 VDD VDD sg13_lv_pmos ad=0.34p pd=2.68u as=0 ps=0 w=1u l=1u
X2474 VDD VSS.t1523 VDD VDD sg13_lv_pmos ad=0.19p pd=1.38u as=0 ps=0 w=1u l=1u
X2475 VSS.t1172 VDD VSS.t1173 VSS.t224 sg13_lv_nmos ad=79.8f pd=0.8u as=0 ps=0 w=0.42u l=1u
X2476 VSS.t1207 VDD VSS.t1206 VSS.t224 sg13_lv_nmos ad=0.1428p pd=1.52u as=0 ps=0 w=0.42u l=1u
X2477 VDD VSS.t1192 VDD VDD sg13_lv_pmos ad=0.34p pd=2.68u as=0 ps=0 w=1u l=1u
X2478 VSS.t2977 VDD VSS.t2976 VSS.t2975 sg13_lv_nmos ad=0.1428p pd=1.52u as=0 ps=0 w=0.42u l=1u
X2479 VDD VSS.t2755 VDD VDD sg13_lv_pmos ad=0.34p pd=2.68u as=0 ps=0 w=1u l=1u
X2480 VSS.t348 VDD VSS.t350 VSS.t349 sg13_lv_nmos ad=79.8f pd=0.8u as=0 ps=0 w=0.42u l=1u
X2481 VDD sg13cmos5l_a21oi_1_0.Y a_16760_16037# VDD sg13_lv_pmos ad=0.1523p pd=1.38u as=0.1428p ps=1.52u w=0.42u l=0.13u
X2482 VSS.t476 VDD VSS.t135 VSS.t477 sg13_lv_nmos ad=79.8f pd=0.8u as=0 ps=0 w=0.42u l=1u
X2483 VSS.t92 a_27311_14845# a_27978_14484# VSS.t2 sg13_lv_nmos ad=0.1406p pd=1.12u as=0.2516p ps=2.16u w=0.74u l=0.13u
X2484 VDD VSS.t1300 VDD VDD sg13_lv_pmos ad=0.34p pd=2.68u as=0 ps=0 w=1u l=1u
X2485 VDD VSS.t620 VDD VDD sg13_lv_pmos ad=0.19p pd=1.38u as=0 ps=0 w=1u l=1u
X2486 VSS.t817 VDD VSS.t816 VSS.t815 sg13_lv_nmos ad=0.1428p pd=1.52u as=0 ps=0 w=0.42u l=1u
X2487 VSS.t275 a_12524_15960# counter_value_o[2] VSS.t274 sg13_lv_nmos ad=0.14875p pd=1.16u as=0.2886p ps=2.26u w=0.74u l=0.13u
X2488 VSS.t1176 VDD VSS.t1177 VSS.t224 sg13_lv_nmos ad=79.8f pd=0.8u as=0 ps=0 w=0.42u l=1u
X2489 VDD VSS.t2703 VDD VDD sg13_lv_pmos ad=0.19p pd=1.38u as=0 ps=0 w=1u l=1u
X2490 VSS.t2245 VDD VSS.t2247 VSS.t2246 sg13_lv_nmos ad=79.8f pd=0.8u as=0 ps=0 w=0.42u l=1u
X2491 VDD VSS.t576 VDD VDD sg13_lv_pmos ad=0.34p pd=2.68u as=0 ps=0 w=1u l=1u
X2492 VSS.t932 VDD VSS.t931 VSS.t930 sg13_lv_nmos ad=0.1428p pd=1.52u as=0 ps=0 w=0.42u l=1u
X2493 VSS.t2370 VDD VSS.t2369 VSS.t2368 sg13_lv_nmos ad=0.1428p pd=1.52u as=0 ps=0 w=0.42u l=1u
X2494 VDD VSS.t796 VDD VDD sg13_lv_pmos ad=0.34p pd=2.68u as=0 ps=0 w=1u l=1u
X2495 VDD VSS.t1455 VDD VDD sg13_lv_pmos ad=0.34p pd=2.68u as=0 ps=0 w=1u l=1u
X2496 VSS.t2718 VDD VSS.t2719 VSS.t2620 sg13_lv_nmos ad=79.8f pd=0.8u as=0 ps=0 w=0.42u l=1u
X2497 sg13cmos5l_buf_16_2.A a_15790_15238# VDD VDD sg13_lv_pmos ad=0.2128p pd=1.5u as=0.2128p ps=1.5u w=1.12u l=0.13u
X2498 VSS.t438 VDD VSS.t441 VSS.t2 sg13_lv_nmos ad=79.8f pd=0.8u as=0 ps=0 w=0.42u l=1u
X2499 VDD VSS.t984 VDD VDD sg13_lv_pmos ad=0.19p pd=1.38u as=0 ps=0 w=1u l=1u
X2500 VSS.t1226 VDD VSS.t1225 VSS.t224 sg13_lv_nmos ad=0.1428p pd=1.52u as=0 ps=0 w=0.42u l=1u
X2501 VSS.t2093 VDD VSS.t2095 VSS.t2094 sg13_lv_nmos ad=79.8f pd=0.8u as=0 ps=0 w=0.42u l=1u
X2502 sg13cmos5l_or3_1_2.C sg13cmos5l_dfrbpq_1_2.Q a_20122_15238# VSS.t65 sg13_lv_nmos ad=0.2516p pd=2.16u as=0.1406p ps=1.12u w=0.74u l=0.13u
X2503 VSS.t1536 VDD VSS.t1535 VSS.t1534 sg13_lv_nmos ad=0.1428p pd=1.52u as=0 ps=0 w=0.42u l=1u
X2504 VSS.t2691 VDD VSS.t2690 VSS.t2620 sg13_lv_nmos ad=0.1428p pd=1.52u as=0 ps=0 w=0.42u l=1u
X2505 VDD VSS.t2653 VDD VDD sg13_lv_pmos ad=0.34p pd=2.68u as=0 ps=0 w=1u l=1u
X2506 VDD VSS.t128 VDD VDD sg13_lv_pmos ad=0.19p pd=1.38u as=0 ps=0 w=1u l=1u
X2507 VSS.t297 sg13cmos5l_dfrbpq_1_5.RESET_B a_26052_13722# VSS.t3211 sg13_lv_nmos ad=0.1626p pd=1.415u as=60.89999f ps=0.71u w=0.42u l=0.13u
X2508 VDD VSS.t1367 VDD VDD sg13_lv_pmos ad=0.34p pd=2.68u as=0 ps=0 w=1u l=1u
X2509 VDD VSS.t2719 VDD VDD sg13_lv_pmos ad=0.34p pd=2.68u as=0 ps=0 w=1u l=1u
X2510 VDD VSS.t1982 VDD VDD sg13_lv_pmos ad=0.34p pd=2.68u as=0 ps=0 w=1u l=1u
X2511 VDD VSS.t2352 VDD VDD sg13_lv_pmos ad=0.19p pd=1.38u as=0 ps=0 w=1u l=1u
X2512 VDD VSS.t2010 VDD VDD sg13_lv_pmos ad=0.19p pd=1.38u as=0 ps=0 w=1u l=1u
X2513 VSS.t523 VDD VSS.t525 VSS.t524 sg13_lv_nmos ad=79.8f pd=0.8u as=0 ps=0 w=0.42u l=1u
X2514 VSS.t586 VDD VSS.t588 VSS.t587 sg13_lv_nmos ad=79.8f pd=0.8u as=0 ps=0 w=0.42u l=1u
X2515 VSS.t832 VDD VSS.t831 VSS.t830 sg13_lv_nmos ad=0.1428p pd=1.52u as=0 ps=0 w=0.42u l=1u
X2516 VSS.t902 VDD VSS.t901 VSS.t900 sg13_lv_nmos ad=0.1428p pd=1.52u as=0 ps=0 w=0.42u l=1u
X2517 VSS.t1262 VDD VSS.t1263 VSS.t224 sg13_lv_nmos ad=79.8f pd=0.8u as=0 ps=0 w=0.42u l=1u
X2518 VSS.t1184 VDD VSS.t1185 VSS.t224 sg13_lv_nmos ad=79.8f pd=0.8u as=0 ps=0 w=0.42u l=1u
X2519 VSS.t456 VDD VSS.t455 VSS.t2 sg13_lv_nmos ad=0.1428p pd=1.52u as=0 ps=0 w=0.42u l=1u
X2520 VDD VSS.t859 VDD VDD sg13_lv_pmos ad=0.19p pd=1.38u as=0 ps=0 w=1u l=1u
X2521 VDD VSS.t1665 VDD VDD sg13_lv_pmos ad=0.34p pd=2.68u as=0 ps=0 w=1u l=1u
X2522 VSS.t2997 VDD VSS.t2996 VSS.t2995 sg13_lv_nmos ad=0.1428p pd=1.52u as=0 ps=0 w=0.42u l=1u
X2523 VSS.t2711 VDD VSS.t2712 VSS.t2620 sg13_lv_nmos ad=79.8f pd=0.8u as=0 ps=0 w=0.42u l=1u
X2524 VDD VSS.t2901 VDD VDD sg13_lv_pmos ad=0.34p pd=2.68u as=0 ps=0 w=1u l=1u
X2525 VDD VSS.t632 VDD VDD sg13_lv_pmos ad=0.19p pd=1.38u as=0 ps=0 w=1u l=1u
X2526 VDD VSS.t535 VDD VDD sg13_lv_pmos ad=0.34p pd=2.68u as=0 ps=0 w=1u l=1u
X2527 VDD VSS.t1024 VDD VDD sg13_lv_pmos ad=0.19p pd=1.38u as=0 ps=0 w=1u l=1u
X2528 VSS.t2465 VDD VSS.t2464 VSS.t2463 sg13_lv_nmos ad=0.1428p pd=1.52u as=0 ps=0 w=0.42u l=1u
X2529 VSS.t2885 VDD VSS.t2768 VSS.t2620 sg13_lv_nmos ad=79.8f pd=0.8u as=0 ps=0 w=0.42u l=1u
X2530 VDD VSS.t1468 VDD VDD sg13_lv_pmos ad=0.19p pd=1.38u as=0 ps=0 w=1u l=1u
X2531 VDD VSS.t2377 VDD VDD sg13_lv_pmos ad=0.19p pd=1.38u as=0 ps=0 w=1u l=1u
X2532 sg13cmos5l_xor2_1_0.B sg13cmos5l_dlygate4sd3_1_5.A a_7544_16362# VSS.t3276 sg13_lv_nmos ad=0.2516p pd=2.16u as=0.1406p ps=1.12u w=0.74u l=0.13u
X2533 VDD VSS.t483 VDD VDD sg13_lv_pmos ad=0.19p pd=1.38u as=0 ps=0 w=1u l=1u
X2534 VSS.t236 VDD VSS.t236 VSS.t603 sg13_lv_nmos ad=79.8f pd=0.8u as=0 ps=0 w=0.42u l=1u
X2535 VSS.t777 VDD VSS.t776 VSS.t775 sg13_lv_nmos ad=0.1428p pd=1.52u as=0 ps=0 w=0.42u l=1u
X2536 VDD VSS.t951 VDD VDD sg13_lv_pmos ad=0.34p pd=2.68u as=0 ps=0 w=1u l=1u
X2537 VSS.t1240 VDD VSS.t1239 VSS.t224 sg13_lv_nmos ad=0.1428p pd=1.52u as=0 ps=0 w=0.42u l=1u
X2538 VSS.t1983 VDD VSS.t1985 VSS.t1984 sg13_lv_nmos ad=79.8f pd=0.8u as=0 ps=0 w=0.42u l=1u
X2539 VDD sg13cmos5l_dlygate4sd3_1_11.X sg13cmos5l_nand4_1_0.Y VDD sg13_lv_pmos ad=0.2128p pd=1.5u as=0.2128p ps=1.5u w=1.12u l=0.13u
X2540 VSS.t2709 VDD VSS.t2710 VSS.t2620 sg13_lv_nmos ad=79.8f pd=0.8u as=0 ps=0 w=0.42u l=1u
X2541 a_25582_15423# a_25697_15424# VSS.t202 VSS.t8 sg13_lv_nmos ad=0.1428p pd=1.52u as=0.1426p ps=1.16u w=0.42u l=0.5u
X2542 VSS.t1486 VDD VSS.t1485 VSS.t1484 sg13_lv_nmos ad=0.1428p pd=1.52u as=0 ps=0 w=0.42u l=1u
X2543 a_15790_15238# clock_i VDD VDD sg13_lv_pmos ad=0.2128p pd=1.5u as=0.2128p ps=1.5u w=1.12u l=0.13u
X2544 VSS.t1656 VDD VSS.t1658 VSS.t1657 sg13_lv_nmos ad=79.8f pd=0.8u as=0 ps=0 w=0.42u l=1u
X2545 VSS.t2048 VDD VSS.t2047 VSS.t2046 sg13_lv_nmos ad=0.1428p pd=1.52u as=0 ps=0 w=0.42u l=1u
X2546 VSS.t528 VDD VSS.t530 VSS.t529 sg13_lv_nmos ad=79.8f pd=0.8u as=0 ps=0 w=0.42u l=1u
X2547 VDD VSS.t2710 VDD VDD sg13_lv_pmos ad=0.34p pd=2.68u as=0 ps=0 w=1u l=1u
X2548 VDD VSS.t2002 VDD VDD sg13_lv_pmos ad=0.34p pd=2.68u as=0 ps=0 w=1u l=1u
X2549 VSS.t1244 VDD VSS.t1243 VSS.t224 sg13_lv_nmos ad=0.1428p pd=1.52u as=0 ps=0 w=0.42u l=1u
X2550 VDD VSS.t1014 VDD VDD sg13_lv_pmos ad=0.19p pd=1.38u as=0 ps=0 w=1u l=1u
X2551 VSS.t1168 VDD VSS.t1166 VSS.t224 sg13_lv_nmos ad=0.1428p pd=1.52u as=0 ps=0 w=0.42u l=1u
X2552 VSS.t1276 VDD VSS.t1277 VSS.t224 sg13_lv_nmos ad=79.8f pd=0.8u as=0 ps=0 w=0.42u l=1u
X2553 VSS.t2230 VDD VSS.t2232 VSS.t2231 sg13_lv_nmos ad=79.8f pd=0.8u as=0 ps=0 w=0.42u l=1u
X2554 a_18969_14607# a_18027_14495# a_18767_14845# VDD sg13_lv_pmos ad=93.45f pd=0.865u as=0.2048p ps=1.63u w=0.42u l=0.13u
X2555 VDD VSS.t450 VDD VDD sg13_lv_pmos ad=0.34p pd=2.68u as=0 ps=0 w=1u l=1u
X2556 VDD VSS.t1685 VDD VDD sg13_lv_pmos ad=0.34p pd=2.68u as=0 ps=0 w=1u l=1u
X2557 VDD VSS.t1962 VDD VDD sg13_lv_pmos ad=0.34p pd=2.68u as=0 ps=0 w=1u l=1u
X2558 VDD VSS.t1184 VDD VDD sg13_lv_pmos ad=0.34p pd=2.68u as=0 ps=0 w=1u l=1u
X2559 VSS.t2305 VDD VSS.t2307 VSS.t2306 sg13_lv_nmos ad=79.8f pd=0.8u as=0 ps=0 w=0.42u l=1u
X2560 VSS.t817 VDD VSS.t816 VSS.t815 sg13_lv_nmos ad=0.1428p pd=1.52u as=0 ps=0 w=0.42u l=1u
X2561 VDD VSS.t3094 VDD VDD sg13_lv_pmos ad=0.19p pd=1.38u as=0 ps=0 w=1u l=1u
X2562 sg13cmos5l_dfrbpq_1_2.CLK a_12212_15202# VSS.t135 VSS.t136 sg13_lv_nmos ad=0.1406p pd=1.12u as=0.1406p ps=1.12u w=0.74u l=0.13u
X2563 a_12212_15202# sg13cmos5l_buf_16_2.A VSS.t481 VSS.t3311 sg13_lv_nmos ad=0.1406p pd=1.12u as=0.1406p ps=1.12u w=0.74u l=0.13u
X2564 VSS.t1047 VDD VSS.t1049 VSS.t1048 sg13_lv_nmos ad=79.8f pd=0.8u as=0 ps=0 w=0.42u l=1u
X2565 VSS.t932 VDD VSS.t931 VSS.t930 sg13_lv_nmos ad=0.1428p pd=1.52u as=0 ps=0 w=0.42u l=1u
X2566 VSS.t387 VDD VSS.t387 VSS.t388 sg13_lv_nmos ad=79.8f pd=0.8u as=0 ps=0 w=0.42u l=1u
X2567 VSS.t540 VDD VSS.t540 VSS.t541 sg13_lv_nmos ad=79.8f pd=0.8u as=0 ps=0 w=0.42u l=1u
X2568 VDD VSS.t576 VDD VDD sg13_lv_pmos ad=0.34p pd=2.68u as=0 ps=0 w=1u l=1u
X2569 VSS.t2741 VDD VSS.t2740 VSS.t2620 sg13_lv_nmos ad=0.1428p pd=1.52u as=0 ps=0 w=0.42u l=1u
X2570 VDD VSS.t2669 VDD VDD sg13_lv_pmos ad=0.34p pd=2.68u as=0 ps=0 w=1u l=1u
X2571 VDD VSS.t1029 VDD VDD sg13_lv_pmos ad=0.19p pd=1.38u as=0 ps=0 w=1u l=1u
X2572 VSS.t2078 VDD VSS.t2080 VSS.t2079 sg13_lv_nmos ad=79.8f pd=0.8u as=0 ps=0 w=0.42u l=1u
X2573 a_20964_14488# a_21483_14495# a_22223_14845# VSS.t7 sg13_lv_nmos ad=0.3473p pd=2.71u as=0.12665p ps=1.145u w=0.74u l=0.13u
X2574 VDD VSS.t1247 VDD VDD sg13_lv_pmos ad=0.19p pd=1.38u as=0 ps=0 w=1u l=1u
X2575 VSS.t1521 VDD VSS.t1520 VSS.t1519 sg13_lv_nmos ad=0.1428p pd=1.52u as=0 ps=0 w=0.42u l=1u
X2576 VDD VSS.t2751 VDD VDD sg13_lv_pmos ad=0.19p pd=1.38u as=0 ps=0 w=1u l=1u
X2577 VSS.t2450 VDD VSS.t2449 VSS.t2448 sg13_lv_nmos ad=0.1428p pd=1.52u as=0 ps=0 w=0.42u l=1u
X2578 a_8698_13690# sg13cmos5l_dlygate4sd3_1_0.A VDD VDD sg13_lv_pmos ad=0.1428p pd=1.52u as=0.1523p ps=1.38u w=0.42u l=0.13u
X2579 VDD VSS.t1480 VDD VDD sg13_lv_pmos ad=0.34p pd=2.68u as=0 ps=0 w=1u l=1u
X2580 VSS.t2682 VDD VSS.t2681 VSS.t2620 sg13_lv_nmos ad=0.1428p pd=1.52u as=0 ps=0 w=0.42u l=1u
X2581 VDD VSS.t2645 VDD VDD sg13_lv_pmos ad=0.34p pd=2.68u as=0 ps=0 w=1u l=1u
X2582 VDD VSS.t2389 VDD VDD sg13_lv_pmos ad=0.34p pd=2.68u as=0 ps=0 w=1u l=1u
X2583 VSS.t832 VDD VSS.t831 VSS.t830 sg13_lv_nmos ad=0.1428p pd=1.52u as=0 ps=0 w=0.42u l=1u
X2584 VSS.t1258 VDD VSS.t1257 VSS.t224 sg13_lv_nmos ad=0.1428p pd=1.52u as=0 ps=0 w=0.42u l=1u
X2585 VDD VSS.t789 VDD VDD sg13_lv_pmos ad=0.19p pd=1.38u as=0 ps=0 w=1u l=1u
X2586 VSS.t712 VDD VSS.t712 VSS.t713 sg13_lv_nmos ad=79.8f pd=0.8u as=0 ps=0 w=0.42u l=1u
X2587 VDD VSS.t2337 VDD VDD sg13_lv_pmos ad=0.19p pd=1.38u as=0 ps=0 w=1u l=1u
X2588 VDD VSS.t1995 VDD VDD sg13_lv_pmos ad=0.19p pd=1.38u as=0 ps=0 w=1u l=1u
X2589 VSS.t1998 VDD VSS.t1997 VSS.t1996 sg13_lv_nmos ad=0.1428p pd=1.52u as=0 ps=0 w=0.42u l=1u
X2590 VSS.t1289 VDD VSS.t1289 VSS.t224 sg13_lv_nmos ad=79.8f pd=0.8u as=0 ps=0 w=0.42u l=1u
X2591 a_21070_16263# a_21185_16262# VDD VDD sg13_lv_pmos ad=0.34p pd=2.68u as=0.2254p ps=1.53u w=1u l=0.5u
X2592 VDD VSS.t1194 VDD VDD sg13_lv_pmos ad=0.34p pd=2.68u as=0 ps=0 w=1u l=1u
X2593 VSS.t2982 VDD VSS.t2981 VSS.t2980 sg13_lv_nmos ad=0.1428p pd=1.52u as=0 ps=0 w=0.42u l=1u
X2594 VSS.t1017 VDD VSS.t1016 VSS.t1015 sg13_lv_nmos ad=0.1428p pd=1.52u as=0 ps=0 w=0.42u l=1u
X2595 VDD VSS.t1193 VDD VDD sg13_lv_pmos ad=0.34p pd=2.68u as=0 ps=0 w=1u l=1u
X2596 VSS.t1294 VDD VSS.t1295 VSS.t224 sg13_lv_nmos ad=79.8f pd=0.8u as=0 ps=0 w=0.42u l=1u
X2597 sg13cmos5l_dfrbpq_1_2.CLK a_12212_15202# VSS.t128 VSS.t130 sg13_lv_nmos ad=0.1406p pd=1.12u as=0.1406p ps=1.12u w=0.74u l=0.13u
X2598 VSS.t577 VDD VSS.t576 VSS.t575 sg13_lv_nmos ad=0.1428p pd=1.52u as=0 ps=0 w=0.42u l=1u
X2599 VSS.t549 VDD VSS.t549 VSS.t662 sg13_lv_nmos ad=0.1428p pd=1.52u as=0 ps=0 w=0.42u l=1u
X2600 VDD VSS.t881 VDD VDD sg13_lv_pmos ad=0.34p pd=2.68u as=0 ps=0 w=1u l=1u
X2601 VDD VSS.t1453 VDD VDD sg13_lv_pmos ad=0.19p pd=1.38u as=0 ps=0 w=1u l=1u
X2602 VSS.t2759 VDD VSS.t2760 VSS.t2620 sg13_lv_nmos ad=79.8f pd=0.8u as=0 ps=0 w=0.42u l=1u
X2603 sg13cmos5l_dlygate4sd3_1_6.X a_9750_14508# VDD VDD sg13_lv_pmos ad=0.4256p pd=3u as=0.2254p ps=1.53u w=1.12u l=0.13u
X2604 VSS.t2250 VDD VSS.t2252 VSS.t2251 sg13_lv_nmos ad=79.8f pd=0.8u as=0 ps=0 w=0.42u l=1u
X2605 VSS.t2731 VDD VSS.t2731 VSS.t2620 sg13_lv_nmos ad=0.1428p pd=1.52u as=0 ps=0 w=0.42u l=1u
X2606 VDD a_6566_15238# a_6678_15302# VDD sg13_lv_pmos ad=0.2254p pd=1.53u as=0.34p ps=2.68u w=1u l=0.5u
X2607 VDD VSS.t1460 VDD VDD sg13_lv_pmos ad=0.34p pd=2.68u as=0 ps=0 w=1u l=1u
X2608 VDD VSS.t1633 VDD VDD sg13_lv_pmos ad=0.19p pd=1.38u as=0 ps=0 w=1u l=1u
X2609 VSS.t1471 VDD VSS.t1470 VSS.t1469 sg13_lv_nmos ad=0.1428p pd=1.52u as=0 ps=0 w=0.42u l=1u
X2610 VSS.t1541 VDD VSS.t1540 VSS.t1539 sg13_lv_nmos ad=0.1428p pd=1.52u as=0 ps=0 w=0.42u l=1u
X2611 VDD VSS.t2638 VDD VDD sg13_lv_pmos ad=0.34p pd=2.68u as=0 ps=0 w=1u l=1u
X2612 VDD VSS.t944 VDD VDD sg13_lv_pmos ad=0.19p pd=1.38u as=0 ps=0 w=1u l=1u
X2613 VDD VSS.t1218 VDD VDD sg13_lv_pmos ad=0.34p pd=2.68u as=0 ps=0 w=1u l=1u
X2614 VDD VSS.t1987 VDD VDD sg13_lv_pmos ad=0.34p pd=2.68u as=0 ps=0 w=1u l=1u
X2615 VDD sg13cmos5l_buf_1_0.X sg13cmos5l_xor2_1_1.B VDD sg13_lv_pmos ad=0.3808p pd=2.92u as=0.2128p ps=1.5u w=1.12u l=0.13u
X2616 VDD sg13cmos5l_or3_1_2.B a_15208_15996# VDD sg13_lv_pmos ad=0.2114p pd=1.54u as=0.2856p ps=2.36u w=0.84u l=0.13u
X2617 VDD VSS.t450 VDD VDD sg13_lv_pmos ad=0.34p pd=2.68u as=0 ps=0 w=1u l=1u
X2618 VDD VSS.t2357 VDD VDD sg13_lv_pmos ad=0.19p pd=1.38u as=0 ps=0 w=1u l=1u
X2619 VDD VSS.t2015 VDD VDD sg13_lv_pmos ad=0.19p pd=1.38u as=0 ps=0 w=1u l=1u
X2620 VSS.t1661 VDD VSS.t1660 VSS.t1659 sg13_lv_nmos ad=0.1428p pd=1.52u as=0 ps=0 w=0.42u l=1u
X2621 VDD VSS.t871 VDD VDD sg13_lv_pmos ad=0.34p pd=2.68u as=0 ps=0 w=1u l=1u
X2622 VSS.t2 a_21381_14495# a_21483_14495# VSS.t6 sg13_lv_nmos ad=5.4903p pd=35.61u as=0.2516p ps=2.16u w=0.74u l=0.13u
X2623 VDD VSS.t1285 VDD VDD sg13_lv_pmos ad=0.34p pd=2.68u as=0 ps=0 w=1u l=1u
X2624 VDD VSS.t527 VDD VDD sg13_lv_pmos ad=0.34p pd=2.68u as=0 ps=0 w=1u l=1u
X2625 VSS.t1047 VDD VSS.t1049 VSS.t1048 sg13_lv_nmos ad=79.8f pd=0.8u as=0 ps=0 w=0.42u l=1u
X2626 VSS.t2470 VDD VSS.t2469 VSS.t2468 sg13_lv_nmos ad=0.1428p pd=1.52u as=0 ps=0 w=0.42u l=1u
X2627 VDD a_32492_15960# counter_value_o[6] VDD sg13_lv_pmos ad=0.2114p pd=1.54u as=0.42p ps=2.99u w=1.12u l=0.13u
X2628 VSS.t737 VDD VSS.t116 VSS.t738 sg13_lv_nmos ad=79.8f pd=0.8u as=0 ps=0 w=0.42u l=1u
X2629 VDD VSS.t1247 VDD VDD sg13_lv_pmos ad=0.19p pd=1.38u as=0 ps=0 w=1u l=1u
X2630 VDD VSS.t2042 VDD VDD sg13_lv_pmos ad=0.34p pd=2.68u as=0 ps=0 w=1u l=1u
X2631 VSS.t98 a_25766_15996# a_25878_16020# VSS.t285 sg13_lv_nmos ad=0.1426p pd=1.16u as=0.1428p ps=1.52u w=0.42u l=0.5u
X2632 VSS.t907 VDD VSS.t906 VSS.t905 sg13_lv_nmos ad=0.1428p pd=1.52u as=0 ps=0 w=0.42u l=1u
X2633 VDD VSS.t3174 VDD VDD sg13_lv_pmos ad=0.19p pd=1.38u as=0 ps=0 w=1u l=1u
X2634 VSS.t2235 VDD VSS.t2237 VSS.t2236 sg13_lv_nmos ad=79.8f pd=0.8u as=0 ps=0 w=0.42u l=1u
X2635 a_3108_15552# a_3627_15356# a_4367_15311# VSS.t149 sg13_lv_nmos ad=0.3473p pd=2.71u as=0.12665p ps=1.145u w=0.74u l=0.13u
X2636 VSS.t1228 VDD VSS.t1229 VSS.t224 sg13_lv_nmos ad=79.8f pd=0.8u as=0 ps=0 w=0.42u l=1u
X2637 VDD VSS.t2659 VDD VDD sg13_lv_pmos ad=0.34p pd=2.68u as=0 ps=0 w=1u l=1u
X2638 VSS.t2712 VDD VSS.t2713 VSS.t2620 sg13_lv_nmos ad=79.8f pd=0.8u as=0 ps=0 w=0.42u l=1u
X2639 VSS.t1456 VDD VSS.t1455 VSS.t1454 sg13_lv_nmos ad=0.1428p pd=1.52u as=0 ps=0 w=0.42u l=1u
X2640 VDD VSS.t911 VDD VDD sg13_lv_pmos ad=0.34p pd=2.68u as=0 ps=0 w=1u l=1u
X2641 VDD VSS.t1465 VDD VDD sg13_lv_pmos ad=0.34p pd=2.68u as=0 ps=0 w=1u l=1u
X2642 VDD VSS.t2374 VDD VDD sg13_lv_pmos ad=0.34p pd=2.68u as=0 ps=0 w=1u l=1u
X2643 VSS.t450 VDD VSS.t450 VSS.t2 sg13_lv_nmos ad=0.1428p pd=1.52u as=0 ps=0 w=0.42u l=1u
X2644 VSS.t782 VDD VSS.t781 VSS.t780 sg13_lv_nmos ad=0.1428p pd=1.52u as=0 ps=0 w=0.42u l=1u
X2645 VDD VSS.t1209 VDD VDD sg13_lv_pmos ad=0.34p pd=2.68u as=0 ps=0 w=1u l=1u
X2646 VDD VSS.t2713 VDD VDD sg13_lv_pmos ad=0.34p pd=2.68u as=0 ps=0 w=1u l=1u
X2647 VSS.t2265 VDD VSS.t2264 VSS.t2263 sg13_lv_nmos ad=0.1428p pd=1.52u as=0 ps=0 w=0.42u l=1u
X2648 VSS.t63 a_18106_15960# a_17825_16262# VSS.t3267 sg13_lv_nmos ad=79.8f pd=0.8u as=0.1428p ps=1.52u w=0.42u l=0.5u
X2649 a_32492_15960# sg13cmos5l_dfrbpq_1_7.Q VDD VDD sg13_lv_pmos ad=0.2856p pd=2.36u as=0.2114p ps=1.54u w=0.84u l=0.13u
X2650 a_25978_15202# sg13cmos5l_o21ai_1_3.Y VSS.t228 VSS.t3255 sg13_lv_nmos ad=0.1428p pd=1.52u as=79.8f ps=0.8u w=0.42u l=0.13u
X2651 VDD VSS.t834 VDD VDD sg13_lv_pmos ad=0.19p pd=1.38u as=0 ps=0 w=1u l=1u
X2652 VSS.t2647 VDD VSS.t2649 VSS.t2620 sg13_lv_nmos ad=79.8f pd=0.8u as=0 ps=0 w=0.42u l=1u
X2653 VDD VSS.t2499 VDD VDD sg13_lv_pmos ad=0.34p pd=2.68u as=0 ps=0 w=1u l=1u
X2654 VSS.t1017 VDD VSS.t1016 VSS.t1015 sg13_lv_nmos ad=0.1428p pd=1.52u as=0 ps=0 w=0.42u l=1u
X2655 VSS.t1205 VDD VSS.t1204 VSS.t224 sg13_lv_nmos ad=0.1428p pd=1.52u as=0 ps=0 w=0.42u l=1u
X2656 VSS.t1237 VDD VSS.t1238 VSS.t224 sg13_lv_nmos ad=79.8f pd=0.8u as=0 ps=0 w=0.42u l=1u
X2657 VDD VSS.t1186 VDD VDD sg13_lv_pmos ad=0.34p pd=2.68u as=0 ps=0 w=1u l=1u
X2658 a_20974_15423# a_21089_15424# VSS.t42 VSS.t3268 sg13_lv_nmos ad=0.1428p pd=1.52u as=0.1426p ps=1.16u w=0.42u l=0.5u
X2659 VDD VSS.t2027 VDD VDD sg13_lv_pmos ad=0.34p pd=2.68u as=0 ps=0 w=1u l=1u
X2660 VSS.t44 a_4367_15311# a_5034_15532# VSS.t3198 sg13_lv_nmos ad=0.1406p pd=1.12u as=0.2516p ps=2.16u w=0.74u l=0.13u
X2661 VSS.t37 a_8176_14726# a_7825_14845# VSS.t51 sg13_lv_nmos ad=79.8f pd=0.8u as=0.1428p ps=1.52u w=0.42u l=0.13u
X2662 VSS.t1210 VDD VSS.t1209 VSS.t224 sg13_lv_nmos ad=0.1428p pd=1.52u as=0 ps=0 w=0.42u l=1u
X2663 a_2540_15960# sg13cmos5l_dlygate4sd3_1_5.A VDD VDD sg13_lv_pmos ad=0.2856p pd=2.36u as=0.2114p ps=1.54u w=0.84u l=0.13u
X2664 VSS.t797 VDD VSS.t796 VSS.t795 sg13_lv_nmos ad=0.1428p pd=1.52u as=0 ps=0 w=0.42u l=1u
X2665 VSS.t982 VDD VSS.t984 VSS.t983 sg13_lv_nmos ad=79.8f pd=0.8u as=0 ps=0 w=0.42u l=1u
X2666 VSS.t2723 VDD VSS.t2722 VSS.t2620 sg13_lv_nmos ad=0.1428p pd=1.52u as=0 ps=0 w=0.42u l=1u
X2667 VDD VSS.t2671 VDD VDD sg13_lv_pmos ad=0.34p pd=2.68u as=0 ps=0 w=1u l=1u
X2668 VDD VSS.t1975 VDD VDD sg13_lv_pmos ad=0.19p pd=1.38u as=0 ps=0 w=1u l=1u
X2669 VSS.t199 sg13cmos5l_dfrbpq_1_7.Q a_24258_15242# VSS.t8 sg13_lv_nmos ad=0.2516p pd=2.16u as=0.1406p ps=1.12u w=0.74u l=0.13u
X2670 a_21190_14909# sg13cmos5l_dfrbpq_1_6.RESET_B VSS.t42 VSS.t173 sg13_lv_nmos ad=37.8f pd=0.6u as=0.1701p ps=1.65u w=0.42u l=0.13u
X2671 VSS.t1165 VDD VSS.t1166 VSS.t224 sg13_lv_nmos ad=79.8f pd=0.8u as=0 ps=0 w=0.42u l=1u
X2672 VDD VSS.t1445 VDD VDD sg13_lv_pmos ad=0.34p pd=2.68u as=0 ps=0 w=1u l=1u
X2673 VSS.t2083 VDD VSS.t2085 VSS.t2084 sg13_lv_nmos ad=79.8f pd=0.8u as=0 ps=0 w=0.42u l=1u
X2674 VSS.t1526 VDD VSS.t1525 VSS.t1524 sg13_lv_nmos ad=0.1428p pd=1.52u as=0 ps=0 w=0.42u l=1u
X2675 VSS.t3177 VDD VSS.t3179 VSS.t3178 sg13_lv_nmos ad=79.8f pd=0.8u as=0 ps=0 w=0.42u l=1u
X2676 VDD VSS.t582 VDD VDD sg13_lv_pmos ad=0.19p pd=1.38u as=0 ps=0 w=1u l=1u
X2677 VDD VSS.t989 VDD VDD sg13_lv_pmos ad=0.19p pd=1.38u as=0 ps=0 w=1u l=1u
X2678 VDD VSS.t1485 VDD VDD sg13_lv_pmos ad=0.34p pd=2.68u as=0 ps=0 w=1u l=1u
X2679 VSS.t2685 VDD VSS.t2684 VSS.t2620 sg13_lv_nmos ad=0.1428p pd=1.52u as=0 ps=0 w=0.42u l=1u
X2680 VDD VSS.t2394 VDD VDD sg13_lv_pmos ad=0.34p pd=2.68u as=0 ps=0 w=1u l=1u
X2681 VDD VSS.t1658 VDD VDD sg13_lv_pmos ad=0.19p pd=1.38u as=0 ps=0 w=1u l=1u
X2682 VDD VSS.t801 VDD VDD sg13_lv_pmos ad=0.34p pd=2.68u as=0 ps=0 w=1u l=1u
X2683 a_9540_15234# sg13cmos5l_dlygate4sd3_1_6.X a_9446_15234# VSS.t3307 sg13_lv_nmos ad=60.89999f pd=0.71u as=0.1428p ps=1.52u w=0.42u l=0.13u
X2684 sg13cmos5l_dfrbpq_1_2.Q a_17994_14020# VSS.t96 VSS.t3188 sg13_lv_nmos ad=0.2516p pd=2.16u as=0.1406p ps=1.12u w=0.74u l=0.13u
X2685 VDD VSS.t2342 VDD VDD sg13_lv_pmos ad=0.19p pd=1.38u as=0 ps=0 w=1u l=1u
X2686 VDD VSS.t2000 VDD VDD sg13_lv_pmos ad=0.19p pd=1.38u as=0 ps=0 w=1u l=1u
X2687 VSS.t2003 VDD VSS.t2002 VSS.t2001 sg13_lv_nmos ad=0.1428p pd=1.52u as=0 ps=0 w=0.42u l=1u
X2688 VDD VSS.t916 VDD VDD sg13_lv_pmos ad=0.34p pd=2.68u as=0 ps=0 w=1u l=1u
X2689 VSS.t1183 VDD VSS.t1184 VSS.t224 sg13_lv_nmos ad=79.8f pd=0.8u as=0 ps=0 w=0.42u l=1u
X2690 VSS.t1219 VDD VSS.t1218 VSS.t224 sg13_lv_nmos ad=0.1428p pd=1.52u as=0 ps=0 w=0.42u l=1u
X2691 VSS.t92 VDD VSS.t92 VSS.t2 sg13_lv_nmos ad=0.1428p pd=1.52u as=0 ps=0 w=0.42u l=1u
X2692 a_10714_14448# sg13cmos5l_dlygate4sd3_1_11.A VSS.t153 VSS.t3237 sg13_lv_nmos ad=0.1428p pd=1.52u as=79.8f ps=0.8u w=0.42u l=0.13u
X2693 VDD VSS.t1312 VDD VDD sg13_lv_pmos ad=0.34p pd=2.68u as=0 ps=0 w=1u l=1u
X2694 VDD VSS.t527 VDD VDD sg13_lv_pmos ad=0.34p pd=2.68u as=0 ps=0 w=1u l=1u
X2695 VSS.t40 a_19546_15202# a_19265_15424# VSS.t65 sg13_lv_nmos ad=79.8f pd=0.8u as=0.1428p ps=1.52u w=0.42u l=0.5u
X2696 a_8121_14607# a_7179_14495# a_7919_14845# VDD sg13_lv_pmos ad=93.45f pd=0.865u as=0.2048p ps=1.63u w=0.42u l=0.13u
X2697 VSS.t69 a_6958_13911# sg13cmos5l_dlygate4sd3_1_1.X VSS.t3183 sg13_lv_nmos ad=0.1426p pd=1.16u as=0.2516p ps=2.16u w=0.74u l=0.13u
X2698 VSS.t718 a_19534_13726# sg13cmos5l_buf_16_2.X VSS.t3305 sg13_lv_nmos ad=0.2516p pd=2.16u as=0.1406p ps=1.12u w=0.74u l=0.13u
X2699 VSS.t528 VDD VSS.t530 VSS.t529 sg13_lv_nmos ad=79.8f pd=0.8u as=0 ps=0 w=0.42u l=1u
X2700 VSS.t907 VDD VSS.t906 VSS.t905 sg13_lv_nmos ad=0.1428p pd=1.52u as=0 ps=0 w=0.42u l=1u
X2701 VSS.t1187 VDD VSS.t1188 VSS.t224 sg13_lv_nmos ad=79.8f pd=0.8u as=0 ps=0 w=0.42u l=1u
X2702 VDD VSS.t2633 VDD VDD sg13_lv_pmos ad=0.19p pd=1.38u as=0 ps=0 w=1u l=1u
X2703 VSS.t1516 VDD VSS.t1515 VSS.t1514 sg13_lv_nmos ad=0.1428p pd=1.52u as=0 ps=0 w=0.42u l=1u
X2704 VSS.t3047 VDD VSS.t3046 VSS.t3045 sg13_lv_nmos ad=0.1428p pd=1.52u as=0 ps=0 w=0.42u l=1u
X2705 VSS.t2250 VDD VSS.t2249 VSS.t2248 sg13_lv_nmos ad=0.1428p pd=1.52u as=0 ps=0 w=0.42u l=1u
X2706 VSS.t952 VDD VSS.t951 VSS.t950 sg13_lv_nmos ad=0.1428p pd=1.52u as=0 ps=0 w=0.42u l=1u
X2707 VSS.t446 VDD VSS.t446 VSS.t2 sg13_lv_nmos ad=79.8f pd=0.8u as=0 ps=0 w=0.42u l=1u
X2708 VDD VSS.t816 VDD VDD sg13_lv_pmos ad=0.34p pd=2.68u as=0 ps=0 w=1u l=1u
X2709 VSS.t1255 VDD VSS.t1256 VSS.t224 sg13_lv_nmos ad=79.8f pd=0.8u as=0 ps=0 w=0.42u l=1u
X2710 VDD VSS.t3159 VDD VDD sg13_lv_pmos ad=0.19p pd=1.38u as=0 ps=0 w=1u l=1u
X2711 VDD VSS.t325 VDD VDD sg13_lv_pmos ad=0.19p pd=1.38u as=0 ps=0 w=1u l=1u
X2712 VSS.t158 a_4366_14751# sg13cmos5l_xnor2_1_0.A VSS.t254 sg13_lv_nmos ad=0.1426p pd=1.16u as=0.2516p ps=2.16u w=0.74u l=0.13u
X2713 VDD VSS.t1638 VDD VDD sg13_lv_pmos ad=0.19p pd=1.38u as=0 ps=0 w=1u l=1u
X2714 VDD VSS.t3111 VDD VDD sg13_lv_pmos ad=0.34p pd=2.68u as=0 ps=0 w=1u l=1u
X2715 VSS.t2703 VDD VSS.t2704 VSS.t2620 sg13_lv_nmos ad=79.8f pd=0.8u as=0 ps=0 w=0.42u l=1u
X2716 VDD a_26842_15202# a_26561_15424# VDD sg13_lv_pmos ad=0.1523p pd=1.38u as=0.34p ps=2.68u w=1u l=0.5u
X2717 VSS.t782 VDD VSS.t781 VSS.t780 sg13_lv_nmos ad=0.1428p pd=1.52u as=0 ps=0 w=0.42u l=1u
X2718 VSS.t370 VDD VSS.t372 VSS.t371 sg13_lv_nmos ad=79.8f pd=0.8u as=0 ps=0 w=0.42u l=1u
X2719 VSS.t42 sg13cmos5l_or3_1_2.X a_20609_15260# VSS.t65 sg13_lv_nmos ad=0.2516p pd=2.16u as=0.1406p ps=1.12u w=0.74u l=0.13u
X2720 VSS.t2038 VDD VSS.t2037 VSS.t2036 sg13_lv_nmos ad=0.1428p pd=1.52u as=0 ps=0 w=0.42u l=1u
X2721 VSS.t48 VDD VSS.t48 VSS.t698 sg13_lv_nmos ad=79.8f pd=0.8u as=0 ps=0 w=0.42u l=1u
X2722 VSS.t1012 VDD VSS.t1014 VSS.t1013 sg13_lv_nmos ad=79.8f pd=0.8u as=0 ps=0 w=0.42u l=1u
X2723 VDD VSS.t1200 VDD VDD sg13_lv_pmos ad=0.19p pd=1.38u as=0 ps=0 w=1u l=1u
X2724 VDD VSS.t1200 VDD VDD sg13_lv_pmos ad=0.34p pd=2.68u as=0 ps=0 w=1u l=1u
X2725 VDD VSS.t2704 VDD VDD sg13_lv_pmos ad=0.34p pd=2.68u as=0 ps=0 w=1u l=1u
X2726 VDD VSS.t2743 VDD VDD sg13_lv_pmos ad=0.19p pd=1.38u as=0 ps=0 w=1u l=1u
X2727 VSS.t1274 VDD VSS.t1275 VSS.t224 sg13_lv_nmos ad=79.8f pd=0.8u as=0 ps=0 w=0.42u l=1u
X2728 VSS.t1195 VDD VSS.t1196 VSS.t224 sg13_lv_nmos ad=79.8f pd=0.8u as=0 ps=0 w=0.42u l=1u
X2729 VDD VSS.t2327 VDD VDD sg13_lv_pmos ad=0.19p pd=1.38u as=0 ps=0 w=1u l=1u
X2730 VSS.t338 VDD VSS.t337 VSS.t336 sg13_lv_nmos ad=0.1428p pd=1.52u as=0 ps=0 w=0.42u l=1u
X2731 VSS.t469 VDD VSS.t153 VSS.t468 sg13_lv_nmos ad=0.1428p pd=1.52u as=0 ps=0 w=0.42u l=1u
X2732 VSS.t572 VDD VSS.t574 VSS.t573 sg13_lv_nmos ad=79.8f pd=0.8u as=0 ps=0 w=0.42u l=1u
X2733 VDD VSS.t879 VDD VDD sg13_lv_pmos ad=0.19p pd=1.38u as=0 ps=0 w=1u l=1u
X2734 VSS.t2797 VDD VSS.t2640 VSS.t2620 sg13_lv_nmos ad=79.8f pd=0.8u as=0 ps=0 w=0.42u l=1u
X2735 a_25860_14922# sg13cmos5l_dfrbpq_1_7.D a_25766_14922# VSS.t7 sg13_lv_nmos ad=60.89999f pd=0.71u as=0.1428p ps=1.52u w=0.42u l=0.13u
X2736 a_24461_14508# sg13cmos5l_o21ai_1_2.A1 a_24359_14508# VDD sg13_lv_pmos ad=0.1575p pd=1.315u as=0.19p ps=1.38u w=1u l=0.13u
X2737 VDD VSS.t555 VDD VDD sg13_lv_pmos ad=0.19p pd=1.38u as=0 ps=0 w=1u l=1u
X2738 VSS.t69 sg13cmos5l_xor2_1_1.A a_7062_13330# VSS.t70 sg13_lv_nmos ad=0.15245p pd=1.17u as=88.8f ps=0.98u w=0.74u l=0.13u
X2739 VSS.t398 VDD VSS.t398 VSS.t401 sg13_lv_nmos ad=79.8f pd=0.8u as=0 ps=0 w=0.42u l=1u
X2740 a_10025_13668# a_10149_13765# VDD VDD sg13_lv_pmos ad=0.2442p pd=2.06u as=2.42015p ps=15.68u w=0.66u l=0.13u
X2741 VSS.t715 a_19534_13726# sg13cmos5l_buf_16_2.X VSS.t3301 sg13_lv_nmos ad=0.1406p pd=1.12u as=0.1406p ps=1.12u w=0.74u l=0.13u
X2742 VSS.t797 VDD VSS.t796 VSS.t795 sg13_lv_nmos ad=0.1428p pd=1.52u as=0 ps=0 w=0.42u l=1u
X2743 VSS.t2753 VDD VSS.t2754 VSS.t2620 sg13_lv_nmos ad=79.8f pd=0.8u as=0 ps=0 w=0.42u l=1u
X2744 VSS.t434 VDD VSS.t434 VSS.t2 sg13_lv_nmos ad=0.1428p pd=1.52u as=0 ps=0 w=0.42u l=1u
X2745 VDD a_26469_14495# a_26571_14495# VDD sg13_lv_pmos ad=2.42015p pd=15.68u as=0.3864p ps=2.93u w=1.12u l=0.13u
X2746 a_26052_13722# sg13cmos5l_dfrbpq_1_5.D a_25958_13722# VSS.t3256 sg13_lv_nmos ad=60.89999f pd=0.71u as=0.1428p ps=1.52u w=0.42u l=0.13u
X2747 VSS.t3196 a_27022_13239# sg13cmos5l_o21ai_1_3.B1 VSS.t3195 sg13_lv_nmos ad=0.1426p pd=1.16u as=0.2516p ps=2.16u w=0.74u l=0.13u
X2748 VSS.t982 VDD VSS.t984 VSS.t983 sg13_lv_nmos ad=79.8f pd=0.8u as=0 ps=0 w=0.42u l=1u
X2749 VDD VSS.t971 VDD VDD sg13_lv_pmos ad=0.34p pd=2.68u as=0 ps=0 w=1u l=1u
X2750 VDD VSS.t2012 VDD VDD sg13_lv_pmos ad=0.34p pd=2.68u as=0 ps=0 w=1u l=1u
X2751 a_17508_14488# a_18027_14495# a_18767_14845# VSS.t39 sg13_lv_nmos ad=0.3473p pd=2.71u as=0.12665p ps=1.145u w=0.74u l=0.13u
X2752 VDD VSS.t3144 VDD VDD sg13_lv_pmos ad=0.19p pd=1.38u as=0 ps=0 w=1u l=1u
X2753 VDD VSS.t414 VDD VDD sg13_lv_pmos ad=0.19p pd=1.38u as=0 ps=0 w=1u l=1u
X2754 VDD VSS.t2663 VDD VDD sg13_lv_pmos ad=0.34p pd=2.68u as=0 ps=0 w=1u l=1u
X2755 VSS.t1461 VDD VSS.t1460 VSS.t1459 sg13_lv_nmos ad=0.1428p pd=1.52u as=0 ps=0 w=0.42u l=1u
X2756 sg13cmos5l_o21ai_1_2.A1 a_15208_15996# VSS.t284 VSS.t3306 sg13_lv_nmos ad=0.2886p pd=2.26u as=0.14875p ps=1.16u w=0.74u l=0.13u
X2757 VSS.t387 VDD VSS.t387 VSS.t390 sg13_lv_nmos ad=79.8f pd=0.8u as=0 ps=0 w=0.42u l=1u
X2758 sg13cmos5l_buf_16_2.A a_15790_15238# VSS.t21 VSS.t26 sg13_lv_nmos ad=0.1406p pd=1.12u as=0.1406p ps=1.12u w=0.74u l=0.13u
X2759 VDD VSS.t582 VDD VDD sg13_lv_pmos ad=0.19p pd=1.38u as=0 ps=0 w=1u l=1u
X2760 VSS.t1631 VDD VSS.t1633 VSS.t1632 sg13_lv_nmos ad=79.8f pd=0.8u as=0 ps=0 w=0.42u l=1u
X2761 VSS.t3162 VDD VSS.t3164 VSS.t3163 sg13_lv_nmos ad=79.8f pd=0.8u as=0 ps=0 w=0.42u l=1u
X2762 VSS.t577 VDD VSS.t576 VSS.t575 sg13_lv_nmos ad=0.1428p pd=1.52u as=0 ps=0 w=0.42u l=1u
X2763 VDD VSS.t1174 VDD VDD sg13_lv_pmos ad=0.34p pd=2.68u as=0 ps=0 w=1u l=1u
X2764 VDD VSS.t1470 VDD VDD sg13_lv_pmos ad=0.34p pd=2.68u as=0 ps=0 w=1u l=1u
X2765 VDD VSS.t2379 VDD VDD sg13_lv_pmos ad=0.34p pd=2.68u as=0 ps=0 w=1u l=1u
X2766 VDD VSS.t846 VDD VDD sg13_lv_pmos ad=0.34p pd=2.68u as=0 ps=0 w=1u l=1u
X2767 VDD VSS.t1034 VDD VDD sg13_lv_pmos ad=0.19p pd=1.38u as=0 ps=0 w=1u l=1u
X2768 VSS.t2270 VDD VSS.t2269 VSS.t2268 sg13_lv_nmos ad=0.1428p pd=1.52u as=0 ps=0 w=0.42u l=1u
X2769 VDD VSS.t1977 VDD VDD sg13_lv_pmos ad=0.34p pd=2.68u as=0 ps=0 w=1u l=1u
X2770 VSS.t2440 VDD VSS.t2442 VSS.t2441 sg13_lv_nmos ad=79.8f pd=0.8u as=0 ps=0 w=0.42u l=1u
X2771 VDD VSS.t2504 VDD VDD sg13_lv_pmos ad=0.34p pd=2.68u as=0 ps=0 w=1u l=1u
X2772 VSS.t1988 VDD VSS.t1987 VSS.t1986 sg13_lv_nmos ad=0.1428p pd=1.52u as=0 ps=0 w=0.42u l=1u
X2773 a_26825_16334# a_26949_16033# VDD VDD sg13_lv_pmos ad=0.2442p pd=2.06u as=2.8961p ps=18.25u w=0.66u l=0.13u
X2774 VSS.t1938 VDD VSS.t1940 VSS.t1939 sg13_lv_nmos ad=79.8f pd=0.8u as=0 ps=0 w=0.42u l=1u
X2775 a_2880_14523# sg13cmos5l_xnor2_1_0.A VDD VDD sg13_lv_pmos ad=0.1596p pd=1.22u as=0.4536p ps=2.76u w=0.84u l=0.13u
X2776 a_19534_13726# sg13cmos5l_buf_16_2.A VDD VDD sg13_lv_pmos ad=0.2128p pd=1.5u as=0.2128p ps=1.5u w=1.12u l=0.13u
X2777 VDD VSS.t1660 VDD VDD sg13_lv_pmos ad=0.34p pd=2.68u as=0 ps=0 w=1u l=1u
X2778 VSS.t3032 VDD VSS.t3034 VSS.t3033 sg13_lv_nmos ad=79.8f pd=0.8u as=0 ps=0 w=0.42u l=1u
X2779 VDD sg13cmos5l_o21ai_1_2.B1 sg13cmos5l_o21ai_1_2.Y VDD sg13_lv_pmos ad=0.3808p pd=2.92u as=0.2128p ps=1.5u w=1.12u l=0.15u
X2780 VSS.t716 VDD VSS.t718 VSS.t717 sg13_lv_nmos ad=79.8f pd=0.8u as=0 ps=0 w=0.42u l=1u
X2781 VSS.t952 VDD VSS.t951 VSS.t950 sg13_lv_nmos ad=0.1428p pd=1.52u as=0 ps=0 w=0.42u l=1u
X2782 VSS.t1292 VDD VSS.t1292 VSS.t224 sg13_lv_nmos ad=79.8f pd=0.8u as=0 ps=0 w=0.42u l=1u
X2783 VSS.t1721 VDD VSS.t1723 VSS.t1722 sg13_lv_nmos ad=79.8f pd=0.8u as=0 ps=0 w=0.42u l=1u
X2784 VDD VSS.t2624 VDD VDD sg13_lv_pmos ad=0.19p pd=1.38u as=0 ps=0 w=1u l=1u
X2785 VSS.t2235 VDD VSS.t2234 VSS.t2233 sg13_lv_nmos ad=0.1428p pd=1.52u as=0 ps=0 w=0.42u l=1u
X2786 VDD a_2880_14523# sg13cmos5l_xnor2_1_0.Y VDD sg13_lv_pmos ad=0.3808p pd=2.92u as=0.2408p ps=1.55u w=1.12u l=0.13u
X2787 VSS.t2725 VDD VSS.t2725 VSS.t2620 sg13_lv_nmos ad=0.1428p pd=1.52u as=0 ps=0 w=0.42u l=1u
X2788 sg13cmos5l_or3_1_3.X a_24265_14508# VSS.t49 VSS.t7 sg13_lv_nmos ad=0.2516p pd=2.16u as=0.13395p ps=1.12u w=0.74u l=0.13u
X2789 a_16068_14040# a_16587_13844# a_17327_13799# VSS.t295 sg13_lv_nmos ad=0.3473p pd=2.71u as=0.12665p ps=1.145u w=0.74u l=0.13u
X2790 VDD VSS.t3096 VDD VDD sg13_lv_pmos ad=0.34p pd=2.68u as=0 ps=0 w=1u l=1u
X2791 VSS.t2088 VDD VSS.t2090 VSS.t2089 sg13_lv_nmos ad=79.8f pd=0.8u as=0 ps=0 w=0.42u l=1u
X2792 VDD VSS.t284 VDD VDD sg13_lv_pmos ad=0.34p pd=2.68u as=0 ps=0 w=1u l=1u
X2793 VSS.t1012 VDD VSS.t1014 VSS.t1013 sg13_lv_nmos ad=79.8f pd=0.8u as=0 ps=0 w=0.42u l=1u
X2794 VDD VSS.t1264 VDD VDD sg13_lv_pmos ad=0.34p pd=2.68u as=0 ps=0 w=1u l=1u
X2795 VSS.t1651 VDD VSS.t1653 VSS.t1652 sg13_lv_nmos ad=79.8f pd=0.8u as=0 ps=0 w=0.42u l=1u
X2796 a_15790_15238# clock_i VSS.t86 VSS.t3245 sg13_lv_nmos ad=0.1406p pd=1.12u as=0.2516p ps=2.16u w=0.74u l=0.13u
X2797 VDD VSS.t809 VDD VDD sg13_lv_pmos ad=0.19p pd=1.38u as=0 ps=0 w=1u l=1u
X2798 VDD VSS.t1001 VDD VDD sg13_lv_pmos ad=0.34p pd=2.68u as=0 ps=0 w=1u l=1u
X2799 VDD VSS.t1455 VDD VDD sg13_lv_pmos ad=0.34p pd=2.68u as=0 ps=0 w=1u l=1u
X2800 VDD sg13cmos5l_dfrbpq_1_2.Q sg13cmos5l_or3_1_2.C VDD sg13_lv_pmos ad=0.3808p pd=2.92u as=0.2128p ps=1.5u w=1.12u l=0.13u
X2801 VSS.t236 VDD VSS.t201 VSS.t724 sg13_lv_nmos ad=79.8f pd=0.8u as=0 ps=0 w=0.42u l=1u
X2802 VSS.t2 a_5495_15315# a_5495_15315# VSS.t123 sg13_lv_nmos ad=5.4903p pd=35.61u as=0.111p ps=1.34u w=0.3u l=0.13u
X2803 VSS.t1301 VDD VSS.t1302 VSS.t224 sg13_lv_nmos ad=79.8f pd=0.8u as=0 ps=0 w=0.42u l=1u
X2804 VDD VSS.t1718 VDD VDD sg13_lv_pmos ad=0.19p pd=1.38u as=0 ps=0 w=1u l=1u
X2805 VSS.t872 VDD VSS.t871 VSS.t870 sg13_lv_nmos ad=0.1428p pd=1.52u as=0 ps=0 w=0.42u l=1u
X2806 VSS.t1591 VDD VSS.t1590 VSS.t1589 sg13_lv_nmos ad=0.1428p pd=1.52u as=0 ps=0 w=0.42u l=1u
X2807 VDD VSS.t2489 VDD VDD sg13_lv_pmos ad=0.34p pd=2.68u as=0 ps=0 w=1u l=1u
X2808 VDD VSS.t2312 VDD VDD sg13_lv_pmos ad=0.19p pd=1.38u as=0 ps=0 w=1u l=1u
X2809 VSS.t1207 VDD VSS.t1208 VSS.t224 sg13_lv_nmos ad=79.8f pd=0.8u as=0 ps=0 w=0.42u l=1u
X2810 VSS.t86 VDD VSS.t86 VSS.t486 sg13_lv_nmos ad=0.1428p pd=1.52u as=0 ps=0 w=0.42u l=1u
X2811 VSS.t308 VDD VSS.t307 VSS.t306 sg13_lv_nmos ad=0.1428p pd=1.52u as=0 ps=0 w=0.42u l=1u
X2812 VDD a_19024_14726# a_18969_14607# VDD sg13_lv_pmos ad=2.42015p pd=15.68u as=93.45f ps=0.865u w=0.42u l=0.13u
X2813 VSS.t1306 VDD VSS.t1307 VSS.t224 sg13_lv_nmos ad=79.8f pd=0.8u as=0 ps=0 w=0.42u l=1u
X2814 VDD VSS.t2065 VDD VDD sg13_lv_pmos ad=0.19p pd=1.38u as=0 ps=0 w=1u l=1u
X2815 a_6948_14909# a_7179_14495# a_6634_14452# VSS.t247 sg13_lv_nmos ad=0.2373p pd=1.97u as=79.8f ps=0.8u w=0.42u l=0.13u
X2816 VDD VSS.t1840 VDD VDD sg13_lv_pmos ad=0.19p pd=1.38u as=0 ps=0 w=1u l=1u
X2817 VSS.t1883 VDD VSS.t1885 VSS.t1884 sg13_lv_nmos ad=79.8f pd=0.8u as=0 ps=0 w=0.42u l=1u
X2818 VSS.t434 VDD VSS.t434 VSS.t2 sg13_lv_nmos ad=0.1428p pd=1.52u as=0 ps=0 w=0.42u l=1u
X2819 VSS.t2425 VDD VSS.t2427 VSS.t2426 sg13_lv_nmos ad=79.8f pd=0.8u as=0 ps=0 w=0.42u l=1u
X2820 VSS.t2 a_3525_15213# a_3627_15356# VSS.t33 sg13_lv_nmos ad=5.4903p pd=35.61u as=0.2516p ps=2.16u w=0.74u l=0.13u
X2821 VDD VSS.t532 VDD VDD sg13_lv_pmos ad=0.34p pd=2.68u as=0 ps=0 w=1u l=1u
X2822 VDD VSS.t116 VDD VDD sg13_lv_pmos ad=0.34p pd=2.68u as=0 ps=0 w=1u l=1u
X2823 VDD VSS.t2367 VDD VDD sg13_lv_pmos ad=0.19p pd=1.38u as=0 ps=0 w=1u l=1u
X2824 a_15782_13722# sg13cmos5l_dfrbpq_1_2.D VDD VDD sg13_lv_pmos ad=79.8f pd=0.8u as=0.1428p ps=1.52u w=0.42u l=0.13u
X2825 VSS.t2706 VDD VSS.t2707 VSS.t2620 sg13_lv_nmos ad=79.8f pd=0.8u as=0 ps=0 w=0.42u l=1u
X2826 VDD VSS.t964 VDD VDD sg13_lv_pmos ad=0.19p pd=1.38u as=0 ps=0 w=1u l=1u
X2827 VSS.t1446 VDD VSS.t1445 VSS.t1444 sg13_lv_nmos ad=0.1428p pd=1.52u as=0 ps=0 w=0.42u l=1u
X2828 VSS.t1973 VDD VSS.t1975 VSS.t1974 sg13_lv_nmos ad=79.8f pd=0.8u as=0 ps=0 w=0.42u l=1u
X2829 VDD a_8302_13911# sg13cmos5l_xor2_1_1.A VDD sg13_lv_pmos ad=0.2254p pd=1.53u as=0.4256p ps=3u w=1.12u l=0.13u
X2830 VSS.t483 sg13cmos5l_buf_16_2.A a_12212_15202# VSS.t3312 sg13_lv_nmos ad=0.1406p pd=1.12u as=0.1406p ps=1.12u w=0.74u l=0.13u
X2831 VSS.t832 VDD VSS.t834 VSS.t833 sg13_lv_nmos ad=79.8f pd=0.8u as=0 ps=0 w=0.42u l=1u
X2832 VDD VSS.t1203 VDD VDD sg13_lv_pmos ad=0.34p pd=2.68u as=0 ps=0 w=1u l=1u
X2833 VDD VSS.t2707 VDD VDD sg13_lv_pmos ad=0.34p pd=2.68u as=0 ps=0 w=1u l=1u
X2834 a_27500_15960# sg13cmos5l_dfrbpq_1_6.Q VDD VDD sg13_lv_pmos ad=0.2856p pd=2.36u as=0.2114p ps=1.54u w=0.84u l=0.13u
X2835 VSS.t2255 VDD VSS.t2254 VSS.t2253 sg13_lv_nmos ad=0.1428p pd=1.52u as=0 ps=0 w=0.42u l=1u
X2836 VSS.t63 sg13cmos5l_o21ai_1_2.A1 a_18610_16374# VSS.t258 sg13_lv_nmos ad=0.1406p pd=1.12u as=0.1406p ps=1.12u w=0.74u l=0.15u
X2837 a_3082_15457# a_3525_15213# a_3465_15625# VDD sg13_lv_pmos ad=79.8f pd=0.8u as=63f ps=0.72u w=0.42u l=0.13u
X2838 VDD VSS.t641 VDD VDD sg13_lv_pmos ad=0.19p pd=1.38u as=0 ps=0 w=1u l=1u
X2839 VDD VSS.t891 VDD VDD sg13_lv_pmos ad=0.34p pd=2.68u as=0 ps=0 w=1u l=1u
X2840 VSS.t2642 VDD VSS.t2643 VSS.t2620 sg13_lv_nmos ad=79.8f pd=0.8u as=0 ps=0 w=0.42u l=1u
X2841 VSS.t2103 VDD VSS.t2102 VSS.t2101 sg13_lv_nmos ad=0.1428p pd=1.52u as=0 ps=0 w=0.42u l=1u
X2842 VSS.t1923 VDD VSS.t1925 VSS.t1924 sg13_lv_nmos ad=79.8f pd=0.8u as=0 ps=0 w=0.42u l=1u
X2843 VDD VSS.t540 VDD VDD sg13_lv_pmos ad=0.34p pd=2.68u as=0 ps=0 w=1u l=1u
X2844 VSS.t3017 VDD VSS.t3019 VSS.t3018 sg13_lv_nmos ad=79.8f pd=0.8u as=0 ps=0 w=0.42u l=1u
X2845 VDD VSS.t2959 VDD VDD sg13_lv_pmos ad=0.19p pd=1.38u as=0 ps=0 w=1u l=1u
X2846 VSS.t21 a_15790_15238# sg13cmos5l_buf_16_2.A VSS.t29 sg13_lv_nmos ad=0.1406p pd=1.12u as=0.1406p ps=1.12u w=0.74u l=0.13u
X2847 VSS.t2445 VDD VSS.t2444 VSS.t2443 sg13_lv_nmos ad=0.1428p pd=1.52u as=0 ps=0 w=0.42u l=1u
X2848 VSS.t1706 VDD VSS.t1708 VSS.t1707 sg13_lv_nmos ad=79.8f pd=0.8u as=0 ps=0 w=0.42u l=1u
X2849 VDD VSS.t2359 VDD VDD sg13_lv_pmos ad=0.34p pd=2.68u as=0 ps=0 w=1u l=1u
X2850 sg13cmos5l_dfrbpq_1_2.CLK a_12212_15202# VDD VDD sg13_lv_pmos ad=0.2128p pd=1.5u as=0.2128p ps=1.5u w=1.12u l=0.13u
X2851 a_12212_15202# sg13cmos5l_buf_16_2.A VDD VDD sg13_lv_pmos ad=0.2128p pd=1.5u as=0.2128p ps=1.5u w=1.12u l=0.13u
X2852 VSS.t1240 VDD VSS.t1241 VSS.t224 sg13_lv_nmos ad=79.8f pd=0.8u as=0 ps=0 w=0.42u l=1u
X2853 VDD VSS.t2017 VDD VDD sg13_lv_pmos ad=0.34p pd=2.68u as=0 ps=0 w=1u l=1u
X2854 VDD VSS.t3149 VDD VDD sg13_lv_pmos ad=0.19p pd=1.38u as=0 ps=0 w=1u l=1u
X2855 VDD VSS.t2665 VDD VDD sg13_lv_pmos ad=0.34p pd=2.68u as=0 ps=0 w=1u l=1u
X2856 a_7985_15288# sg13cmos5l_dlygate4sd3_1_11.X VSS.t37 VSS.t300 sg13_lv_nmos ad=0.17462p pd=1.185u as=0.374p ps=2.46u w=0.55u l=0.13u
X2857 VSS.t641 VDD VSS.t641 VSS.t768 sg13_lv_nmos ad=0.1428p pd=1.52u as=0 ps=0 w=0.42u l=1u
X2858 VDD VSS.t1291 VDD VDD sg13_lv_pmos ad=0.34p pd=2.68u as=0 ps=0 w=1u l=1u
X2859 VSS.t1175 VDD VSS.t1174 VSS.t224 sg13_lv_nmos ad=0.1428p pd=1.52u as=0 ps=0 w=0.42u l=1u
X2860 VSS.t1576 VDD VSS.t1578 VSS.t1577 sg13_lv_nmos ad=79.8f pd=0.8u as=0 ps=0 w=0.42u l=1u
X2861 VSS.t362 VDD VSS.t104 VSS.t361 sg13_lv_nmos ad=0.1428p pd=1.52u as=0 ps=0 w=0.42u l=1u
X2862 VSS.t1636 VDD VSS.t1638 VSS.t1637 sg13_lv_nmos ad=79.8f pd=0.8u as=0 ps=0 w=0.42u l=1u
X2863 VSS.t3167 VDD VSS.t3169 VSS.t3168 sg13_lv_nmos ad=79.8f pd=0.8u as=0 ps=0 w=0.42u l=1u
X2864 VSS.t2073 VDD VSS.t2075 VSS.t2074 sg13_lv_nmos ad=79.8f pd=0.8u as=0 ps=0 w=0.42u l=1u
X2865 VSS.t802 VDD VSS.t801 VSS.t800 sg13_lv_nmos ad=0.1428p pd=1.52u as=0 ps=0 w=0.42u l=1u
X2866 VSS.t2890 VDD VSS.t2771 VSS.t2620 sg13_lv_nmos ad=0.1428p pd=1.52u as=0 ps=0 w=0.42u l=1u
X2867 VSS.t98 sg13cmos5l_a21oi_1_2.Y a_25496_16037# VSS.t3224 sg13_lv_nmos ad=79.8f pd=0.8u as=0.1428p ps=1.52u w=0.42u l=0.13u
X2868 VDD VSS.t620 VDD VDD sg13_lv_pmos ad=0.34p pd=2.68u as=0 ps=0 w=1u l=1u
X2869 VSS.t872 VDD VSS.t871 VSS.t870 sg13_lv_nmos ad=0.1428p pd=1.52u as=0 ps=0 w=0.42u l=1u
X2870 VSS.t1168 VDD VSS.t1169 VSS.t224 sg13_lv_nmos ad=79.8f pd=0.8u as=0 ps=0 w=0.42u l=1u
X2871 VDD VSS.t1703 VDD VDD sg13_lv_pmos ad=0.19p pd=1.38u as=0 ps=0 w=1u l=1u
X2872 VSS.t2240 VDD VSS.t2239 VSS.t2238 sg13_lv_nmos ad=0.1428p pd=1.52u as=0 ps=0 w=0.42u l=1u
X2873 sg13cmos5l_dlygate4sd3_1_6.X a_9750_14508# VSS.t4 VSS.t176 sg13_lv_nmos ad=0.2516p pd=2.16u as=0.1426p ps=1.16u w=0.74u l=0.13u
X2874 VSS.t92 a_27706_15202# a_27425_15424# VSS.t2 sg13_lv_nmos ad=79.8f pd=0.8u as=0.1428p ps=1.52u w=0.42u l=0.5u
X2875 VDD VSS.t994 VDD VDD sg13_lv_pmos ad=0.19p pd=1.38u as=0 ps=0 w=1u l=1u
X2876 VDD VSS.t1655 VDD VDD sg13_lv_pmos ad=0.34p pd=2.68u as=0 ps=0 w=1u l=1u
X2877 VSS.t2635 VDD VSS.t2636 VSS.t2620 sg13_lv_nmos ad=79.8f pd=0.8u as=0 ps=0 w=0.42u l=1u
X2878 VSS.t2715 VDD VSS.t2713 VSS.t2620 sg13_lv_nmos ad=0.1428p pd=1.52u as=0 ps=0 w=0.42u l=1u
X2879 VDD VSS.t2474 VDD VDD sg13_lv_pmos ad=0.34p pd=2.68u as=0 ps=0 w=1u l=1u
X2880 VSS.t1943 VDD VSS.t1945 VSS.t1944 sg13_lv_nmos ad=79.8f pd=0.8u as=0 ps=0 w=0.42u l=1u
X2881 a_24600_14040# sg13cmos5l_o21ai_1_2.A1 VDD VDD sg13_lv_pmos ad=0.2128p pd=1.5u as=0.3808p ps=2.92u w=1.12u l=0.15u
X2882 VSS.t1222 VDD VSS.t1220 VSS.t224 sg13_lv_nmos ad=0.1428p pd=1.52u as=0 ps=0 w=0.42u l=1u
X2883 a_2880_14523# sg13cmos5l_buf_1_0.X a_2843_14832# VSS.t170 sg13_lv_nmos ad=0.2176p pd=1.96u as=78.39999f ps=0.885u w=0.64u l=0.13u
X2884 VSS.t572 VDD VSS.t574 VSS.t573 sg13_lv_nmos ad=79.8f pd=0.8u as=0 ps=0 w=0.42u l=1u
X2885 VDD VSS.t1315 VDD VDD sg13_lv_pmos ad=0.34p pd=2.68u as=0 ps=0 w=1u l=1u
X2886 VSS.t2962 VDD VSS.t2964 VSS.t2963 sg13_lv_nmos ad=79.8f pd=0.8u as=0 ps=0 w=0.42u l=1u
X2887 VDD a_17030_15996# a_17142_16020# VDD sg13_lv_pmos ad=0.2254p pd=1.53u as=0.34p ps=2.68u w=1u l=0.5u
X2888 sg13cmos5l_dfrbpq_1_2.CLK a_12212_15202# VDD VDD sg13_lv_pmos ad=0.2128p pd=1.5u as=0.2128p ps=1.5u w=1.12u l=0.13u
X2889 VSS.t202 a_25402_14448# a_25121_14750# VSS.t7 sg13_lv_nmos ad=79.8f pd=0.8u as=0.1428p ps=1.52u w=0.42u l=0.5u
X2890 VDD VSS.t2700 VDD VDD sg13_lv_pmos ad=0.19p pd=1.38u as=0 ps=0 w=1u l=1u
X2891 a_17316_14922# sg13cmos5l_dfrbpq_1_3.D a_17222_14922# VSS.t3285 sg13_lv_nmos ad=60.89999f pd=0.71u as=0.1428p ps=1.52u w=0.42u l=0.13u
X2892 VDD VSS.t1009 VDD VDD sg13_lv_pmos ad=0.19p pd=1.38u as=0 ps=0 w=1u l=1u
X2893 VDD VSS.t3101 VDD VDD sg13_lv_pmos ad=0.34p pd=2.68u as=0 ps=0 w=1u l=1u
X2894 VSS.t2365 VDD VSS.t2364 VSS.t2363 sg13_lv_nmos ad=0.1428p pd=1.52u as=0 ps=0 w=0.42u l=1u
X2895 VSS.t2058 VDD VSS.t2060 VSS.t2059 sg13_lv_nmos ad=79.8f pd=0.8u as=0 ps=0 w=0.42u l=1u
X2896 VDD a_3525_15213# a_3627_15356# VDD sg13_lv_pmos ad=2.8961p pd=18.25u as=0.3864p ps=2.93u w=1.12u l=0.13u
X2897 VSS.t832 VDD VSS.t834 VSS.t833 sg13_lv_nmos ad=79.8f pd=0.8u as=0 ps=0 w=0.42u l=1u
X2898 VDD VSS.t1460 VDD VDD sg13_lv_pmos ad=0.34p pd=2.68u as=0 ps=0 w=1u l=1u
X2899 VDD VSS.t2369 VDD VDD sg13_lv_pmos ad=0.34p pd=2.68u as=0 ps=0 w=1u l=1u
X2900 VDD VSS.t1633 VDD VDD sg13_lv_pmos ad=0.19p pd=1.38u as=0 ps=0 w=1u l=1u
X2901 VDD VSS.t1688 VDD VDD sg13_lv_pmos ad=0.19p pd=1.38u as=0 ps=0 w=1u l=1u
X2902 VDD VSS.t1880 VDD VDD sg13_lv_pmos ad=0.19p pd=1.38u as=0 ps=0 w=1u l=1u
X2903 VSS.t1978 VDD VSS.t1977 VSS.t1976 sg13_lv_nmos ad=0.1428p pd=1.52u as=0 ps=0 w=0.42u l=1u
X2904 VSS.t104 a_19436_15960# counter_value_o[3] VSS.t103 sg13_lv_nmos ad=0.14875p pd=1.16u as=0.2886p ps=2.26u w=0.74u l=0.13u
X2905 VDD VSS.t1324 VDD VDD sg13_lv_pmos ad=0.34p pd=2.68u as=0 ps=0 w=1u l=1u
X2906 a_26446_15423# a_26561_15424# VDD VDD sg13_lv_pmos ad=0.34p pd=2.68u as=0.2254p ps=1.53u w=1u l=0.5u
X2907 VDD VSS.t48 VDD VDD sg13_lv_pmos ad=0.34p pd=2.68u as=0 ps=0 w=1u l=1u
X2908 a_27568_14726# sg13cmos5l_dfrbpq_1_7.RESET_B VDD VDD sg13_lv_pmos ad=79.8f pd=0.8u as=2.42015p ps=15.68u w=0.42u l=0.13u
X2909 VSS.t2088 VDD VSS.t2087 VSS.t2086 sg13_lv_nmos ad=0.1428p pd=1.52u as=0 ps=0 w=0.42u l=1u
X2910 VSS.t972 VDD VSS.t971 VSS.t970 sg13_lv_nmos ad=0.1428p pd=1.52u as=0 ps=0 w=0.42u l=1u
X2911 VSS.t1888 VDD VSS.t1890 VSS.t1889 sg13_lv_nmos ad=79.8f pd=0.8u as=0 ps=0 w=0.42u l=1u
X2912 VDD VSS.t426 VDD VDD sg13_lv_pmos ad=0.34p pd=2.68u as=0 ps=0 w=1u l=1u
X2913 VSS.t1267 VDD VSS.t1268 VSS.t224 sg13_lv_nmos ad=79.8f pd=0.8u as=0 ps=0 w=0.42u l=1u
X2914 VSS.t2747 VDD VSS.t2748 VSS.t2620 sg13_lv_nmos ad=79.8f pd=0.8u as=0 ps=0 w=0.42u l=1u
X2915 VSS.t2430 VDD VSS.t2432 VSS.t2431 sg13_lv_nmos ad=79.8f pd=0.8u as=0 ps=0 w=0.42u l=1u
X2916 VDD a_16163_16265# sg13cmos5l_a21oi_1_0.A2 VDD sg13_lv_pmos ad=0.3822p pd=1.84u as=0.3808p ps=2.92u w=1.12u l=0.13u
X2917 VDD VSS.t442 VDD VDD sg13_lv_pmos ad=0.34p pd=2.68u as=0 ps=0 w=1u l=1u
X2918 VDD VSS.t3134 VDD VDD sg13_lv_pmos ad=0.19p pd=1.38u as=0 ps=0 w=1u l=1u
X2919 VSS.t802 VDD VSS.t801 VSS.t800 sg13_lv_nmos ad=0.1428p pd=1.52u as=0 ps=0 w=0.42u l=1u
X2920 VSS.t2300 VDD VSS.t2299 VSS.t2298 sg13_lv_nmos ad=0.1428p pd=1.52u as=0 ps=0 w=0.42u l=1u
X2921 sg13cmos5l_nor2_1_0.Y sg13cmos5l_inv_1_0.Y VSS.t61 VSS.t265 sg13_lv_nmos ad=0.1406p pd=1.12u as=0.2516p ps=2.16u w=0.74u l=0.13u
X2922 VSS.t1561 VDD VSS.t1563 VSS.t1562 sg13_lv_nmos ad=79.8f pd=0.8u as=0 ps=0 w=0.42u l=1u
X2923 VSS.t1032 VDD VSS.t1034 VSS.t1033 sg13_lv_nmos ad=79.8f pd=0.8u as=0 ps=0 w=0.42u l=1u
X2924 VSS.t591 VDD VSS.t593 VSS.t592 sg13_lv_nmos ad=79.8f pd=0.8u as=0 ps=0 w=0.42u l=1u
X2925 VDD VSS.t3004 VDD VDD sg13_lv_pmos ad=0.19p pd=1.38u as=0 ps=0 w=1u l=1u
X2926 VDD VSS.t1865 VDD VDD sg13_lv_pmos ad=0.19p pd=1.38u as=0 ps=0 w=1u l=1u
X2927 VSS.t1716 VDD VSS.t1718 VSS.t1717 sg13_lv_nmos ad=79.8f pd=0.8u as=0 ps=0 w=0.42u l=1u
X2928 VDD VSS.t1640 VDD VDD sg13_lv_pmos ad=0.34p pd=2.68u as=0 ps=0 w=1u l=1u
X2929 VSS.t2626 VDD VSS.t2627 VSS.t2620 sg13_lv_nmos ad=79.8f pd=0.8u as=0 ps=0 w=0.42u l=1u
X2930 VSS.t2108 VDD VSS.t2107 VSS.t2106 sg13_lv_nmos ad=0.1428p pd=1.52u as=0 ps=0 w=0.42u l=1u
X2931 VSS.t1928 VDD VSS.t1930 VSS.t1929 sg13_lv_nmos ad=79.8f pd=0.8u as=0 ps=0 w=0.42u l=1u
X2932 VDD VSS.t320 VDD VDD sg13_lv_pmos ad=0.19p pd=1.38u as=0 ps=0 w=1u l=1u
X2933 VSS.t3022 VDD VSS.t3024 VSS.t3023 sg13_lv_nmos ad=79.8f pd=0.8u as=0 ps=0 w=0.42u l=1u
X2934 VDD VSS.t2783 VDD VDD sg13_lv_pmos ad=0.19p pd=1.38u as=0 ps=0 w=1u l=1u
X2935 sg13cmos5l_buf_16_2.X a_19534_13726# VDD VDD sg13_lv_pmos ad=0.2128p pd=1.5u as=0.2128p ps=1.5u w=1.12u l=0.13u
X2936 VDD VSS.t455 VDD VDD sg13_lv_pmos ad=0.34p pd=2.68u as=0 ps=0 w=1u l=1u
X2937 VSS.t1249 VDD VSS.t1247 VSS.t224 sg13_lv_nmos ad=0.1428p pd=1.52u as=0 ps=0 w=0.42u l=1u
X2938 VSS.t1711 VDD VSS.t1713 VSS.t1712 sg13_lv_nmos ad=79.8f pd=0.8u as=0 ps=0 w=0.42u l=1u
X2939 VDD VSS.t2232 VDD VDD sg13_lv_pmos ad=0.19p pd=1.38u as=0 ps=0 w=1u l=1u
X2940 VSS.t426 VDD VSS.t426 VSS.t2 sg13_lv_nmos ad=0.1428p pd=1.52u as=0 ps=0 w=0.42u l=1u
X2941 VDD VSS.t718 VDD VDD sg13_lv_pmos ad=0.34p pd=2.68u as=0 ps=0 w=1u l=1u
X2942 VDD VSS.t2329 VDD VDD sg13_lv_pmos ad=0.34p pd=2.68u as=0 ps=0 w=1u l=1u
X2943 VDD VSS.t2022 VDD VDD sg13_lv_pmos ad=0.34p pd=2.68u as=0 ps=0 w=1u l=1u
X2944 VDD VSS.t3154 VDD VDD sg13_lv_pmos ad=0.19p pd=1.38u as=0 ps=0 w=1u l=1u
X2945 VSS.t1838 VDD VSS.t1840 VSS.t1839 sg13_lv_nmos ad=79.8f pd=0.8u as=0 ps=0 w=0.42u l=1u
X2946 VSS.t66 a_18470_15238# a_18582_15302# VSS.t65 sg13_lv_nmos ad=0.1426p pd=1.16u as=0.1428p ps=1.52u w=0.42u l=0.5u
X2947 VSS.t1292 VDD VSS.t1291 VSS.t224 sg13_lv_nmos ad=0.1428p pd=1.52u as=0 ps=0 w=0.42u l=1u
X2948 VSS.t54 a_16485_13701# a_16587_13844# VSS.t165 sg13_lv_nmos ad=10.4325p pd=68.31u as=0.2516p ps=2.16u w=0.74u l=0.13u
X2949 VDD VSS.t1970 VDD VDD sg13_lv_pmos ad=0.19p pd=1.38u as=0 ps=0 w=1u l=1u
X2950 VSS.t1002 VDD VSS.t1001 VSS.t1000 sg13_lv_nmos ad=0.1428p pd=1.52u as=0 ps=0 w=0.42u l=1u
X2951 VSS.t352 VDD VSS.t275 VSS.t351 sg13_lv_nmos ad=0.1428p pd=1.52u as=0 ps=0 w=0.42u l=1u
X2952 VDD VSS.t441 VDD VDD sg13_lv_pmos ad=0.34p pd=2.68u as=0 ps=0 w=1u l=1u
X2953 VSS.t1903 VDD VSS.t1902 VSS.t1901 sg13_lv_nmos ad=0.1428p pd=1.52u as=0 ps=0 w=0.42u l=1u
X2954 VSS.t562 VDD VSS.t561 VSS.t560 sg13_lv_nmos ad=0.1428p pd=1.52u as=0 ps=0 w=0.42u l=1u
X2955 VDD VSS.t866 VDD VDD sg13_lv_pmos ad=0.34p pd=2.68u as=0 ps=0 w=1u l=1u
X2956 VDD VSS.t1445 VDD VDD sg13_lv_pmos ad=0.34p pd=2.68u as=0 ps=0 w=1u l=1u
X2957 VSS.t2755 VDD VSS.t2755 VSS.t2620 sg13_lv_nmos ad=0.1428p pd=1.52u as=0 ps=0 w=0.42u l=1u
X2958 VSS.t236 sg13cmos5l_or3_1_2.A a_21865_13726# VSS.t3233 sg13_lv_nmos ad=0.13395p pd=1.12u as=0.198p ps=1.27u w=0.55u l=0.13u
X2959 VDD VSS.t844 VDD VDD sg13_lv_pmos ad=0.19p pd=1.38u as=0 ps=0 w=1u l=1u
X2960 VSS.t421 VDD VSS.t423 VSS.t7 sg13_lv_nmos ad=0.1428p pd=1.52u as=0 ps=0 w=0.42u l=1u
X2961 VDD VSS.t46 VDD VDD sg13_lv_pmos ad=0.34p pd=2.68u as=0 ps=0 w=1u l=1u
X2962 VSS.t2245 VDD VSS.t2244 VSS.t2243 sg13_lv_nmos ad=0.1428p pd=1.52u as=0 ps=0 w=0.42u l=1u
X2963 VSS.t1701 VDD VSS.t1703 VSS.t1702 sg13_lv_nmos ad=79.8f pd=0.8u as=0 ps=0 w=0.42u l=1u
X2964 VSS.t1506 VDD VSS.t1508 VSS.t1507 sg13_lv_nmos ad=79.8f pd=0.8u as=0 ps=0 w=0.42u l=1u
X2965 VSS.t2415 VDD VSS.t2417 VSS.t2416 sg13_lv_nmos ad=79.8f pd=0.8u as=0 ps=0 w=0.42u l=1u
X2966 VDD VSS.t201 VDD VDD sg13_lv_pmos ad=0.34p pd=2.68u as=0 ps=0 w=1u l=1u
X2967 VSS.t2718 VDD VSS.t2717 VSS.t2620 sg13_lv_nmos ad=0.1428p pd=1.52u as=0 ps=0 w=0.42u l=1u
X2968 VSS.t201 VDD VSS.t201 VSS.t726 sg13_lv_nmos ad=79.8f pd=0.8u as=0 ps=0 w=0.42u l=1u
X2969 a_16163_16265# sg13cmos5l_xnor2_1_1.A VSS.t216 VSS.t215 sg13_lv_nmos ad=0.198p pd=1.27u as=0.13395p ps=1.12u w=0.55u l=0.13u
X2970 VSS.t972 VDD VSS.t971 VSS.t970 sg13_lv_nmos ad=0.1428p pd=1.52u as=0 ps=0 w=0.42u l=1u
X2971 VDD VSS.t2949 VDD VDD sg13_lv_pmos ad=0.19p pd=1.38u as=0 ps=0 w=1u l=1u
X2972 VDD VSS.t929 VDD VDD sg13_lv_pmos ad=0.19p pd=1.38u as=0 ps=0 w=1u l=1u
X2973 VSS.t877 VDD VSS.t879 VSS.t878 sg13_lv_nmos ad=79.8f pd=0.8u as=0 ps=0 w=0.42u l=1u
X2974 VDD VSS.t2397 VDD VDD sg13_lv_pmos ad=0.19p pd=1.38u as=0 ps=0 w=1u l=1u
X2975 VSS.t2058 VDD VSS.t2057 VSS.t2056 sg13_lv_nmos ad=0.1428p pd=1.52u as=0 ps=0 w=0.42u l=1u
X2976 a_25766_15996# a_25496_16037# VDD VDD sg13_lv_pmos ad=0.34p pd=2.68u as=0.1523p ps=1.38u w=1u l=0.5u
X2977 VDD VSS.t2055 VDD VDD sg13_lv_pmos ad=0.19p pd=1.38u as=0 ps=0 w=1u l=1u
X2978 VSS.t412 VDD VSS.t414 VSS.t413 sg13_lv_nmos ad=79.8f pd=0.8u as=0 ps=0 w=0.42u l=1u
X2979 VDD VSS.t446 VDD VDD sg13_lv_pmos ad=0.34p pd=2.68u as=0 ps=0 w=1u l=1u
X2980 VSS.t1873 VDD VSS.t1875 VSS.t1874 sg13_lv_nmos ad=79.8f pd=0.8u as=0 ps=0 w=0.42u l=1u
X2981 a_17796_14909# a_17508_14488# a_17734_14909# VSS.t291 sg13_lv_nmos ad=0.1428p pd=1.52u as=37.8f ps=0.6u w=0.42u l=0.13u
X2982 VSS.t620 VDD VSS.t620 VSS.t623 sg13_lv_nmos ad=79.8f pd=0.8u as=0 ps=0 w=0.42u l=1u
X2983 VDD VSS.t1276 VDD VDD sg13_lv_pmos ad=0.34p pd=2.68u as=0 ps=0 w=1u l=1u
X2984 VDD VSS.t1503 VDD VDD sg13_lv_pmos ad=0.19p pd=1.38u as=0 ps=0 w=1u l=1u
X2985 VSS.t1032 VDD VSS.t1034 VSS.t1033 sg13_lv_nmos ad=79.8f pd=0.8u as=0 ps=0 w=0.42u l=1u
X2986 VSS.t2659 VDD VSS.t2661 VSS.t2620 sg13_lv_nmos ad=79.8f pd=0.8u as=0 ps=0 w=0.42u l=1u
X2987 VDD VSS.t609 VDD VDD sg13_lv_pmos ad=0.34p pd=2.68u as=0 ps=0 w=1u l=1u
X2988 VDD VSS.t1638 VDD VDD sg13_lv_pmos ad=0.19p pd=1.38u as=0 ps=0 w=1u l=1u
X2989 a_22223_14845# a_21381_14495# a_22129_14845# VSS.t7 sg13_lv_nmos ad=0.12665p pd=1.145u as=0.1428p ps=1.52u w=0.42u l=0.13u
X2990 VDD VSS.t1693 VDD VDD sg13_lv_pmos ad=0.19p pd=1.38u as=0 ps=0 w=1u l=1u
X2991 VDD VSS.t2989 VDD VDD sg13_lv_pmos ad=0.19p pd=1.38u as=0 ps=0 w=1u l=1u
X2992 VDD VSS.t3166 VDD VDD sg13_lv_pmos ad=0.34p pd=2.68u as=0 ps=0 w=1u l=1u
X2993 VDD VSS.t1850 VDD VDD sg13_lv_pmos ad=0.19p pd=1.38u as=0 ps=0 w=1u l=1u
X2994 VSS.t2435 VDD VSS.t2437 VSS.t2436 sg13_lv_nmos ad=79.8f pd=0.8u as=0 ps=0 w=0.42u l=1u
X2995 VDD VSS.t2774 VDD VDD sg13_lv_pmos ad=0.19p pd=1.38u as=0 ps=0 w=1u l=1u
X2996 VSS.t2093 VDD VSS.t2092 VSS.t2091 sg13_lv_nmos ad=0.1428p pd=1.52u as=0 ps=0 w=0.42u l=1u
X2997 VDD VSS.t899 VDD VDD sg13_lv_pmos ad=0.19p pd=1.38u as=0 ps=0 w=1u l=1u
X2998 VSS.t1656 VDD VSS.t1655 VSS.t1654 sg13_lv_nmos ad=0.1428p pd=1.52u as=0 ps=0 w=0.42u l=1u
X2999 VDD VSS.t2382 VDD VDD sg13_lv_pmos ad=0.19p pd=1.38u as=0 ps=0 w=1u l=1u
X3000 a_3396_15247# a_3627_15356# a_3082_15457# VSS.t148 sg13_lv_nmos ad=0.2373p pd=1.97u as=79.8f ps=0.8u w=0.42u l=0.13u
X3001 a_3334_15247# sg13cmos5l_dfrbpq_1_0.RESET_B VSS.t61 VSS.t89 sg13_lv_nmos ad=37.8f pd=0.6u as=0.1701p ps=1.65u w=0.42u l=0.13u
X3002 VDD VSS.t193 VDD VDD sg13_lv_pmos ad=0.19p pd=1.38u as=0 ps=0 w=1u l=1u
X3003 VDD VSS.t543 VDD VDD sg13_lv_pmos ad=0.34p pd=2.68u as=0 ps=0 w=1u l=1u
X3004 VDD VSS.t2007 VDD VDD sg13_lv_pmos ad=0.34p pd=2.68u as=0 ps=0 w=1u l=1u
X3005 VSS.t1002 VDD VSS.t1001 VSS.t1000 sg13_lv_nmos ad=0.1428p pd=1.52u as=0 ps=0 w=0.42u l=1u
X3006 VDD VSS.t836 VDD VDD sg13_lv_pmos ad=0.34p pd=2.68u as=0 ps=0 w=1u l=1u
X3007 VDD VSS.t3139 VDD VDD sg13_lv_pmos ad=0.19p pd=1.38u as=0 ps=0 w=1u l=1u
X3008 VSS.t2400 VDD VSS.t2402 VSS.t2401 sg13_lv_nmos ad=79.8f pd=0.8u as=0 ps=0 w=0.42u l=1u
X3009 VDD VSS.t419 VDD VDD sg13_lv_pmos ad=0.19p pd=1.38u as=0 ps=0 w=1u l=1u
X3010 VDD VSS.t774 VDD VDD sg13_lv_pmos ad=0.19p pd=1.38u as=0 ps=0 w=1u l=1u
X3011 a_6906_12935# sg13cmos5l_xor2_1_1.B VSS.t69 VSS.t111 sg13_lv_nmos ad=0.17462p pd=1.185u as=0.15245p ps=1.17u w=0.55u l=0.13u
X3012 VSS.t1566 VDD VSS.t1568 VSS.t1567 sg13_lv_nmos ad=79.8f pd=0.8u as=0 ps=0 w=0.42u l=1u
X3013 VSS.t1888 VDD VSS.t1887 VSS.t1886 sg13_lv_nmos ad=0.1428p pd=1.52u as=0 ps=0 w=0.42u l=1u
X3014 VDD VSS.t398 VDD VDD sg13_lv_pmos ad=0.19p pd=1.38u as=0 ps=0 w=1u l=1u
X3015 VSS.t1356 VDD VSS.t1200 VSS.t224 sg13_lv_nmos ad=0.1428p pd=1.52u as=0 ps=0 w=0.42u l=1u
X3016 VDD VSS.t1842 VDD VDD sg13_lv_pmos ad=0.34p pd=2.68u as=0 ps=0 w=1u l=1u
X3017 sg13cmos5l_buf_16_2.A a_15790_15238# VDD VDD sg13_lv_pmos ad=0.2128p pd=1.5u as=0.2128p ps=1.5u w=1.12u l=0.13u
X3018 VDD VSS.t1294 VDD VDD sg13_lv_pmos ad=0.34p pd=2.68u as=0 ps=0 w=1u l=1u
X3019 VSS.t2230 VDD VSS.t2229 VSS.t2228 sg13_lv_nmos ad=0.1428p pd=1.52u as=0 ps=0 w=0.42u l=1u
X3020 a_8250_15250# sg13cmos5l_dlygate4sd3_1_11.X VSS.t37 VSS.t299 sg13_lv_nmos ad=88.8f pd=0.98u as=0.15245p ps=1.17u w=0.74u l=0.13u
X3021 VSS.t543 VDD VSS.t546 VSS.t659 sg13_lv_nmos ad=79.8f pd=0.8u as=0 ps=0 w=0.42u l=1u
X3022 VSS.t614 VDD VSS.t614 VSS.t744 sg13_lv_nmos ad=79.8f pd=0.8u as=0 ps=0 w=0.42u l=1u
X3023 VDD VSS.t1645 VDD VDD sg13_lv_pmos ad=0.34p pd=2.68u as=0 ps=0 w=1u l=1u
X3024 VSS.t1686 VDD VSS.t1688 VSS.t1687 sg13_lv_nmos ad=79.8f pd=0.8u as=0 ps=0 w=0.42u l=1u
X3025 VSS.t2628 VDD VSS.t2630 VSS.t2620 sg13_lv_nmos ad=79.8f pd=0.8u as=0 ps=0 w=0.42u l=1u
X3026 VSS.t2709 VDD VSS.t2707 VSS.t2620 sg13_lv_nmos ad=0.1428p pd=1.52u as=0 ps=0 w=0.42u l=1u
X3027 VDD VSS.t347 VDD VDD sg13_lv_pmos ad=0.34p pd=2.68u as=0 ps=0 w=1u l=1u
X3028 VSS.t877 VDD VSS.t879 VSS.t878 sg13_lv_nmos ad=79.8f pd=0.8u as=0 ps=0 w=0.42u l=1u
X3029 VSS.t3027 VDD VSS.t3029 VSS.t3028 sg13_lv_nmos ad=79.8f pd=0.8u as=0 ps=0 w=0.42u l=1u
X3030 VDD VSS.t2934 VDD VDD sg13_lv_pmos ad=0.19p pd=1.38u as=0 ps=0 w=1u l=1u
X3031 VSS.t21 a_15790_15238# sg13cmos5l_buf_16_2.A VSS.t23 sg13_lv_nmos ad=0.1406p pd=1.12u as=0.1406p ps=1.12u w=0.74u l=0.13u
X3032 a_18470_15238# a_18200_15238# VDD VDD sg13_lv_pmos ad=0.34p pd=2.68u as=0.1523p ps=1.38u w=1u l=0.5u
X3033 VDD sg13cmos5l_or3_1_2.A a_22061_14020# VDD sg13_lv_pmos ad=0.3822p pd=1.84u as=0.1575p ps=1.315u w=1u l=0.13u
X3034 a_7077_14495# sg13cmos5l_dfrbpq_1_2.CLK VSS.t2 VSS.t164 sg13_lv_nmos ad=0.2516p pd=2.16u as=5.06795p ps=32.87u w=0.74u l=0.13u
X3035 VDD VSS.t2334 VDD VDD sg13_lv_pmos ad=0.34p pd=2.68u as=0 ps=0 w=1u l=1u
X3036 VDD VSS.t1992 VDD VDD sg13_lv_pmos ad=0.34p pd=2.68u as=0 ps=0 w=1u l=1u
X3037 VDD a_22508_15960# counter_value_o[4] VDD sg13_lv_pmos ad=0.2114p pd=1.54u as=0.42p ps=2.99u w=1.12u l=0.13u
X3038 VSS.t142 VDD VSS.t142 VSS.t479 sg13_lv_nmos ad=79.8f pd=0.8u as=0 ps=0 w=0.42u l=1u
X3039 VDD a_26661_13701# a_26763_13844# VDD sg13_lv_pmos ad=2.42015p pd=15.68u as=0.3864p ps=2.93u w=1.12u l=0.13u
X3040 VDD VSS.t1324 VDD VDD sg13_lv_pmos ad=0.19p pd=1.38u as=0 ps=0 w=1u l=1u
X3041 VDD VSS.t421 VDD VDD sg13_lv_pmos ad=0.19p pd=1.38u as=0 ps=0 w=1u l=1u
X3042 VDD a_9946_13943# sg13cmos5l_tiehi_0.L_HI VDD sg13_lv_pmos ad=2.42015p pd=15.68u as=0.3927p ps=2.99u w=1.155u l=0.13u
X3043 VDD VSS.t1220 VDD VDD sg13_lv_pmos ad=0.19p pd=1.38u as=0 ps=0 w=1u l=1u
X3044 VSS.t1185 VDD VSS.t1185 VSS.t224 sg13_lv_nmos ad=0.1428p pd=1.52u as=0 ps=0 w=0.42u l=1u
X3045 VDD VSS.t3124 VDD VDD sg13_lv_pmos ad=0.19p pd=1.38u as=0 ps=0 w=1u l=1u
X3046 VDD VSS.t2694 VDD VDD sg13_lv_pmos ad=0.19p pd=1.38u as=0 ps=0 w=1u l=1u
X3047 VDD VSS.t1910 VDD VDD sg13_lv_pmos ad=0.19p pd=1.38u as=0 ps=0 w=1u l=1u
X3048 a_19024_14726# sg13cmos5l_dfrbpq_1_3.RESET_B VDD VDD sg13_lv_pmos ad=79.8f pd=0.8u as=2.42015p ps=15.68u w=0.42u l=0.13u
X3049 VSS.t2355 VDD VSS.t2354 VSS.t2353 sg13_lv_nmos ad=0.1428p pd=1.52u as=0 ps=0 w=0.42u l=1u
X3050 VSS.t1179 VDD VSS.t1180 VSS.t224 sg13_lv_nmos ad=79.8f pd=0.8u as=0 ps=0 w=0.42u l=1u
X3051 a_15782_13722# a_16587_13844# a_16042_13945# VDD sg13_lv_pmos ad=0.1428p pd=1.52u as=79.8f ps=0.8u w=0.42u l=0.13u
X3052 VDD VSS.t636 VDD VDD sg13_lv_pmos ad=0.34p pd=2.68u as=0 ps=0 w=1u l=1u
X3053 VSS.t2759 VDD VSS.t2758 VSS.t2620 sg13_lv_nmos ad=0.1428p pd=1.52u as=0 ps=0 w=0.42u l=1u
X3054 VDD VSS.t2035 VDD VDD sg13_lv_pmos ad=0.19p pd=1.38u as=0 ps=0 w=1u l=1u
X3055 a_15790_15238# clock_i VDD VDD sg13_lv_pmos ad=0.2128p pd=1.5u as=0.3808p ps=2.92u w=1.12u l=0.13u
X3056 a_20507_15532# sg13cmos5l_inv_1_0.Y sg13cmos5l_a21oi_1_1.Y VDD sg13_lv_pmos ad=0.2128p pd=1.5u as=0.3808p ps=2.92u w=1.12u l=0.13u
X3057 VDD VSS.t3151 VDD VDD sg13_lv_pmos ad=0.34p pd=2.68u as=0 ps=0 w=1u l=1u
X3058 VDD sg13cmos5l_dfrbpq_1_1.RESET_B a_6374_14922# VDD sg13_lv_pmos ad=0.36237p pd=2.605u as=79.8f ps=0.8u w=0.42u l=0.13u
X3059 VDD VSS.t1678 VDD VDD sg13_lv_pmos ad=0.19p pd=1.38u as=0 ps=0 w=1u l=1u
X3060 VSS.t2420 VDD VSS.t2422 VSS.t2421 sg13_lv_nmos ad=79.8f pd=0.8u as=0 ps=0 w=0.42u l=1u
X3061 VSS.t450 VDD VSS.t450 VSS.t2 sg13_lv_nmos ad=0.1428p pd=1.52u as=0 ps=0 w=0.42u l=1u
X3062 VDD VSS.t1718 VDD VDD sg13_lv_pmos ad=0.19p pd=1.38u as=0 ps=0 w=1u l=1u
X3063 VSS.t1918 VDD VSS.t1920 VSS.t1919 sg13_lv_nmos ad=79.8f pd=0.8u as=0 ps=0 w=0.42u l=1u
X3064 VDD VSS.t2954 VDD VDD sg13_lv_pmos ad=0.19p pd=1.38u as=0 ps=0 w=1u l=1u
X3065 a_22480_14726# a_22223_14845# a_22642_14922# VSS.t7 sg13_lv_nmos ad=0.1428p pd=1.52u as=37.8f ps=0.6u w=0.42u l=0.13u
X3066 VSS.t591 VDD VSS.t593 VSS.t592 sg13_lv_nmos ad=79.8f pd=0.8u as=0 ps=0 w=0.42u l=1u
X3067 VDD VSS.t1548 VDD VDD sg13_lv_pmos ad=0.19p pd=1.38u as=0 ps=0 w=1u l=1u
X3068 a_26441_16334# a_26565_16033# VDD VDD sg13_lv_pmos ad=0.2442p pd=2.06u as=2.8961p ps=18.25u w=0.66u l=0.13u
X3069 a_17030_15996# a_16760_16037# VDD VDD sg13_lv_pmos ad=0.34p pd=2.68u as=0.1523p ps=1.38u w=1u l=0.5u
X3070 VSS.t1277 VDD VSS.t1276 VSS.t224 sg13_lv_nmos ad=0.1428p pd=1.52u as=0 ps=0 w=0.42u l=1u
X3071 VDD VSS.t1316 VDD VDD sg13_lv_pmos ad=0.19p pd=1.38u as=0 ps=0 w=1u l=1u
X3072 VSS.t2637 VDD VSS.t2637 VSS.t2620 sg13_lv_nmos ad=0.1428p pd=1.52u as=0 ps=0 w=0.42u l=1u
X3073 VSS.t333 VDD VSS.t335 VSS.t334 sg13_lv_nmos ad=79.8f pd=0.8u as=0 ps=0 w=0.42u l=1u
X3074 VDD VSS.t552 VDD VDD sg13_lv_pmos ad=0.19p pd=1.38u as=0 ps=0 w=1u l=1u
X3075 VDD VSS.t2688 VDD VDD sg13_lv_pmos ad=0.19p pd=1.38u as=0 ps=0 w=1u l=1u
X3076 VDD VSS.t2362 VDD VDD sg13_lv_pmos ad=0.19p pd=1.38u as=0 ps=0 w=1u l=1u
X3077 VDD VSS.t641 VDD VDD sg13_lv_pmos ad=0.34p pd=2.68u as=0 ps=0 w=1u l=1u
X3078 VSS.t109 VDD VSS.t109 VSS.t393 sg13_lv_nmos ad=79.8f pd=0.8u as=0 ps=0 w=0.42u l=1u
X3079 VSS.t236 VDD VSS.t201 VSS.t605 sg13_lv_nmos ad=79.8f pd=0.8u as=0 ps=0 w=0.42u l=1u
X3080 VSS.t2663 VDD VSS.t2664 VSS.t2620 sg13_lv_nmos ad=79.8f pd=0.8u as=0 ps=0 w=0.42u l=1u
X3081 VSS.t2700 VDD VSS.t2700 VSS.t2620 sg13_lv_nmos ad=79.8f pd=0.8u as=0 ps=0 w=0.42u l=1u
X3082 VDD sg13cmos5l_buf_16_2.A a_12212_15202# VDD sg13_lv_pmos ad=0.2128p pd=1.5u as=0.2128p ps=1.5u w=1.12u l=0.13u
X3083 VSS.t1313 VDD VSS.t1314 VSS.t224 sg13_lv_nmos ad=79.8f pd=0.8u as=0 ps=0 w=0.42u l=1u
X3084 VDD VSS.t1698 VDD VDD sg13_lv_pmos ad=0.19p pd=1.38u as=0 ps=0 w=1u l=1u
X3085 VDD VSS.t2994 VDD VDD sg13_lv_pmos ad=0.19p pd=1.38u as=0 ps=0 w=1u l=1u
X3086 VDD VSS.t1855 VDD VDD sg13_lv_pmos ad=0.19p pd=1.38u as=0 ps=0 w=1u l=1u
X3087 VSS.t1858 VDD VSS.t1857 VSS.t1856 sg13_lv_nmos ad=0.1428p pd=1.52u as=0 ps=0 w=0.42u l=1u
X3088 VDD VSS.t2700 VDD VDD sg13_lv_pmos ad=0.34p pd=2.68u as=0 ps=0 w=1u l=1u
X3089 sg13cmos5l_xor2_1_0.X a_7985_15288# a_8156_15532# VDD sg13_lv_pmos ad=0.3808p pd=2.92u as=0.2128p ps=1.5u w=1.12u l=0.13u
X3090 VSS.t308 VDD VSS.t310 VSS.t309 sg13_lv_nmos ad=79.8f pd=0.8u as=0 ps=0 w=0.42u l=1u
X3091 VSS.t3012 VDD VSS.t3014 VSS.t3013 sg13_lv_nmos ad=79.8f pd=0.8u as=0 ps=0 w=0.42u l=1u
X3092 VDD VSS.t2777 VDD VDD sg13_lv_pmos ad=0.19p pd=1.38u as=0 ps=0 w=1u l=1u
X3093 VSS.t2063 VDD VSS.t2062 VSS.t2061 sg13_lv_nmos ad=0.1428p pd=1.52u as=0 ps=0 w=0.42u l=1u
X3094 VSS.t562 VDD VSS.t561 VSS.t560 sg13_lv_nmos ad=0.1428p pd=1.52u as=0 ps=0 w=0.42u l=1u
X3095 VDD a_15790_15238# sg13cmos5l_buf_16_2.A VDD sg13_lv_pmos ad=0.2128p pd=1.5u as=0.2128p ps=1.5u w=1.12u l=0.13u
X3096 VDD VSS.t450 VDD VDD sg13_lv_pmos ad=0.34p pd=2.68u as=0 ps=0 w=1u l=1u
X3097 VDD sg13cmos5l_xnor2_1_1.A a_16140_14750# VDD sg13_lv_pmos ad=0.4536p pd=2.76u as=0.1596p ps=1.22u w=0.84u l=0.13u
X3098 VDD VSS.t1036 VDD VDD sg13_lv_pmos ad=0.34p pd=2.68u as=0 ps=0 w=1u l=1u
X3099 VDD VSS.t609 VDD VDD sg13_lv_pmos ad=0.19p pd=1.38u as=0 ps=0 w=1u l=1u
X3100 VDD a_22480_14726# a_22425_14607# VDD sg13_lv_pmos ad=2.42015p pd=15.68u as=93.45f ps=0.865u w=0.42u l=0.13u
X3101 VSS.t1322 VDD VSS.t1322 VSS.t224 sg13_lv_nmos ad=79.8f pd=0.8u as=0 ps=0 w=0.42u l=1u
X3102 VSS.t2405 VDD VSS.t2407 VSS.t2406 sg13_lv_nmos ad=79.8f pd=0.8u as=0 ps=0 w=0.42u l=1u
X3103 a_26949_16033# a_26949_16033# VSS.t73 VSS.t3208 sg13_lv_nmos ad=0.111p pd=1.34u as=6.38822p ps=41.325u w=0.3u l=0.13u
X3104 VSS.t4 a_9638_14484# a_9750_14508# VSS.t90 sg13_lv_nmos ad=0.1426p pd=1.16u as=0.1428p ps=1.52u w=0.42u l=0.5u
X3105 VDD VSS.t1493 VDD VDD sg13_lv_pmos ad=0.19p pd=1.38u as=0 ps=0 w=1u l=1u
X3106 VDD VSS.t2966 VDD VDD sg13_lv_pmos ad=0.34p pd=2.68u as=0 ps=0 w=1u l=1u
X3107 VSS.t277 VDD VSS.t488 VSS.t39 sg13_lv_nmos ad=0.1428p pd=1.52u as=0 ps=0 w=0.42u l=1u
X3108 VSS.t1571 VDD VSS.t1573 VSS.t1572 sg13_lv_nmos ad=79.8f pd=0.8u as=0 ps=0 w=0.42u l=1u
X3109 VDD VSS.t2072 VDD VDD sg13_lv_pmos ad=0.34p pd=2.68u as=0 ps=0 w=1u l=1u
X3110 VSS.t842 VDD VSS.t844 VSS.t843 sg13_lv_nmos ad=79.8f pd=0.8u as=0 ps=0 w=0.42u l=1u
X3111 VSS.t1893 VDD VSS.t1892 VSS.t1891 sg13_lv_nmos ad=0.1428p pd=1.52u as=0 ps=0 w=0.42u l=1u
X3112 VDD a_8870_15238# a_8982_15302# VDD sg13_lv_pmos ad=0.2254p pd=1.53u as=0.34p ps=2.68u w=1u l=0.5u
X3113 VSS.t2749 VDD VSS.t2749 VSS.t2620 sg13_lv_nmos ad=0.1428p pd=1.52u as=0 ps=0 w=0.42u l=1u
X3114 VDD VSS.t2656 VDD VDD sg13_lv_pmos ad=0.19p pd=1.38u as=0 ps=0 w=1u l=1u
X3115 VDD VSS.t1238 VDD VDD sg13_lv_pmos ad=0.19p pd=1.38u as=0 ps=0 w=1u l=1u
X3116 VDD VSS.t2020 VDD VDD sg13_lv_pmos ad=0.19p pd=1.38u as=0 ps=0 w=1u l=1u
X3117 a_19024_14726# a_18767_14845# a_19186_14922# VSS.t39 sg13_lv_nmos ad=0.1428p pd=1.52u as=37.8f ps=0.6u w=0.42u l=0.13u
X3118 a_27760_13942# sg13cmos5l_dfrbpq_1_5.RESET_B VDD VDD sg13_lv_pmos ad=79.8f pd=0.8u as=2.42015p ps=15.68u w=0.42u l=0.13u
X3119 VSS.t2435 VDD VSS.t2434 VSS.t2433 sg13_lv_nmos ad=0.1428p pd=1.52u as=0 ps=0 w=0.42u l=1u
X3120 VDD VSS.t1972 VDD VDD sg13_lv_pmos ad=0.34p pd=2.68u as=0 ps=0 w=1u l=1u
X3121 sg13cmos5l_dfrbpq_1_2.D sg13cmos5l_inv_1_0.Y VSS.t86 VSS.t272 sg13_lv_nmos ad=0.1406p pd=1.12u as=0.2516p ps=2.16u w=0.74u l=0.13u
X3122 VSS.t1691 VDD VSS.t1693 VSS.t1692 sg13_lv_nmos ad=79.8f pd=0.8u as=0 ps=0 w=0.42u l=1u
X3123 VDD VSS.t1703 VDD VDD sg13_lv_pmos ad=0.19p pd=1.38u as=0 ps=0 w=1u l=1u
X3124 VSS.t2083 VDD VSS.t2082 VSS.t2081 sg13_lv_nmos ad=0.1428p pd=1.52u as=0 ps=0 w=0.42u l=1u
X3125 VSS.t1903 VDD VSS.t1905 VSS.t1904 sg13_lv_nmos ad=79.8f pd=0.8u as=0 ps=0 w=0.42u l=1u
X3126 VDD VSS.t2939 VDD VDD sg13_lv_pmos ad=0.19p pd=1.38u as=0 ps=0 w=1u l=1u
X3127 VSS.t2997 VDD VSS.t2999 VSS.t2998 sg13_lv_nmos ad=79.8f pd=0.8u as=0 ps=0 w=0.42u l=1u
X3128 VDD VSS.t1655 VDD VDD sg13_lv_pmos ad=0.34p pd=2.68u as=0 ps=0 w=1u l=1u
X3129 VSS.t2500 VDD VSS.t2502 VSS.t2501 sg13_lv_nmos ad=79.8f pd=0.8u as=0 ps=0 w=0.42u l=1u
X3130 VDD VSS.t811 VDD VDD sg13_lv_pmos ad=0.34p pd=2.68u as=0 ps=0 w=1u l=1u
X3131 VDD VSS.t1533 VDD VDD sg13_lv_pmos ad=0.19p pd=1.38u as=0 ps=0 w=1u l=1u
X3132 VDD VSS.t1710 VDD VDD sg13_lv_pmos ad=0.34p pd=2.68u as=0 ps=0 w=1u l=1u
X3133 VSS.t1304 VDD VSS.t1303 VSS.t224 sg13_lv_nmos ad=0.1428p pd=1.52u as=0 ps=0 w=0.42u l=1u
X3134 VDD VSS.t2339 VDD VDD sg13_lv_pmos ad=0.34p pd=2.68u as=0 ps=0 w=1u l=1u
X3135 VSS.t417 VDD VSS.t419 VSS.t418 sg13_lv_nmos ad=79.8f pd=0.8u as=0 ps=0 w=0.42u l=1u
X3136 VDD a_25402_14448# a_25121_14750# VDD sg13_lv_pmos ad=0.1523p pd=1.38u as=0.34p ps=2.68u w=1u l=0.5u
X3137 VDD VSS.t446 VDD VDD sg13_lv_pmos ad=0.34p pd=2.68u as=0 ps=0 w=1u l=1u
X3138 VSS.t1297 VDD VSS.t1298 VSS.t224 sg13_lv_nmos ad=79.8f pd=0.8u as=0 ps=0 w=0.42u l=1u
X3139 VDD VSS.t1915 VDD VDD sg13_lv_pmos ad=0.19p pd=1.38u as=0 ps=0 w=1u l=1u
X3140 VDD VSS.t864 VDD VDD sg13_lv_pmos ad=0.19p pd=1.38u as=0 ps=0 w=1u l=1u
X3141 VDD VSS.t2234 VDD VDD sg13_lv_pmos ad=0.34p pd=2.68u as=0 ps=0 w=1u l=1u
X3142 VSS.t2762 VDD VSS.t2760 VSS.t2620 sg13_lv_nmos ad=0.1428p pd=1.52u as=0 ps=0 w=0.42u l=1u
X3143 VDD VSS.t1281 VDD VDD sg13_lv_pmos ad=0.19p pd=1.38u as=0 ps=0 w=1u l=1u
X3144 VDD VSS.t1229 VDD VDD sg13_lv_pmos ad=0.19p pd=1.38u as=0 ps=0 w=1u l=1u
X3145 VDD VSS.t2733 VDD VDD sg13_lv_pmos ad=0.19p pd=1.38u as=0 ps=0 w=1u l=1u
X3146 VDD VSS.t2040 VDD VDD sg13_lv_pmos ad=0.19p pd=1.38u as=0 ps=0 w=1u l=1u
X3147 VDD VSS.t3156 VDD VDD sg13_lv_pmos ad=0.34p pd=2.68u as=0 ps=0 w=1u l=1u
X3148 VSS.t2420 VDD VSS.t2419 VSS.t2418 sg13_lv_nmos ad=0.1428p pd=1.52u as=0 ps=0 w=0.42u l=1u
X3149 VSS.t1843 VDD VSS.t1842 VSS.t1841 sg13_lv_nmos ad=0.1428p pd=1.52u as=0 ps=0 w=0.42u l=1u
X3150 VDD VSS.t1683 VDD VDD sg13_lv_pmos ad=0.19p pd=1.38u as=0 ps=0 w=1u l=1u
X3151 VSS.t2703 VDD VSS.t2702 VSS.t2620 sg13_lv_nmos ad=0.1428p pd=1.52u as=0 ps=0 w=0.42u l=1u
X3152 VDD VSS.t1688 VDD VDD sg13_lv_pmos ad=0.19p pd=1.38u as=0 ps=0 w=1u l=1u
X3153 a_10149_13765# a_10149_13765# VSS.t54 VSS.t114 sg13_lv_nmos ad=0.111p pd=1.34u as=10.4325p ps=68.31u w=0.3u l=0.13u
X3154 VSS.t897 VDD VSS.t899 VSS.t898 sg13_lv_nmos ad=79.8f pd=0.8u as=0 ps=0 w=0.42u l=1u
X3155 VSS.t1646 VDD VSS.t1645 VSS.t1644 sg13_lv_nmos ad=0.1428p pd=1.52u as=0 ps=0 w=0.42u l=1u
X3156 VSS.t3177 VDD VSS.t3176 VSS.t3175 sg13_lv_nmos ad=0.1428p pd=1.52u as=0 ps=0 w=0.42u l=1u
X3157 VSS.t2485 VDD VSS.t2487 VSS.t2486 sg13_lv_nmos ad=79.8f pd=0.8u as=0 ps=0 w=0.42u l=1u
X3158 VDD VSS.t2372 VDD VDD sg13_lv_pmos ad=0.19p pd=1.38u as=0 ps=0 w=1u l=1u
X3159 a_22508_15960# sg13cmos5l_dfrbpq_1_3.Q VSS.t219 VSS.t276 sg13_lv_nmos ad=0.187p pd=1.78u as=0.14875p ps=1.16u w=0.55u l=0.13u
X3160 VSS.t629 VDD VSS.t629 VSS.t756 sg13_lv_nmos ad=0.1428p pd=1.52u as=0 ps=0 w=0.42u l=1u
X3161 VDD VSS.t632 VDD VDD sg13_lv_pmos ad=0.19p pd=1.38u as=0 ps=0 w=1u l=1u
X3162 VSS.t837 VDD VSS.t836 VSS.t835 sg13_lv_nmos ad=0.1428p pd=1.52u as=0 ps=0 w=0.42u l=1u
X3163 VSS.t2797 VDD VSS.t2639 VSS.t2620 sg13_lv_nmos ad=0.1428p pd=1.52u as=0 ps=0 w=0.42u l=1u
X3164 VSS.t772 VDD VSS.t774 VSS.t773 sg13_lv_nmos ad=79.8f pd=0.8u as=0 ps=0 w=0.42u l=1u
X3165 VSS.t2741 VDD VSS.t2742 VSS.t2620 sg13_lv_nmos ad=79.8f pd=0.8u as=0 ps=0 w=0.42u l=1u
X3166 VDD VSS.t2692 VDD VDD sg13_lv_pmos ad=0.19p pd=1.38u as=0 ps=0 w=1u l=1u
X3167 VSS.t2390 VDD VSS.t2392 VSS.t2391 sg13_lv_nmos ad=79.8f pd=0.8u as=0 ps=0 w=0.42u l=1u
X3168 VSS.t1953 VDD VSS.t1952 VSS.t1951 sg13_lv_nmos ad=0.1428p pd=1.52u as=0 ps=0 w=0.42u l=1u
X3169 VDD VSS.t1478 VDD VDD sg13_lv_pmos ad=0.19p pd=1.38u as=0 ps=0 w=1u l=1u
X3170 VDD VSS.t2951 VDD VDD sg13_lv_pmos ad=0.34p pd=2.68u as=0 ps=0 w=1u l=1u
X3171 VDD a_19534_13726# sg13cmos5l_buf_16_2.X VDD sg13_lv_pmos ad=0.3976p pd=2.95u as=0.2128p ps=1.5u w=1.12u l=0.13u
X3172 VSS.t842 VDD VSS.t844 VSS.t843 sg13_lv_nmos ad=79.8f pd=0.8u as=0 ps=0 w=0.42u l=1u
X3173 VSS.t1238 VDD VSS.t1237 VSS.t224 sg13_lv_nmos ad=0.1428p pd=1.52u as=0 ps=0 w=0.42u l=1u
X3174 VDD a_27503_13799# a_28170_14020# VDD sg13_lv_pmos ad=0.2128p pd=1.5u as=0.3864p ps=2.93u w=1.12u l=0.13u
X3175 VSS.t1556 VDD VSS.t1558 VSS.t1557 sg13_lv_nmos ad=79.8f pd=0.8u as=0 ps=0 w=0.42u l=1u
X3176 VDD VSS.t2057 VDD VDD sg13_lv_pmos ad=0.34p pd=2.68u as=0 ps=0 w=1u l=1u
X3177 VDD VSS.t382 VDD VDD sg13_lv_pmos ad=0.19p pd=1.38u as=0 ps=0 w=1u l=1u
X3178 VDD VSS.t2427 VDD VDD sg13_lv_pmos ad=0.19p pd=1.38u as=0 ps=0 w=1u l=1u
X3179 VDD VSS.t83 VDD VDD sg13_lv_pmos ad=0.19p pd=1.38u as=0 ps=0 w=1u l=1u
X3180 VDD VSS.t609 VDD VDD sg13_lv_pmos ad=0.34p pd=2.68u as=0 ps=0 w=1u l=1u
X3181 VDD VSS.t1860 VDD VDD sg13_lv_pmos ad=0.19p pd=1.38u as=0 ps=0 w=1u l=1u
X3182 VDD sg13cmos5l_tiehi_0.L_HI a_9446_15234# VDD sg13_lv_pmos ad=0.36237p pd=2.605u as=79.8f ps=0.8u w=0.42u l=0.13u
X3183 VSS.t1243 VDD VSS.t1241 VSS.t224 sg13_lv_nmos ad=0.1428p pd=1.52u as=0 ps=0 w=0.42u l=1u
X3184 VDD VSS.t1668 VDD VDD sg13_lv_pmos ad=0.19p pd=1.38u as=0 ps=0 w=1u l=1u
X3185 VSS.t2033 VDD VSS.t2035 VSS.t2034 sg13_lv_nmos ad=79.8f pd=0.8u as=0 ps=0 w=0.42u l=1u
X3186 VSS.t867 VDD VSS.t866 VSS.t865 sg13_lv_nmos ad=0.1428p pd=1.52u as=0 ps=0 w=0.42u l=1u
X3187 VDD VSS.t1957 VDD VDD sg13_lv_pmos ad=0.34p pd=2.68u as=0 ps=0 w=1u l=1u
X3188 VSS.t1166 VDD VSS.t1165 VSS.t224 sg13_lv_nmos ad=0.1428p pd=1.52u as=0 ps=0 w=0.42u l=1u
X3189 VSS.t1203 VDD VSS.t1205 VSS.t224 sg13_lv_nmos ad=79.8f pd=0.8u as=0 ps=0 w=0.42u l=1u
X3190 VSS.t2068 VDD VSS.t2067 VSS.t2066 sg13_lv_nmos ad=0.1428p pd=1.52u as=0 ps=0 w=0.42u l=1u
X3191 VSS.t3162 VDD VSS.t3161 VSS.t3160 sg13_lv_nmos ad=0.1428p pd=1.52u as=0 ps=0 w=0.42u l=1u
X3192 a_21466_15960# sg13cmos5l_a21oi_1_1.Y VSS.t79 VSS.t3236 sg13_lv_nmos ad=0.1428p pd=1.52u as=79.8f ps=0.8u w=0.42u l=0.13u
X3193 VDD VSS.t86 VDD VDD sg13_lv_pmos ad=0.34p pd=2.68u as=0 ps=0 w=1u l=1u
X3194 VDD VSS.t546 VDD VDD sg13_lv_pmos ad=0.34p pd=2.68u as=0 ps=0 w=1u l=1u
X3195 VDD VSS.t614 VDD VDD sg13_lv_pmos ad=0.34p pd=2.68u as=0 ps=0 w=1u l=1u
X3196 VDD VSS.t1044 VDD VDD sg13_lv_pmos ad=0.19p pd=1.38u as=0 ps=0 w=1u l=1u
X3197 sg13cmos5l_buf_1_10.X a_1192_9948# VDD VDD sg13_lv_pmos ad=0.42p pd=2.99u as=0.2114p ps=1.54u w=1.12u l=0.13u
X3198 VDD VSS.t641 VDD VDD sg13_lv_pmos ad=0.19p pd=1.38u as=0 ps=0 w=1u l=1u
X3199 VDD VSS.t1640 VDD VDD sg13_lv_pmos ad=0.34p pd=2.68u as=0 ps=0 w=1u l=1u
X3200 VSS.t118 a_19150_15423# sg13cmos5l_dlygate4sd3_1_10.X VSS.t65 sg13_lv_nmos ad=0.1426p pd=1.16u as=0.2516p ps=2.16u w=0.74u l=0.13u
X3201 VSS.t1171 VDD VSS.t1170 VSS.t224 sg13_lv_nmos ad=0.1428p pd=1.52u as=0 ps=0 w=0.42u l=1u
X3202 VDD VSS.t1695 VDD VDD sg13_lv_pmos ad=0.34p pd=2.68u as=0 ps=0 w=1u l=1u
X3203 VSS.t1546 VDD VSS.t1548 VSS.t1547 sg13_lv_nmos ad=79.8f pd=0.8u as=0 ps=0 w=0.42u l=1u
X3204 VSS.t2440 VDD VSS.t2439 VSS.t2438 sg13_lv_nmos ad=0.1428p pd=1.52u as=0 ps=0 w=0.42u l=1u
X3205 VSS.t927 VDD VSS.t929 VSS.t928 sg13_lv_nmos ad=79.8f pd=0.8u as=0 ps=0 w=0.42u l=1u
X3206 VDD VSS.t2324 VDD VDD sg13_lv_pmos ad=0.34p pd=2.68u as=0 ps=0 w=1u l=1u
X3207 VDD VSS.t794 VDD VDD sg13_lv_pmos ad=0.19p pd=1.38u as=0 ps=0 w=1u l=1u
X3208 VDD VSS.t1498 VDD VDD sg13_lv_pmos ad=0.19p pd=1.38u as=0 ps=0 w=1u l=1u
X3209 VSS.t2622 VDD VSS.t2623 VSS.t2620 sg13_lv_nmos ad=79.8f pd=0.8u as=0 ps=0 w=0.42u l=1u
X3210 a_11248_15454# sg13cmos5l_tiehi_0.L_HI VDD VDD sg13_lv_pmos ad=79.8f pd=0.8u as=2.8961p ps=18.25u w=0.42u l=0.13u
X3211 VSS.t1541 VDD VSS.t1543 VSS.t1542 sg13_lv_nmos ad=79.8f pd=0.8u as=0 ps=0 w=0.42u l=1u
X3212 VDD VSS.t2077 VDD VDD sg13_lv_pmos ad=0.34p pd=2.68u as=0 ps=0 w=1u l=1u
X3213 a_26052_14488# a_26026_14452# VDD VDD sg13_lv_pmos ad=0.34p pd=2.68u as=0.36237p ps=2.605u w=1u l=0.13u
X3214 VDD a_19534_13726# sg13cmos5l_buf_16_2.X VDD sg13_lv_pmos ad=0.2128p pd=1.5u as=0.2128p ps=1.5u w=1.12u l=0.13u
X3215 VSS.t1898 VDD VSS.t1897 VSS.t1896 sg13_lv_nmos ad=0.1428p pd=1.52u as=0 ps=0 w=0.42u l=1u
X3216 sg13cmos5l_nand4_1_0.Y sg13cmos5l_xnor2_1_0.A a_7550_15242# VSS.t3227 sg13_lv_nmos ad=0.2516p pd=2.16u as=0.1406p ps=1.12u w=0.74u l=0.13u
X3217 VDD VSS.t1306 VDD VDD sg13_lv_pmos ad=0.34p pd=2.68u as=0 ps=0 w=1u l=1u
X3218 VSS.t1188 VDD VSS.t1187 VSS.t224 sg13_lv_nmos ad=0.1428p pd=1.52u as=0 ps=0 w=0.42u l=1u
X3219 VSS.t2753 VDD VSS.t2751 VSS.t2620 sg13_lv_nmos ad=0.1428p pd=1.52u as=0 ps=0 w=0.42u l=1u
X3220 VDD VSS.t2623 VDD VDD sg13_lv_pmos ad=0.34p pd=2.68u as=0 ps=0 w=1u l=1u
X3221 VSS.t543 VDD VSS.t543 VSS.t544 sg13_lv_nmos ad=79.8f pd=0.8u as=0 ps=0 w=0.42u l=1u
X3222 VDD VSS.t1220 VDD VDD sg13_lv_pmos ad=0.19p pd=1.38u as=0 ps=0 w=1u l=1u
X3223 VDD VSS.t2724 VDD VDD sg13_lv_pmos ad=0.19p pd=1.38u as=0 ps=0 w=1u l=1u
X3224 VSS.t2405 VDD VSS.t2404 VSS.t2403 sg13_lv_nmos ad=0.1428p pd=1.52u as=0 ps=0 w=0.42u l=1u
X3225 VSS.t897 VDD VSS.t899 VSS.t898 sg13_lv_nmos ad=79.8f pd=0.8u as=0 ps=0 w=0.42u l=1u
X3226 VSS.t1256 VDD VSS.t1255 VSS.t224 sg13_lv_nmos ad=0.1428p pd=1.52u as=0 ps=0 w=0.42u l=1u
X3227 VSS.t1696 VDD VSS.t1698 VSS.t1697 sg13_lv_nmos ad=79.8f pd=0.8u as=0 ps=0 w=0.42u l=1u
X3228 VDD VSS.t620 VDD VDD sg13_lv_pmos ad=0.34p pd=2.68u as=0 ps=0 w=1u l=1u
X3229 VDD VSS.t1011 VDD VDD sg13_lv_pmos ad=0.34p pd=2.68u as=0 ps=0 w=1u l=1u
X3230 VSS.t2470 VDD VSS.t2472 VSS.t2471 sg13_lv_nmos ad=79.8f pd=0.8u as=0 ps=0 w=0.42u l=1u
X3231 VSS.t837 VDD VSS.t836 VSS.t835 sg13_lv_nmos ad=0.1428p pd=1.52u as=0 ps=0 w=0.42u l=1u
X3232 VDD VSS.t1538 VDD VDD sg13_lv_pmos ad=0.19p pd=1.38u as=0 ps=0 w=1u l=1u
X3233 VSS.t2751 VDD VSS.t2749 VSS.t2620 sg13_lv_nmos ad=0.1428p pd=1.52u as=0 ps=0 w=0.42u l=1u
X3234 VDD VSS.t1872 VDD VDD sg13_lv_pmos ad=0.34p pd=2.68u as=0 ps=0 w=1u l=1u
X3235 VDD a_25766_15996# a_25878_16020# VDD sg13_lv_pmos ad=0.2254p pd=1.53u as=0.34p ps=2.68u w=1u l=0.5u
X3236 a_26601_14113# a_26244_14040# VDD VDD sg13_lv_pmos ad=63f pd=0.72u as=0.1563p ps=1.22u w=0.42u l=0.13u
X3237 VSS.t772 VDD VSS.t774 VSS.t773 sg13_lv_nmos ad=79.8f pd=0.8u as=0 ps=0 w=0.42u l=1u
X3238 VDD VSS.t1233 VDD VDD sg13_lv_pmos ad=0.19p pd=1.38u as=0 ps=0 w=1u l=1u
X3239 VSS.t1196 VDD VSS.t1195 VSS.t224 sg13_lv_nmos ad=0.1428p pd=1.52u as=0 ps=0 w=0.42u l=1u
X3240 VDD VSS.t949 VDD VDD sg13_lv_pmos ad=0.19p pd=1.38u as=0 ps=0 w=1u l=1u
X3241 VSS.t2632 VDD VSS.t2631 VSS.t2620 sg13_lv_nmos ad=0.1428p pd=1.52u as=0 ps=0 w=0.42u l=1u
X3242 VSS.t712 a_19534_13726# sg13cmos5l_buf_16_2.X VSS.t3297 sg13_lv_nmos ad=0.1406p pd=1.12u as=0.1406p ps=1.12u w=0.74u l=0.13u
X3243 VDD VSS.t2682 VDD VDD sg13_lv_pmos ad=0.19p pd=1.38u as=0 ps=0 w=1u l=1u
X3244 VSS.t3032 VDD VSS.t3031 VSS.t3030 sg13_lv_nmos ad=0.1428p pd=1.52u as=0 ps=0 w=0.42u l=1u
X3245 VSS.t1491 VDD VSS.t1493 VSS.t1492 sg13_lv_nmos ad=79.8f pd=0.8u as=0 ps=0 w=0.42u l=1u
X3246 VDD VSS.t369 VDD VDD sg13_lv_pmos ad=0.34p pd=2.68u as=0 ps=0 w=1u l=1u
X3247 a_6660_14488# a_7179_14495# a_7919_14845# VSS.t264 sg13_lv_nmos ad=0.3473p pd=2.71u as=0.12665p ps=1.145u w=0.74u l=0.13u
X3248 VSS.t1721 VDD VSS.t1720 VSS.t1719 sg13_lv_nmos ad=0.1428p pd=1.52u as=0 ps=0 w=0.42u l=1u
X3249 VSS.t83 a_14549_15238# sg13cmos5l_or3_1_2.B VSS.t82 sg13_lv_nmos ad=0.1406p pd=1.12u as=0.1406p ps=1.12u w=0.74u l=0.13u
X3250 VSS.t552 VDD VSS.t552 VSS.t664 sg13_lv_nmos ad=79.8f pd=0.8u as=0 ps=0 w=0.42u l=1u
X3251 VDD VSS.t1503 VDD VDD sg13_lv_pmos ad=0.19p pd=1.38u as=0 ps=0 w=1u l=1u
X3252 VDD VSS.t2412 VDD VDD sg13_lv_pmos ad=0.19p pd=1.38u as=0 ps=0 w=1u l=1u
X3253 VSS.t1883 VDD VSS.t1882 VSS.t1881 sg13_lv_nmos ad=0.1428p pd=1.52u as=0 ps=0 w=0.42u l=1u
X3254 VDD VSS.t1232 VDD VDD sg13_lv_pmos ad=0.19p pd=1.38u as=0 ps=0 w=1u l=1u
X3255 VDD VSS.t2736 VDD VDD sg13_lv_pmos ad=0.19p pd=1.38u as=0 ps=0 w=1u l=1u
X3256 VDD VSS.t2010 VDD VDD sg13_lv_pmos ad=0.19p pd=1.38u as=0 ps=0 w=1u l=1u
X3257 sg13cmos5l_buf_16_2.A a_15790_15238# VSS.t21 VSS.t22 sg13_lv_nmos ad=0.1406p pd=1.12u as=0.1406p ps=1.12u w=0.74u l=0.13u
X3258 VSS.t867 VDD VSS.t866 VSS.t865 sg13_lv_nmos ad=0.1428p pd=1.52u as=0 ps=0 w=0.42u l=1u
X3259 VSS.t1270 VDD VSS.t1269 VSS.t224 sg13_lv_nmos ad=0.1428p pd=1.52u as=0 ps=0 w=0.42u l=1u
X3260 VDD VSS.t2364 VDD VDD sg13_lv_pmos ad=0.34p pd=2.68u as=0 ps=0 w=1u l=1u
X3261 VSS.t2425 VDD VSS.t2424 VSS.t2423 sg13_lv_nmos ad=0.1428p pd=1.52u as=0 ps=0 w=0.42u l=1u
X3262 VSS.t201 VDD VSS.t201 VSS.t607 sg13_lv_nmos ad=79.8f pd=0.8u as=0 ps=0 w=0.42u l=1u
X3263 VDD VSS.t1510 VDD VDD sg13_lv_pmos ad=0.34p pd=2.68u as=0 ps=0 w=1u l=1u
X3264 VDD VSS.t3126 VDD VDD sg13_lv_pmos ad=0.34p pd=2.68u as=0 ps=0 w=1u l=1u
X3265 VDD VSS.t1845 VDD VDD sg13_lv_pmos ad=0.19p pd=1.38u as=0 ps=0 w=1u l=1u
X3266 VSS.t375 VDD VSS.t268 VSS.t376 sg13_lv_nmos ad=79.8f pd=0.8u as=0 ps=0 w=0.42u l=1u
X3267 a_2916_15234# sg13cmos5l_nor2_1_0.Y a_2822_15234# VSS.t150 sg13_lv_nmos ad=60.89999f pd=0.71u as=0.1428p ps=1.52u w=0.42u l=0.13u
X3268 VDD VSS.t1693 VDD VDD sg13_lv_pmos ad=0.19p pd=1.38u as=0 ps=0 w=1u l=1u
X3269 VSS.t1973 VDD VSS.t1972 VSS.t1971 sg13_lv_nmos ad=0.1428p pd=1.52u as=0 ps=0 w=0.42u l=1u
X3270 VSS.t216 sg13cmos5l_a21oi_1_0.A2 a_15809_16344# VSS.t231 sg13_lv_nmos ad=0.2516p pd=2.16u as=0.1406p ps=1.12u w=0.74u l=0.13u
X3271 VSS.t1037 VDD VSS.t1036 VSS.t1035 sg13_lv_nmos ad=0.1428p pd=1.52u as=0 ps=0 w=0.42u l=1u
X3272 VDD VSS.t2377 VDD VDD sg13_lv_pmos ad=0.19p pd=1.38u as=0 ps=0 w=1u l=1u
X3273 VSS.t927 VDD VSS.t929 VSS.t928 sg13_lv_nmos ad=79.8f pd=0.8u as=0 ps=0 w=0.42u l=1u
X3274 VDD VSS.t1213 VDD VDD sg13_lv_pmos ad=0.34p pd=2.68u as=0 ps=0 w=1u l=1u
X3275 sg13cmos5l_dlygate4sd3_1_11.A a_11658_15532# VSS.t102 VSS.t209 sg13_lv_nmos ad=0.2516p pd=2.16u as=0.1406p ps=1.12u w=0.74u l=0.13u
X3276 VDD VSS.t901 VDD VDD sg13_lv_pmos ad=0.34p pd=2.68u as=0 ps=0 w=1u l=1u
X3277 VSS.t1531 VDD VSS.t1533 VSS.t1532 sg13_lv_nmos ad=79.8f pd=0.8u as=0 ps=0 w=0.42u l=1u
X3278 VSS.t1711 VDD VSS.t1710 VSS.t1709 sg13_lv_nmos ad=0.1428p pd=1.52u as=0 ps=0 w=0.42u l=1u
X3279 VSS.t2642 VDD VSS.t2641 VSS.t2620 sg13_lv_nmos ad=0.1428p pd=1.52u as=0 ps=0 w=0.42u l=1u
X3280 VSS.t2743 VDD VSS.t2745 VSS.t2620 sg13_lv_nmos ad=79.8f pd=0.8u as=0 ps=0 w=0.42u l=1u
X3281 VDD VSS.t2694 VDD VDD sg13_lv_pmos ad=0.19p pd=1.38u as=0 ps=0 w=1u l=1u
X3282 VSS.t1923 VDD VSS.t1922 VSS.t1921 sg13_lv_nmos ad=0.1428p pd=1.52u as=0 ps=0 w=0.42u l=1u
X3283 VSS.t710 a_19534_13726# sg13cmos5l_buf_16_2.X VSS.t3293 sg13_lv_nmos ad=0.1406p pd=1.12u as=0.1406p ps=1.12u w=0.74u l=0.13u
X3284 VDD VSS.t1483 VDD VDD sg13_lv_pmos ad=0.19p pd=1.38u as=0 ps=0 w=1u l=1u
X3285 VDD VSS.t2956 VDD VDD sg13_lv_pmos ad=0.34p pd=2.68u as=0 ps=0 w=1u l=1u
X3286 VDD VSS.t387 VDD VDD sg13_lv_pmos ad=0.34p pd=2.68u as=0 ps=0 w=1u l=1u
X3287 a_26409_14531# a_26052_14488# VDD VDD sg13_lv_pmos ad=63f pd=0.72u as=0.1563p ps=1.22u w=0.42u l=0.13u
X3288 VDD VSS.t1251 VDD VDD sg13_lv_pmos ad=0.19p pd=1.38u as=0 ps=0 w=1u l=1u
X3289 VSS.t1324 VDD VSS.t1325 VSS.t224 sg13_lv_nmos ad=79.8f pd=0.8u as=0 ps=0 w=0.42u l=1u
X3290 VSS.t1706 VDD VSS.t1705 VSS.t1704 sg13_lv_nmos ad=0.1428p pd=1.52u as=0 ps=0 w=0.42u l=1u
X3291 VDD VSS.t2432 VDD VDD sg13_lv_pmos ad=0.19p pd=1.38u as=0 ps=0 w=1u l=1u
X3292 VSS.t2455 VDD VSS.t2457 VSS.t2456 sg13_lv_nmos ad=79.8f pd=0.8u as=0 ps=0 w=0.42u l=1u
X3293 VDD VSS.t419 VDD VDD sg13_lv_pmos ad=0.19p pd=1.38u as=0 ps=0 w=1u l=1u
X3294 VDD VSS.t776 VDD VDD sg13_lv_pmos ad=0.34p pd=2.68u as=0 ps=0 w=1u l=1u
X3295 VDD VSS.t1316 VDD VDD sg13_lv_pmos ad=0.34p pd=2.68u as=0 ps=0 w=1u l=1u
X3296 VDD VSS.t2969 VDD VDD sg13_lv_pmos ad=0.19p pd=1.38u as=0 ps=0 w=1u l=1u
X3297 VSS.t2038 VDD VSS.t2040 VSS.t2039 sg13_lv_nmos ad=79.8f pd=0.8u as=0 ps=0 w=0.42u l=1u
X3298 a_20964_14488# a_20938_14452# VSS.t42 VSS.t41 sg13_lv_nmos ad=0.2516p pd=2.16u as=0.1626p ps=1.415u w=0.74u l=0.13u
X3299 VDD VSS.t1962 VDD VDD sg13_lv_pmos ad=0.34p pd=2.68u as=0 ps=0 w=1u l=1u
X3300 VSS.t1681 VDD VSS.t1683 VSS.t1682 sg13_lv_nmos ad=79.8f pd=0.8u as=0 ps=0 w=0.42u l=1u
X3301 sg13cmos5l_nor2_1_1.B a_8982_15302# VSS.t106 VSS.t155 sg13_lv_nmos ad=0.2516p pd=2.16u as=0.1426p ps=1.16u w=0.74u l=0.13u
X3302 VSS.t2 a_7077_14495# a_7179_14495# VSS.t248 sg13_lv_nmos ad=5.4903p pd=35.61u as=0.2516p ps=2.16u w=0.74u l=0.13u
X3303 VDD VSS.t434 VDD VDD sg13_lv_pmos ad=0.34p pd=2.68u as=0 ps=0 w=1u l=1u
X3304 VDD VSS.t303 VDD VDD sg13_lv_pmos ad=0.34p pd=2.68u as=0 ps=0 w=1u l=1u
X3305 VDD VSS.t1192 VDD VDD sg13_lv_pmos ad=0.19p pd=1.38u as=0 ps=0 w=1u l=1u
X3306 VSS.t2665 VDD VSS.t2665 VSS.t2620 sg13_lv_nmos ad=0.1428p pd=1.52u as=0 ps=0 w=0.42u l=1u
X3307 a_22642_14922# sg13cmos5l_dfrbpq_1_6.RESET_B VSS.t9 VSS.t7 sg13_lv_nmos ad=37.8f pd=0.6u as=79.8f ps=0.8u w=0.42u l=0.13u
X3308 VSS.t323 VDD VSS.t253 VSS.t322 sg13_lv_nmos ad=0.1428p pd=1.52u as=0 ps=0 w=0.42u l=1u
X3309 VDD VSS.t1645 VDD VDD sg13_lv_pmos ad=0.34p pd=2.68u as=0 ps=0 w=1u l=1u
X3310 VDD a_15790_15238# sg13cmos5l_buf_16_2.A VDD sg13_lv_pmos ad=0.2128p pd=1.5u as=0.2128p ps=1.5u w=1.12u l=0.13u
X3311 sg13cmos5l_o21ai_1_3.A2 sg13cmos5l_dfrbpq_1_6.Q VDD VDD sg13_lv_pmos ad=0.2128p pd=1.5u as=0.2128p ps=1.5u w=1.12u l=0.13u
X3312 VDD VSS.t1260 VDD VDD sg13_lv_pmos ad=0.19p pd=1.38u as=0 ps=0 w=1u l=1u
X3313 VDD VSS.t1700 VDD VDD sg13_lv_pmos ad=0.34p pd=2.68u as=0 ps=0 w=1u l=1u
X3314 VSS.t1551 VDD VSS.t1553 VSS.t1552 sg13_lv_nmos ad=79.8f pd=0.8u as=0 ps=0 w=0.42u l=1u
X3315 VSS.t3082 VDD VSS.t3084 VSS.t3083 sg13_lv_nmos ad=79.8f pd=0.8u as=0 ps=0 w=0.42u l=1u
X3316 VSS.t2285 VDD VSS.t2287 VSS.t2286 sg13_lv_nmos ad=79.8f pd=0.8u as=0 ps=0 w=0.42u l=1u
X3317 VDD VSS.t1857 VDD VDD sg13_lv_pmos ad=0.34p pd=2.68u as=0 ps=0 w=1u l=1u
X3318 VSS.t236 VDD VSS.t236 VSS.t720 sg13_lv_nmos ad=79.8f pd=0.8u as=0 ps=0 w=0.42u l=1u
X3319 VDD VSS.t2778 VDD VDD sg13_lv_pmos ad=0.34p pd=2.68u as=0 ps=0 w=1u l=1u
X3320 VDD VSS.t601 VDD VDD sg13_lv_pmos ad=0.34p pd=2.68u as=0 ps=0 w=1u l=1u
X3321 VSS.t862 VDD VSS.t864 VSS.t863 sg13_lv_nmos ad=79.8f pd=0.8u as=0 ps=0 w=0.42u l=1u
X3322 VSS.t710 sg13cmos5l_buf_16_2.A a_19534_13726# VSS.t3320 sg13_lv_nmos ad=0.1406p pd=1.12u as=0.1406p ps=1.12u w=0.74u l=0.13u
X3323 VSS.t1307 VDD VSS.t1306 VSS.t224 sg13_lv_nmos ad=0.1428p pd=1.52u as=0 ps=0 w=0.42u l=1u
X3324 VDD VSS.t2389 VDD VDD sg13_lv_pmos ad=0.34p pd=2.68u as=0 ps=0 w=1u l=1u
X3325 VDD VSS.t931 VDD VDD sg13_lv_pmos ad=0.34p pd=2.68u as=0 ps=0 w=1u l=1u
X3326 VDD a_3095_16301# a_3095_16071# VDD sg13_lv_pmos ad=2.8961p pd=18.25u as=0.2442p ps=2.06u w=0.66u l=0.13u
X3327 VDD VSS.t2625 VDD VDD sg13_lv_pmos ad=0.34p pd=2.68u as=0 ps=0 w=1u l=1u
X3328 VSS.t1868 VDD VSS.t1867 VSS.t1866 sg13_lv_nmos ad=0.1428p pd=1.52u as=0 ps=0 w=0.42u l=1u
X3329 VDD VSS.t1223 VDD VDD sg13_lv_pmos ad=0.19p pd=1.38u as=0 ps=0 w=1u l=1u
X3330 VDD VSS.t2727 VDD VDD sg13_lv_pmos ad=0.19p pd=1.38u as=0 ps=0 w=1u l=1u
X3331 VDD VSS.t1995 VDD VDD sg13_lv_pmos ad=0.19p pd=1.38u as=0 ps=0 w=1u l=1u
X3332 VSS.t614 VDD VSS.t614 VSS.t615 sg13_lv_nmos ad=79.8f pd=0.8u as=0 ps=0 w=0.42u l=1u
X3333 VSS.t2410 VDD VSS.t2409 VSS.t2408 sg13_lv_nmos ad=0.1428p pd=1.52u as=0 ps=0 w=0.42u l=1u
X3334 VSS.t147 a_12212_15202# sg13cmos5l_dfrbpq_1_2.CLK VSS.t146 sg13_lv_nmos ad=0.1406p pd=1.12u as=0.1406p ps=1.12u w=0.74u l=0.13u
X3335 VDD VSS.t869 VDD VDD sg13_lv_pmos ad=0.19p pd=1.38u as=0 ps=0 w=1u l=1u
X3336 VDD VSS.t1495 VDD VDD sg13_lv_pmos ad=0.34p pd=2.68u as=0 ps=0 w=1u l=1u
X3337 VDD VSS.t2349 VDD VDD sg13_lv_pmos ad=0.34p pd=2.68u as=0 ps=0 w=1u l=1u
X3338 a_10089_15625# a_9732_15552# VDD VDD sg13_lv_pmos ad=63f pd=0.72u as=0.1563p ps=1.22u w=0.42u l=0.13u
X3339 VSS.t1666 VDD VSS.t1668 VSS.t1667 sg13_lv_nmos ad=79.8f pd=0.8u as=0 ps=0 w=0.42u l=1u
X3340 VSS.t253 a_7916_15960# counter_value_o[1] VSS.t3200 sg13_lv_nmos ad=0.14875p pd=1.16u as=0.2886p ps=2.26u w=0.74u l=0.13u
X3341 VSS.t1576 VDD VSS.t1575 VSS.t1574 sg13_lv_nmos ad=0.1428p pd=1.52u as=0 ps=0 w=0.42u l=1u
X3342 a_18106_15960# sg13cmos5l_dlygate4sd3_1_7.A VSS.t63 VSS.t3265 sg13_lv_nmos ad=0.1428p pd=1.52u as=79.8f ps=0.8u w=0.42u l=0.13u
X3343 VDD VSS.t525 VDD VDD sg13_lv_pmos ad=0.19p pd=1.38u as=0 ps=0 w=1u l=1u
X3344 VDD VSS.t831 VDD VDD sg13_lv_pmos ad=0.34p pd=2.68u as=0 ps=0 w=1u l=1u
X3345 VSS.t1037 VDD VSS.t1036 VSS.t1035 sg13_lv_nmos ad=0.1428p pd=1.52u as=0 ps=0 w=0.42u l=1u
X3346 VDD VSS.t1678 VDD VDD sg13_lv_pmos ad=0.19p pd=1.38u as=0 ps=0 w=1u l=1u
X3347 sg13cmos5l_buf_1_0.X a_1192_3900# VSS.t2621 VSS.t2620 sg13_lv_nmos ad=0.2886p pd=2.26u as=0.14875p ps=1.16u w=0.74u l=0.13u
X3348 VSS.t2475 VDD VSS.t2477 VSS.t2476 sg13_lv_nmos ad=79.8f pd=0.8u as=0 ps=0 w=0.42u l=1u
X3349 VDD VSS.t3016 VDD VDD sg13_lv_pmos ad=0.34p pd=2.68u as=0 ps=0 w=1u l=1u
X3350 VDD VSS.t1877 VDD VDD sg13_lv_pmos ad=0.34p pd=2.68u as=0 ps=0 w=1u l=1u
X3351 sg13cmos5l_o21ai_1_2.Y sg13cmos5l_o21ai_1_2.A2 a_24600_14040# VDD sg13_lv_pmos ad=0.2128p pd=1.5u as=0.2128p ps=1.5u w=1.12u l=0.15u
X3352 VDD VSS.t2050 VDD VDD sg13_lv_pmos ad=0.19p pd=1.38u as=0 ps=0 w=1u l=1u
X3353 VSS.t1696 VDD VSS.t1695 VSS.t1694 sg13_lv_nmos ad=0.1428p pd=1.52u as=0 ps=0 w=0.42u l=1u
X3354 VDD VSS.t1548 VDD VDD sg13_lv_pmos ad=0.19p pd=1.38u as=0 ps=0 w=1u l=1u
X3355 VSS.t2635 VDD VSS.t2634 VSS.t2620 sg13_lv_nmos ad=0.1428p pd=1.52u as=0 ps=0 w=0.42u l=1u
X3356 VDD VSS.t2686 VDD VDD sg13_lv_pmos ad=0.19p pd=1.38u as=0 ps=0 w=1u l=1u
X3357 VDD VSS.t884 VDD VDD sg13_lv_pmos ad=0.19p pd=1.38u as=0 ps=0 w=1u l=1u
X3358 VSS.t3002 VDD VSS.t3001 VSS.t3000 sg13_lv_nmos ad=0.1428p pd=1.52u as=0 ps=0 w=0.42u l=1u
X3359 VSS.t632 VDD VSS.t632 VSS.t759 sg13_lv_nmos ad=79.8f pd=0.8u as=0 ps=0 w=0.42u l=1u
X3360 VSS.t1496 VDD VSS.t1498 VSS.t1497 sg13_lv_nmos ad=79.8f pd=0.8u as=0 ps=0 w=0.42u l=1u
X3361 VSS.t777 VDD VSS.t779 VSS.t778 sg13_lv_nmos ad=79.8f pd=0.8u as=0 ps=0 w=0.42u l=1u
X3362 VDD VSS.t2015 VDD VDD sg13_lv_pmos ad=0.19p pd=1.38u as=0 ps=0 w=1u l=1u
X3363 VSS.t187 sg13cmos5l_o21ai_1_3.B1 a_25129_13726# VSS.t186 sg13_lv_nmos ad=0.13395p pd=1.12u as=0.198p ps=1.27u w=0.55u l=0.13u
X3364 VDD VSS.t821 VDD VDD sg13_lv_pmos ad=0.34p pd=2.68u as=0 ps=0 w=1u l=1u
X3365 VSS.t1241 VDD VSS.t1240 VSS.t224 sg13_lv_nmos ad=0.1428p pd=1.52u as=0 ps=0 w=0.42u l=1u
X3366 VDD VSS.t3131 VDD VDD sg13_lv_pmos ad=0.34p pd=2.68u as=0 ps=0 w=1u l=1u
X3367 VSS.t2633 VDD VSS.t2632 VSS.t2620 sg13_lv_nmos ad=0.1428p pd=1.52u as=0 ps=0 w=0.42u l=1u
X3368 VSS.t142 a_12212_15202# sg13cmos5l_dfrbpq_1_2.CLK VSS.t141 sg13_lv_nmos ad=0.1406p pd=1.12u as=0.1406p ps=1.12u w=0.74u l=0.13u
X3369 VDD VSS.t421 VDD VDD sg13_lv_pmos ad=0.34p pd=2.68u as=0 ps=0 w=1u l=1u
X3370 VDD VSS.t1698 VDD VDD sg13_lv_pmos ad=0.19p pd=1.38u as=0 ps=0 w=1u l=1u
X3371 VSS.t44 a_4762_14448# a_4481_14750# VSS.t223 sg13_lv_nmos ad=79.8f pd=0.8u as=0.1428p ps=1.52u w=0.42u l=0.5u
X3372 VDD VSS.t609 VDD VDD sg13_lv_pmos ad=0.34p pd=2.68u as=0 ps=0 w=1u l=1u
X3373 VSS.t1 a_27310_15423# sg13cmos5l_o21ai_1_2.B1 VSS.t2 sg13_lv_nmos ad=0.1426p pd=1.16u as=0.2516p ps=2.16u w=0.74u l=0.13u
X3374 a_26218_13945# a_26661_13701# a_25958_13722# VSS.t57 sg13_lv_nmos ad=79.8f pd=0.8u as=0.1296p ps=1.52u w=0.42u l=0.13u
X3375 VDD a_17327_13799# a_17994_14020# VDD sg13_lv_pmos ad=0.2128p pd=1.5u as=0.3864p ps=2.93u w=1.12u l=0.13u
X3376 VDD VSS.t187 VDD VDD sg13_lv_pmos ad=0.34p pd=2.68u as=0 ps=0 w=1u l=1u
X3377 VDD VSS.t2042 VDD VDD sg13_lv_pmos ad=0.34p pd=2.68u as=0 ps=0 w=1u l=1u
X3378 a_20678_14922# a_21483_14495# a_20938_14452# VDD sg13_lv_pmos ad=0.1428p pd=1.52u as=79.8f ps=0.8u w=0.42u l=0.13u
X3379 VSS.t1169 VDD VSS.t1168 VSS.t224 sg13_lv_nmos ad=0.1428p pd=1.52u as=0 ps=0 w=0.42u l=1u
X3380 VSS.t1198 VDD VSS.t1199 VSS.t224 sg13_lv_nmos ad=79.8f pd=0.8u as=0 ps=0 w=0.42u l=1u
X3381 VSS.t2430 VDD VSS.t2429 VSS.t2428 sg13_lv_nmos ad=0.1428p pd=1.52u as=0 ps=0 w=0.42u l=1u
X3382 VSS.t2270 VDD VSS.t2272 VSS.t2271 sg13_lv_nmos ad=79.8f pd=0.8u as=0 ps=0 w=0.42u l=1u
X3383 VSS.t535 VDD VSS.t537 VSS.t653 sg13_lv_nmos ad=79.8f pd=0.8u as=0 ps=0 w=0.42u l=1u
X3384 VSS.t792 VDD VSS.t794 VSS.t793 sg13_lv_nmos ad=79.8f pd=0.8u as=0 ps=0 w=0.42u l=1u
X3385 VSS.t1536 VDD VSS.t1538 VSS.t1537 sg13_lv_nmos ad=79.8f pd=0.8u as=0 ps=0 w=0.42u l=1u
X3386 VSS.t1716 VDD VSS.t1715 VSS.t1714 sg13_lv_nmos ad=0.1428p pd=1.52u as=0 ps=0 w=0.42u l=1u
X3387 VSS.t3067 VDD VSS.t3069 VSS.t3068 sg13_lv_nmos ad=79.8f pd=0.8u as=0 ps=0 w=0.42u l=1u
X3388 sg13cmos5l_or3_1_3.X a_24265_14508# VDD VDD sg13_lv_pmos ad=0.3808p pd=2.92u as=0.3822p ps=1.84u w=1.12u l=0.13u
X3389 VDD a_8698_13690# a_8417_13912# VDD sg13_lv_pmos ad=0.1523p pd=1.38u as=0.34p ps=2.68u w=1u l=0.5u
X3390 VDD VSS.t1049 VDD VDD sg13_lv_pmos ad=0.19p pd=1.38u as=0 ps=0 w=1u l=1u
X3391 VSS.t862 VDD VSS.t864 VSS.t863 sg13_lv_nmos ad=79.8f pd=0.8u as=0 ps=0 w=0.42u l=1u
X3392 VDD VSS.t851 VDD VDD sg13_lv_pmos ad=0.34p pd=2.68u as=0 ps=0 w=1u l=1u
X3393 VDD VSS.t2676 VDD VDD sg13_lv_pmos ad=0.19p pd=1.38u as=0 ps=0 w=1u l=1u
X3394 VSS.t1928 VDD VSS.t1927 VSS.t1926 sg13_lv_nmos ad=0.1428p pd=1.52u as=0 ps=0 w=0.42u l=1u
X3395 a_9638_14484# a_9368_14525# VSS.t106 VSS.t195 sg13_lv_nmos ad=0.1428p pd=1.52u as=79.8f ps=0.8u w=0.42u l=0.5u
X3396 VDD VSS.t2961 VDD VDD sg13_lv_pmos ad=0.34p pd=2.68u as=0 ps=0 w=1u l=1u
X3397 VSS.t3022 VDD VSS.t3021 VSS.t3020 sg13_lv_nmos ad=0.1428p pd=1.52u as=0 ps=0 w=0.42u l=1u
X3398 VSS.t193 VDD VSS.t193 VSS.t403 sg13_lv_nmos ad=79.8f pd=0.8u as=0 ps=0 w=0.42u l=1u
X3399 sg13cmos5l_nor2_1_1.Y sg13cmos5l_inv_1_0.Y VSS.t106 VSS.t273 sg13_lv_nmos ad=0.1406p pd=1.12u as=0.2516p ps=2.16u w=0.74u l=0.13u
X3400 VDD VSS.t2374 VDD VDD sg13_lv_pmos ad=0.34p pd=2.68u as=0 ps=0 w=1u l=1u
X3401 VDD VSS.t1493 VDD VDD sg13_lv_pmos ad=0.19p pd=1.38u as=0 ps=0 w=1u l=1u
X3402 VDD VSS.t2402 VDD VDD sg13_lv_pmos ad=0.19p pd=1.38u as=0 ps=0 w=1u l=1u
X3403 VSS.t2460 VDD VSS.t2462 VSS.t2461 sg13_lv_nmos ad=79.8f pd=0.8u as=0 ps=0 w=0.42u l=1u
X3404 VSS.t79 a_21070_16263# sg13cmos5l_dfrbpq_1_6.D VSS.t3322 sg13_lv_nmos ad=0.1426p pd=1.16u as=0.2516p ps=2.16u w=0.74u l=0.13u
X3405 VDD VSS.t914 VDD VDD sg13_lv_pmos ad=0.19p pd=1.38u as=0 ps=0 w=1u l=1u
X3406 VDD VSS.t1212 VDD VDD sg13_lv_pmos ad=0.19p pd=1.38u as=0 ps=0 w=1u l=1u
X3407 VSS.t1177 VDD VSS.t1177 VSS.t224 sg13_lv_nmos ad=0.1428p pd=1.52u as=0 ps=0 w=0.42u l=1u
X3408 VSS.t1286 VDD VSS.t1287 VSS.t224 sg13_lv_nmos ad=79.8f pd=0.8u as=0 ps=0 w=0.42u l=1u
X3409 VDD VSS.t1319 VDD VDD sg13_lv_pmos ad=0.34p pd=2.68u as=0 ps=0 w=1u l=1u
X3410 VSS.t1626 VDD VSS.t1628 VSS.t1627 sg13_lv_nmos ad=79.8f pd=0.8u as=0 ps=0 w=0.42u l=1u
X3411 VSS.t2008 VDD VSS.t2010 VSS.t2009 sg13_lv_nmos ad=79.8f pd=0.8u as=0 ps=0 w=0.42u l=1u
X3412 VSS.t481 VDD VSS.t147 VSS.t480 sg13_lv_nmos ad=0.1428p pd=1.52u as=0 ps=0 w=0.42u l=1u
X3413 VSS.t126 a_27418_12936# a_27137_13238# VSS.t194 sg13_lv_nmos ad=79.8f pd=0.8u as=0.1428p ps=1.52u w=0.42u l=0.5u
X3414 VSS.t1216 VDD VSS.t1217 VSS.t224 sg13_lv_nmos ad=79.8f pd=0.8u as=0 ps=0 w=0.42u l=1u
X3415 VDD VSS.t1311 VDD VDD sg13_lv_pmos ad=0.19p pd=1.38u as=0 ps=0 w=1u l=1u
X3416 VSS.t1511 VDD VSS.t1510 VSS.t1509 sg13_lv_nmos ad=0.1428p pd=1.52u as=0 ps=0 w=0.42u l=1u
X3417 VDD VSS.t2688 VDD VDD sg13_lv_pmos ad=0.34p pd=2.68u as=0 ps=0 w=1u l=1u
X3418 VDD VSS.t525 VDD VDD sg13_lv_pmos ad=0.19p pd=1.38u as=0 ps=0 w=1u l=1u
X3419 a_15876_13722# sg13cmos5l_dfrbpq_1_2.D a_15782_13722# VSS.t177 sg13_lv_nmos ad=60.89999f pd=0.71u as=0.1428p ps=1.52u w=0.42u l=0.13u
X3420 VDD VSS.t625 VDD VDD sg13_lv_pmos ad=0.34p pd=2.68u as=0 ps=0 w=1u l=1u
X3421 VSS.t1340 VDD VSS.t1181 VSS.t224 sg13_lv_nmos ad=0.1428p pd=1.52u as=0 ps=0 w=0.42u l=1u
X3422 VDD VSS.t2027 VDD VDD sg13_lv_pmos ad=0.34p pd=2.68u as=0 ps=0 w=1u l=1u
X3423 VSS.t947 VDD VSS.t949 VSS.t948 sg13_lv_nmos ad=79.8f pd=0.8u as=0 ps=0 w=0.42u l=1u
X3424 VDD VSS.t1670 VDD VDD sg13_lv_pmos ad=0.34p pd=2.68u as=0 ps=0 w=1u l=1u
X3425 VDD VSS.t1862 VDD VDD sg13_lv_pmos ad=0.34p pd=2.68u as=0 ps=0 w=1u l=1u
X3426 VSS.t442 VDD VSS.t442 VSS.t2 sg13_lv_nmos ad=0.1428p pd=1.52u as=0 ps=0 w=0.42u l=1u
X3427 VSS.t3052 VDD VSS.t3054 VSS.t3053 sg13_lv_nmos ad=79.8f pd=0.8u as=0 ps=0 w=0.42u l=1u
X3428 VSS.t2255 VDD VSS.t2257 VSS.t2256 sg13_lv_nmos ad=79.8f pd=0.8u as=0 ps=0 w=0.42u l=1u
X3429 VDD VSS.t434 VDD VDD sg13_lv_pmos ad=0.19p pd=1.38u as=0 ps=0 w=1u l=1u
X3430 VDD VSS.t1533 VDD VDD sg13_lv_pmos ad=0.19p pd=1.38u as=0 ps=0 w=1u l=1u
X3431 VDD VSS.t1710 VDD VDD sg13_lv_pmos ad=0.34p pd=2.68u as=0 ps=0 w=1u l=1u
X3432 VDD VSS.t2781 VDD VDD sg13_lv_pmos ad=0.34p pd=2.68u as=0 ps=0 w=1u l=1u
X3433 VDD VSS.t135 VDD VDD sg13_lv_pmos ad=0.34p pd=2.68u as=0 ps=0 w=1u l=1u
X3434 VSS.t2330 VDD VSS.t2332 VSS.t2331 sg13_lv_nmos ad=79.8f pd=0.8u as=0 ps=0 w=0.42u l=1u
X3435 VSS.t777 VDD VSS.t779 VSS.t778 sg13_lv_nmos ad=79.8f pd=0.8u as=0 ps=0 w=0.42u l=1u
X3436 VDD VSS.t2394 VDD VDD sg13_lv_pmos ad=0.34p pd=2.68u as=0 ps=0 w=1u l=1u
X3437 VDD VSS.t2052 VDD VDD sg13_lv_pmos ad=0.34p pd=2.68u as=0 ps=0 w=1u l=1u
X3438 VSS.t1481 VDD VSS.t1483 VSS.t1482 sg13_lv_nmos ad=79.8f pd=0.8u as=0 ps=0 w=0.42u l=1u
X3439 VSS.t689 VDD VSS.t688 VSS.t687 sg13_lv_nmos ad=0.1428p pd=1.52u as=0 ps=0 w=0.42u l=1u
X3440 VSS.t1268 VDD VSS.t1267 VSS.t224 sg13_lv_nmos ad=0.1428p pd=1.52u as=0 ps=0 w=0.42u l=1u
X3441 VDD VSS.t1226 VDD VDD sg13_lv_pmos ad=0.19p pd=1.38u as=0 ps=0 w=1u l=1u
X3442 VDD VSS.t2730 VDD VDD sg13_lv_pmos ad=0.19p pd=1.38u as=0 ps=0 w=1u l=1u
X3443 VDD VSS.t2000 VDD VDD sg13_lv_pmos ad=0.19p pd=1.38u as=0 ps=0 w=1u l=1u
X3444 a_26565_16033# a_26565_16033# VSS.t73 VSS.t3282 sg13_lv_nmos ad=0.111p pd=1.34u as=6.38822p ps=41.325u w=0.3u l=0.13u
X3445 a_4569_15549# a_3627_15356# a_4367_15311# VDD sg13_lv_pmos ad=93.45f pd=0.865u as=0.2048p ps=1.63u w=0.42u l=0.13u
X3446 VSS.t2415 VDD VSS.t2414 VSS.t2413 sg13_lv_nmos ad=0.1428p pd=1.52u as=0 ps=0 w=0.42u l=1u
X3447 VDD VSS.t374 VDD VDD sg13_lv_pmos ad=0.34p pd=2.68u as=0 ps=0 w=1u l=1u
X3448 VDD VSS.t1500 VDD VDD sg13_lv_pmos ad=0.34p pd=2.68u as=0 ps=0 w=1u l=1u
X3449 VSS.t2624 VDD VSS.t2624 VSS.t2620 sg13_lv_nmos ad=0.1428p pd=1.52u as=0 ps=0 w=0.42u l=1u
X3450 VDD VSS.t2354 VDD VDD sg13_lv_pmos ad=0.34p pd=2.68u as=0 ps=0 w=1u l=1u
X3451 VDD VSS.t636 VDD VDD sg13_lv_pmos ad=0.34p pd=2.68u as=0 ps=0 w=1u l=1u
X3452 VSS.t1963 VDD VSS.t1962 VSS.t1961 sg13_lv_nmos ad=0.1428p pd=1.52u as=0 ps=0 w=0.42u l=1u
X3453 sg13cmos5l_dlygate4sd3_1_20.A a_28170_14020# VDD VDD sg13_lv_pmos ad=0.3808p pd=2.92u as=0.2128p ps=1.5u w=1.12u l=0.13u
X3454 VSS.t1273 VDD VSS.t1272 VSS.t224 sg13_lv_nmos ad=0.1428p pd=1.52u as=0 ps=0 w=0.42u l=1u
X3455 VSS.t1546 VDD VSS.t1545 VSS.t1544 sg13_lv_nmos ad=0.1428p pd=1.52u as=0 ps=0 w=0.42u l=1u
X3456 VDD VSS.t1683 VDD VDD sg13_lv_pmos ad=0.19p pd=1.38u as=0 ps=0 w=1u l=1u
X3457 VSS.t395 VDD VSS.t109 VSS.t394 sg13_lv_nmos ad=0.1428p pd=1.52u as=0 ps=0 w=0.42u l=1u
X3458 VSS.t201 VDD VSS.t201 VSS.t606 sg13_lv_nmos ad=0.1428p pd=1.52u as=0 ps=0 w=0.42u l=1u
X3459 VSS.t2480 VDD VSS.t2482 VSS.t2481 sg13_lv_nmos ad=79.8f pd=0.8u as=0 ps=0 w=0.42u l=1u
X3460 VDD sg13cmos5l_o21ai_1_3.B1 a_25325_14020# VDD sg13_lv_pmos ad=0.3822p pd=1.84u as=0.1575p ps=1.315u w=1u l=0.13u
X3461 VSS.t792 VDD VSS.t794 VSS.t793 sg13_lv_nmos ad=79.8f pd=0.8u as=0 ps=0 w=0.42u l=1u
X3462 VSS.t1304 VDD VSS.t1305 VSS.t224 sg13_lv_nmos ad=79.8f pd=0.8u as=0 ps=0 w=0.42u l=1u
X3463 VDD VSS.t1513 VDD VDD sg13_lv_pmos ad=0.19p pd=1.38u as=0 ps=0 w=1u l=1u
X3464 VDD VSS.t2986 VDD VDD sg13_lv_pmos ad=0.34p pd=2.68u as=0 ps=0 w=1u l=1u
X3465 VDD VSS.t1847 VDD VDD sg13_lv_pmos ad=0.34p pd=2.68u as=0 ps=0 w=1u l=1u
X3466 VSS.t1701 VDD VSS.t1700 VSS.t1699 sg13_lv_nmos ad=0.1428p pd=1.52u as=0 ps=0 w=0.42u l=1u
X3467 VDD VSS.t2773 VDD VDD sg13_lv_pmos ad=0.34p pd=2.68u as=0 ps=0 w=1u l=1u
X3468 VDD VSS.t2668 VDD VDD sg13_lv_pmos ad=0.19p pd=1.38u as=0 ps=0 w=1u l=1u
X3469 VSS.t1913 VDD VSS.t1912 VSS.t1911 sg13_lv_nmos ad=0.1428p pd=1.52u as=0 ps=0 w=0.42u l=1u
X3470 VDD VSS.t2946 VDD VDD sg13_lv_pmos ad=0.34p pd=2.68u as=0 ps=0 w=1u l=1u
X3471 VSS.t3007 VDD VSS.t3006 VSS.t3005 sg13_lv_nmos ad=0.1428p pd=1.52u as=0 ps=0 w=0.42u l=1u
X3472 VSS.t537 VDD VSS.t535 VSS.t536 sg13_lv_nmos ad=0.1428p pd=1.52u as=0 ps=0 w=0.42u l=1u
X3473 VDD VSS.t906 VDD VDD sg13_lv_pmos ad=0.34p pd=2.68u as=0 ps=0 w=1u l=1u
X3474 VDD sg13cmos5l_dfrbpq_1_5.RESET_B a_25958_13722# VDD sg13_lv_pmos ad=0.36237p pd=2.605u as=79.8f ps=0.8u w=0.42u l=0.13u
X3475 VDD VSS.t1173 VDD VDD sg13_lv_pmos ad=0.19p pd=1.38u as=0 ps=0 w=1u l=1u
X3476 VDD a_27418_12936# a_27137_13238# VDD sg13_lv_pmos ad=0.1523p pd=1.38u as=0.34p ps=2.68u w=1u l=0.5u
X3477 VDD VSS.t829 VDD VDD sg13_lv_pmos ad=0.19p pd=1.38u as=0 ps=0 w=1u l=1u
X3478 VDD VSS.t1021 VDD VDD sg13_lv_pmos ad=0.34p pd=2.68u as=0 ps=0 w=1u l=1u
X3479 VSS.t1282 VDD VSS.t1281 VSS.t224 sg13_lv_nmos ad=0.1428p pd=1.52u as=0 ps=0 w=0.42u l=1u
X3480 VDD VSS.t1478 VDD VDD sg13_lv_pmos ad=0.19p pd=1.38u as=0 ps=0 w=1u l=1u
X3481 VSS.t2445 VDD VSS.t2447 VSS.t2446 sg13_lv_nmos ad=79.8f pd=0.8u as=0 ps=0 w=0.42u l=1u
X3482 sg13cmos5l_xor2_1_0.X sg13cmos5l_xor2_1_0.B a_8250_15250# VSS.t242 sg13_lv_nmos ad=0.1628p pd=1.18u as=88.8f ps=0.98u w=0.74u l=0.13u
X3483 VDD VSS.t2387 VDD VDD sg13_lv_pmos ad=0.19p pd=1.38u as=0 ps=0 w=1u l=1u
X3484 VDD VSS.t2721 VDD VDD sg13_lv_pmos ad=0.19p pd=1.38u as=0 ps=0 w=1u l=1u
X3485 VSS.t2275 VDD VSS.t2277 VSS.t2276 sg13_lv_nmos ad=79.8f pd=0.8u as=0 ps=0 w=0.42u l=1u
X3486 VSS.t2400 VDD VSS.t2399 VSS.t2398 sg13_lv_nmos ad=0.1428p pd=1.52u as=0 ps=0 w=0.42u l=1u
X3487 VDD sg13cmos5l_a21oi_1_0.A1 a_15707_15996# VDD sg13_lv_pmos ad=0.2128p pd=1.5u as=0.2128p ps=1.5u w=1.12u l=0.13u
X3488 VSS.t1611 VDD VSS.t1613 VSS.t1612 sg13_lv_nmos ad=79.8f pd=0.8u as=0 ps=0 w=0.42u l=1u
X3489 VDD sg13cmos5l_dfrbpq_1_1.RESET_B a_6634_14452# VDD sg13_lv_pmos ad=0.1563p pd=1.22u as=0.147p ps=1.54u w=0.42u l=0.13u
X3490 VSS.t2736 VDD VSS.t2737 VSS.t2620 sg13_lv_nmos ad=79.8f pd=0.8u as=0 ps=0 w=0.42u l=1u
X3491 VDD VSS.t712 VDD VDD sg13_lv_pmos ad=0.19p pd=1.38u as=0 ps=0 w=1u l=1u
X3492 VDD VSS.t781 VDD VDD sg13_lv_pmos ad=0.34p pd=2.68u as=0 ps=0 w=1u l=1u
X3493 VSS.t1566 VDD VSS.t1565 VSS.t1564 sg13_lv_nmos ad=0.1428p pd=1.52u as=0 ps=0 w=0.42u l=1u
X3494 VSS.t1496 VDD VSS.t1495 VSS.t1494 sg13_lv_nmos ad=0.1428p pd=1.52u as=0 ps=0 w=0.42u l=1u
X3495 VDD VSS.t1668 VDD VDD sg13_lv_pmos ad=0.19p pd=1.38u as=0 ps=0 w=1u l=1u
X3496 a_37484_15960# sg13cmos5l_dlygate4sd3_1_20.A VDD VDD sg13_lv_pmos ad=0.2856p pd=2.36u as=0.2114p ps=1.54u w=0.84u l=0.13u
X3497 VSS.t947 VDD VSS.t949 VSS.t948 sg13_lv_nmos ad=79.8f pd=0.8u as=0 ps=0 w=0.42u l=1u
X3498 VDD VSS.t1225 VDD VDD sg13_lv_pmos ad=0.34p pd=2.68u as=0 ps=0 w=1u l=1u
X3499 VSS.t1436 VDD VSS.t1319 VSS.t224 sg13_lv_nmos ad=79.8f pd=0.8u as=0 ps=0 w=0.42u l=1u
X3500 sg13cmos5l_xnor2_1_0.Y a_2880_14523# a_3029_14854# VSS.t3226 sg13_lv_nmos ad=0.2516p pd=2.16u as=0.1406p ps=1.12u w=0.74u l=0.13u
X3501 VDD VSS.t1233 VDD VDD sg13_lv_pmos ad=0.34p pd=2.68u as=0 ps=0 w=1u l=1u
X3502 VDD VSS.t2737 VDD VDD sg13_lv_pmos ad=0.34p pd=2.68u as=0 ps=0 w=1u l=1u
X3503 VDD VSS.t2012 VDD VDD sg13_lv_pmos ad=0.34p pd=2.68u as=0 ps=0 w=1u l=1u
X3504 VSS.t596 VDD VSS.t595 VSS.t594 sg13_lv_nmos ad=0.1428p pd=1.52u as=0 ps=0 w=0.42u l=1u
X3505 VDD VSS.t438 VDD VDD sg13_lv_pmos ad=0.19p pd=1.38u as=0 ps=0 w=1u l=1u
X3506 VSS.t2240 VDD VSS.t2242 VSS.t2241 sg13_lv_nmos ad=79.8f pd=0.8u as=0 ps=0 w=0.42u l=1u
X3507 VSS.t1933 VDD VSS.t1932 VSS.t1931 sg13_lv_nmos ad=0.1428p pd=1.52u as=0 ps=0 w=0.42u l=1u
X3508 VDD VSS.t1695 VDD VDD sg13_lv_pmos ad=0.34p pd=2.68u as=0 ps=0 w=1u l=1u
X3509 VDD VSS.t1263 VDD VDD sg13_lv_pmos ad=0.19p pd=1.38u as=0 ps=0 w=1u l=1u
X3510 VDD VSS.t2931 VDD VDD sg13_lv_pmos ad=0.34p pd=2.68u as=0 ps=0 w=1u l=1u
X3511 VSS.t2495 VDD VSS.t2494 VSS.t2493 sg13_lv_nmos ad=0.1428p pd=1.52u as=0 ps=0 w=0.42u l=1u
X3512 VSS.t2315 VDD VSS.t2317 VSS.t2316 sg13_lv_nmos ad=79.8f pd=0.8u as=0 ps=0 w=0.42u l=1u
X3513 VDD VSS.t796 VDD VDD sg13_lv_pmos ad=0.34p pd=2.68u as=0 ps=0 w=1u l=1u
X3514 VDD VSS.t984 VDD VDD sg13_lv_pmos ad=0.19p pd=1.38u as=0 ps=0 w=1u l=1u
X3515 VDD VSS.t1560 VDD VDD sg13_lv_pmos ad=0.34p pd=2.68u as=0 ps=0 w=1u l=1u
X3516 VDD VSS.t2379 VDD VDD sg13_lv_pmos ad=0.34p pd=2.68u as=0 ps=0 w=1u l=1u
X3517 VDD VSS.t1498 VDD VDD sg13_lv_pmos ad=0.19p pd=1.38u as=0 ps=0 w=1u l=1u
X3518 VDD VSS.t2407 VDD VDD sg13_lv_pmos ad=0.19p pd=1.38u as=0 ps=0 w=1u l=1u
X3519 VSS.t867 VDD VSS.t869 VSS.t868 sg13_lv_nmos ad=79.8f pd=0.8u as=0 ps=0 w=0.42u l=1u
X3520 VSS.t1596 VDD VSS.t1598 VSS.t1597 sg13_lv_nmos ad=79.8f pd=0.8u as=0 ps=0 w=0.42u l=1u
X3521 VDD VSS.t2696 VDD VDD sg13_lv_pmos ad=0.34p pd=2.68u as=0 ps=0 w=1u l=1u
X3522 VSS.t2013 VDD VSS.t2015 VSS.t2014 sg13_lv_nmos ad=79.8f pd=0.8u as=0 ps=0 w=0.42u l=1u
X3523 sg13cmos5l_xor2_1_0.B sg13cmos5l_buf_1_0.X VDD VDD sg13_lv_pmos ad=0.2128p pd=1.5u as=0.3808p ps=2.92u w=1.12u l=0.13u
X3524 VSS.t1300 VDD VSS.t1298 VSS.t224 sg13_lv_nmos ad=0.1428p pd=1.52u as=0 ps=0 w=0.42u l=1u
X3525 VDD VSS.t2434 VDD VDD sg13_lv_pmos ad=0.34p pd=2.68u as=0 ps=0 w=1u l=1u
X3526 VSS.t2465 VDD VSS.t2467 VSS.t2466 sg13_lv_nmos ad=79.8f pd=0.8u as=0 ps=0 w=0.42u l=1u
X3527 a_4624_15454# a_4367_15311# a_4786_15234# VSS.t3197 sg13_lv_nmos ad=0.1428p pd=1.52u as=37.8f ps=0.6u w=0.42u l=0.13u
X3528 a_7346_15242# sg13cmos5l_buf_1_0.X VSS.t77 VSS.t166 sg13_lv_nmos ad=0.1406p pd=1.12u as=0.2516p ps=2.16u w=0.74u l=0.13u
X3529 VSS.t434 VDD VSS.t434 VSS.t2 sg13_lv_nmos ad=79.8f pd=0.8u as=0 ps=0 w=0.42u l=1u
X3530 a_10318_14751# a_10433_14750# VDD VDD sg13_lv_pmos ad=0.34p pd=2.68u as=0.2254p ps=1.53u w=1u l=0.5u
X3531 a_26026_14452# a_26469_14495# a_25766_14922# VSS.t180 sg13_lv_nmos ad=79.8f pd=0.8u as=0.1296p ps=1.52u w=0.42u l=0.13u
X3532 VDD VSS.t1675 VDD VDD sg13_lv_pmos ad=0.34p pd=2.68u as=0 ps=0 w=1u l=1u
X3533 VDD VSS.t2971 VDD VDD sg13_lv_pmos ad=0.34p pd=2.68u as=0 ps=0 w=1u l=1u
X3534 VSS.t2043 VDD VSS.t2042 VSS.t2041 sg13_lv_nmos ad=0.1428p pd=1.52u as=0 ps=0 w=0.42u l=1u
X3535 VSS.t1220 VDD VSS.t1219 VSS.t224 sg13_lv_nmos ad=0.1428p pd=1.52u as=0 ps=0 w=0.42u l=1u
X3536 VSS.t1526 VDD VSS.t1528 VSS.t1527 sg13_lv_nmos ad=79.8f pd=0.8u as=0 ps=0 w=0.42u l=1u
X3537 VSS.t3057 VDD VSS.t3059 VSS.t3058 sg13_lv_nmos ad=79.8f pd=0.8u as=0 ps=0 w=0.42u l=1u
X3538 VSS.t2260 VDD VSS.t2262 VSS.t2261 sg13_lv_nmos ad=79.8f pd=0.8u as=0 ps=0 w=0.42u l=1u
X3539 VDD VSS.t1538 VDD VDD sg13_lv_pmos ad=0.19p pd=1.38u as=0 ps=0 w=1u l=1u
X3540 VSS.t882 VDD VSS.t884 VSS.t883 sg13_lv_nmos ad=79.8f pd=0.8u as=0 ps=0 w=0.42u l=1u
X3541 VDD VSS.t1243 VDD VDD sg13_lv_pmos ad=0.34p pd=2.68u as=0 ps=0 w=1u l=1u
X3542 VDD VSS.t2765 VDD VDD sg13_lv_pmos ad=0.34p pd=2.68u as=0 ps=0 w=1u l=1u
X3543 VDD VSS.t951 VDD VDD sg13_lv_pmos ad=0.34p pd=2.68u as=0 ps=0 w=1u l=1u
X3544 VSS.t2335 VDD VSS.t2337 VSS.t2336 sg13_lv_nmos ad=79.8f pd=0.8u as=0 ps=0 w=0.42u l=1u
X3545 VSS.t1 a_26842_15202# a_26561_15424# VSS.t0 sg13_lv_nmos ad=79.8f pd=0.8u as=0.1428p ps=1.52u w=0.42u l=0.5u
X3546 a_18767_14845# a_17925_14495# a_18673_14845# VSS.t39 sg13_lv_nmos ad=0.12665p pd=1.145u as=0.1428p ps=1.52u w=0.42u l=0.13u
X3547 VSS.t822 VDD VSS.t821 VSS.t820 sg13_lv_nmos ad=0.1428p pd=1.52u as=0 ps=0 w=0.42u l=1u
X3548 VDD VSS.t488 VDD VDD sg13_lv_pmos ad=0.34p pd=2.68u as=0 ps=0 w=1u l=1u
X3549 VDD a_14549_15238# sg13cmos5l_or3_1_2.B VDD sg13_lv_pmos ad=0.2128p pd=1.5u as=0.2128p ps=1.5u w=1.12u l=0.13u
X3550 VDD VSS.t2712 VDD VDD sg13_lv_pmos ad=0.19p pd=1.38u as=0 ps=0 w=1u l=1u
X3551 VSS.t2385 VDD VSS.t2384 VSS.t2383 sg13_lv_nmos ad=0.1428p pd=1.52u as=0 ps=0 w=0.42u l=1u
X3552 VDD VSS.t1505 VDD VDD sg13_lv_pmos ad=0.34p pd=2.68u as=0 ps=0 w=1u l=1u
X3553 sg13cmos5l_buf_16_2.A a_15790_15238# VDD VDD sg13_lv_pmos ad=0.2128p pd=1.5u as=0.2128p ps=1.5u w=1.12u l=0.13u
X3554 VDD VSS.t540 VDD VDD sg13_lv_pmos ad=0.19p pd=1.38u as=0 ps=0 w=1u l=1u
X3555 VDD VSS.t1014 VDD VDD sg13_lv_pmos ad=0.19p pd=1.38u as=0 ps=0 w=1u l=1u
X3556 VDD VSS.t2065 VDD VDD sg13_lv_pmos ad=0.19p pd=1.38u as=0 ps=0 w=1u l=1u
X3557 VSS.t1551 VDD VSS.t1550 VSS.t1549 sg13_lv_nmos ad=0.1428p pd=1.52u as=0 ps=0 w=0.42u l=1u
X3558 VDD VSS.t1510 VDD VDD sg13_lv_pmos ad=0.34p pd=2.68u as=0 ps=0 w=1u l=1u
X3559 VSS.t2700 VDD VSS.t2699 VSS.t2620 sg13_lv_nmos ad=0.1428p pd=1.52u as=0 ps=0 w=0.42u l=1u
X3560 VDD VSS.t2419 VDD VDD sg13_lv_pmos ad=0.34p pd=2.68u as=0 ps=0 w=1u l=1u
X3561 VSS.t2300 VDD VSS.t2302 VSS.t2301 sg13_lv_nmos ad=79.8f pd=0.8u as=0 ps=0 w=0.42u l=1u
X3562 VDD VSS.t135 VDD VDD sg13_lv_pmos ad=0.19p pd=1.38u as=0 ps=0 w=1u l=1u
X3563 VSS.t2450 VDD VSS.t2452 VSS.t2451 sg13_lv_nmos ad=79.8f pd=0.8u as=0 ps=0 w=0.42u l=1u
X3564 a_27706_15202# sg13cmos5l_dfrbpq_1_7.Q VSS.t92 VSS.t2 sg13_lv_nmos ad=0.1428p pd=1.52u as=79.8f ps=0.8u w=0.42u l=0.13u
X3565 VSS.t1196 VDD VSS.t1197 VSS.t224 sg13_lv_nmos ad=79.8f pd=0.8u as=0 ps=0 w=0.42u l=1u
X3566 VSS.t1234 VDD VSS.t1233 VSS.t224 sg13_lv_nmos ad=0.1428p pd=1.52u as=0 ps=0 w=0.42u l=1u
X3567 VDD VSS.t2991 VDD VDD sg13_lv_pmos ad=0.34p pd=2.68u as=0 ps=0 w=1u l=1u
X3568 VDD VSS.t1852 VDD VDD sg13_lv_pmos ad=0.34p pd=2.68u as=0 ps=0 w=1u l=1u
X3569 VSS.t2028 VDD VSS.t2027 VSS.t2026 sg13_lv_nmos ad=0.1428p pd=1.52u as=0 ps=0 w=0.42u l=1u
X3570 a_27311_14845# a_26469_14495# a_26052_14488# VDD sg13_lv_pmos ad=0.2048p pd=1.63u as=0.34p ps=2.68u w=1u l=0.13u
X3571 VSS.t852 VDD VSS.t851 VSS.t850 sg13_lv_nmos ad=0.1428p pd=1.52u as=0 ps=0 w=0.42u l=1u
X3572 VDD VSS.t2367 VDD VDD sg13_lv_pmos ad=0.19p pd=1.38u as=0 ps=0 w=1u l=1u
X3573 VDD VSS.t2025 VDD VDD sg13_lv_pmos ad=0.19p pd=1.38u as=0 ps=0 w=1u l=1u
X3574 VSS.t18 a_15790_15238# sg13cmos5l_buf_16_2.A VSS.t17 sg13_lv_nmos ad=0.1406p pd=1.12u as=0.1406p ps=1.12u w=0.74u l=0.13u
X3575 VSS.t1671 VDD VSS.t1670 VSS.t1669 sg13_lv_nmos ad=0.1428p pd=1.52u as=0 ps=0 w=0.42u l=1u
X3576 VSS.t122 VDD VSS.t421 VSS.t8 sg13_lv_nmos ad=79.8f pd=0.8u as=0 ps=0 w=0.42u l=1u
X3577 VDD VSS.t904 VDD VDD sg13_lv_pmos ad=0.19p pd=1.38u as=0 ps=0 w=1u l=1u
X3578 VSS.t1918 VDD VSS.t1917 VSS.t1916 sg13_lv_nmos ad=0.1428p pd=1.52u as=0 ps=0 w=0.42u l=1u
X3579 VSS.t729 VDD VSS.t187 VSS.t728 sg13_lv_nmos ad=0.1428p pd=1.52u as=0 ps=0 w=0.42u l=1u
X3580 VSS.t641 VDD VSS.t641 VSS.t767 sg13_lv_nmos ad=79.8f pd=0.8u as=0 ps=0 w=0.42u l=1u
X3581 VDD VSS.t1289 VDD VDD sg13_lv_pmos ad=0.19p pd=1.38u as=0 ps=0 w=1u l=1u
X3582 VSS.t3012 VDD VSS.t3011 VSS.t3010 sg13_lv_nmos ad=0.1428p pd=1.52u as=0 ps=0 w=0.42u l=1u
X3583 VDD VSS.t1029 VDD VDD sg13_lv_pmos ad=0.19p pd=1.38u as=0 ps=0 w=1u l=1u
X3584 VSS.t2480 VDD VSS.t2479 VSS.t2478 sg13_lv_nmos ad=0.1428p pd=1.52u as=0 ps=0 w=0.42u l=1u
X3585 VSS.t867 VDD VSS.t869 VSS.t868 sg13_lv_nmos ad=79.8f pd=0.8u as=0 ps=0 w=0.42u l=1u
X3586 VDD VSS.t1483 VDD VDD sg13_lv_pmos ad=0.19p pd=1.38u as=0 ps=0 w=1u l=1u
X3587 VSS.t2893 VDD VSS.t2776 VSS.t2620 sg13_lv_nmos ad=79.8f pd=0.8u as=0 ps=0 w=0.42u l=1u
X3588 VSS.t912 VDD VSS.t914 VSS.t913 sg13_lv_nmos ad=79.8f pd=0.8u as=0 ps=0 w=0.42u l=1u
X3589 VDD VSS.t2392 VDD VDD sg13_lv_pmos ad=0.19p pd=1.38u as=0 ps=0 w=1u l=1u
X3590 VSS.t2280 VDD VSS.t2282 VSS.t2281 sg13_lv_nmos ad=79.8f pd=0.8u as=0 ps=0 w=0.42u l=1u
X3591 VSS.t228 sg13cmos5l_dfrbpq_1_7.RESET_B a_25860_14922# VSS.t227 sg13_lv_nmos ad=0.1626p pd=1.415u as=60.89999f ps=0.71u w=0.42u l=0.13u
X3592 VDD VSS.t779 VDD VDD sg13_lv_pmos ad=0.19p pd=1.38u as=0 ps=0 w=1u l=1u
X3593 VSS.t1998 VDD VSS.t2000 VSS.t1999 sg13_lv_nmos ad=79.8f pd=0.8u as=0 ps=0 w=0.42u l=1u
X3594 VSS.t2739 VDD VSS.t2740 VSS.t2620 sg13_lv_nmos ad=79.8f pd=0.8u as=0 ps=0 w=0.42u l=1u
X3595 sg13cmos5l_buf_16_2.X a_19534_13726# VSS.t710 VSS.t3290 sg13_lv_nmos ad=0.1406p pd=1.12u as=0.1406p ps=1.12u w=0.74u l=0.13u
X3596 VSS.t1501 VDD VSS.t1500 VSS.t1499 sg13_lv_nmos ad=0.1428p pd=1.52u as=0 ps=0 w=0.42u l=1u
X3597 a_3294_15934# a_3095_16071# VSS.t73 VSS.t74 sg13_lv_nmos ad=0.27427p pd=2.28u as=6.38822p ps=41.325u w=0.795u l=0.13u
X3598 VSS.t1180 VDD VSS.t1179 VSS.t224 sg13_lv_nmos ad=0.1428p pd=1.52u as=0 ps=0 w=0.42u l=1u
X3599 VSS.t81 VDD VSS.t483 VSS.t484 sg13_lv_nmos ad=0.1428p pd=1.52u as=0 ps=0 w=0.42u l=1u
X3600 VSS.t533 VDD VSS.t535 VSS.t534 sg13_lv_nmos ad=79.8f pd=0.8u as=0 ps=0 w=0.42u l=1u
X3601 VDD VSS.t1236 VDD VDD sg13_lv_pmos ad=0.34p pd=2.68u as=0 ps=0 w=1u l=1u
X3602 VDD VSS.t2740 VDD VDD sg13_lv_pmos ad=0.34p pd=2.68u as=0 ps=0 w=1u l=1u
X3603 VDD VSS.t2017 VDD VDD sg13_lv_pmos ad=0.34p pd=2.68u as=0 ps=0 w=1u l=1u
X3604 VSS.t882 VDD VSS.t884 VSS.t883 sg13_lv_nmos ad=79.8f pd=0.8u as=0 ps=0 w=0.42u l=1u
X3605 VSS.t625 VDD VSS.t625 VSS.t753 sg13_lv_nmos ad=0.1428p pd=1.52u as=0 ps=0 w=0.42u l=1u
X3606 VSS.t1511 VDD VSS.t1513 VSS.t1512 sg13_lv_nmos ad=79.8f pd=0.8u as=0 ps=0 w=0.42u l=1u
X3607 VSS.t1691 VDD VSS.t1690 VSS.t1689 sg13_lv_nmos ad=0.1428p pd=1.52u as=0 ps=0 w=0.42u l=1u
X3608 VSS.t3042 VDD VSS.t3044 VSS.t3043 sg13_lv_nmos ad=79.8f pd=0.8u as=0 ps=0 w=0.42u l=1u
X3609 VSS.t2245 VDD VSS.t2247 VSS.t2246 sg13_lv_nmos ad=79.8f pd=0.8u as=0 ps=0 w=0.42u l=1u
X3610 VDD VSS.t387 VDD VDD sg13_lv_pmos ad=0.19p pd=1.38u as=0 ps=0 w=1u l=1u
X3611 VSS.t14 clock_i a_15790_15238# VSS.t3251 sg13_lv_nmos ad=0.1406p pd=1.12u as=0.1406p ps=1.12u w=0.74u l=0.13u
X3612 VSS.t609 VDD VSS.t609 VSS.t610 sg13_lv_nmos ad=79.8f pd=0.8u as=0 ps=0 w=0.42u l=1u
X3613 VDD VSS.t1700 VDD VDD sg13_lv_pmos ad=0.34p pd=2.68u as=0 ps=0 w=1u l=1u
X3614 VSS.t707 sg13cmos5l_buf_16_2.A a_19534_13726# VSS.t3318 sg13_lv_nmos ad=0.1406p pd=1.12u as=0.1406p ps=1.12u w=0.74u l=0.13u
X3615 VSS.t2500 VDD VSS.t2499 VSS.t2498 sg13_lv_nmos ad=0.1428p pd=1.52u as=0 ps=0 w=0.42u l=1u
X3616 VSS.t2320 VDD VSS.t2322 VSS.t2321 sg13_lv_nmos ad=79.8f pd=0.8u as=0 ps=0 w=0.42u l=1u
X3617 a_16163_16265# sg13cmos5l_o21ai_1_2.A1 a_16461_16020# VDD sg13_lv_pmos ad=0.34p pd=2.68u as=0.19p ps=1.38u w=1u l=0.13u
X3618 VSS.t21 sg13cmos5l_dfrbpq_1_2.Q a_18200_15238# VSS.t3204 sg13_lv_nmos ad=79.8f pd=0.8u as=0.1428p ps=1.52u w=0.42u l=0.13u
X3619 VSS.t822 VDD VSS.t821 VSS.t820 sg13_lv_nmos ad=0.1428p pd=1.52u as=0 ps=0 w=0.42u l=1u
X3620 VSS.t1252 VDD VSS.t1251 VSS.t224 sg13_lv_nmos ad=0.1428p pd=1.52u as=0 ps=0 w=0.42u l=1u
X3621 VDD VSS.t3109 VDD VDD sg13_lv_pmos ad=0.19p pd=1.38u as=0 ps=0 w=1u l=1u
X3622 VDD VSS.t1530 VDD VDD sg13_lv_pmos ad=0.34p pd=2.68u as=0 ps=0 w=1u l=1u
X3623 VDD VSS.t1224 VDD VDD sg13_lv_pmos ad=0.19p pd=1.38u as=0 ps=0 w=1u l=1u
X3624 VDD sg13cmos5l_dfrbpq_1_3.Q sg13cmos5l_o21ai_1_2.A2 VDD sg13_lv_pmos ad=0.2128p pd=1.5u as=0.2128p ps=1.5u w=1.12u l=0.13u
X3625 VDD VSS.t934 VDD VDD sg13_lv_pmos ad=0.19p pd=1.38u as=0 ps=0 w=1u l=1u
X3626 VSS.t1601 VDD VSS.t1603 VSS.t1602 sg13_lv_nmos ad=79.8f pd=0.8u as=0 ps=0 w=0.42u l=1u
X3627 VDD VSS.t2678 VDD VDD sg13_lv_pmos ad=0.34p pd=2.68u as=0 ps=0 w=1u l=1u
X3628 VDD VSS.t48 VDD VDD sg13_lv_pmos ad=0.19p pd=1.38u as=0 ps=0 w=1u l=1u
X3629 VDD VSS.t1490 VDD VDD sg13_lv_pmos ad=0.34p pd=2.68u as=0 ps=0 w=1u l=1u
X3630 VDD a_12212_15202# sg13cmos5l_dfrbpq_1_2.CLK VDD sg13_lv_pmos ad=0.2128p pd=1.5u as=0.2128p ps=1.5u w=1.12u l=0.13u
X3631 VSS.t1192 VDD VSS.t1192 VSS.t224 sg13_lv_nmos ad=0.1428p pd=1.52u as=0 ps=0 w=0.42u l=1u
X3632 VDD VSS.t1256 VDD VDD sg13_lv_pmos ad=0.19p pd=1.38u as=0 ps=0 w=1u l=1u
X3633 VDD VSS.t2760 VDD VDD sg13_lv_pmos ad=0.19p pd=1.38u as=0 ps=0 w=1u l=1u
X3634 VSS.t73 VDD VSS.t73 VSS.t379 sg13_lv_nmos ad=0.1428p pd=1.52u as=0 ps=0 w=0.42u l=1u
X3635 VDD VSS.t871 VDD VDD sg13_lv_pmos ad=0.34p pd=2.68u as=0 ps=0 w=1u l=1u
X3636 VDD VSS.t1495 VDD VDD sg13_lv_pmos ad=0.34p pd=2.68u as=0 ps=0 w=1u l=1u
X3637 VSS.t2465 VDD VSS.t2464 VSS.t2463 sg13_lv_nmos ad=0.1428p pd=1.52u as=0 ps=0 w=0.42u l=1u
X3638 VDD VSS.t2404 VDD VDD sg13_lv_pmos ad=0.34p pd=2.68u as=0 ps=0 w=1u l=1u
X3639 VDD VSS.t426 VDD VDD sg13_lv_pmos ad=0.19p pd=1.38u as=0 ps=0 w=1u l=1u
X3640 VSS.t852 VDD VSS.t851 VSS.t850 sg13_lv_nmos ad=0.1428p pd=1.52u as=0 ps=0 w=0.42u l=1u
X3641 VSS.t1261 VDD VSS.t1260 VSS.t224 sg13_lv_nmos ad=0.1428p pd=1.52u as=0 ps=0 w=0.42u l=1u
X3642 VSS.t2295 VDD VSS.t2294 VSS.t2293 sg13_lv_nmos ad=0.1428p pd=1.52u as=0 ps=0 w=0.42u l=1u
X3643 sg13cmos5l_or3_1_1.X a_25129_13726# VSS.t187 VSS.t3189 sg13_lv_nmos ad=0.2516p pd=2.16u as=0.13395p ps=1.12u w=0.74u l=0.13u
X3644 VDD VSS.t2976 VDD VDD sg13_lv_pmos ad=0.34p pd=2.68u as=0 ps=0 w=1u l=1u
X3645 VDD VSS.t1837 VDD VDD sg13_lv_pmos ad=0.34p pd=2.68u as=0 ps=0 w=1u l=1u
X3646 VDD VSS.t332 VDD VDD sg13_lv_pmos ad=0.34p pd=2.68u as=0 ps=0 w=1u l=1u
X3647 VDD VSS.t442 VDD VDD sg13_lv_pmos ad=0.19p pd=1.38u as=0 ps=0 w=1u l=1u
X3648 VSS.t2013 VDD VSS.t2012 VSS.t2011 sg13_lv_nmos ad=0.1428p pd=1.52u as=0 ps=0 w=0.42u l=1u
X3649 VSS.t398 VDD VSS.t395 VSS.t397 sg13_lv_nmos ad=0.1428p pd=1.52u as=0 ps=0 w=0.42u l=1u
X3650 VSS.t596 VDD VSS.t595 VSS.t594 sg13_lv_nmos ad=0.1428p pd=1.52u as=0 ps=0 w=0.42u l=1u
X3651 VSS.t1022 VDD VSS.t1021 VSS.t1020 sg13_lv_nmos ad=0.1428p pd=1.52u as=0 ps=0 w=0.42u l=1u
X3652 VDD VSS.t2369 VDD VDD sg13_lv_pmos ad=0.34p pd=2.68u as=0 ps=0 w=1u l=1u
X3653 VSS.t912 VDD VSS.t914 VSS.t913 sg13_lv_nmos ad=79.8f pd=0.8u as=0 ps=0 w=0.42u l=1u
X3654 VDD VSS.t1204 VDD VDD sg13_lv_pmos ad=0.34p pd=2.68u as=0 ps=0 w=1u l=1u
X3655 VSS.t1280 VDD VSS.t1279 VSS.t224 sg13_lv_nmos ad=0.1428p pd=1.52u as=0 ps=0 w=0.42u l=1u
X3656 VSS.t582 VDD VSS.t581 VSS.t580 sg13_lv_nmos ad=0.1428p pd=1.52u as=0 ps=0 w=0.42u l=1u
X3657 VDD VSS.t1880 VDD VDD sg13_lv_pmos ad=0.19p pd=1.38u as=0 ps=0 w=1u l=1u
X3658 VDD VSS.t2719 VDD VDD sg13_lv_pmos ad=0.19p pd=1.38u as=0 ps=0 w=1u l=1u
X3659 VSS.t1561 VDD VSS.t1560 VSS.t1559 sg13_lv_nmos ad=0.1428p pd=1.52u as=0 ps=0 w=0.42u l=1u
X3660 VSS.t2265 VDD VSS.t2267 VSS.t2266 sg13_lv_nmos ad=79.8f pd=0.8u as=0 ps=0 w=0.42u l=1u
X3661 VDD VSS.t641 VDD VDD sg13_lv_pmos ad=0.34p pd=2.68u as=0 ps=0 w=1u l=1u
X3662 VDD VSS.t307 VDD VDD sg13_lv_pmos ad=0.34p pd=2.68u as=0 ps=0 w=1u l=1u
X3663 VSS.t1285 VDD VSS.t1284 VSS.t224 sg13_lv_nmos ad=0.1428p pd=1.52u as=0 ps=0 w=0.42u l=1u
X3664 VDD VSS.t1475 VDD VDD sg13_lv_pmos ad=0.34p pd=2.68u as=0 ps=0 w=1u l=1u
X3665 VDD VSS.t834 VDD VDD sg13_lv_pmos ad=0.19p pd=1.38u as=0 ps=0 w=1u l=1u
X3666 VSS.t2113 VDD VSS.t2115 VSS.t2114 sg13_lv_nmos ad=79.8f pd=0.8u as=0 ps=0 w=0.42u l=1u
X3667 VDD a_12212_15202# sg13cmos5l_dfrbpq_1_2.CLK VDD sg13_lv_pmos ad=0.2128p pd=1.5u as=0.2128p ps=1.5u w=1.12u l=0.13u
X3668 VSS.t1316 VDD VSS.t1316 VSS.t224 sg13_lv_nmos ad=79.8f pd=0.8u as=0 ps=0 w=0.42u l=1u
X3669 VSS.t1556 VDD VSS.t1555 VSS.t1554 sg13_lv_nmos ad=0.1428p pd=1.52u as=0 ps=0 w=0.42u l=1u
X3670 VSS.t2305 VDD VSS.t2307 VSS.t2306 sg13_lv_nmos ad=79.8f pd=0.8u as=0 ps=0 w=0.42u l=1u
X3671 VDD a_4762_14448# a_4481_14750# VDD sg13_lv_pmos ad=0.1523p pd=1.38u as=0.34p ps=2.68u w=1u l=0.5u
X3672 VDD VSS.t430 VDD VDD sg13_lv_pmos ad=0.34p pd=2.68u as=0 ps=0 w=1u l=1u
X3673 VDD VSS.t1227 VDD VDD sg13_lv_pmos ad=0.34p pd=2.68u as=0 ps=0 w=1u l=1u
X3674 VDD VSS.t2731 VDD VDD sg13_lv_pmos ad=0.34p pd=2.68u as=0 ps=0 w=1u l=1u
X3675 VSS.t2033 VDD VSS.t2032 VSS.t2031 sg13_lv_nmos ad=0.1428p pd=1.52u as=0 ps=0 w=0.42u l=1u
X3676 VDD VSS.t2030 VDD VDD sg13_lv_pmos ad=0.19p pd=1.38u as=0 ps=0 w=1u l=1u
X3677 VSS.t1676 VDD VSS.t1675 VSS.t1674 sg13_lv_nmos ad=0.1428p pd=1.52u as=0 ps=0 w=0.42u l=1u
X3678 VSS.t632 VDD VSS.t632 VSS.t634 sg13_lv_nmos ad=79.8f pd=0.8u as=0 ps=0 w=0.42u l=1u
X3679 a_25115_15996# sg13cmos5l_inv_1_0.Y sg13cmos5l_dlygate4sd3_1_15.A VDD sg13_lv_pmos ad=0.2128p pd=1.5u as=0.3808p ps=2.92u w=1.12u l=0.13u
X3680 VDD VSS.t1184 VDD VDD sg13_lv_pmos ad=0.19p pd=1.38u as=0 ps=0 w=1u l=1u
X3681 a_9638_14484# a_9368_14525# VDD VDD sg13_lv_pmos ad=0.34p pd=2.68u as=0.1523p ps=1.38u w=1u l=0.5u
X3682 VDD VSS.t1041 VDD VDD sg13_lv_pmos ad=0.34p pd=2.68u as=0 ps=0 w=1u l=1u
X3683 VSS.t2485 VDD VSS.t2484 VSS.t2483 sg13_lv_nmos ad=0.1428p pd=1.52u as=0 ps=0 w=0.42u l=1u
X3684 a_17482_14452# a_17925_14495# a_17865_14531# VDD sg13_lv_pmos ad=79.8f pd=0.8u as=63f ps=0.72u w=0.42u l=0.13u
X3685 VDD VSS.t1515 VDD VDD sg13_lv_pmos ad=0.34p pd=2.68u as=0 ps=0 w=1u l=1u
X3686 VDD VSS.t1865 VDD VDD sg13_lv_pmos ad=0.19p pd=1.38u as=0 ps=0 w=1u l=1u
X3687 VSS.t2778 VDD VSS.t2779 VSS.t2620 sg13_lv_nmos ad=79.8f pd=0.8u as=0 ps=0 w=0.42u l=1u
X3688 VDD VSS.t2710 VDD VDD sg13_lv_pmos ad=0.19p pd=1.38u as=0 ps=0 w=1u l=1u
X3689 VSS.t1983 VDD VSS.t1982 VSS.t1981 sg13_lv_nmos ad=0.1428p pd=1.52u as=0 ps=0 w=0.42u l=1u
X3690 VDD VSS.t201 VDD VDD sg13_lv_pmos ad=0.19p pd=1.38u as=0 ps=0 w=1u l=1u
X3691 VDD VSS.t801 VDD VDD sg13_lv_pmos ad=0.34p pd=2.68u as=0 ps=0 w=1u l=1u
X3692 VSS.t236 VDD VSS.t236 VSS.t721 sg13_lv_nmos ad=0.1428p pd=1.52u as=0 ps=0 w=0.42u l=1u
X3693 VSS.t1586 VDD VSS.t1588 VSS.t1587 sg13_lv_nmos ad=79.8f pd=0.8u as=0 ps=0 w=0.42u l=1u
X3694 VSS.t2721 VDD VSS.t2722 VSS.t2620 sg13_lv_nmos ad=79.8f pd=0.8u as=0 ps=0 w=0.42u l=1u
X3695 VSS.t1298 VDD VSS.t1297 VSS.t224 sg13_lv_nmos ad=0.1428p pd=1.52u as=0 ps=0 w=0.42u l=1u
X3696 VDD VSS.t2457 VDD VDD sg13_lv_pmos ad=0.19p pd=1.38u as=0 ps=0 w=1u l=1u
X3697 VDD VSS.t916 VDD VDD sg13_lv_pmos ad=0.34p pd=2.68u as=0 ps=0 w=1u l=1u
X3698 VSS.t1506 VDD VSS.t1505 VSS.t1504 sg13_lv_nmos ad=0.1428p pd=1.52u as=0 ps=0 w=0.42u l=1u
X3699 VDD VSS.t2232 VDD VDD sg13_lv_pmos ad=0.19p pd=1.38u as=0 ps=0 w=1u l=1u
X3700 VSS.t2063 VDD VSS.t2065 VSS.t2064 sg13_lv_nmos ad=79.8f pd=0.8u as=0 ps=0 w=0.42u l=1u
X3701 VDD VSS.t446 VDD VDD sg13_lv_pmos ad=0.19p pd=1.38u as=0 ps=0 w=1u l=1u
X3702 VDD VSS.t1239 VDD VDD sg13_lv_pmos ad=0.34p pd=2.68u as=0 ps=0 w=1u l=1u
X3703 VDD VSS.t2022 VDD VDD sg13_lv_pmos ad=0.34p pd=2.68u as=0 ps=0 w=1u l=1u
X3704 VSS.t73 a_3095_16301# a_3095_16301# VSS.t3323 sg13_lv_nmos ad=6.38822p pd=41.325u as=0.111p ps=1.34u w=0.3u l=0.13u
X3705 VDD VSS.t2722 VDD VDD sg13_lv_pmos ad=0.34p pd=2.68u as=0 ps=0 w=1u l=1u
X3706 VSS.t2280 VDD VSS.t2279 VSS.t2278 sg13_lv_nmos ad=0.1428p pd=1.52u as=0 ps=0 w=0.42u l=1u
X3707 VDD VSS.t854 VDD VDD sg13_lv_pmos ad=0.19p pd=1.38u as=0 ps=0 w=1u l=1u
X3708 VSS.t21 VDD VSS.t21 VSS.t487 sg13_lv_nmos ad=0.1428p pd=1.52u as=0 ps=0 w=0.42u l=1u
X3709 VSS.t614 VDD VSS.t614 VSS.t616 sg13_lv_nmos ad=0.1428p pd=1.52u as=0 ps=0 w=0.42u l=1u
X3710 VSS.t3047 VDD VSS.t3049 VSS.t3048 sg13_lv_nmos ad=79.8f pd=0.8u as=0 ps=0 w=0.42u l=1u
X3711 VSS.t2656 VDD VSS.t2658 VSS.t2620 sg13_lv_nmos ad=79.8f pd=0.8u as=0 ps=0 w=0.42u l=1u
X3712 VSS.t2250 VDD VSS.t2252 VSS.t2251 sg13_lv_nmos ad=79.8f pd=0.8u as=0 ps=0 w=0.42u l=1u
X3713 VSS.t185 VDD VSS.t185 VSS.t667 sg13_lv_nmos ad=0.1428p pd=1.52u as=0 ps=0 w=0.42u l=1u
X3714 VDD VSS.t1275 VDD VDD sg13_lv_pmos ad=0.19p pd=1.38u as=0 ps=0 w=1u l=1u
X3715 a_17925_14495# sg13cmos5l_buf_16_2.X VDD VDD sg13_lv_pmos ad=0.4088p pd=2.97u as=2.3367p ps=15.135u w=1.12u l=0.13u
X3716 VDD VSS.t574 VDD VDD sg13_lv_pmos ad=0.19p pd=1.38u as=0 ps=0 w=1u l=1u
X3717 VDD VSS.t816 VDD VDD sg13_lv_pmos ad=0.34p pd=2.68u as=0 ps=0 w=1u l=1u
X3718 VSS.t1022 VDD VSS.t1021 VSS.t1020 sg13_lv_nmos ad=0.1428p pd=1.52u as=0 ps=0 w=0.42u l=1u
X3719 VDD VSS.t1670 VDD VDD sg13_lv_pmos ad=0.34p pd=2.68u as=0 ps=0 w=1u l=1u
X3720 VSS.t1223 VDD VSS.t1224 VSS.t224 sg13_lv_nmos ad=79.8f pd=0.8u as=0 ps=0 w=0.42u l=1u
X3721 VDD VSS.t1535 VDD VDD sg13_lv_pmos ad=0.34p pd=2.68u as=0 ps=0 w=1u l=1u
X3722 VDD VSS.t466 VDD VDD sg13_lv_pmos ad=0.19p pd=1.38u as=0 ps=0 w=1u l=1u
X3723 VSS.t1893 VDD VSS.t1895 VSS.t1894 sg13_lv_nmos ad=79.8f pd=0.8u as=0 ps=0 w=0.42u l=1u
X3724 VDD VSS.t2681 VDD VDD sg13_lv_pmos ad=0.34p pd=2.68u as=0 ps=0 w=1u l=1u
X3725 VSS.t1312 VDD VSS.t1311 VSS.t224 sg13_lv_nmos ad=0.1428p pd=1.52u as=0 ps=0 w=0.42u l=1u
X3726 VDD sg13cmos5l_or3_1_3.X a_24821_15532# VDD sg13_lv_pmos ad=0.2128p pd=1.5u as=0.3808p ps=2.92u w=1.12u l=0.13u
X3727 VSS.t625 VDD VSS.t625 VSS.t752 sg13_lv_nmos ad=79.8f pd=0.8u as=0 ps=0 w=0.42u l=1u
X3728 VSS.t827 VDD VSS.t829 VSS.t828 sg13_lv_nmos ad=79.8f pd=0.8u as=0 ps=0 w=0.42u l=1u
X3729 VDD VSS.t886 VDD VDD sg13_lv_pmos ad=0.34p pd=2.68u as=0 ps=0 w=1u l=1u
X3730 VDD VSS.t1259 VDD VDD sg13_lv_pmos ad=0.19p pd=1.38u as=0 ps=0 w=1u l=1u
X3731 VSS.t1491 VDD VSS.t1490 VSS.t1489 sg13_lv_nmos ad=0.1428p pd=1.52u as=0 ps=0 w=0.42u l=1u
X3732 VSS.t2098 VDD VSS.t2100 VSS.t2099 sg13_lv_nmos ad=79.8f pd=0.8u as=0 ps=0 w=0.42u l=1u
X3733 VDD VSS.t2055 VDD VDD sg13_lv_pmos ad=0.19p pd=1.38u as=0 ps=0 w=1u l=1u
X3734 VDD VSS.t430 VDD VDD sg13_lv_pmos ad=0.34p pd=2.68u as=0 ps=0 w=1u l=1u
X3735 VDD VSS.t1500 VDD VDD sg13_lv_pmos ad=0.34p pd=2.68u as=0 ps=0 w=1u l=1u
X3736 VSS.t2470 VDD VSS.t2469 VSS.t2468 sg13_lv_nmos ad=0.1428p pd=1.52u as=0 ps=0 w=0.42u l=1u
X3737 VSS.t98 sg13cmos5l_or3_1_1.X a_25217_16344# VSS.t97 sg13_lv_nmos ad=0.2516p pd=2.16u as=0.1406p ps=1.12u w=0.74u l=0.13u
X3738 VSS.t2694 VDD VSS.t2693 VSS.t2620 sg13_lv_nmos ad=0.1428p pd=1.52u as=0 ps=0 w=0.42u l=1u
X3739 VDD VSS.t2409 VDD VDD sg13_lv_pmos ad=0.34p pd=2.68u as=0 ps=0 w=1u l=1u
X3740 VDD VSS.t2981 VDD VDD sg13_lv_pmos ad=0.34p pd=2.68u as=0 ps=0 w=1u l=1u
X3741 VSS.t2235 VDD VSS.t2237 VSS.t2236 sg13_lv_nmos ad=79.8f pd=0.8u as=0 ps=0 w=0.42u l=1u
X3742 VSS.t2018 VDD VSS.t2017 VSS.t2016 sg13_lv_nmos ad=0.1428p pd=1.52u as=0 ps=0 w=0.42u l=1u
X3743 VSS.t21 sg13cmos5l_dfrbpq_1_3.RESET_B a_17316_14922# VSS.t3217 sg13_lv_nmos ad=0.1626p pd=1.415u as=60.89999f ps=0.71u w=0.42u l=0.13u
X3744 VDD VSS.t971 VDD VDD sg13_lv_pmos ad=0.34p pd=2.68u as=0 ps=0 w=1u l=1u
X3745 VSS.t1968 VDD VSS.t1970 VSS.t1969 sg13_lv_nmos ad=79.8f pd=0.8u as=0 ps=0 w=0.42u l=1u
X3746 VDD VSS.t1513 VDD VDD sg13_lv_pmos ad=0.19p pd=1.38u as=0 ps=0 w=1u l=1u
X3747 VSS.t2310 VDD VSS.t2312 VSS.t2311 sg13_lv_nmos ad=79.8f pd=0.8u as=0 ps=0 w=0.42u l=1u
X3748 VDD VSS.t2110 VDD VDD sg13_lv_pmos ad=0.19p pd=1.38u as=0 ps=0 w=1u l=1u
X3749 VDD VSS.t109 VDD VDD sg13_lv_pmos ad=0.34p pd=2.68u as=0 ps=0 w=1u l=1u
X3750 a_8302_13911# a_8417_13912# VSS.t46 VSS.t205 sg13_lv_nmos ad=0.1428p pd=1.52u as=0.1426p ps=1.16u w=0.42u l=0.5u
X3751 VDD VSS.t641 VDD VDD sg13_lv_pmos ad=0.34p pd=2.68u as=0 ps=0 w=1u l=1u
X3752 VDD VSS.t1850 VDD VDD sg13_lv_pmos ad=0.19p pd=1.38u as=0 ps=0 w=1u l=1u
X3753 VSS.t2770 VDD VSS.t2771 VSS.t2620 sg13_lv_nmos ad=79.8f pd=0.8u as=0 ps=0 w=0.42u l=1u
X3754 VDD VSS.t2640 VDD VDD sg13_lv_pmos ad=0.19p pd=1.38u as=0 ps=0 w=1u l=1u
X3755 VSS.t641 VDD VSS.t641 VSS.t645 sg13_lv_nmos ad=0.1428p pd=1.52u as=0 ps=0 w=0.42u l=1u
X3756 VSS.t641 VDD VSS.t647 VSS.t769 sg13_lv_nmos ad=79.8f pd=0.8u as=0 ps=0 w=0.42u l=1u
X3757 VDD VSS.t1292 VDD VDD sg13_lv_pmos ad=0.19p pd=1.38u as=0 ps=0 w=1u l=1u
X3758 VSS.t1531 VDD VSS.t1530 VSS.t1529 sg13_lv_nmos ad=0.1428p pd=1.52u as=0 ps=0 w=0.42u l=1u
X3759 VSS.t3062 VDD VSS.t3061 VSS.t3060 sg13_lv_nmos ad=0.1428p pd=1.52u as=0 ps=0 w=0.42u l=1u
X3760 VSS.t2265 VDD VSS.t2264 VSS.t2263 sg13_lv_nmos ad=0.1428p pd=1.52u as=0 ps=0 w=0.42u l=1u
X3761 VDD a_19534_13726# sg13cmos5l_buf_16_2.X VDD sg13_lv_pmos ad=0.2128p pd=1.5u as=0.2128p ps=1.5u w=1.12u l=0.13u
X3762 VSS.t2743 VDD VSS.t2743 VSS.t2620 sg13_lv_nmos ad=0.1428p pd=1.52u as=0 ps=0 w=0.42u l=1u
X3763 VSS.t537 VDD VSS.t537 VSS.t654 sg13_lv_nmos ad=0.1428p pd=1.52u as=0 ps=0 w=0.42u l=1u
X3764 VDD VSS.t1034 VDD VDD sg13_lv_pmos ad=0.19p pd=1.38u as=0 ps=0 w=1u l=1u
X3765 VDD VSS.t345 VDD VDD sg13_lv_pmos ad=0.19p pd=1.38u as=0 ps=0 w=1u l=1u
X3766 VSS.t395 VDD VSS.t395 VSS.t396 sg13_lv_nmos ad=79.8f pd=0.8u as=0 ps=0 w=0.42u l=1u
X3767 sg13cmos5l_dfrbpq_1_7.Q a_27978_14484# VDD VDD sg13_lv_pmos ad=0.3808p pd=2.92u as=0.2128p ps=1.5u w=1.12u l=0.13u
X3768 VDD VSS.t1653 VDD VDD sg13_lv_pmos ad=0.19p pd=1.38u as=0 ps=0 w=1u l=1u
X3769 a_8176_14726# a_7919_14845# a_8338_14922# VSS.t35 sg13_lv_nmos ad=0.1428p pd=1.52u as=37.8f ps=0.6u w=0.42u l=0.13u
X3770 VSS.t126 a_27760_13942# a_27409_13799# VSS.t125 sg13_lv_nmos ad=79.8f pd=0.8u as=0.1428p ps=1.52u w=0.42u l=0.13u
X3771 VDD VSS.t2007 VDD VDD sg13_lv_pmos ad=0.34p pd=2.68u as=0 ps=0 w=1u l=1u
X3772 VSS.t473 VDD VSS.t102 VSS.t472 sg13_lv_nmos ad=0.1428p pd=1.52u as=0 ps=0 w=0.42u l=1u
X3773 VDD a_10991_15311# a_11658_15532# VDD sg13_lv_pmos ad=0.2128p pd=1.5u as=0.3864p ps=2.93u w=1.12u l=0.13u
X3774 VDD VSS.t1302 VDD VDD sg13_lv_pmos ad=0.19p pd=1.38u as=0 ps=0 w=1u l=1u
X3775 VDD VSS.t574 VDD VDD sg13_lv_pmos ad=0.19p pd=1.38u as=0 ps=0 w=1u l=1u
X3776 a_26842_15202# sg13cmos5l_dlygate4sd3_1_15.A VDD VDD sg13_lv_pmos ad=0.1428p pd=1.52u as=0.1523p ps=1.38u w=0.42u l=0.13u
X3777 VSS.t1333 VDD VSS.t1332 VSS.t224 sg13_lv_nmos ad=0.1428p pd=1.52u as=0 ps=0 w=0.42u l=1u
X3778 VSS.t1282 VDD VSS.t1283 VSS.t224 sg13_lv_nmos ad=79.8f pd=0.8u as=0 ps=0 w=0.42u l=1u
X3779 VDD VSS.t2272 VDD VDD sg13_lv_pmos ad=0.19p pd=1.38u as=0 ps=0 w=1u l=1u
X3780 VSS.t2455 VDD VSS.t2454 VSS.t2453 sg13_lv_nmos ad=0.1428p pd=1.52u as=0 ps=0 w=0.42u l=1u
X3781 VSS.t932 VDD VSS.t934 VSS.t933 sg13_lv_nmos ad=79.8f pd=0.8u as=0 ps=0 w=0.42u l=1u
X3782 VDD VSS.t1520 VDD VDD sg13_lv_pmos ad=0.34p pd=2.68u as=0 ps=0 w=1u l=1u
X3783 a_26340_14909# a_26571_14495# a_26026_14452# VSS.t204 sg13_lv_nmos ad=0.2373p pd=1.97u as=79.8f ps=0.8u w=0.42u l=0.13u
X3784 VDD VSS.t1001 VDD VDD sg13_lv_pmos ad=0.34p pd=2.68u as=0 ps=0 w=1u l=1u
X3785 VSS.t2762 VDD VSS.t2763 VSS.t2620 sg13_lv_nmos ad=79.8f pd=0.8u as=0 ps=0 w=0.42u l=1u
X3786 VSS.t1878 VDD VSS.t1880 VSS.t1879 sg13_lv_nmos ad=79.8f pd=0.8u as=0 ps=0 w=0.42u l=1u
X3787 a_25766_14922# sg13cmos5l_dfrbpq_1_7.D VDD VDD sg13_lv_pmos ad=79.8f pd=0.8u as=0.1428p ps=1.52u w=0.42u l=0.13u
X3788 VDD a_19534_13726# sg13cmos5l_buf_16_2.X VDD sg13_lv_pmos ad=0.2128p pd=1.5u as=0.2128p ps=1.5u w=1.12u l=0.13u
X3789 VSS.t827 VDD VSS.t829 VSS.t828 sg13_lv_nmos ad=79.8f pd=0.8u as=0 ps=0 w=0.42u l=1u
X3790 VDD VSS.t1560 VDD VDD sg13_lv_pmos ad=0.34p pd=2.68u as=0 ps=0 w=1u l=1u
X3791 VDD VSS.t153 VDD VDD sg13_lv_pmos ad=0.34p pd=2.68u as=0 ps=0 w=1u l=1u
X3792 a_23762_14850# sg13cmos5l_dfrbpq_1_6.Q VSS.t10 VSS.t7 sg13_lv_nmos ad=0.1406p pd=1.12u as=0.2886p ps=2.26u w=0.74u l=0.13u
X3793 VSS.t1591 VDD VSS.t1593 VSS.t1592 sg13_lv_nmos ad=79.8f pd=0.8u as=0 ps=0 w=0.42u l=1u
X3794 VSS.t2724 VDD VSS.t2725 VSS.t2620 sg13_lv_nmos ad=79.8f pd=0.8u as=0 ps=0 w=0.42u l=1u
X3795 sg13cmos5l_dlygate4sd3_1_8.X a_18582_15302# VDD VDD sg13_lv_pmos ad=0.4256p pd=3u as=0.2254p ps=1.53u w=1.12u l=0.13u
X3796 VDD sg13cmos5l_dfrbpq_1_0.RESET_B a_2822_15234# VDD sg13_lv_pmos ad=0.36237p pd=2.605u as=79.8f ps=0.8u w=0.42u l=0.13u
X3797 VSS.t1476 VDD VSS.t1475 VSS.t1474 sg13_lv_nmos ad=0.1428p pd=1.52u as=0 ps=0 w=0.42u l=1u
X3798 a_12524_15960# sg13cmos5l_dlygate4sd3_1_11.A VDD VDD sg13_lv_pmos ad=0.2856p pd=2.36u as=0.2114p ps=1.54u w=0.84u l=0.13u
X3799 a_24265_14508# sg13cmos5l_o21ai_1_2.A1 VSS.t199 VSS.t7 sg13_lv_nmos ad=0.198p pd=1.27u as=0.1045p ps=0.93u w=0.55u l=0.13u
X3800 VSS.t582 VDD VSS.t581 VSS.t580 sg13_lv_nmos ad=0.1428p pd=1.52u as=0 ps=0 w=0.42u l=1u
X3801 VDD VSS.t1250 VDD VDD sg13_lv_pmos ad=0.19p pd=1.38u as=0 ps=0 w=1u l=1u
X3802 VSS.t2068 VDD VSS.t2070 VSS.t2069 sg13_lv_nmos ad=79.8f pd=0.8u as=0 ps=0 w=0.42u l=1u
X3803 VSS.t77 VDD VSS.t466 VSS.t467 sg13_lv_nmos ad=0.1428p pd=1.52u as=0 ps=0 w=0.42u l=1u
X3804 a_17529_14037# a_16587_13844# a_17327_13799# VDD sg13_lv_pmos ad=93.45f pd=0.865u as=0.2048p ps=1.63u w=0.42u l=0.13u
X3805 VDD sg13cmos5l_xnor2_1_0.Y a_3512_16037# VDD sg13_lv_pmos ad=0.1523p pd=1.38u as=0.1428p ps=1.52u w=0.42u l=0.13u
X3806 sg13cmos5l_nor2_1_3.B a_16140_14750# VDD VDD sg13_lv_pmos ad=0.2408p pd=1.55u as=0.3808p ps=2.92u w=1.12u l=0.13u
X3807 VDD VSS.t1220 VDD VDD sg13_lv_pmos ad=0.34p pd=2.68u as=0 ps=0 w=1u l=1u
X3808 VDD VSS.t2725 VDD VDD sg13_lv_pmos ad=0.34p pd=2.68u as=0 ps=0 w=1u l=1u
X3809 VSS.t2285 VDD VSS.t2284 VSS.t2283 sg13_lv_nmos ad=0.1428p pd=1.52u as=0 ps=0 w=0.42u l=1u
X3810 VDD VSS.t1992 VDD VDD sg13_lv_pmos ad=0.34p pd=2.68u as=0 ps=0 w=1u l=1u
X3811 VSS.t382 VDD VSS.t73 VSS.t381 sg13_lv_nmos ad=0.1428p pd=1.52u as=0 ps=0 w=0.42u l=1u
X3812 VSS.t2742 VDD VSS.t2741 VSS.t2620 sg13_lv_nmos ad=0.1428p pd=1.52u as=0 ps=0 w=0.42u l=1u
X3813 VDD VSS.t1910 VDD VDD sg13_lv_pmos ad=0.19p pd=1.38u as=0 ps=0 w=1u l=1u
X3814 VSS.t1953 VDD VSS.t1955 VSS.t1954 sg13_lv_nmos ad=79.8f pd=0.8u as=0 ps=0 w=0.42u l=1u
X3815 VDD a_8176_14726# a_8121_14607# VDD sg13_lv_pmos ad=2.42015p pd=15.68u as=93.45f ps=0.865u w=0.42u l=0.13u
X3816 VSS.t1264 VDD VSS.t1263 VSS.t224 sg13_lv_nmos ad=0.1428p pd=1.52u as=0 ps=0 w=0.42u l=1u
X3817 VDD VSS.t1675 VDD VDD sg13_lv_pmos ad=0.34p pd=2.68u as=0 ps=0 w=1u l=1u
X3818 VDD VSS.t2257 VDD VDD sg13_lv_pmos ad=0.19p pd=1.38u as=0 ps=0 w=1u l=1u
X3819 VSS.t2475 VDD VSS.t2474 VSS.t2473 sg13_lv_nmos ad=0.1428p pd=1.52u as=0 ps=0 w=0.42u l=1u
X3820 VSS.t2295 VDD VSS.t2297 VSS.t2296 sg13_lv_nmos ad=79.8f pd=0.8u as=0 ps=0 w=0.42u l=1u
X3821 VDD VSS.t2095 VDD VDD sg13_lv_pmos ad=0.19p pd=1.38u as=0 ps=0 w=1u l=1u
X3822 VDD VSS.t2047 VDD VDD sg13_lv_pmos ad=0.34p pd=2.68u as=0 ps=0 w=1u l=1u
X3823 VSS.t1863 VDD VSS.t1865 VSS.t1864 sg13_lv_nmos ad=79.8f pd=0.8u as=0 ps=0 w=0.42u l=1u
X3824 a_6634_14452# a_7077_14495# a_7017_14531# VDD sg13_lv_pmos ad=79.8f pd=0.8u as=63f ps=0.72u w=0.42u l=0.13u
X3825 VDD VSS.t3179 VDD VDD sg13_lv_pmos ad=0.19p pd=1.38u as=0 ps=0 w=1u l=1u
X3826 VDD VSS.t2684 VDD VDD sg13_lv_pmos ad=0.34p pd=2.68u as=0 ps=0 w=1u l=1u
X3827 VSS.t2735 VDD VSS.t2734 VSS.t2620 sg13_lv_nmos ad=0.1428p pd=1.52u as=0 ps=0 w=0.42u l=1u
X3828 VSS.t523 VDD VSS.t522 VSS.t521 sg13_lv_nmos ad=0.1428p pd=1.52u as=0 ps=0 w=0.42u l=1u
X3829 VDD sg13cmos5l_buf_16_2.A a_19534_13726# VDD sg13_lv_pmos ad=0.2128p pd=1.5u as=0.2128p ps=1.5u w=1.12u l=0.13u
X3830 VDD VSS.t891 VDD VDD sg13_lv_pmos ad=0.34p pd=2.68u as=0 ps=0 w=1u l=1u
X3831 VSS.t185 VDD VSS.t185 VSS.t666 sg13_lv_nmos ad=79.8f pd=0.8u as=0 ps=0 w=0.42u l=1u
X3832 VSS.t2103 VDD VSS.t2105 VSS.t2104 sg13_lv_nmos ad=79.8f pd=0.8u as=0 ps=0 w=0.42u l=1u
X3833 sg13cmos5l_dfrbpq_1_7.Q a_27978_14484# VSS.t92 VSS.t2 sg13_lv_nmos ad=0.2516p pd=2.16u as=0.1406p ps=1.12u w=0.74u l=0.13u
X3834 VDD VSS.t1505 VDD VDD sg13_lv_pmos ad=0.34p pd=2.68u as=0 ps=0 w=1u l=1u
X3835 VDD VSS.t2414 VDD VDD sg13_lv_pmos ad=0.34p pd=2.68u as=0 ps=0 w=1u l=1u
X3836 VDD VSS.t312 VDD VDD sg13_lv_pmos ad=0.34p pd=2.68u as=0 ps=0 w=1u l=1u
X3837 VDD VSS.t450 VDD VDD sg13_lv_pmos ad=0.19p pd=1.38u as=0 ps=0 w=1u l=1u
X3838 a_27418_12936# sg13cmos5l_dlygate4sd3_1_20.A VDD VDD sg13_lv_pmos ad=0.1428p pd=1.52u as=0.1523p ps=1.38u w=0.42u l=0.13u
X3839 VSS.t1606 VDD VSS.t1605 VSS.t1604 sg13_lv_nmos ad=0.1428p pd=1.52u as=0 ps=0 w=0.42u l=1u
X3840 VDD VSS.t2362 VDD VDD sg13_lv_pmos ad=0.19p pd=1.38u as=0 ps=0 w=1u l=1u
X3841 VSS.t2023 VDD VSS.t2022 VSS.t2021 sg13_lv_nmos ad=0.1428p pd=1.52u as=0 ps=0 w=0.42u l=1u
X3842 VSS.t92 VDD VSS.t92 VSS.t2 sg13_lv_nmos ad=0.1428p pd=1.52u as=0 ps=0 w=0.42u l=1u
X3843 VSS.t2733 VDD VSS.t2731 VSS.t2620 sg13_lv_nmos ad=0.1428p pd=1.52u as=0 ps=0 w=0.42u l=1u
X3844 VDD a_15790_15238# sg13cmos5l_buf_16_2.A VDD sg13_lv_pmos ad=0.2128p pd=1.5u as=0.2128p ps=1.5u w=1.12u l=0.13u
X3845 VSS.t902 VDD VSS.t904 VSS.t903 sg13_lv_nmos ad=79.8f pd=0.8u as=0 ps=0 w=0.42u l=1u
X3846 VSS.t932 VDD VSS.t934 VSS.t933 sg13_lv_nmos ad=79.8f pd=0.8u as=0 ps=0 w=0.42u l=1u
X3847 VDD VSS.t1216 VDD VDD sg13_lv_pmos ad=0.34p pd=2.68u as=0 ps=0 w=1u l=1u
X3848 VDD VSS.t2080 VDD VDD sg13_lv_pmos ad=0.19p pd=1.38u as=0 ps=0 w=1u l=1u
X3849 a_6886_14909# sg13cmos5l_dfrbpq_1_1.RESET_B VSS.t77 VSS.t212 sg13_lv_nmos ad=37.8f pd=0.6u as=0.1701p ps=1.65u w=0.42u l=0.13u
X3850 VDD VSS.t430 VDD VDD sg13_lv_pmos ad=0.19p pd=1.38u as=0 ps=0 w=1u l=1u
X3851 a_7354_13690# sg13cmos5l_dlygate4sd3_1_1.A VSS.t69 VSS.t3184 sg13_lv_nmos ad=0.1428p pd=1.52u as=79.8f ps=0.8u w=0.42u l=0.13u
X3852 VDD VSS.t1855 VDD VDD sg13_lv_pmos ad=0.19p pd=1.38u as=0 ps=0 w=1u l=1u
X3853 VDD VSS.t2643 VDD VDD sg13_lv_pmos ad=0.19p pd=1.38u as=0 ps=0 w=1u l=1u
X3854 VDD VSS.t2704 VDD VDD sg13_lv_pmos ad=0.19p pd=1.38u as=0 ps=0 w=1u l=1u
X3855 VSS.t1898 VDD VSS.t1900 VSS.t1899 sg13_lv_nmos ad=79.8f pd=0.8u as=0 ps=0 w=0.42u l=1u
X3856 VSS.t1536 VDD VSS.t1535 VSS.t1534 sg13_lv_nmos ad=0.1428p pd=1.52u as=0 ps=0 w=0.42u l=1u
X3857 VSS.t3067 VDD VSS.t3066 VSS.t3065 sg13_lv_nmos ad=0.1428p pd=1.52u as=0 ps=0 w=0.42u l=1u
X3858 VSS.t2270 VDD VSS.t2269 VSS.t2268 sg13_lv_nmos ad=0.1428p pd=1.52u as=0 ps=0 w=0.42u l=1u
X3859 VSS.t446 VDD VSS.t450 VSS.t2 sg13_lv_nmos ad=79.8f pd=0.8u as=0 ps=0 w=0.42u l=1u
X3860 VSS.t2440 VDD VSS.t2442 VSS.t2441 sg13_lv_nmos ad=79.8f pd=0.8u as=0 ps=0 w=0.42u l=1u
X3861 a_9732_15552# a_9706_15457# VDD VDD sg13_lv_pmos ad=0.34p pd=2.68u as=0.36237p ps=2.605u w=1u l=0.13u
X3862 VSS.t609 VDD VSS.t609 VSS.t742 sg13_lv_nmos ad=79.8f pd=0.8u as=0 ps=0 w=0.42u l=1u
X3863 VDD VSS.t1254 VDD VDD sg13_lv_pmos ad=0.19p pd=1.38u as=0 ps=0 w=1u l=1u
X3864 VSS.t2345 VDD VSS.t2344 VSS.t2343 sg13_lv_nmos ad=0.1428p pd=1.52u as=0 ps=0 w=0.42u l=1u
X3865 VSS.t2715 VDD VSS.t2716 VSS.t2620 sg13_lv_nmos ad=79.8f pd=0.8u as=0 ps=0 w=0.42u l=1u
X3866 VDD VSS.t2447 VDD VDD sg13_lv_pmos ad=0.19p pd=1.38u as=0 ps=0 w=1u l=1u
X3867 a_18470_15238# a_18200_15238# VSS.t21 VSS.t161 sg13_lv_nmos ad=0.1428p pd=1.52u as=79.8f ps=0.8u w=0.42u l=0.5u
X3868 VSS.t1202 VDD VSS.t1203 VSS.t224 sg13_lv_nmos ad=79.8f pd=0.8u as=0 ps=0 w=0.42u l=1u
X3869 a_26052_14488# a_26571_14495# a_27311_14845# VSS.t2 sg13_lv_nmos ad=0.3473p pd=2.71u as=0.12665p ps=1.145u w=0.74u l=0.13u
X3870 VDD VSS.t201 VDD VDD sg13_lv_pmos ad=0.19p pd=1.38u as=0 ps=0 w=1u l=1u
X3871 VSS.t2053 VDD VSS.t2055 VSS.t2054 sg13_lv_nmos ad=79.8f pd=0.8u as=0 ps=0 w=0.42u l=1u
X3872 sg13cmos5l_o21ai_1_2.A2 sg13cmos5l_dfrbpq_1_2.Q VDD VDD sg13_lv_pmos ad=0.3808p pd=2.92u as=0.2128p ps=1.5u w=1.12u l=0.13u
X3873 VDD VSS.t1212 VDD VDD sg13_lv_pmos ad=0.34p pd=2.68u as=0 ps=0 w=1u l=1u
X3874 VDD VSS.t2716 VDD VDD sg13_lv_pmos ad=0.34p pd=2.68u as=0 ps=0 w=1u l=1u
X3875 a_17508_14488# a_17482_14452# VDD VDD sg13_lv_pmos ad=0.34p pd=2.68u as=0.36237p ps=2.605u w=1u l=0.13u
X3876 VSS.t2008 VDD VSS.t2007 VSS.t2006 sg13_lv_nmos ad=0.1428p pd=1.52u as=0 ps=0 w=0.42u l=1u
X3877 VSS.t641 VDD VSS.t641 VSS.t644 sg13_lv_nmos ad=79.8f pd=0.8u as=0 ps=0 w=0.42u l=1u
X3878 VSS.t2650 VDD VSS.t2652 VSS.t2620 sg13_lv_nmos ad=79.8f pd=0.8u as=0 ps=0 w=0.42u l=1u
X3879 sg13cmos5l_nand4_1_0.Y sg13cmos5l_xor2_1_1.A VDD VDD sg13_lv_pmos ad=0.2128p pd=1.5u as=0.2128p ps=1.5u w=1.12u l=0.13u
X3880 VSS.t1291 VDD VSS.t1289 VSS.t224 sg13_lv_nmos ad=0.1428p pd=1.52u as=0 ps=0 w=0.42u l=1u
X3881 VDD VSS.t2072 VDD VDD sg13_lv_pmos ad=0.34p pd=2.68u as=0 ps=0 w=1u l=1u
X3882 VDD VSS.t446 VDD VDD sg13_lv_pmos ad=0.19p pd=1.38u as=0 ps=0 w=1u l=1u
X3883 VDD VSS.t1269 VDD VDD sg13_lv_pmos ad=0.34p pd=2.68u as=0 ps=0 w=1u l=1u
X3884 VDD VSS.t2771 VDD VDD sg13_lv_pmos ad=0.34p pd=2.68u as=0 ps=0 w=1u l=1u
X3885 VDD clock_i a_15790_15238# VDD sg13_lv_pmos ad=0.2128p pd=1.5u as=0.2128p ps=1.5u w=1.12u l=0.13u
X3886 a_16175_14854# sg13cmos5l_xnor2_1_1.A VSS.t14 VSS.t213 sg13_lv_nmos ad=0.2516p pd=2.16u as=0.1898p ps=1.36u w=0.74u l=0.13u
X3887 VSS.t620 VDD VSS.t620 VSS.t619 sg13_lv_nmos ad=0.1428p pd=1.52u as=0 ps=0 w=0.42u l=1u
X3888 VSS.t2460 VDD VSS.t2459 VSS.t2458 sg13_lv_nmos ad=0.1428p pd=1.52u as=0 ps=0 w=0.42u l=1u
X3889 VDD VSS.t1525 VDD VDD sg13_lv_pmos ad=0.34p pd=2.68u as=0 ps=0 w=1u l=1u
X3890 VDD VSS.t2242 VDD VDD sg13_lv_pmos ad=0.19p pd=1.38u as=0 ps=0 w=1u l=1u
X3891 VSS.t2882 VDD VSS.t2765 VSS.t2620 sg13_lv_nmos ad=79.8f pd=0.8u as=0 ps=0 w=0.42u l=1u
X3892 VDD VSS.t2032 VDD VDD sg13_lv_pmos ad=0.34p pd=2.68u as=0 ps=0 w=1u l=1u
X3893 VSS.t1848 VDD VSS.t1850 VSS.t1849 sg13_lv_nmos ad=79.8f pd=0.8u as=0 ps=0 w=0.42u l=1u
X3894 VDD VSS.t799 VDD VDD sg13_lv_pmos ad=0.19p pd=1.38u as=0 ps=0 w=1u l=1u
X3895 VDD VSS.t1530 VDD VDD sg13_lv_pmos ad=0.34p pd=2.68u as=0 ps=0 w=1u l=1u
X3896 VDD VSS.t3164 VDD VDD sg13_lv_pmos ad=0.19p pd=1.38u as=0 ps=0 w=1u l=1u
X3897 a_21252_14909# a_20964_14488# a_21190_14909# VSS.t91 sg13_lv_nmos ad=0.1428p pd=1.52u as=37.8f ps=0.6u w=0.42u l=0.13u
X3898 VDD VSS.t2675 VDD VDD sg13_lv_pmos ad=0.34p pd=2.68u as=0 ps=0 w=1u l=1u
X3899 VSS.t887 VDD VSS.t886 VSS.t885 sg13_lv_nmos ad=0.1428p pd=1.52u as=0 ps=0 w=0.42u l=1u
X3900 VSS.t135 a_12212_15202# sg13cmos5l_dfrbpq_1_2.CLK VSS.t137 sg13_lv_nmos ad=0.1406p pd=1.12u as=0.1406p ps=1.12u w=0.74u l=0.13u
X3901 VDD VSS.t450 VDD VDD sg13_lv_pmos ad=0.19p pd=1.38u as=0 ps=0 w=1u l=1u
X3902 VSS.t2898 VDD VSS.t2779 VSS.t2620 sg13_lv_nmos ad=0.1428p pd=1.52u as=0 ps=0 w=0.42u l=1u
X3903 VDD VSS.t1490 VDD VDD sg13_lv_pmos ad=0.34p pd=2.68u as=0 ps=0 w=1u l=1u
X3904 VDD VSS.t2399 VDD VDD sg13_lv_pmos ad=0.34p pd=2.68u as=0 ps=0 w=1u l=1u
X3905 VSS.t625 VDD VSS.t625 VSS.t627 sg13_lv_nmos ad=0.1428p pd=1.52u as=0 ps=0 w=0.42u l=1u
X3906 VSS.t2290 VDD VSS.t2289 VSS.t2288 sg13_lv_nmos ad=0.1428p pd=1.52u as=0 ps=0 w=0.42u l=1u
X3907 a_16596_14832# sg13cmos5l_o21ai_1_2.A1 a_16140_14750# VSS.t260 sg13_lv_nmos ad=78.39999f pd=0.885u as=0.2176p ps=1.96u w=0.64u l=0.13u
X3908 VSS.t625 VDD VSS.t755 VSS.t754 sg13_lv_nmos ad=79.8f pd=0.8u as=0 ps=0 w=0.42u l=1u
X3909 VSS.t902 VDD VSS.t904 VSS.t903 sg13_lv_nmos ad=79.8f pd=0.8u as=0 ps=0 w=0.42u l=1u
X3910 VDD a_21934_15423# sg13cmos5l_or3_1_2.A VDD sg13_lv_pmos ad=0.2254p pd=1.53u as=0.4256p ps=3u w=1.12u l=0.13u
X3911 VDD VSS.t530 VDD VDD sg13_lv_pmos ad=0.19p pd=1.38u as=0 ps=0 w=1u l=1u
X3912 VDD VSS.t593 VDD VDD sg13_lv_pmos ad=0.19p pd=1.38u as=0 ps=0 w=1u l=1u
X3913 VDD VSS.t1915 VDD VDD sg13_lv_pmos ad=0.19p pd=1.38u as=0 ps=0 w=1u l=1u
X3914 VSS.t2724 VDD VSS.t2723 VSS.t2620 sg13_lv_nmos ad=0.1428p pd=1.52u as=0 ps=0 w=0.42u l=1u
X3915 VSS.t1958 VDD VSS.t1960 VSS.t1959 sg13_lv_nmos ad=79.8f pd=0.8u as=0 ps=0 w=0.42u l=1u
X3916 VDD VSS.t814 VDD VDD sg13_lv_pmos ad=0.19p pd=1.38u as=0 ps=0 w=1u l=1u
X3917 VSS.t1235 VDD VSS.t1236 VSS.t224 sg13_lv_nmos ad=79.8f pd=0.8u as=0 ps=0 w=0.42u l=1u
X3918 VDD VSS.t2234 VDD VDD sg13_lv_pmos ad=0.34p pd=2.68u as=0 ps=0 w=1u l=1u
X3919 VDD VSS.t12 VDD VDD sg13_lv_pmos ad=0.34p pd=2.68u as=0 ps=0 w=1u l=1u
X3920 VSS.t1199 VDD VSS.t1198 VSS.t224 sg13_lv_nmos ad=0.1428p pd=1.52u as=0 ps=0 w=0.42u l=1u
X3921 VDD VSS.t2636 VDD VDD sg13_lv_pmos ad=0.19p pd=1.38u as=0 ps=0 w=1u l=1u
X3922 VDD VSS.t411 VDD VDD sg13_lv_pmos ad=0.34p pd=2.68u as=0 ps=0 w=1u l=1u
X3923 VSS.t1521 VDD VSS.t1520 VSS.t1519 sg13_lv_nmos ad=0.1428p pd=1.52u as=0 ps=0 w=0.42u l=1u
X3924 VSS.t3052 VDD VSS.t3051 VSS.t3050 sg13_lv_nmos ad=0.1428p pd=1.52u as=0 ps=0 w=0.42u l=1u
X3925 VSS.t2255 VDD VSS.t2254 VSS.t2253 sg13_lv_nmos ad=0.1428p pd=1.52u as=0 ps=0 w=0.42u l=1u
X3926 VSS.t1868 VDD VSS.t1870 VSS.t1869 sg13_lv_nmos ad=79.8f pd=0.8u as=0 ps=0 w=0.42u l=1u
X3927 VSS.t636 VDD VSS.t636 VSS.t761 sg13_lv_nmos ad=79.8f pd=0.8u as=0 ps=0 w=0.42u l=1u
X3928 VSS.t1163 VDD VSS.t1164 VSS.t224 sg13_lv_nmos ad=79.8f pd=0.8u as=0 ps=0 w=0.42u l=1u
X3929 VDD sg13cmos5l_dlygate4sd3_1_18.X a_25115_15996# VDD sg13_lv_pmos ad=0.2128p pd=1.5u as=0.2128p ps=1.5u w=1.12u l=0.13u
X3930 VSS.t73 VDD VSS.t73 VSS.t380 sg13_lv_nmos ad=79.8f pd=0.8u as=0 ps=0 w=0.42u l=1u
X3931 a_9732_15552# a_9706_15457# VSS.t106 VSS.t117 sg13_lv_nmos ad=0.2516p pd=2.16u as=0.1626p ps=1.415u w=0.74u l=0.13u
X3932 VDD VSS.t546 VDD VDD sg13_lv_pmos ad=0.19p pd=1.38u as=0 ps=0 w=1u l=1u
X3933 VDD VSS.t614 VDD VDD sg13_lv_pmos ad=0.19p pd=1.38u as=0 ps=0 w=1u l=1u
X3934 VDD VSS.t1244 VDD VDD sg13_lv_pmos ad=0.19p pd=1.38u as=0 ps=0 w=1u l=1u
X3935 VDD VSS.t2748 VDD VDD sg13_lv_pmos ad=0.19p pd=1.38u as=0 ps=0 w=1u l=1u
X3936 VDD VSS.t1475 VDD VDD sg13_lv_pmos ad=0.34p pd=2.68u as=0 ps=0 w=1u l=1u
X3937 VSS.t2665 VDD VSS.t2667 VSS.t2620 sg13_lv_nmos ad=79.8f pd=0.8u as=0 ps=0 w=0.42u l=1u
X3938 VDD VSS.t2384 VDD VDD sg13_lv_pmos ad=0.34p pd=2.68u as=0 ps=0 w=1u l=1u
X3939 VSS.t2445 VDD VSS.t2444 VSS.t2443 sg13_lv_nmos ad=0.1428p pd=1.52u as=0 ps=0 w=0.42u l=1u
X3940 VDD VSS.t335 VDD VDD sg13_lv_pmos ad=0.19p pd=1.38u as=0 ps=0 w=1u l=1u
X3941 VSS.t132 a_12212_15202# sg13cmos5l_dfrbpq_1_2.CLK VSS.t131 sg13_lv_nmos ad=0.1406p pd=1.12u as=0.1406p ps=1.12u w=0.74u l=0.13u
X3942 sg13cmos5l_or3_1_2.X a_21865_13726# VDD VDD sg13_lv_pmos ad=0.3808p pd=2.92u as=0.3822p ps=1.84u w=1.12u l=0.13u
X3943 VSS.t2275 VDD VSS.t2274 VSS.t2273 sg13_lv_nmos ad=0.1428p pd=1.52u as=0 ps=0 w=0.42u l=1u
X3944 VDD VSS.t561 VDD VDD sg13_lv_pmos ad=0.34p pd=2.68u as=0 ps=0 w=1u l=1u
X3945 VSS.t917 VDD VSS.t916 VSS.t915 sg13_lv_nmos ad=0.1428p pd=1.52u as=0 ps=0 w=0.42u l=1u
X3946 VDD VSS.t1895 VDD VDD sg13_lv_pmos ad=0.19p pd=1.38u as=0 ps=0 w=1u l=1u
X3947 VSS.t1611 VDD VSS.t1610 VSS.t1609 sg13_lv_nmos ad=0.1428p pd=1.52u as=0 ps=0 w=0.42u l=1u
X3948 VSS.t1993 VDD VSS.t1992 VSS.t1991 sg13_lv_nmos ad=0.1428p pd=1.52u as=0 ps=0 w=0.42u l=1u
X3949 VSS.t434 VDD VSS.t434 VSS.t2 sg13_lv_nmos ad=79.8f pd=0.8u as=0 ps=0 w=0.42u l=1u
X3950 VDD VSS.t969 VDD VDD sg13_lv_pmos ad=0.19p pd=1.38u as=0 ps=0 w=1u l=1u
X3951 VSS.t1217 VDD VSS.t1216 VSS.t224 sg13_lv_nmos ad=0.1428p pd=1.52u as=0 ps=0 w=0.42u l=1u
X3952 VSS.t2736 VDD VSS.t2735 VSS.t2620 sg13_lv_nmos ad=0.1428p pd=1.52u as=0 ps=0 w=0.42u l=1u
X3953 VDD VSS.t2302 VDD VDD sg13_lv_pmos ad=0.19p pd=1.38u as=0 ps=0 w=1u l=1u
X3954 a_17222_14922# sg13cmos5l_dfrbpq_1_3.D VDD VDD sg13_lv_pmos ad=79.8f pd=0.8u as=0.1428p ps=1.52u w=0.42u l=0.13u
X3955 VDD VSS.t398 VDD VDD sg13_lv_pmos ad=0.34p pd=2.68u as=0 ps=0 w=1u l=1u
X3956 VDD VSS.t1260 VDD VDD sg13_lv_pmos ad=0.34p pd=2.68u as=0 ps=0 w=1u l=1u
X3957 VDD VSS.t2057 VDD VDD sg13_lv_pmos ad=0.34p pd=2.68u as=0 ps=0 w=1u l=1u
X3958 VSS.t476 VDD VSS.t132 VSS.t475 sg13_lv_nmos ad=0.1428p pd=1.52u as=0 ps=0 w=0.42u l=1u
X3959 VDD VSS.t2427 VDD VDD sg13_lv_pmos ad=0.19p pd=1.38u as=0 ps=0 w=1u l=1u
X3960 VDD VSS.t2085 VDD VDD sg13_lv_pmos ad=0.19p pd=1.38u as=0 ps=0 w=1u l=1u
X3961 VSS.t1908 VDD VSS.t1910 VSS.t1909 sg13_lv_nmos ad=79.8f pd=0.8u as=0 ps=0 w=0.42u l=1u
X3962 VDD VSS.t1860 VDD VDD sg13_lv_pmos ad=0.19p pd=1.38u as=0 ps=0 w=1u l=1u
X3963 VDD VSS.t2707 VDD VDD sg13_lv_pmos ad=0.19p pd=1.38u as=0 ps=0 w=1u l=1u
X3964 VDD sg13cmos5l_xor2_1_0.X a_8600_15238# VDD sg13_lv_pmos ad=0.1523p pd=1.38u as=0.1428p ps=1.52u w=0.42u l=0.13u
X3965 VSS.t620 VDD VSS.t620 VSS.t747 sg13_lv_nmos ad=0.1428p pd=1.52u as=0 ps=0 w=0.42u l=1u
X3966 VSS.t1541 VDD VSS.t1540 VSS.t1539 sg13_lv_nmos ad=0.1428p pd=1.52u as=0 ps=0 w=0.42u l=1u
X3967 VSS.t2755 VDD VSS.t2757 VSS.t2620 sg13_lv_nmos ad=79.8f pd=0.8u as=0 ps=0 w=0.42u l=1u
X3968 VDD VSS.t2627 VDD VDD sg13_lv_pmos ad=0.19p pd=1.38u as=0 ps=0 w=1u l=1u
X3969 VSS.t2240 VDD VSS.t2239 VSS.t2238 sg13_lv_nmos ad=0.1428p pd=1.52u as=0 ps=0 w=0.42u l=1u
X3970 VSS.t887 VDD VSS.t886 VSS.t885 sg13_lv_nmos ad=0.1428p pd=1.52u as=0 ps=0 w=0.42u l=1u
X3971 VSS.t1253 VDD VSS.t1254 VSS.t224 sg13_lv_nmos ad=79.8f pd=0.8u as=0 ps=0 w=0.42u l=1u
X3972 VSS.t193 VDD VSS.t193 VSS.t405 sg13_lv_nmos ad=79.8f pd=0.8u as=0 ps=0 w=0.42u l=1u
X3973 VDD VSS.t844 VDD VDD sg13_lv_pmos ad=0.19p pd=1.38u as=0 ps=0 w=1u l=1u
X3974 VDD VSS.t1515 VDD VDD sg13_lv_pmos ad=0.34p pd=2.68u as=0 ps=0 w=1u l=1u
X3975 a_3108_15552# a_3082_15457# VDD VDD sg13_lv_pmos ad=0.34p pd=2.68u as=0.36237p ps=2.605u w=1u l=0.13u
X3976 VDD VSS.t620 VDD VDD sg13_lv_pmos ad=0.19p pd=1.38u as=0 ps=0 w=1u l=1u
X3977 VSS.t2315 VDD VSS.t2314 VSS.t2313 sg13_lv_nmos ad=0.1428p pd=1.52u as=0 ps=0 w=0.42u l=1u
X3978 VSS.t2678 VDD VSS.t2679 VSS.t2620 sg13_lv_nmos ad=79.8f pd=0.8u as=0 ps=0 w=0.42u l=1u
X3979 VDD VSS.t1723 VDD VDD sg13_lv_pmos ad=0.19p pd=1.38u as=0 ps=0 w=1u l=1u
X3980 VDD VSS.t3019 VDD VDD sg13_lv_pmos ad=0.19p pd=1.38u as=0 ps=0 w=1u l=1u
X3981 VSS.t2754 VDD VSS.t2755 VSS.t2620 sg13_lv_nmos ad=79.8f pd=0.8u as=0 ps=0 w=0.42u l=1u
X3982 VDD a_17925_14495# a_18027_14495# VDD sg13_lv_pmos ad=2.42015p pd=15.68u as=0.3864p ps=2.93u w=1.12u l=0.13u
X3983 VDD VSS.t530 VDD VDD sg13_lv_pmos ad=0.19p pd=1.38u as=0 ps=0 w=1u l=1u
X3984 VDD VSS.t593 VDD VDD sg13_lv_pmos ad=0.19p pd=1.38u as=0 ps=0 w=1u l=1u
X3985 VDD VSS.t936 VDD VDD sg13_lv_pmos ad=0.34p pd=2.68u as=0 ps=0 w=1u l=1u
X3986 VSS.t523 VDD VSS.t522 VSS.t521 sg13_lv_nmos ad=0.1428p pd=1.52u as=0 ps=0 w=0.42u l=1u
X3987 VSS.t2653 VDD VSS.t2655 VSS.t2620 sg13_lv_nmos ad=79.8f pd=0.8u as=0 ps=0 w=0.42u l=1u
X3988 a_24821_15532# sg13cmos5l_dlygate4sd3_1_19.X VDD VDD sg13_lv_pmos ad=0.2128p pd=1.5u as=0.2128p ps=1.5u w=1.12u l=0.13u
X3989 VDD VSS.t2077 VDD VDD sg13_lv_pmos ad=0.34p pd=2.68u as=0 ps=0 w=1u l=1u
X3990 a_26244_14040# a_26218_13945# VSS.t297 VSS.t296 sg13_lv_nmos ad=0.2516p pd=2.16u as=0.1626p ps=1.415u w=0.74u l=0.13u
X3991 VDD VSS.t1251 VDD VDD sg13_lv_pmos ad=0.34p pd=2.68u as=0 ps=0 w=1u l=1u
X3992 VDD VSS.t2755 VDD VDD sg13_lv_pmos ad=0.34p pd=2.68u as=0 ps=0 w=1u l=1u
X3993 VSS.t3037 VDD VSS.t3039 VSS.t3038 sg13_lv_nmos ad=79.8f pd=0.8u as=0 ps=0 w=0.42u l=1u
X3994 VDD VSS.t367 VDD VDD sg13_lv_pmos ad=0.19p pd=1.38u as=0 ps=0 w=1u l=1u
X3995 VSS.t187 sg13cmos5l_o21ai_1_3.A2 a_25129_13726# VSS.t233 sg13_lv_nmos ad=0.1045p pd=0.93u as=0.187p ps=1.78u w=0.55u l=0.13u
X3996 VDD VSS.t284 VDD VDD sg13_lv_pmos ad=0.19p pd=1.38u as=0 ps=0 w=1u l=1u
X3997 VDD VSS.t2247 VDD VDD sg13_lv_pmos ad=0.19p pd=1.38u as=0 ps=0 w=1u l=1u
X3998 VDD VSS.t434 VDD VDD sg13_lv_pmos ad=0.19p pd=1.38u as=0 ps=0 w=1u l=1u
X3999 VDD VSS.t999 VDD VDD sg13_lv_pmos ad=0.19p pd=1.38u as=0 ps=0 w=1u l=1u
X4000 VDD VSS.t2037 VDD VDD sg13_lv_pmos ad=0.34p pd=2.68u as=0 ps=0 w=1u l=1u
X4001 VSS.t236 VDD VSS.t236 VSS.t602 sg13_lv_nmos ad=0.1428p pd=1.52u as=0 ps=0 w=0.42u l=1u
X4002 VSS.t1853 VDD VSS.t1855 VSS.t1854 sg13_lv_nmos ad=79.8f pd=0.8u as=0 ps=0 w=0.42u l=1u
X4003 VDD VSS.t1535 VDD VDD sg13_lv_pmos ad=0.34p pd=2.68u as=0 ps=0 w=1u l=1u
X4004 VDD VSS.t3169 VDD VDD sg13_lv_pmos ad=0.19p pd=1.38u as=0 ps=0 w=1u l=1u
X4005 VSS.t2652 VDD VSS.t2653 VSS.t2620 sg13_lv_nmos ad=79.8f pd=0.8u as=0 ps=0 w=0.42u l=1u
X4006 VSS.t365 VDD VSS.t219 VSS.t364 sg13_lv_nmos ad=0.1428p pd=1.52u as=0 ps=0 w=0.42u l=1u
X4007 a_6660_14488# a_6634_14452# VSS.t77 VSS.t246 sg13_lv_nmos ad=0.2516p pd=2.16u as=0.1626p ps=1.415u w=0.74u l=0.13u
X4008 a_20938_14452# a_21381_14495# a_20678_14922# VSS.t5 sg13_lv_nmos ad=79.8f pd=0.8u as=0.1296p ps=1.52u w=0.42u l=0.13u
X4009 VSS.t185 a_8698_13690# a_8417_13912# VSS.t184 sg13_lv_nmos ad=79.8f pd=0.8u as=0.1428p ps=1.52u w=0.42u l=0.5u
X4010 VDD VSS.t1872 VDD VDD sg13_lv_pmos ad=0.34p pd=2.68u as=0 ps=0 w=1u l=1u
X4011 VDD VSS.t2713 VDD VDD sg13_lv_pmos ad=0.34p pd=2.68u as=0 ps=0 w=1u l=1u
X4012 VSS.t917 VDD VSS.t916 VSS.t915 sg13_lv_nmos ad=0.1428p pd=1.52u as=0 ps=0 w=0.42u l=1u
X4013 VSS.t2882 VDD VSS.t2764 VSS.t2620 sg13_lv_nmos ad=0.1428p pd=1.52u as=0 ps=0 w=0.42u l=1u
X4014 sg13cmos5l_dlygate4sd3_1_5.A a_5034_15532# VSS.t44 VSS.t159 sg13_lv_nmos ad=0.2516p pd=2.16u as=0.1406p ps=1.12u w=0.74u l=0.13u
X4015 a_8338_14922# sg13cmos5l_dfrbpq_1_1.RESET_B VSS.t37 VSS.t211 sg13_lv_nmos ad=37.8f pd=0.6u as=79.8f ps=0.8u w=0.42u l=0.13u
X4016 VDD VSS.t561 VDD VDD sg13_lv_pmos ad=0.34p pd=2.68u as=0 ps=0 w=1u l=1u
X4017 VDD VSS.t899 VDD VDD sg13_lv_pmos ad=0.19p pd=1.38u as=0 ps=0 w=1u l=1u
X4018 VSS.t185 VDD VSS.t185 VSS.t553 sg13_lv_nmos ad=0.1428p pd=1.52u as=0 ps=0 w=0.42u l=1u
X4019 VSS.t2260 VDD VSS.t2259 VSS.t2258 sg13_lv_nmos ad=0.1428p pd=1.52u as=0 ps=0 w=0.42u l=1u
X4020 VSS.t1276 VDD VSS.t1275 VSS.t224 sg13_lv_nmos ad=0.1428p pd=1.52u as=0 ps=0 w=0.42u l=1u
X4021 VDD VSS.t1292 VDD VDD sg13_lv_pmos ad=0.19p pd=1.38u as=0 ps=0 w=1u l=1u
X4022 VSS.t1596 VDD VSS.t1595 VSS.t1594 sg13_lv_nmos ad=0.1428p pd=1.52u as=0 ps=0 w=0.42u l=1u
X4023 VSS.t2644 VDD VSS.t2646 VSS.t2620 sg13_lv_nmos ad=79.8f pd=0.8u as=0 ps=0 w=0.42u l=1u
X4024 VSS.t2727 VDD VSS.t2725 VSS.t2620 sg13_lv_nmos ad=0.1428p pd=1.52u as=0 ps=0 w=0.42u l=1u
X4025 VDD VSS.t2464 VDD VDD sg13_lv_pmos ad=0.34p pd=2.68u as=0 ps=0 w=1u l=1u
X4026 VSS.t1963 VDD VSS.t1965 VSS.t1964 sg13_lv_nmos ad=79.8f pd=0.8u as=0 ps=0 w=0.42u l=1u
X4027 VDD VSS.t2661 VDD VDD sg13_lv_pmos ad=0.19p pd=1.38u as=0 ps=0 w=1u l=1u
X4028 VSS.t2300 VDD VSS.t2299 VSS.t2298 sg13_lv_nmos ad=0.1428p pd=1.52u as=0 ps=0 w=0.42u l=1u
X4029 VDD VSS.t836 VDD VDD sg13_lv_pmos ad=0.34p pd=2.68u as=0 ps=0 w=1u l=1u
X4030 VDD VSS.t2964 VDD VDD sg13_lv_pmos ad=0.19p pd=1.38u as=0 ps=0 w=1u l=1u
X4031 VSS.t1319 VDD VSS.t1318 VSS.t224 sg13_lv_nmos ad=0.1428p pd=1.52u as=0 ps=0 w=0.42u l=1u
X4032 VDD VSS.t2412 VDD VDD sg13_lv_pmos ad=0.19p pd=1.38u as=0 ps=0 w=1u l=1u
X4033 VDD VSS.t2070 VDD VDD sg13_lv_pmos ad=0.19p pd=1.38u as=0 ps=0 w=1u l=1u
X4034 VSS.t2073 VDD VSS.t2072 VSS.t2071 sg13_lv_nmos ad=0.1428p pd=1.52u as=0 ps=0 w=0.42u l=1u
X4035 VDD VSS.t774 VDD VDD sg13_lv_pmos ad=0.19p pd=1.38u as=0 ps=0 w=1u l=1u
X4036 sg13cmos5l_xnor2_1_1.A sg13cmos5l_dlygate4sd3_1_8.X VSS.t104 VSS.t3194 sg13_lv_nmos ad=0.2516p pd=2.16u as=0.2516p ps=2.16u w=0.74u l=0.13u
X4037 VDD VSS.t1845 VDD VDD sg13_lv_pmos ad=0.19p pd=1.38u as=0 ps=0 w=1u l=1u
X4038 VDD VSS.t2364 VDD VDD sg13_lv_pmos ad=0.34p pd=2.68u as=0 ps=0 w=1u l=1u
X4039 a_21381_14495# sg13cmos5l_buf_16_2.X VDD VDD sg13_lv_pmos ad=0.4088p pd=2.97u as=2.3367p ps=15.135u w=1.12u l=0.13u
X4040 VSS.t1526 VDD VSS.t1525 VSS.t1524 sg13_lv_nmos ad=0.1428p pd=1.52u as=0 ps=0 w=0.42u l=1u
X4041 VSS.t318 VDD VSS.t317 VSS.t316 sg13_lv_nmos ad=0.1428p pd=1.52u as=0 ps=0 w=0.42u l=1u
X4042 VSS.t387 VDD VSS.t382 VSS.t386 sg13_lv_nmos ad=0.1428p pd=1.52u as=0 ps=0 w=0.42u l=1u
X4043 VDD VSS.t434 VDD VDD sg13_lv_pmos ad=0.19p pd=1.38u as=0 ps=0 w=1u l=1u
X4044 VDD VSS.t889 VDD VDD sg13_lv_pmos ad=0.19p pd=1.38u as=0 ps=0 w=1u l=1u
X4045 VDD VSS.t1940 VDD VDD sg13_lv_pmos ad=0.19p pd=1.38u as=0 ps=0 w=1u l=1u
X4046 a_3108_15552# a_3082_15457# VSS.t61 VSS.t60 sg13_lv_nmos ad=0.2516p pd=2.16u as=0.1626p ps=1.415u w=0.74u l=0.13u
X4047 VDD VSS.t1185 VDD VDD sg13_lv_pmos ad=0.34p pd=2.68u as=0 ps=0 w=1u l=1u
X4048 VSS.t54 a_26661_13701# a_26763_13844# VSS.t53 sg13_lv_nmos ad=10.4325p pd=68.31u as=0.2516p ps=2.16u w=0.74u l=0.13u
X4049 VDD VSS.t614 VDD VDD sg13_lv_pmos ad=0.34p pd=2.68u as=0 ps=0 w=1u l=1u
X4050 VSS.t2893 VDD VSS.t2774 VSS.t2620 sg13_lv_nmos ad=0.1428p pd=1.52u as=0 ps=0 w=0.42u l=1u
X4051 VSS.t2669 VDD VSS.t2670 VSS.t2620 sg13_lv_nmos ad=79.8f pd=0.8u as=0 ps=0 w=0.42u l=1u
X4052 VDD VSS.t1653 VDD VDD sg13_lv_pmos ad=0.19p pd=1.38u as=0 ps=0 w=1u l=1u
X4053 VDD VSS.t718 VDD VDD sg13_lv_pmos ad=0.19p pd=1.38u as=0 ps=0 w=1u l=1u
X4054 VDD VSS.t1708 VDD VDD sg13_lv_pmos ad=0.19p pd=1.38u as=0 ps=0 w=1u l=1u
X4055 VSS.t712 VDD VSS.t710 VSS.t711 sg13_lv_nmos ad=0.1428p pd=1.52u as=0 ps=0 w=0.42u l=1u
X4056 VSS.t216 sg13cmos5l_a21oi_1_0.Y a_16760_16037# VSS.t3263 sg13_lv_nmos ad=79.8f pd=0.8u as=0.1428p ps=1.52u w=0.42u l=0.13u
X4057 VDD VSS.t2307 VDD VDD sg13_lv_pmos ad=0.19p pd=1.38u as=0 ps=0 w=1u l=1u
X4058 a_17710_16263# a_17825_16262# VSS.t63 VSS.t220 sg13_lv_nmos ad=0.1428p pd=1.52u as=0.1426p ps=1.16u w=0.42u l=0.5u
X4059 a_24054_15242# sg13cmos5l_dfrbpq_1_2.Q sg13cmos5l_o21ai_1_3.A2 VSS.t8 sg13_lv_nmos ad=0.1406p pd=1.12u as=0.2516p ps=2.16u w=0.74u l=0.13u
X4060 VDD VSS.t438 VDD VDD sg13_lv_pmos ad=0.19p pd=1.38u as=0 ps=0 w=1u l=1u
X4061 VDD VSS.t2432 VDD VDD sg13_lv_pmos ad=0.19p pd=1.38u as=0 ps=0 w=1u l=1u
X4062 VDD VSS.t2090 VDD VDD sg13_lv_pmos ad=0.19p pd=1.38u as=0 ps=0 w=1u l=1u
X4063 VSS.t1913 VDD VSS.t1915 VSS.t1914 sg13_lv_nmos ad=79.8f pd=0.8u as=0 ps=0 w=0.42u l=1u
X4064 VSS.t641 VDD VSS.t647 VSS.t646 sg13_lv_nmos ad=79.8f pd=0.8u as=0 ps=0 w=0.42u l=1u
X4065 VSS.t228 a_26446_15423# sg13cmos5l_dfrbpq_1_5.D VSS.t281 sg13_lv_nmos ad=0.1426p pd=1.16u as=0.2516p ps=2.16u w=0.74u l=0.13u
X4066 VSS.t61 sg13cmos5l_xnor2_1_0.A a_3029_14854# VSS.t3229 sg13_lv_nmos ad=0.1898p pd=1.36u as=0.2516p ps=2.16u w=0.74u l=0.13u
X4067 VSS.t42 sg13cmos5l_dfrbpq_1_6.RESET_B a_20772_14922# VSS.t172 sg13_lv_nmos ad=0.1626p pd=1.415u as=60.89999f ps=0.71u w=0.42u l=0.13u
X4068 VSS.t236 sg13cmos5l_or3_1_2.C a_21865_13726# VSS.t3260 sg13_lv_nmos ad=0.1045p pd=0.93u as=0.187p ps=1.78u w=0.55u l=0.13u
X4069 VSS.t797 VDD VSS.t799 VSS.t798 sg13_lv_nmos ad=79.8f pd=0.8u as=0 ps=0 w=0.42u l=1u
X4070 VDD VSS.t2630 VDD VDD sg13_lv_pmos ad=0.19p pd=1.38u as=0 ps=0 w=1u l=1u
X4071 VSS.t2245 VDD VSS.t2244 VSS.t2243 sg13_lv_nmos ad=0.1428p pd=1.52u as=0 ps=0 w=0.42u l=1u
X4072 VDD VSS.t856 VDD VDD sg13_lv_pmos ad=0.34p pd=2.68u as=0 ps=0 w=1u l=1u
X4073 VSS.t3042 VDD VSS.t3041 VSS.t3040 sg13_lv_nmos ad=0.1428p pd=1.52u as=0 ps=0 w=0.42u l=1u
X4074 VSS.t2415 VDD VSS.t2417 VSS.t2416 sg13_lv_nmos ad=79.8f pd=0.8u as=0 ps=0 w=0.42u l=1u
X4075 VDD VSS.t1520 VDD VDD sg13_lv_pmos ad=0.34p pd=2.68u as=0 ps=0 w=1u l=1u
X4076 VSS.t2643 VDD VSS.t2644 VSS.t2620 sg13_lv_nmos ad=79.8f pd=0.8u as=0 ps=0 w=0.42u l=1u
X4077 sg13cmos5l_dfrbpq_1_1.D sg13cmos5l_inv_1_0.Y VSS.t77 VSS.t271 sg13_lv_nmos ad=0.1406p pd=1.12u as=0.2516p ps=2.16u w=0.74u l=0.13u
X4078 VSS.t1214 VDD VSS.t1215 VSS.t224 sg13_lv_nmos ad=79.8f pd=0.8u as=0 ps=0 w=0.42u l=1u
X4079 VSS.t2320 VDD VSS.t2319 VSS.t2318 sg13_lv_nmos ad=0.1428p pd=1.52u as=0 ps=0 w=0.42u l=1u
X4080 VSS.t1581 VDD VSS.t1583 VSS.t1582 sg13_lv_nmos ad=79.8f pd=0.8u as=0 ps=0 w=0.42u l=1u
X4081 VSS.t469 a_11248_15454# a_10897_15311# VSS.t3324 sg13_lv_nmos ad=79.8f pd=0.8u as=0.1428p ps=1.52u w=0.42u l=0.13u
X4082 VDD VSS.t1857 VDD VDD sg13_lv_pmos ad=0.34p pd=2.68u as=0 ps=0 w=1u l=1u
X4083 VDD VSS.t201 VDD VDD sg13_lv_pmos ad=0.19p pd=1.38u as=0 ps=0 w=1u l=1u
X4084 sg13cmos5l_buf_16_2.X a_19534_13726# VSS.t715 VSS.t3302 sg13_lv_nmos ad=0.1406p pd=1.12u as=0.1406p ps=1.12u w=0.74u l=0.13u
X4085 VDD VSS.t2705 VDD VDD sg13_lv_pmos ad=0.34p pd=2.68u as=0 ps=0 w=1u l=1u
X4086 VSS.t601 VDD VSS.t600 VSS.t599 sg13_lv_nmos ad=0.1428p pd=1.52u as=0 ps=0 w=0.42u l=1u
X4087 VSS.t892 VDD VSS.t891 VSS.t890 sg13_lv_nmos ad=0.1428p pd=1.52u as=0 ps=0 w=0.42u l=1u
X4088 VDD VSS.t3024 VDD VDD sg13_lv_pmos ad=0.19p pd=1.38u as=0 ps=0 w=1u l=1u
X4089 VSS.t2757 VDD VSS.t2758 VSS.t2620 sg13_lv_nmos ad=79.8f pd=0.8u as=0 ps=0 w=0.42u l=1u
X4090 VDD VSS.t1885 VDD VDD sg13_lv_pmos ad=0.19p pd=1.38u as=0 ps=0 w=1u l=1u
X4091 VSS.t1219 VDD VSS.t1220 VSS.t224 sg13_lv_nmos ad=79.8f pd=0.8u as=0 ps=0 w=0.42u l=1u
X4092 VSS.t812 VDD VSS.t814 VSS.t813 sg13_lv_nmos ad=79.8f pd=0.8u as=0 ps=0 w=0.42u l=1u
X4093 sg13cmos5l_buf_16_2.X a_19534_13726# VDD VDD sg13_lv_pmos ad=0.2128p pd=1.5u as=0.2128p ps=1.5u w=1.12u l=0.13u
X4094 VSS.t2637 VDD VSS.t2638 VSS.t2620 sg13_lv_nmos ad=79.8f pd=0.8u as=0 ps=0 w=0.42u l=1u
X4095 VDD VSS.t2449 VDD VDD sg13_lv_pmos ad=0.34p pd=2.68u as=0 ps=0 w=1u l=1u
X4096 VSS.t1948 VDD VSS.t1950 VSS.t1949 sg13_lv_nmos ad=79.8f pd=0.8u as=0 ps=0 w=0.42u l=1u
X4097 VDD VSS.t629 VDD VDD sg13_lv_pmos ad=0.34p pd=2.68u as=0 ps=0 w=1u l=1u
X4098 VDD VSS.t1254 VDD VDD sg13_lv_pmos ad=0.34p pd=2.68u as=0 ps=0 w=1u l=1u
X4099 VDD VSS.t2758 VDD VDD sg13_lv_pmos ad=0.34p pd=2.68u as=0 ps=0 w=1u l=1u
X4100 VSS.t21 a_15790_15238# sg13cmos5l_buf_16_2.A VSS.t27 sg13_lv_nmos ad=0.1406p pd=1.12u as=0.1406p ps=1.12u w=0.74u l=0.13u
X4101 VSS.t442 VDD VSS.t442 VSS.t2 sg13_lv_nmos ad=0.1428p pd=1.52u as=0 ps=0 w=0.42u l=1u
X4102 VDD VSS.t2252 VDD VDD sg13_lv_pmos ad=0.19p pd=1.38u as=0 ps=0 w=1u l=1u
X4103 a_16314_14484# sg13cmos5l_o21ai_1_2.A1 sg13cmos5l_nor2_1_3.B VDD sg13_lv_pmos ad=0.1428p pd=1.375u as=0.2408p ps=1.55u w=1.12u l=0.13u
X4104 VDD VSS.t819 VDD VDD sg13_lv_pmos ad=0.19p pd=1.38u as=0 ps=0 w=1u l=1u
X4105 VDD VSS.t2349 VDD VDD sg13_lv_pmos ad=0.34p pd=2.68u as=0 ps=0 w=1u l=1u
X4106 VSS.t2435 VDD VSS.t2437 VSS.t2436 sg13_lv_nmos ad=79.8f pd=0.8u as=0 ps=0 w=0.42u l=1u
X4107 VSS.t1858 VDD VSS.t1860 VSS.t1859 sg13_lv_nmos ad=79.8f pd=0.8u as=0 ps=0 w=0.42u l=1u
X4108 VSS.t2636 VDD VSS.t2637 VSS.t2620 sg13_lv_nmos ad=79.8f pd=0.8u as=0 ps=0 w=0.42u l=1u
X4109 VDD sg13cmos5l_buf_1_0.X a_2880_14523# VDD sg13_lv_pmos ad=0.2891p pd=1.695u as=0.1596p ps=1.22u w=0.84u l=0.13u
X4110 VDD sg13cmos5l_buf_16_2.A a_19534_13726# VDD sg13_lv_pmos ad=0.2128p pd=1.5u as=0.2128p ps=1.5u w=1.12u l=0.13u
X4111 VDD VSS.t1322 VDD VDD sg13_lv_pmos ad=0.19p pd=1.38u as=0 ps=0 w=1u l=1u
X4112 VDD VSS.t2102 VDD VDD sg13_lv_pmos ad=0.34p pd=2.68u as=0 ps=0 w=1u l=1u
X4113 VDD VSS.t1925 VDD VDD sg13_lv_pmos ad=0.19p pd=1.38u as=0 ps=0 w=1u l=1u
X4114 VSS.t193 VDD VSS.t193 VSS.t407 sg13_lv_nmos ad=0.1428p pd=1.52u as=0 ps=0 w=0.42u l=1u
X4115 VDD VSS.t1877 VDD VDD sg13_lv_pmos ad=0.34p pd=2.68u as=0 ps=0 w=1u l=1u
X4116 VDD VSS.t2717 VDD VDD sg13_lv_pmos ad=0.34p pd=2.68u as=0 ps=0 w=1u l=1u
X4117 VSS.t636 VDD VSS.t636 VSS.t638 sg13_lv_nmos ad=0.1428p pd=1.52u as=0 ps=0 w=0.42u l=1u
X4118 a_27418_12936# sg13cmos5l_dlygate4sd3_1_20.A VSS.t126 VSS.t191 sg13_lv_nmos ad=0.1428p pd=1.52u as=79.8f ps=0.8u w=0.42u l=0.13u
X4119 VSS.t636 VDD VSS.t54 VSS.t763 sg13_lv_nmos ad=79.8f pd=0.8u as=0 ps=0 w=0.42u l=1u
X4120 VSS.t1166 VDD VSS.t1166 VSS.t224 sg13_lv_nmos ad=79.8f pd=0.8u as=0 ps=0 w=0.42u l=1u
X4121 VSS.t2885 VDD VSS.t2766 VSS.t2620 sg13_lv_nmos ad=0.1428p pd=1.52u as=0 ps=0 w=0.42u l=1u
X4122 VDD VSS.t2637 VDD VDD sg13_lv_pmos ad=0.34p pd=2.68u as=0 ps=0 w=1u l=1u
X4123 VDD VSS.t2050 VDD VDD sg13_lv_pmos ad=0.19p pd=1.38u as=0 ps=0 w=1u l=1u
X4124 VSS.t44 VDD VSS.t44 VSS.t464 sg13_lv_nmos ad=0.1428p pd=1.52u as=0 ps=0 w=0.42u l=1u
X4125 VDD a_2540_15960# counter_value_o[0] VDD sg13_lv_pmos ad=0.2114p pd=1.54u as=0.42p ps=2.99u w=1.12u l=0.13u
X4126 VSS.t967 VDD VSS.t969 VSS.t968 sg13_lv_nmos ad=79.8f pd=0.8u as=0 ps=0 w=0.42u l=1u
X4127 VSS.t2902 VDD VSS.t2904 VSS.t2903 sg13_lv_nmos ad=79.8f pd=0.8u as=0 ps=0 w=0.42u l=1u
X4128 VDD VSS.t1036 VDD VDD sg13_lv_pmos ad=0.34p pd=2.68u as=0 ps=0 w=1u l=1u
X4129 VSS.t1721 VDD VSS.t1723 VSS.t1722 sg13_lv_nmos ad=79.8f pd=0.8u as=0 ps=0 w=0.42u l=1u
X4130 VSS.t2730 VDD VSS.t2729 VSS.t2620 sg13_lv_nmos ad=0.1428p pd=1.52u as=0 ps=0 w=0.42u l=1u
X4131 VDD VSS.t2469 VDD VDD sg13_lv_pmos ad=0.34p pd=2.68u as=0 ps=0 w=1u l=1u
X4132 VSS.t1933 VDD VSS.t1935 VSS.t1934 sg13_lv_nmos ad=79.8f pd=0.8u as=0 ps=0 w=0.42u l=1u
X4133 sg13cmos5l_or3_1_2.B a_14549_15238# VSS.t83 VSS.t84 sg13_lv_nmos ad=0.1406p pd=1.12u as=0.1406p ps=1.12u w=0.74u l=0.13u
X4134 VDD VSS.t21 VDD VDD sg13_lv_pmos ad=0.34p pd=2.68u as=0 ps=0 w=1u l=1u
X4135 VSS.t86 clock_i a_15790_15238# VSS.t3246 sg13_lv_nmos ad=0.1406p pd=1.12u as=0.1406p ps=1.12u w=0.74u l=0.13u
X4136 VDD VSS.t2075 VDD VDD sg13_lv_pmos ad=0.19p pd=1.38u as=0 ps=0 w=1u l=1u
X4137 VSS.t2078 VDD VSS.t2077 VSS.t2076 sg13_lv_nmos ad=0.1428p pd=1.52u as=0 ps=0 w=0.42u l=1u
X4138 VDD a_20974_15423# sg13cmos5l_dlygate4sd3_1_13.X VDD sg13_lv_pmos ad=0.2254p pd=1.53u as=0.4256p ps=3u w=1.12u l=0.13u
X4139 VDD VSS.t426 VDD VDD sg13_lv_pmos ad=0.19p pd=1.38u as=0 ps=0 w=1u l=1u
X4140 VSS.t797 VDD VSS.t799 VSS.t798 sg13_lv_nmos ad=79.8f pd=0.8u as=0 ps=0 w=0.42u l=1u
X4141 VDD VSS.t786 VDD VDD sg13_lv_pmos ad=0.34p pd=2.68u as=0 ps=0 w=1u l=1u
X4142 VDD VSS.t1563 VDD VDD sg13_lv_pmos ad=0.19p pd=1.38u as=0 ps=0 w=1u l=1u
X4143 a_26244_14040# a_26218_13945# VDD VDD sg13_lv_pmos ad=0.34p pd=2.68u as=0.36237p ps=2.605u w=1u l=0.13u
X4144 VDD VSS.t193 VDD VDD sg13_lv_pmos ad=0.34p pd=2.68u as=0 ps=0 w=1u l=1u
X4145 VSS.t733 VDD VSS.t297 VSS.t732 sg13_lv_nmos ad=0.1428p pd=1.52u as=0 ps=0 w=0.42u l=1u
X4146 VSS.t1175 VDD VSS.t1176 VSS.t224 sg13_lv_nmos ad=79.8f pd=0.8u as=0 ps=0 w=0.42u l=1u
X4147 VSS.t61 sg13cmos5l_dfrbpq_1_0.RESET_B a_2916_15234# VSS.t88 sg13_lv_nmos ad=0.1626p pd=1.415u as=60.89999f ps=0.71u w=0.42u l=0.13u
X4148 a_22330_15202# sg13cmos5l_dfrbpq_1_6.Q VSS.t9 VSS.t8 sg13_lv_nmos ad=0.1428p pd=1.52u as=79.8f ps=0.8u w=0.42u l=0.13u
X4149 VSS.t2230 VDD VSS.t2229 VSS.t2228 sg13_lv_nmos ad=0.1428p pd=1.52u as=0 ps=0 w=0.42u l=1u
X4150 VSS.t1843 VDD VSS.t1845 VSS.t1844 sg13_lv_nmos ad=79.8f pd=0.8u as=0 ps=0 w=0.42u l=1u
X4151 VDD VSS.t1303 VDD VDD sg13_lv_pmos ad=0.34p pd=2.68u as=0 ps=0 w=1u l=1u
X4152 VDD VSS.t1175 VDD VDD sg13_lv_pmos ad=0.19p pd=1.38u as=0 ps=0 w=1u l=1u
X4153 VSS.t1591 VDD VSS.t1590 VSS.t1589 sg13_lv_nmos ad=0.1428p pd=1.52u as=0 ps=0 w=0.42u l=1u
X4154 VSS.t3122 VDD VSS.t3121 VSS.t3120 sg13_lv_nmos ad=0.1428p pd=1.52u as=0 ps=0 w=0.42u l=1u
X4155 VSS.t2305 VDD VSS.t2304 VSS.t2303 sg13_lv_nmos ad=0.1428p pd=1.52u as=0 ps=0 w=0.42u l=1u
X4156 VSS.t892 VDD VSS.t891 VSS.t890 sg13_lv_nmos ad=0.1428p pd=1.52u as=0 ps=0 w=0.42u l=1u
X4157 VDD VSS.t2264 VDD VDD sg13_lv_pmos ad=0.34p pd=2.68u as=0 ps=0 w=1u l=1u
X4158 VSS.t2671 VDD VSS.t2673 VSS.t2620 sg13_lv_nmos ad=79.8f pd=0.8u as=0 ps=0 w=0.42u l=1u
X4159 VDD a_21466_15960# a_21185_16262# VDD sg13_lv_pmos ad=0.1523p pd=1.38u as=0.34p ps=2.68u w=1u l=0.5u
X4160 VSS.t937 VDD VSS.t936 VSS.t935 sg13_lv_nmos ad=0.1428p pd=1.52u as=0 ps=0 w=0.42u l=1u
X4161 VSS.t812 VDD VSS.t814 VSS.t813 sg13_lv_nmos ad=79.8f pd=0.8u as=0 ps=0 w=0.42u l=1u
X4162 VSS.t1246 VDD VSS.t1247 VSS.t224 sg13_lv_nmos ad=79.8f pd=0.8u as=0 ps=0 w=0.42u l=1u
X4163 VDD VSS.t1713 VDD VDD sg13_lv_pmos ad=0.19p pd=1.38u as=0 ps=0 w=1u l=1u
X4164 VDD VSS.t3009 VDD VDD sg13_lv_pmos ad=0.19p pd=1.38u as=0 ps=0 w=1u l=1u
X4165 VSS.t2748 VDD VSS.t2749 VSS.t2620 sg13_lv_nmos ad=79.8f pd=0.8u as=0 ps=0 w=0.42u l=1u
X4166 VDD VSS.t1870 VDD VDD sg13_lv_pmos ad=0.19p pd=1.38u as=0 ps=0 w=1u l=1u
X4167 VSS.t1873 VDD VSS.t1872 VSS.t1871 sg13_lv_nmos ad=0.1428p pd=1.52u as=0 ps=0 w=0.42u l=1u
X4168 VSS.t442 VDD VSS.t442 VSS.t2 sg13_lv_nmos ad=79.8f pd=0.8u as=0 ps=0 w=0.42u l=1u
X4169 VSS.t92 VDD VSS.t426 VSS.t2 sg13_lv_nmos ad=79.8f pd=0.8u as=0 ps=0 w=0.42u l=1u
X4170 VSS.t1586 VDD VSS.t1585 VSS.t1584 sg13_lv_nmos ad=0.1428p pd=1.52u as=0 ps=0 w=0.42u l=1u
X4171 VDD sg13cmos5l_dfrbpq_1_2.RESET_B a_15782_13722# VDD sg13_lv_pmos ad=0.36237p pd=2.605u as=79.8f ps=0.8u w=0.42u l=0.13u
X4172 VSS.t2721 VDD VSS.t2719 VSS.t2620 sg13_lv_nmos ad=0.1428p pd=1.52u as=0 ps=0 w=0.42u l=1u
X4173 VSS.t2113 VDD VSS.t2112 VSS.t2111 sg13_lv_nmos ad=0.1428p pd=1.52u as=0 ps=0 w=0.42u l=1u
X4174 a_27503_13799# a_26661_13701# a_27409_13799# VSS.t59 sg13_lv_nmos ad=0.12665p pd=1.145u as=0.1428p ps=1.52u w=0.42u l=0.13u
X4175 VDD VSS.t1244 VDD VDD sg13_lv_pmos ad=0.34p pd=2.68u as=0 ps=0 w=1u l=1u
X4176 VDD VSS.t2749 VDD VDD sg13_lv_pmos ad=0.34p pd=2.68u as=0 ps=0 w=1u l=1u
X4177 VDD VSS.t2402 VDD VDD sg13_lv_pmos ad=0.19p pd=1.38u as=0 ps=0 w=1u l=1u
X4178 a_12212_15202# sg13cmos5l_buf_16_2.A VSS.t483 VSS.t3313 sg13_lv_nmos ad=0.1406p pd=1.12u as=0.1406p ps=1.12u w=0.74u l=0.13u
X4179 VSS.t549 VDD VSS.t546 VSS.t548 sg13_lv_nmos ad=0.1428p pd=1.52u as=0 ps=0 w=0.42u l=1u
X4180 VSS.t997 VDD VSS.t999 VSS.t998 sg13_lv_nmos ad=79.8f pd=0.8u as=0 ps=0 w=0.42u l=1u
X4181 VDD VSS.t2060 VDD VDD sg13_lv_pmos ad=0.19p pd=1.38u as=0 ps=0 w=1u l=1u
X4182 a_7916_15960# sg13cmos5l_dlygate4sd3_1_0.A VDD VDD sg13_lv_pmos ad=0.2856p pd=2.36u as=0.2114p ps=1.54u w=0.84u l=0.13u
X4183 VSS.t1265 VDD VSS.t1266 VSS.t224 sg13_lv_nmos ad=79.8f pd=0.8u as=0 ps=0 w=0.42u l=1u
X4184 VDD VSS.t2237 VDD VDD sg13_lv_pmos ad=0.19p pd=1.38u as=0 ps=0 w=1u l=1u
X4185 VSS.t557 VDD VSS.t559 VSS.t558 sg13_lv_nmos ad=79.8f pd=0.8u as=0 ps=0 w=0.42u l=1u
X4186 VDD VSS.t864 VDD VDD sg13_lv_pmos ad=0.19p pd=1.38u as=0 ps=0 w=1u l=1u
X4187 VSS.t2656 VDD VSS.t2656 VSS.t2620 sg13_lv_nmos ad=0.1428p pd=1.52u as=0 ps=0 w=0.42u l=1u
X4188 a_2822_15234# a_3627_15356# a_3082_15457# VDD sg13_lv_pmos ad=0.1428p pd=1.52u as=79.8f ps=0.8u w=0.42u l=0.13u
X4189 VSS.t2420 VDD VSS.t2422 VSS.t2421 sg13_lv_nmos ad=79.8f pd=0.8u as=0 ps=0 w=0.42u l=1u
X4190 VDD VSS.t1525 VDD VDD sg13_lv_pmos ad=0.34p pd=2.68u as=0 ps=0 w=1u l=1u
X4191 VDD a_17710_16263# sg13cmos5l_a21oi_1_0.A1 VDD sg13_lv_pmos ad=0.2254p pd=1.53u as=0.4256p ps=3u w=1.12u l=0.13u
X4192 VDD VSS.t1508 VDD VDD sg13_lv_pmos ad=0.19p pd=1.38u as=0 ps=0 w=1u l=1u
X4193 VSS.t2627 VDD VSS.t2628 VSS.t2620 sg13_lv_nmos ad=79.8f pd=0.8u as=0 ps=0 w=0.42u l=1u
X4194 VDD VSS.t253 VDD VDD sg13_lv_pmos ad=0.34p pd=2.68u as=0 ps=0 w=1u l=1u
X4195 VDD VSS.t284 VDD VDD sg13_lv_pmos ad=0.19p pd=1.38u as=0 ps=0 w=1u l=1u
X4196 a_7919_14845# a_7077_14495# a_7825_14845# VSS.t249 sg13_lv_nmos ad=0.12665p pd=1.145u as=0.1428p ps=1.52u w=0.42u l=0.13u
X4197 VSS.t2325 VDD VSS.t2324 VSS.t2323 sg13_lv_nmos ad=0.1428p pd=1.52u as=0 ps=0 w=0.42u l=1u
X4198 VDD VSS.t2087 VDD VDD sg13_lv_pmos ad=0.34p pd=2.68u as=0 ps=0 w=1u l=1u
X4199 sg13cmos5l_buf_16_2.A a_15790_15238# VSS.t21 VSS.t30 sg13_lv_nmos ad=0.1406p pd=1.12u as=0.1406p ps=1.12u w=0.74u l=0.13u
X4200 VDD a_4624_15454# a_4569_15549# VDD sg13_lv_pmos ad=2.8961p pd=18.25u as=93.45f ps=0.865u w=0.42u l=0.13u
X4201 a_16068_14040# a_16042_13945# VSS.t689 VSS.t3288 sg13_lv_nmos ad=0.2516p pd=2.16u as=0.1626p ps=1.415u w=0.74u l=0.13u
X4202 VDD VSS.t1237 VDD VDD sg13_lv_pmos ad=0.34p pd=2.68u as=0 ps=0 w=1u l=1u
X4203 VDD VSS.t1862 VDD VDD sg13_lv_pmos ad=0.34p pd=2.68u as=0 ps=0 w=1u l=1u
X4204 sg13cmos5l_dfrbpq_1_2.RESET_B a_15486_15486# VDD VDD sg13_lv_pmos ad=0.3927p pd=2.99u as=2.8961p ps=18.25u w=1.155u l=0.13u
X4205 VSS.t430 VDD VSS.t430 VSS.t2 sg13_lv_nmos ad=0.1428p pd=1.52u as=0 ps=0 w=0.42u l=1u
X4206 VSS.t967 VDD VSS.t969 VSS.t968 sg13_lv_nmos ad=79.8f pd=0.8u as=0 ps=0 w=0.42u l=1u
X4207 VDD VSS.t956 VDD VDD sg13_lv_pmos ad=0.34p pd=2.68u as=0 ps=0 w=1u l=1u
X4208 VDD VSS.t2628 VDD VDD sg13_lv_pmos ad=0.34p pd=2.68u as=0 ps=0 w=1u l=1u
X4209 VDD VSS.t2707 VDD VDD sg13_lv_pmos ad=0.34p pd=2.68u as=0 ps=0 w=1u l=1u
X4210 VDD a_12212_15202# sg13cmos5l_dfrbpq_1_2.CLK VDD sg13_lv_pmos ad=0.2128p pd=1.5u as=0.2128p ps=1.5u w=1.12u l=0.13u
X4211 VDD VSS.t96 VDD VDD sg13_lv_pmos ad=0.19p pd=1.38u as=0 ps=0 w=1u l=1u
X4212 VDD VSS.t3029 VDD VDD sg13_lv_pmos ad=0.19p pd=1.38u as=0 ps=0 w=1u l=1u
X4213 VDD VSS.t1890 VDD VDD sg13_lv_pmos ad=0.19p pd=1.38u as=0 ps=0 w=1u l=1u
X4214 VSS.t417 VDD VSS.t416 VSS.t415 sg13_lv_nmos ad=0.1428p pd=1.52u as=0 ps=0 w=0.42u l=1u
X4215 VSS.t48 VDD VSS.t48 VSS.t695 sg13_lv_nmos ad=0.1428p pd=1.52u as=0 ps=0 w=0.42u l=1u
X4216 VSS.t1706 VDD VSS.t1708 VSS.t1707 sg13_lv_nmos ad=79.8f pd=0.8u as=0 ps=0 w=0.42u l=1u
X4217 VSS.t284 sg13cmos5l_or3_1_2.B a_15208_15996# VSS.t283 sg13_lv_nmos ad=0.14875p pd=1.16u as=0.187p ps=1.78u w=0.55u l=0.13u
X4218 VSS.t2098 VDD VSS.t2097 VSS.t2096 sg13_lv_nmos ad=0.1428p pd=1.52u as=0 ps=0 w=0.42u l=1u
X4219 VDD VSS.t2052 VDD VDD sg13_lv_pmos ad=0.34p pd=2.68u as=0 ps=0 w=1u l=1u
X4220 VDD VSS.t1165 VDD VDD sg13_lv_pmos ad=0.34p pd=2.68u as=0 ps=0 w=1u l=1u
X4221 a_10318_14751# a_10433_14750# VSS.t4 VSS.t3 sg13_lv_nmos ad=0.1428p pd=1.52u as=0.1426p ps=1.16u w=0.42u l=0.5u
X4222 VDD VSS.t1019 VDD VDD sg13_lv_pmos ad=0.19p pd=1.38u as=0 ps=0 w=1u l=1u
X4223 VSS.t1279 VDD VSS.t1280 VSS.t224 sg13_lv_nmos ad=79.8f pd=0.8u as=0 ps=0 w=0.42u l=1u
X4224 a_25766_15996# a_25496_16037# VSS.t98 VSS.t301 sg13_lv_nmos ad=0.1428p pd=1.52u as=79.8f ps=0.8u w=0.42u l=0.5u
X4225 sg13cmos5l_dfrbpq_1_2.CLK a_12212_15202# VSS.t132 VSS.t133 sg13_lv_nmos ad=0.1406p pd=1.12u as=0.1406p ps=1.12u w=0.74u l=0.13u
X4226 a_19436_15960# sg13cmos5l_dfrbpq_1_2.Q VDD VDD sg13_lv_pmos ad=0.2856p pd=2.36u as=0.2114p ps=1.54u w=0.84u l=0.13u
X4227 VSS.t1576 VDD VSS.t1578 VSS.t1577 sg13_lv_nmos ad=79.8f pd=0.8u as=0 ps=0 w=0.42u l=1u
X4228 VDD VSS.t2354 VDD VDD sg13_lv_pmos ad=0.34p pd=2.68u as=0 ps=0 w=1u l=1u
X4229 VSS.t109 a_32492_15960# counter_value_o[6] VSS.t108 sg13_lv_nmos ad=0.14875p pd=1.16u as=0.2886p ps=2.26u w=0.74u l=0.13u
X4230 VSS.t887 VDD VSS.t889 VSS.t888 sg13_lv_nmos ad=79.8f pd=0.8u as=0 ps=0 w=0.42u l=1u
X4231 VSS.t1446 VDD VSS.t1448 VSS.t1447 sg13_lv_nmos ad=79.8f pd=0.8u as=0 ps=0 w=0.42u l=1u
X4232 VSS.t2638 VDD VSS.t2639 VSS.t2620 sg13_lv_nmos ad=79.8f pd=0.8u as=0 ps=0 w=0.42u l=1u
X4233 VDD VSS.t411 VDD VDD sg13_lv_pmos ad=0.34p pd=2.68u as=0 ps=0 w=1u l=1u
X4234 a_18767_14845# a_17925_14495# a_17508_14488# VDD sg13_lv_pmos ad=0.2048p pd=1.63u as=0.34p ps=2.68u w=1u l=0.13u
X4235 VDD VSS.t1930 VDD VDD sg13_lv_pmos ad=0.19p pd=1.38u as=0 ps=0 w=1u l=1u
X4236 VSS.t937 VDD VSS.t936 VSS.t935 sg13_lv_nmos ad=0.1428p pd=1.52u as=0 ps=0 w=0.42u l=1u
X4237 VDD VSS.t1166 VDD VDD sg13_lv_pmos ad=0.19p pd=1.38u as=0 ps=0 w=1u l=1u
X4238 VDD VSS.t2249 VDD VDD sg13_lv_pmos ad=0.34p pd=2.68u as=0 ps=0 w=1u l=1u
X4239 VSS.t625 VDD VSS.t629 VSS.t628 sg13_lv_nmos ad=79.8f pd=0.8u as=0 ps=0 w=0.42u l=1u
X4240 VDD VSS.t1847 VDD VDD sg13_lv_pmos ad=0.34p pd=2.68u as=0 ps=0 w=1u l=1u
X4241 VSS.t2770 VDD VSS.t2769 VSS.t2620 sg13_lv_nmos ad=0.1428p pd=1.52u as=0 ps=0 w=0.42u l=1u
X4242 VDD VSS.t2639 VDD VDD sg13_lv_pmos ad=0.34p pd=2.68u as=0 ps=0 w=1u l=1u
X4243 VDD VSS.t2742 VDD VDD sg13_lv_pmos ad=0.19p pd=1.38u as=0 ps=0 w=1u l=1u
X4244 VDD a_12212_15202# sg13cmos5l_dfrbpq_1_2.CLK VDD sg13_lv_pmos ad=0.2128p pd=1.5u as=0.2128p ps=1.5u w=1.12u l=0.13u
X4245 VSS.t442 VDD VSS.t442 VSS.t2 sg13_lv_nmos ad=79.8f pd=0.8u as=0 ps=0 w=0.42u l=1u
X4246 VDD VSS.t3171 VDD VDD sg13_lv_pmos ad=0.34p pd=2.68u as=0 ps=0 w=1u l=1u
X4247 VDD VSS.t466 VDD VDD sg13_lv_pmos ad=0.34p pd=2.68u as=0 ps=0 w=1u l=1u
X4248 VDD VSS.t543 VDD VDD sg13_lv_pmos ad=0.19p pd=1.38u as=0 ps=0 w=1u l=1u
X4249 VSS.t2712 VDD VSS.t2711 VSS.t2620 sg13_lv_nmos ad=0.1428p pd=1.52u as=0 ps=0 w=0.42u l=1u
X4250 VSS.t614 VDD VSS.t614 VSS.t743 sg13_lv_nmos ad=0.1428p pd=1.52u as=0 ps=0 w=0.42u l=1u
X4251 VSS.t997 VDD VSS.t999 VSS.t998 sg13_lv_nmos ad=79.8f pd=0.8u as=0 ps=0 w=0.42u l=1u
X4252 VDD VSS.t1255 VDD VDD sg13_lv_pmos ad=0.34p pd=2.68u as=0 ps=0 w=1u l=1u
X4253 a_32492_15960# sg13cmos5l_dfrbpq_1_7.Q VSS.t109 VSS.t3221 sg13_lv_nmos ad=0.187p pd=1.78u as=0.14875p ps=1.16u w=0.55u l=0.13u
X4254 VDD VSS.t794 VDD VDD sg13_lv_pmos ad=0.19p pd=1.38u as=0 ps=0 w=1u l=1u
X4255 VDD VSS.t986 VDD VDD sg13_lv_pmos ad=0.34p pd=2.68u as=0 ps=0 w=1u l=1u
X4256 VDD VSS.t236 VDD VDD sg13_lv_pmos ad=0.19p pd=1.38u as=0 ps=0 w=1u l=1u
X4257 VSS.t1666 VDD VSS.t1665 VSS.t1664 sg13_lv_nmos ad=0.1428p pd=1.52u as=0 ps=0 w=0.42u l=1u
X4258 VDD VSS.t2387 VDD VDD sg13_lv_pmos ad=0.19p pd=1.38u as=0 ps=0 w=1u l=1u
X4259 VDD VSS.t1568 VDD VDD sg13_lv_pmos ad=0.19p pd=1.38u as=0 ps=0 w=1u l=1u
X4260 VSS.t2661 VDD VSS.t2662 VSS.t2620 sg13_lv_nmos ad=79.8f pd=0.8u as=0 ps=0 w=0.42u l=1u
X4261 VDD VSS.t1902 VDD VDD sg13_lv_pmos ad=0.34p pd=2.68u as=0 ps=0 w=1u l=1u
X4262 VSS.t303 VDD VSS.t303 VSS.t304 sg13_lv_nmos ad=79.8f pd=0.8u as=0 ps=0 w=0.42u l=1u
X4263 sg13cmos5l_dfrbpq_1_2.CLK a_12212_15202# VSS.t128 VSS.t127 sg13_lv_nmos ad=0.1406p pd=1.12u as=0.2516p ps=2.16u w=0.74u l=0.13u
X4264 VSS.t857 VDD VSS.t856 VSS.t855 sg13_lv_nmos ad=0.1428p pd=1.52u as=0 ps=0 w=0.42u l=1u
X4265 sg13cmos5l_dfrbpq_1_6.Q a_22890_14484# VDD VDD sg13_lv_pmos ad=0.3808p pd=2.92u as=0.2128p ps=1.5u w=1.12u l=0.13u
X4266 VDD VSS.t909 VDD VDD sg13_lv_pmos ad=0.19p pd=1.38u as=0 ps=0 w=1u l=1u
X4267 VSS.t2647 VDD VSS.t2647 VSS.t2620 sg13_lv_nmos ad=0.1428p pd=1.52u as=0 ps=0 w=0.42u l=1u
X4268 VDD VSS.t2700 VDD VDD sg13_lv_pmos ad=0.19p pd=1.38u as=0 ps=0 w=1u l=1u
X4269 VSS.t1968 VDD VSS.t1967 VSS.t1966 sg13_lv_nmos ad=0.1428p pd=1.52u as=0 ps=0 w=0.42u l=1u
X4270 VSS.t352 VDD VSS.t354 VSS.t353 sg13_lv_nmos ad=79.8f pd=0.8u as=0 ps=0 w=0.42u l=1u
X4271 VDD VSS.t442 VDD VDD sg13_lv_pmos ad=0.19p pd=1.38u as=0 ps=0 w=1u l=1u
X4272 VDD a_27311_14845# a_27568_14726# VDD sg13_lv_pmos ad=2.42015p pd=15.68u as=79.8f ps=0.8u w=0.42u l=0.13u
X4273 a_26661_13701# sg13cmos5l_buf_16_2.X VDD VDD sg13_lv_pmos ad=0.4088p pd=2.97u as=2.3367p ps=15.135u w=1.12u l=0.13u
X4274 VDD VSS.t1195 VDD VDD sg13_lv_pmos ad=0.34p pd=2.68u as=0 ps=0 w=1u l=1u
X4275 VSS.t2310 VDD VSS.t2309 VSS.t2308 sg13_lv_nmos ad=0.1428p pd=1.52u as=0 ps=0 w=0.42u l=1u
X4276 a_2540_15960# sg13cmos5l_dlygate4sd3_1_5.A VSS.t303 VSS.t3275 sg13_lv_nmos ad=0.187p pd=1.78u as=0.14875p ps=1.16u w=0.55u l=0.13u
X4277 VDD VSS.t2269 VDD VDD sg13_lv_pmos ad=0.34p pd=2.68u as=0 ps=0 w=1u l=1u
X4278 VSS.t2500 VDD VSS.t2502 VSS.t2501 sg13_lv_nmos ad=79.8f pd=0.8u as=0 ps=0 w=0.42u l=1u
X4279 VSS.t430 VDD VSS.t430 VSS.t2 sg13_lv_nmos ad=0.1428p pd=1.52u as=0 ps=0 w=0.42u l=1u
X4280 VSS.t2675 VDD VSS.t2676 VSS.t2620 sg13_lv_nmos ad=79.8f pd=0.8u as=0 ps=0 w=0.42u l=1u
X4281 VDD VSS.t2442 VDD VDD sg13_lv_pmos ad=0.19p pd=1.38u as=0 ps=0 w=1u l=1u
X4282 VDD VSS.t784 VDD VDD sg13_lv_pmos ad=0.19p pd=1.38u as=0 ps=0 w=1u l=1u
X4283 VSS.t1217 VDD VSS.t1218 VSS.t224 sg13_lv_nmos ad=79.8f pd=0.8u as=0 ps=0 w=0.42u l=1u
X4284 VDD VSS.t3014 VDD VDD sg13_lv_pmos ad=0.19p pd=1.38u as=0 ps=0 w=1u l=1u
X4285 VDD VSS.t1875 VDD VDD sg13_lv_pmos ad=0.19p pd=1.38u as=0 ps=0 w=1u l=1u
X4286 VSS.t1878 VDD VSS.t1877 VSS.t1876 sg13_lv_nmos ad=0.1428p pd=1.52u as=0 ps=0 w=0.42u l=1u
X4287 VSS.t2048 VDD VSS.t2050 VSS.t2049 sg13_lv_nmos ad=79.8f pd=0.8u as=0 ps=0 w=0.42u l=1u
X4288 a_19150_15423# a_19265_15424# VSS.t118 VSS.t65 sg13_lv_nmos ad=0.1428p pd=1.52u as=0.1426p ps=1.16u w=0.42u l=0.5u
X4289 VDD VSS.t949 VDD VDD sg13_lv_pmos ad=0.19p pd=1.38u as=0 ps=0 w=1u l=1u
X4290 VDD VSS.t1723 VDD VDD sg13_lv_pmos ad=0.19p pd=1.38u as=0 ps=0 w=1u l=1u
X4291 VSS.t61 sg13cmos5l_nor2_1_0.B sg13cmos5l_nor2_1_0.Y VSS.t232 sg13_lv_nmos ad=0.2516p pd=2.16u as=0.1406p ps=1.12u w=0.74u l=0.13u
X4292 VDD VSS.t201 VDD VDD sg13_lv_pmos ad=0.19p pd=1.38u as=0 ps=0 w=1u l=1u
X4293 VDD VSS.t1247 VDD VDD sg13_lv_pmos ad=0.34p pd=2.68u as=0 ps=0 w=1u l=1u
X4294 VDD VSS.t2751 VDD VDD sg13_lv_pmos ad=0.34p pd=2.68u as=0 ps=0 w=1u l=1u
X4295 VDD VSS.t2407 VDD VDD sg13_lv_pmos ad=0.19p pd=1.38u as=0 ps=0 w=1u l=1u
X4296 VSS.t817 VDD VSS.t819 VSS.t818 sg13_lv_nmos ad=79.8f pd=0.8u as=0 ps=0 w=0.42u l=1u
X4297 VDD a_27500_15960# counter_value_o[5] VDD sg13_lv_pmos ad=0.2114p pd=1.54u as=0.42p ps=2.99u w=1.12u l=0.13u
X4298 VSS.t887 VDD VSS.t889 VSS.t888 sg13_lv_nmos ad=79.8f pd=0.8u as=0 ps=0 w=0.42u l=1u
X4299 VSS.t2922 VDD VSS.t2921 VSS.t2920 sg13_lv_nmos ad=0.1428p pd=1.52u as=0 ps=0 w=0.42u l=1u
X4300 VDD VSS.t876 VDD VDD sg13_lv_pmos ad=0.34p pd=2.68u as=0 ps=0 w=1u l=1u
X4301 VSS.t1561 VDD VSS.t1563 VSS.t1562 sg13_lv_nmos ad=79.8f pd=0.8u as=0 ps=0 w=0.42u l=1u
X4302 VSS.t1226 VDD VSS.t1227 VSS.t224 sg13_lv_nmos ad=79.8f pd=0.8u as=0 ps=0 w=0.42u l=1u
X4303 VSS.t689 sg13cmos5l_dfrbpq_1_2.RESET_B a_15876_13722# VSS.t3279 sg13_lv_nmos ad=0.1626p pd=1.415u as=60.89999f ps=0.71u w=0.42u l=0.13u
X4304 VSS.t2630 VDD VSS.t2631 VSS.t2620 sg13_lv_nmos ad=79.8f pd=0.8u as=0 ps=0 w=0.42u l=1u
X4305 VDD VSS.t2434 VDD VDD sg13_lv_pmos ad=0.34p pd=2.68u as=0 ps=0 w=1u l=1u
X4306 VDD VSS.t2092 VDD VDD sg13_lv_pmos ad=0.34p pd=2.68u as=0 ps=0 w=1u l=1u
X4307 VSS.t2485 VDD VSS.t2487 VSS.t2486 sg13_lv_nmos ad=79.8f pd=0.8u as=0 ps=0 w=0.42u l=1u
X4308 VSS.t1191 VDD VSS.t1190 VSS.t224 sg13_lv_nmos ad=0.1428p pd=1.52u as=0 ps=0 w=0.42u l=1u
X4309 VSS.t1231 VDD VSS.t1232 VSS.t224 sg13_lv_nmos ad=79.8f pd=0.8u as=0 ps=0 w=0.42u l=1u
X4310 VDD VSS.t2631 VDD VDD sg13_lv_pmos ad=0.34p pd=2.68u as=0 ps=0 w=1u l=1u
X4311 VDD VSS.t2999 VDD VDD sg13_lv_pmos ad=0.19p pd=1.38u as=0 ps=0 w=1u l=1u
X4312 a_6958_13911# a_7073_13912# VSS.t69 VSS.t183 sg13_lv_nmos ad=0.1428p pd=1.52u as=0.1426p ps=1.16u w=0.42u l=0.5u
X4313 VDD VSS.t1325 VDD VDD sg13_lv_pmos ad=0.19p pd=1.38u as=0 ps=0 w=1u l=1u
X4314 a_20772_14922# sg13cmos5l_dfrbpq_1_6.D a_20678_14922# VSS.t39 sg13_lv_nmos ad=60.89999f pd=0.71u as=0.1428p ps=1.52u w=0.42u l=0.13u
X4315 VDD VSS.t641 VDD VDD sg13_lv_pmos ad=0.34p pd=2.68u as=0 ps=0 w=1u l=1u
X4316 VSS.t1711 VDD VSS.t1713 VSS.t1712 sg13_lv_nmos ad=79.8f pd=0.8u as=0 ps=0 w=0.42u l=1u
X4317 VSS.t636 VDD VSS.t636 VSS.t762 sg13_lv_nmos ad=0.1428p pd=1.52u as=0 ps=0 w=0.42u l=1u
X4318 VDD VSS.t537 VDD VDD sg13_lv_pmos ad=0.19p pd=1.38u as=0 ps=0 w=1u l=1u
X4319 VSS.t787 VDD VSS.t786 VSS.t785 sg13_lv_nmos ad=0.1428p pd=1.52u as=0 ps=0 w=0.42u l=1u
X4320 VSS.t2684 VDD VSS.t2682 VSS.t2620 sg13_lv_nmos ad=0.1428p pd=1.52u as=0 ps=0 w=0.42u l=1u
X4321 VSS.t857 VDD VSS.t856 VSS.t855 sg13_lv_nmos ad=0.1428p pd=1.52u as=0 ps=0 w=0.42u l=1u
X4322 VDD a_21381_14495# a_21483_14495# VDD sg13_lv_pmos ad=2.42015p pd=15.68u as=0.3864p ps=2.93u w=1.12u l=0.13u
X4323 sg13cmos5l_or3_1_2.X a_21865_13726# VSS.t236 VSS.t235 sg13_lv_nmos ad=0.2516p pd=2.16u as=0.13395p ps=1.12u w=0.74u l=0.13u
X4324 VDD VSS.t1553 VDD VDD sg13_lv_pmos ad=0.19p pd=1.38u as=0 ps=0 w=1u l=1u
X4325 VSS.t2760 VDD VSS.t2759 VSS.t2620 sg13_lv_nmos ad=0.1428p pd=1.52u as=0 ps=0 w=0.42u l=1u
X4326 VDD VSS.t1887 VDD VDD sg13_lv_pmos ad=0.34p pd=2.68u as=0 ps=0 w=1u l=1u
X4327 VSS.t2018 VDD VSS.t2020 VSS.t2019 sg13_lv_nmos ad=79.8f pd=0.8u as=0 ps=0 w=0.42u l=1u
X4328 a_17734_14909# sg13cmos5l_dfrbpq_1_3.RESET_B VSS.t21 VSS.t3219 sg13_lv_nmos ad=37.8f pd=0.6u as=0.1701p ps=1.65u w=0.42u l=0.13u
X4329 VDD VSS.t954 VDD VDD sg13_lv_pmos ad=0.19p pd=1.38u as=0 ps=0 w=1u l=1u
X4330 VSS.t1208 VDD VSS.t1207 VSS.t224 sg13_lv_nmos ad=0.1428p pd=1.52u as=0 ps=0 w=0.42u l=1u
X4331 a_17030_15996# a_16760_16037# VSS.t216 VSS.t3205 sg13_lv_nmos ad=0.1428p pd=1.52u as=79.8f ps=0.8u w=0.42u l=0.5u
X4332 VDD VSS.t426 VDD VDD sg13_lv_pmos ad=0.34p pd=2.68u as=0 ps=0 w=1u l=1u
X4333 a_24156_15242# sg13cmos5l_dfrbpq_1_3.Q a_24054_15242# VSS.t8 sg13_lv_nmos ad=0.1406p pd=1.12u as=0.1406p ps=1.12u w=0.74u l=0.13u
X4334 sg13cmos5l_dfrbpq_1_6.Q a_22890_14484# VSS.t122 VSS.t7 sg13_lv_nmos ad=0.2516p pd=2.16u as=0.1406p ps=1.12u w=0.74u l=0.13u
X4335 VDD VSS.t2419 VDD VDD sg13_lv_pmos ad=0.34p pd=2.68u as=0 ps=0 w=1u l=1u
X4336 VSS.t1506 VDD VSS.t1508 VSS.t1507 sg13_lv_nmos ad=79.8f pd=0.8u as=0 ps=0 w=0.42u l=1u
X4337 VSS.t168 VDD VSS.t168 VSS.t321 sg13_lv_nmos ad=0.1428p pd=1.52u as=0 ps=0 w=0.42u l=1u
X4338 VDD sg13cmos5l_or3_1_2.A sg13cmos5l_o21ai_1_1.Y VDD sg13_lv_pmos ad=0.3808p pd=2.92u as=0.2128p ps=1.5u w=1.12u l=0.15u
X4339 VDD VSS.t552 VDD VDD sg13_lv_pmos ad=0.34p pd=2.68u as=0 ps=0 w=1u l=1u
X4340 VSS.t1365 VDD VSS.t1212 VSS.t224 sg13_lv_nmos ad=0.1428p pd=1.52u as=0 ps=0 w=0.42u l=1u
X4341 VDD VSS.t2254 VDD VDD sg13_lv_pmos ad=0.34p pd=2.68u as=0 ps=0 w=1u l=1u
X4342 VSS.t557 VDD VSS.t559 VSS.t558 sg13_lv_nmos ad=79.8f pd=0.8u as=0 ps=0 w=0.42u l=1u
X4343 VDD VSS.t1852 VDD VDD sg13_lv_pmos ad=0.34p pd=2.68u as=0 ps=0 w=1u l=1u
X4344 VDD VSS.t2702 VDD VDD sg13_lv_pmos ad=0.34p pd=2.68u as=0 ps=0 w=1u l=1u
X4345 VSS.t1244 VDD VSS.t1244 VSS.t224 sg13_lv_nmos ad=79.8f pd=0.8u as=0 ps=0 w=0.42u l=1u
X4346 VDD VSS.t1241 VDD VDD sg13_lv_pmos ad=0.19p pd=1.38u as=0 ps=0 w=1u l=1u
X4347 VDD VSS.t2745 VDD VDD sg13_lv_pmos ad=0.19p pd=1.38u as=0 ps=0 w=1u l=1u
X4348 VDD VSS.t2025 VDD VDD sg13_lv_pmos ad=0.19p pd=1.38u as=0 ps=0 w=1u l=1u
X4349 a_16068_14040# a_16042_13945# VDD VDD sg13_lv_pmos ad=0.34p pd=2.68u as=0.36237p ps=2.605u w=1u l=0.13u
X4350 VDD VSS.t3176 VDD VDD sg13_lv_pmos ad=0.34p pd=2.68u as=0 ps=0 w=1u l=1u
X4351 VSS.t2440 VDD VSS.t2439 VSS.t2438 sg13_lv_nmos ad=0.1428p pd=1.52u as=0 ps=0 w=0.42u l=1u
X4352 VSS.t1863 VDD VSS.t1862 VSS.t1861 sg13_lv_nmos ad=0.1428p pd=1.52u as=0 ps=0 w=0.42u l=1u
X4353 VDD VSS.t614 VDD VDD sg13_lv_pmos ad=0.19p pd=1.38u as=0 ps=0 w=1u l=1u
X4354 VDD VSS.t2444 VDD VDD sg13_lv_pmos ad=0.34p pd=2.68u as=0 ps=0 w=1u l=1u
X4355 VSS.t942 VDD VSS.t941 VSS.t940 sg13_lv_nmos ad=0.1428p pd=1.52u as=0 ps=0 w=0.42u l=1u
X4356 VDD VSS.t1708 VDD VDD sg13_lv_pmos ad=0.19p pd=1.38u as=0 ps=0 w=1u l=1u
X4357 VSS.t817 VDD VSS.t819 VSS.t818 sg13_lv_nmos ad=79.8f pd=0.8u as=0 ps=0 w=0.42u l=1u
X4358 VSS.t1249 VDD VSS.t1250 VSS.t224 sg13_lv_nmos ad=79.8f pd=0.8u as=0 ps=0 w=0.42u l=1u
X4359 VSS.t2505 VDD VSS.t2507 VSS.t2506 sg13_lv_nmos ad=79.8f pd=0.8u as=0 ps=0 w=0.42u l=1u
X4360 VDD VSS.t2392 VDD VDD sg13_lv_pmos ad=0.19p pd=1.38u as=0 ps=0 w=1u l=1u
X4361 VSS.t2053 VDD VSS.t2052 VSS.t2051 sg13_lv_nmos ad=0.1428p pd=1.52u as=0 ps=0 w=0.42u l=1u
X4362 VDD VSS.t1573 VDD VDD sg13_lv_pmos ad=0.19p pd=1.38u as=0 ps=0 w=1u l=1u
X4363 VSS.t2664 VDD VSS.t2665 VSS.t2620 sg13_lv_nmos ad=79.8f pd=0.8u as=0 ps=0 w=0.42u l=1u
X4364 a_7066_16366# sg13cmos5l_dlygate4sd3_1_3.X sg13cmos5l_xor2_1_1.B VSS.t286 sg13_lv_nmos ad=0.1406p pd=1.12u as=0.2516p ps=2.16u w=0.74u l=0.13u
X4365 VDD VSS.t921 VDD VDD sg13_lv_pmos ad=0.34p pd=2.68u as=0 ps=0 w=1u l=1u
X4366 VSS.t2907 VDD VSS.t2906 VSS.t2905 sg13_lv_nmos ad=0.1428p pd=1.52u as=0 ps=0 w=0.42u l=1u
X4367 VDD VSS.t688 VDD VDD sg13_lv_pmos ad=0.34p pd=2.68u as=0 ps=0 w=1u l=1u
X4368 VSS.t2650 VDD VSS.t2650 VSS.t2620 sg13_lv_nmos ad=0.1428p pd=1.52u as=0 ps=0 w=0.42u l=1u
X4369 VDD VSS.t2665 VDD VDD sg13_lv_pmos ad=0.34p pd=2.68u as=0 ps=0 w=1u l=1u
X4370 VSS.t1938 VDD VSS.t1937 VSS.t1936 sg13_lv_nmos ad=0.1428p pd=1.52u as=0 ps=0 w=0.42u l=1u
X4371 VSS.t12 VDD VSS.t73 VSS.t378 sg13_lv_nmos ad=79.8f pd=0.8u as=0 ps=0 w=0.42u l=1u
X4372 VDD VSS.t869 VDD VDD sg13_lv_pmos ad=0.19p pd=1.38u as=0 ps=0 w=1u l=1u
X4373 a_6026_15532# sg13cmos5l_inv_1_0.Y VDD VDD sg13_lv_pmos ad=0.1176p pd=1.33u as=0.4032p ps=2.96u w=1.12u l=0.13u
X4374 VSS.t957 VDD VSS.t956 VSS.t955 sg13_lv_nmos ad=0.1428p pd=1.52u as=0 ps=0 w=0.42u l=1u
X4375 VDD VSS.t2239 VDD VDD sg13_lv_pmos ad=0.34p pd=2.68u as=0 ps=0 w=1u l=1u
X4376 a_21370_15202# sg13cmos5l_o21ai_1_1.Y VSS.t288 VSS.t287 sg13_lv_nmos ad=0.1428p pd=1.52u as=79.8f ps=0.8u w=0.42u l=0.13u
X4377 VSS.t1258 VDD VSS.t1259 VSS.t224 sg13_lv_nmos ad=79.8f pd=0.8u as=0 ps=0 w=0.42u l=1u
X4378 VSS.t2470 VDD VSS.t2472 VSS.t2471 sg13_lv_nmos ad=79.8f pd=0.8u as=0 ps=0 w=0.42u l=1u
X4379 sg13cmos5l_a21oi_1_1.Y sg13cmos5l_inv_1_0.Y VSS.t257 VSS.t65 sg13_lv_nmos ad=0.1406p pd=1.12u as=0.2516p ps=2.16u w=0.74u l=0.13u
X4380 VSS.t450 VDD VSS.t450 VSS.t2 sg13_lv_nmos ad=79.8f pd=0.8u as=0 ps=0 w=0.42u l=1u
X4381 VDD VSS.t330 VDD VDD sg13_lv_pmos ad=0.19p pd=1.38u as=0 ps=0 w=1u l=1u
X4382 VDD VSS.t438 VDD VDD sg13_lv_pmos ad=0.34p pd=2.68u as=0 ps=0 w=1u l=1u
X4383 VSS.t1466 VDD VSS.t1465 VSS.t1464 sg13_lv_nmos ad=0.1428p pd=1.52u as=0 ps=0 w=0.42u l=1u
X4384 VDD VSS.t2984 VDD VDD sg13_lv_pmos ad=0.19p pd=1.38u as=0 ps=0 w=1u l=1u
X4385 VDD VSS.t3161 VDD VDD sg13_lv_pmos ad=0.34p pd=2.68u as=0 ps=0 w=1u l=1u
X4386 VSS.t2375 VDD VSS.t2374 VSS.t2373 sg13_lv_nmos ad=0.1428p pd=1.52u as=0 ps=0 w=0.42u l=1u
X4387 VSS.t1848 VDD VSS.t1847 VSS.t1846 sg13_lv_nmos ad=0.1428p pd=1.52u as=0 ps=0 w=0.42u l=1u
X4388 a_26244_14040# a_26763_13844# a_27503_13799# VSS.t3191 sg13_lv_nmos ad=0.3473p pd=2.71u as=0.12665p ps=1.145u w=0.74u l=0.13u
X4389 VSS.t787 VDD VSS.t786 VSS.t785 sg13_lv_nmos ad=0.1428p pd=1.52u as=0 ps=0 w=0.42u l=1u
X4390 VDD VSS.t1240 VDD VDD sg13_lv_pmos ad=0.34p pd=2.68u as=0 ps=0 w=1u l=1u
X4391 VSS.t96 VDD VSS.t96 VSS.t700 sg13_lv_nmos ad=79.8f pd=0.8u as=0 ps=0 w=0.42u l=1u
X4392 VSS.t1017 VDD VSS.t1019 VSS.t1018 sg13_lv_nmos ad=79.8f pd=0.8u as=0 ps=0 w=0.42u l=1u
X4393 VDD VSS.t1194 VDD VDD sg13_lv_pmos ad=0.19p pd=1.38u as=0 ps=0 w=1u l=1u
X4394 VSS.t2675 VDD VSS.t2821 VSS.t2620 sg13_lv_nmos ad=0.1428p pd=1.52u as=0 ps=0 w=0.42u l=1u
R0 VSS.t461 VSS.t247 2.35027e+06
R1 VSS.n746 VSS.n745 1.347e+06
R2 VSS.t2620 VSS.n395 4108.7
R3 VSS.n395 VSS.n452 4108.7
R4 VSS.n452 VSS.n509 4108.7
R5 VSS.n509 VSS.t224 4108.7
R6 VSS.t224 VSS.n593 4108.7
R7 VSS.n593 VSS.n667 4108.7
R8 VSS.n667 VSS.n691 4108.7
R9 VSS.n691 VSS.n953 3692.29
R10 VSS.n948 VSS.t461 1217.18
R11 VSS.t2923 VSS.n109 183.805
R12 VSS.n109 VSS.t2943 183.805
R13 VSS.n109 VSS.t2958 183.805
R14 VSS.n109 VSS.t2963 183.805
R15 VSS.n109 VSS.t2988 183.806
R16 VSS.n109 VSS.t2993 183.806
R17 VSS.t3003 VSS.n109 183.806
R18 VSS.t3013 VSS.n109 183.805
R19 VSS.t3023 VSS.n109 183.805
R20 VSS.t3038 VSS.n109 183.805
R21 VSS.t3058 VSS.n109 183.806
R22 VSS.n109 VSS.t3073 183.806
R23 VSS.n109 VSS.t3083 183.805
R24 VSS.t3095 VSS.n109 182.028
R25 VSS.t3098 VSS.n109 183.804
R26 VSS.t3143 VSS.n109 183.806
R27 VSS.t3153 VSS.n109 183.806
R28 VSS.n109 VSS.t3158 183.805
R29 VSS.t3173 VSS.n109 183.805
R30 VSS.t2620 VSS.n109 4435.04
R31 VSS.t3228 VSS.n201 8.07964
R32 VSS.t2231 VSS.n26 109.986
R33 VSS.t2241 VSS.n26 109.992
R34 VSS.t2256 VSS.n26 109.993
R35 VSS.t2261 VSS.n26 109.992
R36 VSS.t2266 VSS.n26 109.993
R37 VSS.t2281 VSS.n26 109.992
R38 VSS.t2291 VSS.n26 109.992
R39 VSS.t2326 VSS.n26 109.992
R40 VSS.t2341 VSS.n26 109.992
R41 VSS.t2351 VSS.n26 109.992
R42 VSS.t2356 VSS.n26 109.993
R43 VSS.t2361 VSS.n26 109.992
R44 VSS.t2371 VSS.n26 109.992
R45 VSS.t2381 VSS.n26 109.992
R46 VSS.t2401 VSS.n26 109.993
R47 VSS.t2406 VSS.n26 109.992
R48 VSS.t2431 VSS.n26 109.992
R49 VSS.t2451 VSS.n26 109.992
R50 VSS.t2456 VSS.n26 109.993
R51 VSS.t2461 VSS.n26 109.992
R52 VSS.n26 VSS.t2476 109.992
R53 VSS.t2501 VSS.n26 109.992
R54 VSS.t1839 VSS.n23 109.986
R55 VSS.t1854 VSS.n23 109.993
R56 VSS.n23 VSS.t1861 108.999
R57 VSS.t1869 VSS.n23 109.992
R58 VSS.t1879 VSS.n23 109.992
R59 VSS.t1909 VSS.n23 109.992
R60 VSS.t1926 VSS.n23 108.999
R61 VSS.n23 VSS.t1934 109.992
R62 VSS.n23 VSS.t1944 109.993
R63 VSS.t1949 VSS.n23 109.992
R64 VSS.t1959 VSS.n23 109.992
R65 VSS.n23 VSS.t1964 109.993
R66 VSS.n23 VSS.t1974 109.992
R67 VSS.t1989 VSS.n23 109.993
R68 VSS.n23 VSS.t1994 109.992
R69 VSS.t1999 VSS.n23 109.992
R70 VSS.t2004 VSS.n23 109.993
R71 VSS.t2044 VSS.n23 109.992
R72 VSS.n23 VSS.t2049 109.993
R73 VSS.n23 VSS.t2059 109.993
R74 VSS.n23 VSS.t2089 109.992
R75 VSS.n23 VSS.t2099 109.992
R76 VSS.n23 VSS.t2109 109.992
R77 VSS.t1447 VSS.n24 109.986
R78 VSS.t1462 VSS.n24 109.993
R79 VSS.n24 VSS.t1469 108.999
R80 VSS.t1477 VSS.n24 109.992
R81 VSS.t1487 VSS.n24 109.992
R82 VSS.t1517 VSS.n24 109.992
R83 VSS.n24 VSS.t1534 108.999
R84 VSS.n24 VSS.t1542 109.992
R85 VSS.n24 VSS.t1552 109.993
R86 VSS.t1557 VSS.n24 109.992
R87 VSS.t1567 VSS.n24 109.992
R88 VSS.t1577 VSS.n24 109.993
R89 VSS.t1587 VSS.n24 109.993
R90 VSS.t1597 VSS.n24 109.993
R91 VSS.t1607 VSS.n24 109.992
R92 VSS.t1617 VSS.n24 109.992
R93 VSS.n24 VSS.t1622 109.993
R94 VSS.n24 VSS.t1632 109.992
R95 VSS.t1647 VSS.n24 109.993
R96 VSS.n24 VSS.t1652 109.992
R97 VSS.t1677 VSS.n24 109.992
R98 VSS.n24 VSS.t1702 109.993
R99 VSS.n25 VSS.t785 108.999
R100 VSS.n25 VSS.t798 109.993
R101 VSS.t803 VSS.n25 109.992
R102 VSS.t823 VSS.n25 109.992
R103 VSS.t833 VSS.n25 109.992
R104 VSS.n25 VSS.t868 109.992
R105 VSS.t873 VSS.n25 109.993
R106 VSS.n25 VSS.t878 109.992
R107 VSS.n25 VSS.t898 109.993
R108 VSS.t903 VSS.n25 109.992
R109 VSS.t913 VSS.n25 109.992
R110 VSS.t923 VSS.n25 109.992
R111 VSS.n25 VSS.t943 109.993
R112 VSS.t948 VSS.n25 109.992
R113 VSS.t968 VSS.n25 109.992
R114 VSS.n25 VSS.t973 109.992
R115 VSS.t998 VSS.n25 109.993
R116 VSS.t664 VSS.t54 109.639
R117 VSS.n162 VSS.t54 10.7817
R118 VSS.t568 VSS.t54 109.992
R119 VSS.t54 VSS.t575 108.999
R120 VSS.t54 VSS.t592 109.992
R121 VSS.t54 VSS.t597 109.992
R122 VSS.n26 VSS.n395 427.5
R123 VSS.n23 VSS.n452 427.5
R124 VSS.n24 VSS.n509 427.5
R125 VSS.n25 VSS.n593 427.5
R126 VSS.t54 VSS.n667 427.5
R127 VSS.n182 VSS.t534 242.846
R128 VSS.n216 VSS.t538 242.846
R129 VSS.n215 VSS.t541 242.846
R130 VSS.t3317 VSS.n196 28.5605
R131 VSS.n128 VSS.t235 15.1036
R132 VSS.n205 VSS.t3189 15.7034
R133 VSS.t2 VSS.n691 427.5
R134 VSS.n741 VSS.t67 408.31
R135 VSS.t3192 VSS.n197 413.86
R136 VSS.t2900 VSS.n109 181.875
R137 VSS.t2910 VSS.n109 182.042
R138 VSS.t2945 VSS.n109 182.042
R139 VSS.t2965 VSS.n109 182.042
R140 VSS.t2970 VSS.n109 182.042
R141 VSS.t2980 VSS.n109 182.042
R142 VSS.n109 VSS.t3025 182.042
R143 VSS.n109 VSS.t3040 182.042
R144 VSS.n109 VSS.t3060 182.042
R145 VSS.n109 VSS.t3065 182.042
R146 VSS.n109 VSS.t3085 182.042
R147 VSS.n109 VSS.t3105 182.042
R148 VSS.t3110 VSS.n109 182.042
R149 VSS.n109 VSS.t3125 182.042
R150 VSS.t3130 VSS.n109 182.042
R151 VSS.n109 VSS.t3135 182.042
R152 VSS.n109 VSS.t3160 182.042
R153 VSS.t3165 VSS.n109 182.042
R154 VSS.n217 VSS.t690 236.502
R155 VSS.t3191 VSS.n861 398.572
R156 VSS.n926 VSS.t295 398.572
R157 VSS.n918 VSS.t3317 398.572
R158 VSS.t3302 VSS.n780 398.572
R159 VSS.t207 VSS.n723 398.572
R160 VSS.n942 VSS.t130 398.572
R161 VSS.n935 VSS.t3311 398.572
R162 VSS.t3274 VSS.n14 398.228
R163 VSS.t289 VSS.n16 398.228
R164 VSS.n77 VSS.t3184 397.132
R165 VSS.t251 VSS.n91 397.132
R166 VSS.n72 VSS.t191 397.132
R167 VSS.n21 VSS.t3204 393.462
R168 VSS.t247 VSS.n689 391.118
R169 VSS.t298 VSS.n200 392.921
R170 VSS.n842 VSS.t28 387.5
R171 VSS.t3230 VSS.n946 386.82
R172 VSS.t287 VSS.n3 386.526
R173 VSS.n903 VSS.t186 385.714
R174 VSS.n124 VSS.t160 36.4612
R175 VSS.t3273 VSS.n719 382.522
R176 VSS.n200 VSS.t166 40.4646
R177 VSS.t82 VSS.n823 377.144
R178 VSS.t6 VSS.n3 376.724
R179 VSS.n919 VSS.t3316 372.858
R180 VSS.n774 VSS.t3319 372.858
R181 VSS.t3304 VSS.n910 372.858
R182 VSS.n943 VSS.t129 372.858
R183 VSS.n756 VSS.t133 372.858
R184 VSS.n824 VSS.t3313 372.858
R185 VSS.t3255 VSS.n818 370.834
R186 VSS.n783 VSS.t3260 368.572
R187 VSS.n12 VSS.t249 368.142
R188 VSS.n717 VSS.t171 366.668
R189 VSS.t3245 VSS.n123 52.5375
R190 VSS.n75 VSS.t3305 362.846
R191 VSS.t3314 VSS.n19 362.846
R192 VSS.t30 VSS.n840 362.5
R193 VSS.n838 VSS.t197 361.033
R194 VSS.n740 VSS.t248 361.033
R195 VSS.t271 VSS.n736 356.735
R196 VSS.t241 VSS.n730 356.735
R197 VSS.t111 VSS.n765 355.714
R198 VSS.t34 VSS.n179 366.63
R199 VSS.t159 VSS.n945 352.437
R200 VSS.n150 VSS.t115 60.3116
R201 VSS.n927 VSS.t3187 351.43
R202 VSS.n944 VSS.t209 351.43
R203 VSS.n826 VSS.t84 351.43
R204 VSS.n722 VSS.t43 348.139
R205 VSS.t125 VSS.n859 347.144
R206 VSS.t47 VSS.n923 347.144
R207 VSS.t3320 VSS.n772 347.144
R208 VSS.n913 VSS.t3300 347.144
R209 VSS.n753 VSS.t3324 347.144
R210 VSS.t134 VSS.n754 347.144
R211 VSS.t3309 VSS.n936 347.144
R212 VSS.n831 VSS.t3251 347.144
R213 VSS.n14 VSS.t76 346.652
R214 VSS.t282 VSS.n781 342.858
R215 VSS.t262 VSS.n903 342.858
R216 VSS.t36 VSS.n15 342.354
R217 VSS.n921 VSS.t95 341.418
R218 VSS.n739 VSS.t246 339.543
R219 VSS.t290 VSS.t3248 338.572
R220 VSS.t255 VSS.t3250 338.572
R221 VSS.t2903 VSS.n109 183.804
R222 VSS.t2928 VSS.n109 183.806
R223 VSS.t2938 VSS.n109 183.806
R224 VSS.t2948 VSS.n109 183.806
R225 VSS.t2953 VSS.n109 183.806
R226 VSS.t2978 VSS.n109 183.806
R227 VSS.t3008 VSS.n109 183.806
R228 VSS.t3018 VSS.n109 183.806
R229 VSS.t3033 VSS.n109 183.806
R230 VSS.t3048 VSS.n109 183.806
R231 VSS.t3078 VSS.n109 183.806
R232 VSS.t3103 VSS.n109 183.806
R233 VSS.t3123 VSS.n109 183.806
R234 VSS.t3133 VSS.n109 183.806
R235 VSS.t3168 VSS.n109 183.806
R236 VSS.t3178 VSS.n109 183.806
R237 VSS.n133 VSS.t50 72.5331
R238 VSS.t3288 VSS.n929 329.168
R239 VSS.t296 VSS.n865 329.168
R240 VSS.t41 VSS.n821 329.168
R241 VSS.t3264 VSS.n820 329.168
R242 VSS.n843 VSS.t3181 329.168
R243 VSS.t60 VSS.n715 329.168
R244 VSS.n747 VSS.t117 329.168
R245 VSS.n749 VSS.t38 329.168
R246 VSS.t254 VSS.t149 326.649
R247 VSS.n719 VSS.t3198 326.649
R248 VSS.n211 VSS.t101 341.418
R249 VSS.n827 VSS.t85 325.714
R250 VSS.n914 VSS.t3299 321.43
R251 VSS.t3237 VSS.t239 321.43
R252 VSS.n938 VSS.t146 321.43
R253 VSS.n832 VSS.t13 321.43
R254 VSS.n15 VSS.t107 320.865
R255 VSS.t232 VSS.n713 320.834
R256 VSS.n199 VSS.t75 77.2391
R257 VSS.n109 VSS.t3175 182.042
R258 VSS.t3170 VSS.n109 182.042
R259 VSS.n109 VSS.t3163 183.805
R260 VSS.n109 VSS.t3155 182.042
R261 VSS.t3150 VSS.n109 182.042
R262 VSS.n109 VSS.t3145 182.042
R263 VSS.n109 VSS.t3140 182.042
R264 VSS.n109 VSS.t3138 183.805
R265 VSS.n109 VSS.t3128 183.805
R266 VSS.n109 VSS.t3120 182.042
R267 VSS.t3115 VSS.n109 182.042
R268 VSS.t3113 VSS.n109 183.806
R269 VSS.n109 VSS.t3108 183.805
R270 VSS.n109 VSS.t3100 182.042
R271 VSS.n109 VSS.t3090 182.038
R272 VSS.n109 VSS.t3088 183.806
R273 VSS.n109 VSS.t3080 182.042
R274 VSS.t3075 VSS.n109 182.042
R275 VSS.n109 VSS.t3070 182.042
R276 VSS.n109 VSS.t3068 183.805
R277 VSS.n109 VSS.t3063 183.806
R278 VSS.t3055 VSS.n109 182.042
R279 VSS.t3050 VSS.n109 182.042
R280 VSS.t3045 VSS.n109 182.042
R281 VSS.n109 VSS.t3043 183.805
R282 VSS.t3035 VSS.n109 182.042
R283 VSS.t3030 VSS.n109 182.042
R284 VSS.n109 VSS.t3028 183.806
R285 VSS.t3020 VSS.n109 182.042
R286 VSS.t3015 VSS.n109 182.042
R287 VSS.t3010 VSS.n109 182.042
R288 VSS.t3005 VSS.n109 182.042
R289 VSS.t3000 VSS.n109 182.042
R290 VSS.t2995 VSS.n109 182.042
R291 VSS.n109 VSS.t2990 182.042
R292 VSS.n109 VSS.t2985 182.042
R293 VSS.t2983 VSS.n109 183.805
R294 VSS.n109 VSS.t2975 182.042
R295 VSS.t2973 VSS.n109 183.805
R296 VSS.t2968 VSS.n109 183.806
R297 VSS.n109 VSS.t2960 182.042
R298 VSS.n109 VSS.t2955 182.042
R299 VSS.n109 VSS.t2950 182.042
R300 VSS.n109 VSS.t2940 182.042
R301 VSS.n109 VSS.t2935 182.042
R302 VSS.n109 VSS.t2930 182.042
R303 VSS.n109 VSS.t2925 182.042
R304 VSS.n109 VSS.t2920 182.042
R305 VSS.t2915 VSS.n109 182.042
R306 VSS.t2913 VSS.n109 183.805
R307 VSS.t2905 VSS.n109 182.042
R308 VSS.t3246 VSS.t272 317.144
R309 VSS.t3247 VSS.t3180 317.144
R310 VSS.n745 VSS.t152 313.755
R311 VSS.t110 VSS.t3183 308.572
R312 VSS.t55 VSS.t2 291.142
R313 VSS.n835 VSS.t65 305.159
R314 VSS.n738 VSS.t3284 305.159
R315 VSS.n744 VSS.t3307 305.159
R316 VSS.t3256 VSS.n134 312.969
R317 VSS.n845 VSS.t3285 304.286
R318 VSS.t150 VSS.n201 304.615
R319 VSS.t3291 VSS.n916 295.714
R320 VSS.n915 VSS.t3298 295.714
R321 VSS.t137 VSS.n940 295.714
R322 VSS.n939 VSS.t145 295.714
R323 VSS.n833 VSS.t15 295.714
R324 VSS.n846 VSS.t24 295.714
R325 VSS.n854 VSS.t120 292.264
R326 VSS.t157 VSS.n720 292.264
R327 VSS.t226 VSS.n734 292.264
R328 VSS.t243 VSS.n728 292.264
R329 VSS.t164 VSS.n12 290.779
R330 VSS.n742 VSS.t299 287.966
R331 VSS.n771 VSS.t70 287.144
R332 VSS.n906 VSS.t200 287.144
R333 VSS.n132 VSS.t234 293.533
R334 VSS.t233 VSS.t188 287.144
R335 VSS.t3268 VSS.n820 283.334
R336 VSS.t90 VSS.n726 283.334
R337 VSS.n854 VSS.t52 275.072
R338 VSS.t56 VSS.n835 275.072
R339 VSS.t2 VSS.n163 10.4544
R340 VSS.t0 VSS.t2 274.2
R341 VSS.n777 VSS.t3292 270
R342 VSS.n759 VSS.t138 270
R343 VSS.n834 VSS.t16 270
R344 VSS.n847 VSS.t23 270
R345 VSS.t245 VSS.t212 266.476
R346 VSS.t211 VSS.t35 266.476
R347 VSS.t3281 VSS.t94 265.714
R348 VSS.t3216 VSS.t100 265.714
R349 VSS.t3206 VSS.n822 265.714
R350 VSS.n132 VSS.t263 97.9414
R351 VSS.t3280 VSS.t3289 258.334
R352 VSS.t3213 VSS.t124 258.334
R353 VSS.n868 VSS.t57 258.334
R354 VSS.t203 VSS.t230 258.334
R355 VSS.n856 VSS.t180 258.334
R356 VSS.t173 VSS.t91 258.334
R357 VSS.t3219 VSS.t291 258.334
R358 VSS.t196 VSS.n839 258.334
R359 VSS.t32 VSS.n714 258.334
R360 VSS.t64 VSS.t3215 258.334
R361 VSS.n748 VSS.t237 258.334
R362 VSS.t161 VSS.n836 257.88
R363 VSS.t155 VSS.t105 257.88
R364 VSS.t194 VSS.n860 257.144
R365 VSS.n127 VSS.t721 99.5776
R366 VSS.t54 VSS.t580 108.999
R367 VSS.t739 VSS.n151 99.5774
R368 VSS.t54 VSS.n149 9.63482
R369 VSS.t743 VSS.n154 99.5774
R370 VSS.n146 VSS.t745 99.5774
R371 VSS.t747 VSS.n156 99.5774
R372 VSS.n145 VSS.t749 99.5774
R373 VSS.n158 VSS.t54 9.63482
R374 VSS.t54 VSS.n143 9.63482
R375 VSS.n159 VSS.t54 9.63482
R376 VSS.t54 VSS.n140 9.63482
R377 VSS.t760 VSS.n167 99.5774
R378 VSS.t54 VSS.n138 9.63482
R379 VSS.n169 VSS.t54 9.63482
R380 VSS.n136 VSS.t766 99.5774
R381 VSS.t768 VSS.n173 99.5774
R382 VSS.n130 VSS.t723 99.5774
R383 VSS.n126 VSS.t725 99.5774
R384 VSS.n84 VSS.t536 251.417
R385 VSS.n85 VSS.t539 251.417
R386 VSS.n87 VSS.t542 251.417
R387 VSS.n81 VSS.t545 251.417
R388 VSS.n82 VSS.t548 251.417
R389 VSS.t663 VSS.n77 251.417
R390 VSS.n91 VSS.t667 251.417
R391 VSS.n75 VSS.t719 251.417
R392 VSS.n19 VSS.t484 251.417
R393 VSS.t3279 VSS.n928 250.952
R394 VSS.n864 VSS.t3211 250.952
R395 VSS.n844 VSS.t3217 250.952
R396 VSS.n716 VSS.t88 250.952
R397 VSS.n855 VSS.t280 250
R398 VSS.n932 VSS.t294 249.002
R399 VSS.t3190 VSS.n56 249.002
R400 VSS.t112 VSS.n21 249.002
R401 VSS.n778 VSS.t3293 244.286
R402 VSS.n779 VSS.t3296 244.286
R403 VSS.n760 VSS.t139 244.286
R404 VSS.n761 VSS.t143 244.286
R405 VSS.n850 VSS.t17 244.286
R406 VSS.t554 VSS.n121 100.903
R407 VSS.t607 VSS.n131 100.883
R408 VSS.n125 VSS.t54 9.30721
R409 VSS.n129 VSS.t54 9.30721
R410 VSS.n174 VSS.t54 9.30721
R411 VSS.n137 VSS.t642 100.883
R412 VSS.t639 VSS.n170 100.883
R413 VSS.n139 VSS.t637 100.883
R414 VSS.t634 VSS.n168 100.883
R415 VSS.t54 VSS.n141 9.30721
R416 VSS.n160 VSS.t54 9.30721
R417 VSS.n142 VSS.t626 100.883
R418 VSS.t623 VSS.n157 100.883
R419 VSS.t54 VSS.n144 9.30721
R420 VSS.n155 VSS.t54 9.30721
R421 VSS.t54 VSS.n147 9.30721
R422 VSS.t612 VSS.n153 100.883
R423 VSS.t54 VSS.n148 9.30721
R424 VSS.n83 VSS.t653 242.846
R425 VSS.n86 VSS.t655 242.846
R426 VSS.n88 VSS.t657 242.846
R427 VSS.n80 VSS.t659 242.846
R428 VSS.t698 VSS.n924 242.846
R429 VSS.t3226 VSS.t3193 237.5
R430 VSS.t464 VSS.n171 102.07
R431 VSS.n26 VSS.t2228 108.722
R432 VSS.n26 VSS.t2233 108.999
R433 VSS.n26 VSS.t2243 108.999
R434 VSS.n26 VSS.t2273 108.999
R435 VSS.n26 VSS.t2283 108.999
R436 VSS.n26 VSS.t2298 109.001
R437 VSS.n26 VSS.t2308 109.001
R438 VSS.n26 VSS.t2313 108.999
R439 VSS.n26 VSS.t2333 108.999
R440 VSS.n26 VSS.t2373 108.999
R441 VSS.n26 VSS.t2383 108.999
R442 VSS.n26 VSS.t2393 108.999
R443 VSS.n26 VSS.t2408 109.001
R444 VSS.n26 VSS.t2418 109.001
R445 VSS.n26 VSS.t2423 108.999
R446 VSS.n26 VSS.t2468 108.999
R447 VSS.n26 VSS.t2478 108.999
R448 VSS.t2483 VSS.n26 108.999
R449 VSS.t2493 VSS.n26 108.999
R450 VSS.n23 VSS.t1841 108.999
R451 VSS.t1871 VSS.n23 108.999
R452 VSS.t1881 VSS.n23 108.999
R453 VSS.n23 VSS.t1886 109.001
R454 VSS.t1901 VSS.n23 108.999
R455 VSS.t1911 VSS.n23 108.999
R456 VSS.t1951 VSS.n23 108.999
R457 VSS.n23 VSS.t1976 108.999
R458 VSS.t1981 VSS.n23 108.999
R459 VSS.t2006 VSS.n23 109.001
R460 VSS.n23 VSS.t2021 108.999
R461 VSS.t2026 VSS.n23 108.999
R462 VSS.n23 VSS.t2051 108.999
R463 VSS.t2066 VSS.n23 108.999
R464 VSS.n23 VSS.t2071 108.999
R465 VSS.t2076 VSS.n23 109.001
R466 VSS.n23 VSS.t2081 108.999
R467 VSS.n23 VSS.t2091 108.999
R468 VSS.n23 VSS.t2101 108.999
R469 VSS.n23 VSS.t2111 108.999
R470 VSS.n24 VSS.t1444 108.722
R471 VSS.n24 VSS.t1449 108.999
R472 VSS.t1479 VSS.n24 108.999
R473 VSS.t1489 VSS.n24 108.999
R474 VSS.n24 VSS.t1494 109.001
R475 VSS.t1509 VSS.n24 108.999
R476 VSS.t1519 VSS.n24 108.999
R477 VSS.t1559 VSS.n24 108.999
R478 VSS.t1569 VSS.n24 108.999
R479 VSS.t1589 VSS.n24 109.001
R480 VSS.t1609 VSS.n24 108.999
R481 VSS.n24 VSS.t1624 108.999
R482 VSS.n24 VSS.t1634 108.999
R483 VSS.t1639 VSS.n24 108.999
R484 VSS.n24 VSS.t1654 108.999
R485 VSS.t1669 VSS.n24 108.999
R486 VSS.t1679 VSS.n24 108.999
R487 VSS.n24 VSS.t1684 109.001
R488 VSS.t805 VSS.n25 108.999
R489 VSS.n25 VSS.t840 108.999
R490 VSS.t855 VSS.n25 108.999
R491 VSS.n25 VSS.t880 109.001
R492 VSS.t915 VSS.n25 108.999
R493 VSS.t925 VSS.n25 108.999
R494 VSS.t950 VSS.n25 108.999
R495 VSS.t960 VSS.n25 108.999
R496 VSS.t990 VSS.n25 109.001
R497 VSS.n25 VSS.t1015 108.999
R498 VSS.t1030 VSS.n25 108.999
R499 VSS.n25 VSS.t1035 108.999
R500 VSS.t1040 VSS.n25 108.999
R501 VSS.n25 VSS.t1045 108.999
R502 VSS.t54 VSS.n197 9.63523
R503 VSS.n182 VSS.t652 251.417
R504 VSS.n216 VSS.t654 251.417
R505 VSS.n215 VSS.t656 251.417
R506 VSS.n203 VSS.t658 251.417
R507 VSS.n214 VSS.t660 251.417
R508 VSS.n114 VSS.t665 248.656
R509 VSS.t553 VSS.n764 235.714
R510 VSS.t687 VSS.t54 252.065
R511 VSS.n151 VSS.t608 242.431
R512 VSS.t611 VSS.n149 242.431
R513 VSS.n154 VSS.t613 242.431
R514 VSS.t616 VSS.n146 242.431
R515 VSS.n156 VSS.t619 242.431
R516 VSS.t622 VSS.n145 242.431
R517 VSS.n158 VSS.t624 242.431
R518 VSS.t627 VSS.n143 242.431
R519 VSS.n159 VSS.t630 242.431
R520 VSS.t633 VSS.n140 242.431
R521 VSS.n167 VSS.t635 242.431
R522 VSS.t638 VSS.n138 242.431
R523 VSS.n169 VSS.t640 242.431
R524 VSS.t643 VSS.n136 242.431
R525 VSS.n173 VSS.t645 242.431
R526 VSS.n922 VSS.t699 235.714
R527 VSS.n912 VSS.t714 235.714
R528 VSS.n127 VSS.t602 242.431
R529 VSS.n130 VSS.t604 242.431
R530 VSS.n126 VSS.t606 242.431
R531 VSS.t3189 VSS.t728 235.714
R532 VSS.n212 VSS.t468 251.417
R533 VSS.t209 VSS.n161 69.0108
R534 VSS.n937 VSS.t480 235.714
R535 VSS.t2 VSS.t410 108.722
R536 VSS.t2 VSS.t415 108.999
R537 VSS.t769 VSS.t646 234.188
R538 VSS.n853 VSS.t292 233.333
R539 VSS.n718 VSS.t148 233.333
R540 VSS.t206 VSS.n725 233.333
R541 VSS.n866 VSS.t732 229.167
R542 VSS.n23 VSS.t1859 109.992
R543 VSS.n23 VSS.t1919 109.993
R544 VSS.n23 VSS.t1924 109.992
R545 VSS.n24 VSS.t1467 109.992
R546 VSS.n24 VSS.t1527 109.993
R547 VSS.n24 VSS.t1532 109.992
R548 VSS.n25 VSS.t773 109.986
R549 VSS.n25 VSS.t783 109.992
R550 VSS.n25 VSS.t848 109.992
R551 VSS.n203 VSS.t544 242.846
R552 VSS.n214 VSS.t547 242.846
R553 VSS.n162 VSS.t670 232.714
R554 VSS.t54 VSS.t563 109.993
R555 VSS.t54 VSS.t573 109.992
R556 VSS.t740 VSS.n148 234.188
R557 VSS.t744 VSS.n147 234.188
R558 VSS.n155 VSS.t746 234.188
R559 VSS.t748 VSS.n144 234.188
R560 VSS.n160 VSS.t754 234.188
R561 VSS.t757 VSS.n141 234.188
R562 VSS.n174 VSS.t767 234.188
R563 VSS.n917 VSS.t709 227.143
R564 VSS.n911 VSS.t717 227.143
R565 VSS.t722 VSS.n129 234.188
R566 VSS.t724 VSS.n125 234.188
R567 VSS.n134 VSS.t730 102.457
R568 VSS.n211 VSS.t470 242.846
R569 VSS.n941 VSS.t477 227.143
R570 VSS.t482 VSS.n762 227.143
R571 VSS.n825 VSS.t485 227.143
R572 VSS.n732 VSS.t300 223.496
R573 VSS.t706 VSS.t3318 222.857
R574 VSS.t475 VSS.t131 222.857
R575 VSS.t54 VSS.t727 222.041
R576 VSS.n867 VSS.t734 220.833
R577 VSS.t3295 VSS.n776 218.571
R578 VSS.t141 VSS.n758 218.571
R579 VSS.t19 VSS.n849 218.571
R580 VSS.n849 VSS.t20 218.571
R581 VSS.t467 VSS.n689 206.304
R582 VSS.n737 VSS.t467 206.304
R583 VSS.t662 VSS.t54 110.71
R584 VSS.t663 VSS.n97 183.584
R585 VSS.n135 VSS.t599 15.0018
R586 VSS.n827 VSS.t486 205.714
R587 VSS.t486 VSS.n822 205.714
R588 VSS.n848 VSS.t487 205.714
R589 VSS.t68 VSS.n79 204.274
R590 VSS.t3233 VSS.t720 201.429
R591 VSS.t465 VSS.t2 201.143
R592 VSS.t2276 VSS.n26 109.993
R593 VSS.t2296 VSS.n26 109.993
R594 VSS.t2306 VSS.n26 109.993
R595 VSS.t2316 VSS.n26 109.993
R596 VSS.t2331 VSS.n26 109.993
R597 VSS.t2346 VSS.n26 109.993
R598 VSS.t2366 VSS.n26 109.993
R599 VSS.t2376 VSS.n26 109.993
R600 VSS.t2386 VSS.n26 109.993
R601 VSS.t2396 VSS.n26 109.993
R602 VSS.t2416 VSS.n26 109.993
R603 VSS.t2426 VSS.n26 109.993
R604 VSS.t2436 VSS.n26 109.993
R605 VSS.t2446 VSS.n26 109.993
R606 VSS.n26 VSS.t2466 109.993
R607 VSS.t2481 VSS.n26 109.993
R608 VSS.t2506 VSS.n26 109.993
R609 VSS.t1894 VSS.n23 109.993
R610 VSS.t1914 VSS.n23 109.993
R611 VSS.t1939 VSS.n23 109.993
R612 VSS.t1969 VSS.n23 109.993
R613 VSS.t1984 VSS.n23 109.993
R614 VSS.t2014 VSS.n23 109.993
R615 VSS.t2039 VSS.n23 109.993
R616 VSS.t2084 VSS.n23 109.993
R617 VSS.t2104 VSS.n23 109.993
R618 VSS.t2114 VSS.n23 109.993
R619 VSS.t1502 VSS.n24 109.993
R620 VSS.t1522 VSS.n24 109.993
R621 VSS.t1537 VSS.n24 109.993
R622 VSS.t1547 VSS.n24 109.993
R623 VSS.t1572 VSS.n24 109.993
R624 VSS.t1627 VSS.n24 109.993
R625 VSS.t1642 VSS.n24 109.993
R626 VSS.t1662 VSS.n24 109.993
R627 VSS.t1672 VSS.n24 109.993
R628 VSS.t1692 VSS.n24 109.993
R629 VSS.t1712 VSS.n24 109.993
R630 VSS.t1722 VSS.n24 109.993
R631 VSS.t788 VSS.n25 109.993
R632 VSS.t818 VSS.n25 109.993
R633 VSS.t828 VSS.n25 109.993
R634 VSS.t838 VSS.n25 109.993
R635 VSS.t843 VSS.n25 109.993
R636 VSS.t853 VSS.n25 109.993
R637 VSS.t863 VSS.n25 109.993
R638 VSS.t888 VSS.n25 109.993
R639 VSS.t908 VSS.n25 109.993
R640 VSS.t933 VSS.n25 109.993
R641 VSS.t953 VSS.n25 109.993
R642 VSS.t958 VSS.n25 109.993
R643 VSS.t963 VSS.n25 109.993
R644 VSS.t978 VSS.n25 109.993
R645 VSS.t988 VSS.n25 109.993
R646 VSS.t1008 VSS.n25 109.993
R647 VSS.t1048 VSS.n25 109.993
R648 VSS.t524 VSS.t54 109.986
R649 VSS.t54 VSS.t529 109.993
R650 VSS.t666 VSS.t54 200.613
R651 VSS.t558 VSS.t54 109.986
R652 VSS.t54 VSS.t583 109.993
R653 VSS.t587 VSS.t54 109.993
R654 VSS.t738 VSS.t54 200.613
R655 VSS.t704 VSS.t54 200.613
R656 VSS.n134 VSS.t54 7.66905
R657 VSS.t474 VSS.t2 200.613
R658 VSS.t413 VSS.t2 109.986
R659 VSS.n76 VSS.t534 199.989
R660 VSS.n83 VSS.t538 199.989
R661 VSS.n86 VSS.t541 199.989
R662 VSS.n88 VSS.t544 199.989
R663 VSS.n80 VSS.t547 199.989
R664 VSS.t550 VSS.n98 109.579
R665 VSS.t551 VSS.n97 102.626
R666 VSS.t668 VSS.n89 199.989
R667 VSS.n64 VSS.t740 199.989
R668 VSS.t742 VSS.n65 199.989
R669 VSS.n63 VSS.t744 199.989
R670 VSS.t746 VSS.n66 199.989
R671 VSS.n62 VSS.t748 199.989
R672 VSS.t750 VSS.n67 199.989
R673 VSS.n61 VSS.t752 199.989
R674 VSS.t754 VSS.n68 199.989
R675 VSS.n60 VSS.t757 199.989
R676 VSS.t759 VSS.n69 199.989
R677 VSS.n59 VSS.t761 199.989
R678 VSS.t763 VSS.n70 199.989
R679 VSS.n58 VSS.t765 199.989
R680 VSS.t767 VSS.n71 199.989
R681 VSS.n57 VSS.t769 199.989
R682 VSS.n909 VSS.t722 199.989
R683 VSS.n908 VSS.t724 199.989
R684 VSS.n907 VSS.t726 199.989
R685 VSS.n778 VSS.t3294 192.857
R686 VSS.n779 VSS.t3295 192.857
R687 VSS.n760 VSS.t140 192.857
R688 VSS.n761 VSS.t141 192.857
R689 VSS.n850 VSS.t19 192.857
R690 VSS.t20 VSS.n848 192.857
R691 VSS.t2 VSS.n171 7.34127
R692 VSS.n26 VSS.t2503 108.999
R693 VSS.t2498 VSS.n26 109.001
R694 VSS.t2496 VSS.n26 109.993
R695 VSS.t2488 VSS.n26 109.001
R696 VSS.t2486 VSS.n26 109.993
R697 VSS.n26 VSS.t2473 109.001
R698 VSS.n26 VSS.t2471 109.993
R699 VSS.t2463 VSS.n26 108.999
R700 VSS.t2458 VSS.n26 109.001
R701 VSS.t2453 VSS.n26 108.999
R702 VSS.t2448 VSS.n26 109.001
R703 VSS.t2443 VSS.n26 108.999
R704 VSS.t2438 VSS.n26 109.001
R705 VSS.t2433 VSS.n26 108.999
R706 VSS.t2428 VSS.n26 109.001
R707 VSS.n26 VSS.t2421 109.992
R708 VSS.t2413 VSS.n26 108.999
R709 VSS.n26 VSS.t2411 109.992
R710 VSS.t2403 VSS.n26 109.001
R711 VSS.t2398 VSS.n26 108.999
R712 VSS.t2388 VSS.n26 109.001
R713 VSS.t2378 VSS.n26 109.001
R714 VSS.t2368 VSS.n26 109.001
R715 VSS.t2363 VSS.n26 108.999
R716 VSS.t2358 VSS.n26 109.001
R717 VSS.t2353 VSS.n26 108.999
R718 VSS.t2348 VSS.n26 109.001
R719 VSS.t2343 VSS.n26 108.999
R720 VSS.t2338 VSS.n26 109.001
R721 VSS.n26 VSS.t2336 109.993
R722 VSS.t2328 VSS.n26 108.999
R723 VSS.t2323 VSS.n26 109.001
R724 VSS.n26 VSS.t2311 109.992
R725 VSS.t2303 VSS.n26 108.999
R726 VSS.n26 VSS.t2301 109.992
R727 VSS.t2293 VSS.n26 108.999
R728 VSS.t2288 VSS.n26 109.001
R729 VSS.n26 VSS.t2286 109.993
R730 VSS.t2278 VSS.n26 109.001
R731 VSS.t2268 VSS.n26 109.001
R732 VSS.t2263 VSS.n26 108.999
R733 VSS.t2258 VSS.n26 109.001
R734 VSS.t2253 VSS.n26 108.999
R735 VSS.t2248 VSS.n26 109.001
R736 VSS.n26 VSS.t2246 109.993
R737 VSS.t2238 VSS.n26 109.001
R738 VSS.n26 VSS.t2236 109.993
R739 VSS.t2318 VSS.n26 108.999
R740 VSS.n23 VSS.t2106 109.001
R741 VSS.n23 VSS.t2096 109.001
R742 VSS.n23 VSS.t2094 109.993
R743 VSS.n23 VSS.t2086 109.001
R744 VSS.t2079 VSS.n23 109.992
R745 VSS.n23 VSS.t2074 109.993
R746 VSS.t2069 VSS.n23 109.993
R747 VSS.t2061 VSS.n23 109.001
R748 VSS.n23 VSS.t2056 108.999
R749 VSS.n23 VSS.t2054 109.993
R750 VSS.n23 VSS.t2046 108.999
R751 VSS.t2041 VSS.n23 109.001
R752 VSS.n23 VSS.t2036 108.999
R753 VSS.t2031 VSS.n23 109.001
R754 VSS.t2029 VSS.n23 109.993
R755 VSS.n23 VSS.t2024 109.993
R756 VSS.n23 VSS.t2016 109.001
R757 VSS.t2011 VSS.n23 108.999
R758 VSS.t2009 VSS.n23 109.992
R759 VSS.t2001 VSS.n23 108.999
R760 VSS.t1996 VSS.n23 109.001
R761 VSS.n23 VSS.t1991 109.001
R762 VSS.t1986 VSS.n23 108.999
R763 VSS.n23 VSS.t1979 109.993
R764 VSS.n23 VSS.t1971 109.001
R765 VSS.t1966 VSS.n23 108.999
R766 VSS.n23 VSS.t1961 108.999
R767 VSS.t1956 VSS.n23 109.001
R768 VSS.t1954 VSS.n23 109.993
R769 VSS.t1946 VSS.n23 109.001
R770 VSS.n23 VSS.t1941 108.999
R771 VSS.t1936 VSS.n23 108.999
R772 VSS.n23 VSS.t1931 109.001
R773 VSS.n23 VSS.t1921 109.001
R774 VSS.t1916 VSS.n23 108.999
R775 VSS.t1906 VSS.n23 109.001
R776 VSS.t1904 VSS.n23 109.993
R777 VSS.t1896 VSS.n23 109.001
R778 VSS.n23 VSS.t1891 108.999
R779 VSS.n23 VSS.t1889 109.992
R780 VSS.t1884 VSS.n23 109.993
R781 VSS.t1876 VSS.n23 109.001
R782 VSS.t1874 VSS.n23 109.993
R783 VSS.t1866 VSS.n23 109.001
R784 VSS.t1864 VSS.n23 109.993
R785 VSS.n23 VSS.t1856 109.001
R786 VSS.t1851 VSS.n23 108.999
R787 VSS.t1846 VSS.n23 109.001
R788 VSS.n23 VSS.t1844 109.993
R789 VSS.t1836 VSS.n23 108.722
R790 VSS.t1929 VSS.n23 109.993
R791 VSS.n24 VSS.t1719 108.999
R792 VSS.t1714 VSS.n24 109.001
R793 VSS.n24 VSS.t1709 108.999
R794 VSS.t1704 VSS.n24 109.001
R795 VSS.n24 VSS.t1699 108.999
R796 VSS.t1694 VSS.n24 109.001
R797 VSS.n24 VSS.t1689 108.999
R798 VSS.n24 VSS.t1687 109.992
R799 VSS.t1682 VSS.n24 109.993
R800 VSS.t1674 VSS.n24 109.001
R801 VSS.t1664 VSS.n24 109.001
R802 VSS.n24 VSS.t1659 108.999
R803 VSS.n24 VSS.t1657 109.993
R804 VSS.n24 VSS.t1649 109.001
R805 VSS.t1644 VSS.n24 108.999
R806 VSS.n24 VSS.t1637 109.993
R807 VSS.n24 VSS.t1629 109.001
R808 VSS.n24 VSS.t1619 108.999
R809 VSS.t1614 VSS.n24 109.001
R810 VSS.t1612 VSS.n24 109.993
R811 VSS.t1604 VSS.n24 109.001
R812 VSS.n24 VSS.t1599 109.001
R813 VSS.t1594 VSS.n24 108.999
R814 VSS.t1592 VSS.n24 109.992
R815 VSS.t1584 VSS.n24 108.999
R816 VSS.n24 VSS.t1579 109.001
R817 VSS.t1574 VSS.n24 108.999
R818 VSS.t1564 VSS.n24 109.001
R819 VSS.t1562 VSS.n24 109.993
R820 VSS.t1554 VSS.n24 109.001
R821 VSS.n24 VSS.t1549 108.999
R822 VSS.t1544 VSS.n24 108.999
R823 VSS.n24 VSS.t1539 109.001
R824 VSS.n24 VSS.t1529 109.001
R825 VSS.t1524 VSS.n24 108.999
R826 VSS.t1514 VSS.n24 109.001
R827 VSS.t1512 VSS.n24 109.993
R828 VSS.t1504 VSS.n24 109.001
R829 VSS.n24 VSS.t1499 108.999
R830 VSS.n24 VSS.t1497 109.992
R831 VSS.t1492 VSS.n24 109.993
R832 VSS.t1484 VSS.n24 109.001
R833 VSS.t1482 VSS.n24 109.993
R834 VSS.t1474 VSS.n24 109.001
R835 VSS.t1472 VSS.n24 109.993
R836 VSS.n24 VSS.t1464 109.001
R837 VSS.t1459 VSS.n24 108.999
R838 VSS.t1454 VSS.n24 109.001
R839 VSS.n24 VSS.t1452 109.993
R840 VSS.t1043 VSS.n25 109.993
R841 VSS.n25 VSS.t1038 109.993
R842 VSS.t1033 VSS.n25 109.993
R843 VSS.t1025 VSS.n25 109.001
R844 VSS.n25 VSS.t1020 109.001
R845 VSS.n25 VSS.t1018 109.993
R846 VSS.n25 VSS.t1010 109.001
R847 VSS.t1005 VSS.n25 108.999
R848 VSS.n25 VSS.t1000 109.001
R849 VSS.t995 VSS.n25 108.999
R850 VSS.t993 VSS.n25 109.992
R851 VSS.t985 VSS.n25 108.999
R852 VSS.n25 VSS.t980 109.001
R853 VSS.t975 VSS.n25 108.999
R854 VSS.n25 VSS.t970 109.001
R855 VSS.t965 VSS.n25 109.001
R856 VSS.t955 VSS.n25 108.999
R857 VSS.t945 VSS.n25 109.001
R858 VSS.n25 VSS.t940 108.999
R859 VSS.t935 VSS.n25 109.001
R860 VSS.t930 VSS.n25 108.999
R861 VSS.t928 VSS.n25 109.993
R862 VSS.t920 VSS.n25 109.001
R863 VSS.t918 VSS.n25 109.993
R864 VSS.t910 VSS.n25 109.001
R865 VSS.n25 VSS.t905 108.999
R866 VSS.t900 VSS.n25 109.001
R867 VSS.n25 VSS.t895 108.999
R868 VSS.t890 VSS.n25 109.001
R869 VSS.n25 VSS.t885 108.999
R870 VSS.n25 VSS.t883 109.992
R871 VSS.n25 VSS.t875 109.001
R872 VSS.t870 VSS.n25 108.999
R873 VSS.n25 VSS.t865 109.001
R874 VSS.t858 VSS.n25 109.993
R875 VSS.t850 VSS.n25 108.999
R876 VSS.n25 VSS.t845 109.001
R877 VSS.n25 VSS.t835 108.999
R878 VSS.t830 VSS.n25 109.001
R879 VSS.n25 VSS.t825 108.999
R880 VSS.t820 VSS.n25 109.001
R881 VSS.n25 VSS.t815 108.999
R882 VSS.t810 VSS.n25 109.001
R883 VSS.t808 VSS.n25 109.993
R884 VSS.t800 VSS.n25 109.001
R885 VSS.n25 VSS.t795 108.999
R886 VSS.n25 VSS.t790 109.001
R887 VSS.t780 VSS.n25 109.001
R888 VSS.t775 VSS.n25 109.001
R889 VSS.t770 VSS.n25 108.722
R890 VSS.n25 VSS.t860 108.999
R891 VSS.t54 VSS.t589 109.001
R892 VSS.t54 VSS.t584 108.999
R893 VSS.t54 VSS.t578 109.993
R894 VSS.t570 VSS.t54 109.001
R895 VSS.t565 VSS.t54 109.001
R896 VSS.t560 VSS.t54 108.999
R897 VSS.t556 VSS.t54 108.993
R898 VSS.t526 VSS.t54 108.999
R899 VSS.t521 VSS.t54 108.722
R900 VSS.n135 VSS.t54 96.0266
R901 VSS.t54 VSS.t594 109.001
R902 VSS.t54 VSS.t728 192.042
R903 VSS.n161 VSS.t472 101.781
R904 VSS.t2 VSS.t418 109.993
R905 VSS.t54 VSS.t669 108.951
R906 VSS.t652 VSS.n84 191.417
R907 VSS.t654 VSS.n85 191.417
R908 VSS.t656 VSS.n87 191.417
R909 VSS.t658 VSS.n81 191.417
R910 VSS.t660 VSS.n82 191.417
R911 VSS.n89 VSS.t553 191.417
R912 VSS.t608 VSS.n64 191.417
R913 VSS.n65 VSS.t611 191.417
R914 VSS.t613 VSS.n63 191.417
R915 VSS.n66 VSS.t616 191.417
R916 VSS.t619 VSS.n62 191.417
R917 VSS.n67 VSS.t622 191.417
R918 VSS.t624 VSS.n61 191.417
R919 VSS.n68 VSS.t627 191.417
R920 VSS.t630 VSS.n60 191.417
R921 VSS.n69 VSS.t633 191.417
R922 VSS.t635 VSS.n59 191.417
R923 VSS.n70 VSS.t638 191.417
R924 VSS.t640 VSS.n58 191.417
R925 VSS.n71 VSS.t643 191.417
R926 VSS.t645 VSS.n57 191.417
R927 VSS.t699 VSS.n921 191.417
R928 VSS.t602 VSS.n909 191.417
R929 VSS.t604 VSS.n908 191.417
R930 VSS.t606 VSS.n907 191.417
R931 VSS.t732 VSS.n73 186.502
R932 VSS.t653 VSS.n770 184.286
R933 VSS.t655 VSS.n769 184.286
R934 VSS.t657 VSS.n768 184.286
R935 VSS.t659 VSS.n767 184.286
R936 VSS.t661 VSS.n766 184.286
R937 VSS.t668 VSS.n121 234.186
R938 VSS.t610 VSS.n148 100.883
R939 VSS.t742 VSS.n153 234.188
R940 VSS.t615 VSS.n147 100.883
R941 VSS.n155 VSS.t617 100.883
R942 VSS.t621 VSS.n144 100.883
R943 VSS.t750 VSS.n157 234.188
R944 VSS.n142 VSS.t752 234.188
R945 VSS.n160 VSS.t628 100.883
R946 VSS.t631 VSS.n141 100.883
R947 VSS.t759 VSS.n168 234.188
R948 VSS.n139 VSS.t761 234.188
R949 VSS.t763 VSS.n170 234.188
R950 VSS.n137 VSS.t765 234.188
R951 VSS.n174 VSS.t644 100.883
R952 VSS.n925 VSS.t698 184.286
R953 VSS.n920 VSS.t700 184.286
R954 VSS.t713 VSS.n775 184.286
R955 VSS.t720 VSS.n781 184.286
R956 VSS.n129 VSS.t603 100.883
R957 VSS.n125 VSS.t605 100.883
R958 VSS.t726 VSS.n131 234.188
R959 VSS.t470 VSS.n751 184.286
R960 VSS.t479 VSS.n757 184.286
R961 VSS.t690 VSS.n930 179.167
R962 VSS.n863 VSS.t734 179.167
R963 VSS.t300 VSS.t264 176.219
R964 VSS.t531 VSS.n197 99.5817
R965 VSS.t536 VSS.n770 175.714
R966 VSS.t539 VSS.n769 175.714
R967 VSS.t542 VSS.n768 175.714
R968 VSS.t545 VSS.n767 175.714
R969 VSS.t548 VSS.n766 175.714
R970 VSS.t667 VSS.n764 175.714
R971 VSS.t741 VSS.n149 99.5774
R972 VSS.n158 VSS.t751 99.5774
R973 VSS.t753 VSS.n143 99.5774
R974 VSS.n159 VSS.t756 99.5774
R975 VSS.t758 VSS.n140 99.5774
R976 VSS.t762 VSS.n138 99.5774
R977 VSS.n169 VSS.t764 99.5774
R978 VSS.n773 VSS.t706 175.714
R979 VSS.t711 VSS.n776 175.714
R980 VSS.t719 VSS.n782 175.714
R981 VSS.n752 VSS.t468 175.714
R982 VSS.n755 VSS.t475 175.714
R983 VSS.t478 VSS.n758 175.714
R984 VSS.t485 VSS.t80 175.714
R985 VSS.t717 VSS.t3303 171.429
R986 VSS.t3312 VSS.t482 171.429
R987 VSS.n931 VSS.t692 170.833
R988 VSS.n78 VSS.t93 169.989
R989 VSS.n90 VSS.t184 169.989
R990 VSS.t87 VSS.t223 167.623
R991 VSS.t700 VSS.t3188 167.143
R992 VSS.t3293 VSS.n777 167.143
R993 VSS.t3296 VSS.n775 167.143
R994 VSS.t261 VSS.n906 167.143
R995 VSS.t139 VSS.n759 167.143
R996 VSS.t143 VSS.n757 167.143
R997 VSS.t22 VSS.n847 167.143
R998 VSS.t294 VSS.n931 166.667
R999 VSS.n868 VSS.t3190 166.667
R1000 VSS.n856 VSS.t204 166.667
R1001 VSS.t292 VSS.n819 166.667
R1002 VSS.n839 VSS.t112 166.667
R1003 VSS.n748 VSS.t206 166.667
R1004 VSS.t695 VSS.n932 165.669
R1005 VSS.n56 VSS.t3195 165.669
R1006 VSS.t3315 VSS.t704 162.857
R1007 VSS.t127 VSS.t474 162.857
R1008 VSS.n739 VSS.t210 159.026
R1009 VSS.t670 VSS.t119 158.571
R1010 VSS.t17 VSS.t217 158.571
R1011 VSS.n4 VSS.t5 157.335
R1012 VSS.n7 VSS.t32 157.335
R1013 VSS.t237 VSS.n17 157.335
R1014 VSS.n837 VSS.t161 154.728
R1015 VSS.t240 VSS.n735 154.728
R1016 VSS.t71 VSS.n163 95.1439
R1017 VSS.t195 VSS.n727 154.728
R1018 VSS.n929 VSS.t3279 154.167
R1019 VSS.n865 VSS.t3211 154.167
R1020 VSS.n855 VSS.t227 154.167
R1021 VSS.t172 VSS.n821 154.167
R1022 VSS.t88 VSS.n715 154.167
R1023 VSS.n747 VSS.t3214 154.167
R1024 VSS.t3269 VSS.n819 150
R1025 VSS.n948 VSS.n713 150
R1026 VSS.t3 VSS.n749 150
R1027 VSS.n946 VSS.t123 146.132
R1028 VSS.n162 VSS.t114 92.4073
R1029 VSS.t3212 VSS.t736 145.714
R1030 VSS.n124 VSS.t3206 160.458
R1031 VSS.t3185 VSS.n180 157.335
R1032 VSS.t57 VSS.n867 141.667
R1033 VSS.t190 VSS.t738 141.429
R1034 VSS.n916 VSS.t3292 141.429
R1035 VSS.n915 VSS.t3297 141.429
R1036 VSS.n940 VSS.t138 141.429
R1037 VSS.n939 VSS.t144 141.429
R1038 VSS.t23 VSS.n846 141.429
R1039 VSS.n836 VSS.t56 137.536
R1040 VSS.t3301 VSS.t714 137.143
R1041 VSS.t480 VSS.t3310 137.143
R1042 VSS.t205 VSS.t54 136.327
R1043 VSS.n8 VSS.t157 136.05
R1044 VSS.n13 VSS.t226 136.05
R1045 VSS.t3266 VSS.t2 132.976
R1046 VSS.t484 VSS.t244 132.857
R1047 VSS.n10 VSS.t90 132.335
R1048 VSS.t200 VSS.n133 136.9
R1049 VSS.t234 VSS.n905 124.287
R1050 VSS.t183 VSS.n765 120.001
R1051 VSS.t736 VSS.t189 120.001
R1052 VSS.n1 VSS.t203 119.835
R1053 VSS.t91 VSS.n4 119.835
R1054 VSS.t3193 VSS.n7 119.835
R1055 VSS.t204 VSS.t3266 116.668
R1056 VSS.n852 VSS.t3268 116.668
R1057 VSS.n917 VSS.t3291 115.715
R1058 VSS.t3298 VSS.n914 115.715
R1059 VSS.n941 VSS.t137 115.715
R1060 VSS.t145 VSS.n938 115.715
R1061 VSS.t15 VSS.n832 115.715
R1062 VSS.t24 VSS.n845 115.715
R1063 VSS.t148 VSS.t265 112.501
R1064 VSS.t5 VSS.t3269 108.334
R1065 VSS.t55 VSS.t3231 107.451
R1066 VSS.t33 VSS.n179 3.54975
R1067 VSS.t3284 VSS.n735 107.451
R1068 VSS.t3227 VSS.t164 107.451
R1069 VSS.t107 VSS.n729 107.451
R1070 VSS.t3307 VSS.n727 107.451
R1071 VSS.n928 VSS.t177 107.144
R1072 VSS.t3195 VSS.n860 107.144
R1073 VSS.t695 VSS.n927 107.144
R1074 VSS.n864 VSS.t3256 107.144
R1075 VSS.n750 VSS.t3 107.144
R1076 VSS.n180 VSS.t3289 119.835
R1077 VSS.t124 VSS.n863 104.168
R1078 VSS.t291 VSS.n841 104.168
R1079 VSS.t181 VSS.t0 103.153
R1080 VSS.t223 VSS.t3197 98.8544
R1081 VSS.t210 VSS.t240 98.8544
R1082 VSS.t260 VSS.n833 98.5719
R1083 VSS.n716 VSS.t170 98.5719
R1084 VSS.n133 VSS.t54 3.7375
R1085 VSS.t59 VSS.t194 94.2862
R1086 VSS.t709 VSS.t3290 94.2862
R1087 VSS.t477 VSS.t136 94.2862
R1088 VSS.n105 VSS.t73 0.121888
R1089 VSS.t349 VSS.n112 26.2653
R1090 VSS.t3217 VSS.t26 91.6672
R1091 VSS.n113 VSS.t73 4.37815
R1092 VSS.n106 VSS.t73 0.369632
R1093 VSS.t3276 VSS.n810 90.5956
R1094 VSS.n722 VSS.t87 90.2584
R1095 VSS.n859 VSS.t3212 90.0005
R1096 VSS.n923 VSS.t3281 90.0005
R1097 VSS.t3290 VSS.n772 90.0005
R1098 VSS.n913 VSS.t3299 90.0005
R1099 VSS.n753 VSS.t3216 90.0005
R1100 VSS.t136 VSS.n754 90.0005
R1101 VSS.n936 VSS.t146 90.0005
R1102 VSS.t25 VSS.n844 90.0005
R1103 VSS.t270 VSS.n39 89.7897
R1104 VSS.t2 VSS.t208 89.4189
R1105 VSS.n176 VSS.t286 11.9808
R1106 VSS.t73 VSS.n27 0.121827
R1107 VSS.t73 VSS.t321 26.5044
R1108 VSS.t73 VSS.n119 0.121827
R1109 VSS.t329 VSS.n119 26.2522
R1110 VSS.t334 VSS.n118 26.2515
R1111 VSS.n110 VSS.t73 0.121819
R1112 VSS.n103 VSS.t73 0.225189
R1113 VSS.n806 VSS.t3199 89.2763
R1114 VSS.t366 VSS.n108 26.1547
R1115 VSS.t73 VSS.n107 0.121827
R1116 VSS.t3271 VSS.n5 88.7727
R1117 VSS.t246 VSS.n13 88.7727
R1118 VSS.n16 VSS.t155 88.7727
R1119 VSS.n114 VSS.t45 67.8926
R1120 VSS.n106 VSS.t3194 12.5765
R1121 VSS.t692 VSS.t3185 87.5005
R1122 VSS.t169 VSS.n813 86.8557
R1123 VSS.t3286 VSS.n2 86.5025
R1124 VSS.t281 VSS.n1 86.5025
R1125 VSS.t117 VSS.n10 86.5025
R1126 VSS.n17 VSS.t176 86.5025
R1127 VSS.n945 VSS.t3198 85.9604
R1128 VSS.n952 VSS.t3239 85.7552
R1129 VSS.t3263 VSS.n40 85.7552
R1130 VSS.n44 VSS.t3265 85.7543
R1131 VSS.t3236 VSS.n798 85.7543
R1132 VSS.n150 VSS.t190 99.148
R1133 VSS.t95 VSS.n920 85.7148
R1134 VSS.t3297 VSS.t713 85.7148
R1135 VSS.n944 VSS.t101 85.7148
R1136 VSS.t144 VSS.t479 85.7148
R1137 VSS.t85 VSS.n826 85.7148
R1138 VSS.n791 VSS.t3224 83.6281
R1139 VSS.t123 VSS.t465 81.6624
R1140 VSS.t76 VSS.n736 81.6624
R1141 VSS.t105 VSS.n728 81.6624
R1142 VSS.t188 VSS.n904 81.4291
R1143 VSS.t3180 VSS.n828 81.4291
R1144 VSS.t231 VSS.n806 81.2075
R1145 VSS.t97 VSS.n791 81.2075
R1146 VSS.n813 VSS.t167 80.4006
R1147 VSS.t43 VSS.n8 80.1767
R1148 VSS.n72 VSS.t125 79.9891
R1149 VSS.n924 VSS.t47 79.9891
R1150 VSS.t280 VSS.t3286 79.1672
R1151 VSS.t31 VSS.t196 79.1672
R1152 VSS.n718 VSS.t232 79.1672
R1153 VSS.n150 VSS.t54 2.91846
R1154 VSS.n807 VSS.t3272 74.234
R1155 VSS.n792 VSS.t3207 74.234
R1156 VSS.n812 VSS.t250 73.4271
R1157 VSS.n178 VSS.t73 2.33087
R1158 VSS.n721 VSS.t254 73.0664
R1159 VSS.t3183 VSS.n199 76.9533
R1160 VSS.t184 VSS.t666 72.8576
R1161 VSS.t283 VSS.n49 73.0469
R1162 VSS.n37 VSS.t11 72.8441
R1163 VSS.n35 VSS.t3221 72.8441
R1164 VSS.n32 VSS.t192 72.8441
R1165 VSS.n177 VSS.t74 76.9073
R1166 VSS.t215 VSS.n794 72.6202
R1167 VSS.n802 VSS.t3257 72.6202
R1168 VSS.t3283 VSS.n165 76.9074
R1169 VSS.t279 VSS.n236 76.9071
R1170 VSS.t2 VSS.t273 72.2022
R1171 VSS.t189 VSS.t54 72.0417
R1172 VSS.t3197 VSS.n9 71.5807
R1173 VSS.n11 VSS.t241 71.5807
R1174 VSS.n79 VSS.t111 71.4177
R1175 VSS.n930 VSS.t3288 70.8338
R1176 VSS.n866 VSS.t296 70.8338
R1177 VSS.t180 VSS.t281 70.8338
R1178 VSS.n851 VSS.t41 70.8338
R1179 VSS.n851 VSS.t3264 70.8338
R1180 VSS.t38 VSS.n725 70.8338
R1181 VSS.t252 VSS.n208 72.8451
R1182 VSS.t3238 VSS.n234 72.8451
R1183 VSS.t3203 VSS.n106 72.8798
R1184 VSS.t276 VSS.n326 72.8451
R1185 VSS.t3242 VSS.n178 14.882
R1186 VSS.t3200 VSS.n809 70.1995
R1187 VSS.n808 VSS.t3306 70.1995
R1188 VSS.n801 VSS.t103 70.1995
R1189 VSS.t218 VSS.n164 13.9374
R1190 VSS.n190 VSS.t108 13.9422
R1191 VSS.n186 VSS.t3277 13.9422
R1192 VSS.n804 VSS.t259 69.3927
R1193 VSS.t93 VSS.t68 68.5719
R1194 VSS.t177 VSS.t687 68.5719
R1195 VSS.n783 VSS.t282 68.5719
R1196 VSS.n904 VSS.t262 68.5719
R1197 VSS.n0 VSS.t181 67.2827
R1198 VSS.n5 VSS.t6 67.2827
R1199 VSS.t227 VSS.t7 66.6672
R1200 VSS.t39 VSS.t172 66.6672
R1201 VSS.t3214 VSS.n746 66.6672
R1202 VSS.t3201 VSS.n794 64.5513
R1203 VSS.t52 VSS.t3271 64.4704
R1204 VSS.t51 VSS.n730 64.4704
R1205 VSS.t273 VSS.t243 64.4704
R1206 VSS.t73 VSS.n236 10.0584
R1207 VSS.n177 VSS.t3323 16.2308
R1208 VSS.n165 VSS.t73 10.0579
R1209 VSS.n919 VSS.t3315 64.2862
R1210 VSS.n774 VSS.t3320 64.2862
R1211 VSS.t3300 VSS.n912 64.2862
R1212 VSS.n910 VSS.t3305 64.2862
R1213 VSS.t3324 VSS.n752 64.2862
R1214 VSS.n943 VSS.t127 64.2862
R1215 VSS.n756 VSS.t134 64.2862
R1216 VSS.n937 VSS.t3309 64.2862
R1217 VSS.n824 VSS.t3314 64.2862
R1218 VSS.t3251 VSS.n830 64.2862
R1219 VSS.t3209 VSS.n43 63.9684
R1220 VSS.n38 VSS.t3282 63.9684
R1221 VSS.n113 VSS.t3235 16.4138
R1222 VSS.n47 VSS.t3210 64.8345
R1223 VSS.n101 VSS.t3223 16.4133
R1224 VSS.t26 VSS.n843 62.5005
R1225 VSS.n840 VSS.t31 62.5005
R1226 VSS.t3267 VSS.n41 62.3556
R1227 VSS.n800 VSS.t3243 62.3556
R1228 VSS.t3241 VSS.n950 62.3546
R1229 VSS.n45 VSS.t3205 62.3546
R1230 VSS.t301 VSS.n29 62.3546
R1231 VSS.t3202 VSS.n797 62.1307
R1232 VSS.n721 VSS.t34 60.1724
R1233 VSS.n171 VSS.t159 69.1846
R1234 VSS.t249 VSS.n732 60.1724
R1235 VSS.t299 VSS.t51 60.1724
R1236 VSS.t242 VSS.t211 60.1724
R1237 VSS.t152 VSS.n163 66.0715
R1238 VSS.n861 VSS.t59 60.0005
R1239 VSS.t3187 VSS.n926 60.0005
R1240 VSS.t3188 VSS.t54 76.3513
R1241 VSS.t239 VSS.n723 60.0005
R1242 VSS.n823 VSS.t84 60.0005
R1243 VSS.n829 VSS.t290 60.0005
R1244 VSS.t214 VSS.n42 59.934
R1245 VSS.t244 VSS.t2 59.1846
R1246 VSS.n48 VSS.t358 58.6622
R1247 VSS.n36 VSS.t379 26.1053
R1248 VSS.t73 VSS.n52 0.121828
R1249 VSS.n53 VSS.t389 26.1052
R1250 VSS.n55 VSS.t394 26.1053
R1251 VSS.t397 VSS.n95 26.106
R1252 VSS.n94 VSS.t400 26.1053
R1253 VSS.t402 VSS.n96 26.106
R1254 VSS.n33 VSS.t404 26.1052
R1255 VSS.n37 VSS.t377 58.3211
R1256 VSS.n35 VSS.t392 58.3211
R1257 VSS.n32 VSS.t407 58.3211
R1258 VSS.n6 VSS.t3229 57.3359
R1259 VSS.t73 VSS.n152 0.219073
R1260 VSS.n48 VSS.t357 57.0465
R1261 VSS.n50 VSS.t73 0.219018
R1262 VSS.n30 VSS.t378 26.1544
R1263 VSS.t73 VSS.n51 0.12182
R1264 VSS.n31 VSS.t388 26.2515
R1265 VSS.n53 VSS.t73 0.12186
R1266 VSS.t73 VSS.n54 0.219018
R1267 VSS.n55 VSS.t73 0.121828
R1268 VSS.t73 VSS.n95 0.12182
R1269 VSS.n94 VSS.t73 0.121828
R1270 VSS.t73 VSS.n96 0.12182
R1271 VSS.n953 VSS.t302 56.194
R1272 VSS.n737 VSS.t271 55.8744
R1273 VSS.t35 VSS.n729 55.8744
R1274 VSS.t3321 VSS.t36 55.8744
R1275 VSS.t665 VSS.t205 55.7148
R1276 VSS.t94 VSS.n922 55.7148
R1277 VSS.t100 VSS.n751 55.7148
R1278 VSS.t272 VSS.n123 58.1725
R1279 VSS.t3225 VSS.n113 64.8344
R1280 VSS.n46 VSS.t220 64.8343
R1281 VSS.n300 VSS.t78 64.8283
R1282 VSS.n101 VSS.t285 64.8345
R1283 VSS.t265 VSS.n714 54.1672
R1284 VSS.n803 VSS.t258 54.0618
R1285 VSS.n73 VSS.t3213 53.1692
R1286 VSS.t73 VSS.t391 26.5067
R1287 VSS.t73 VSS.t406 26.5067
R1288 VSS.t73 VSS.t305 26.5067
R1289 VSS.n49 VSS.t73 0.203604
R1290 VSS.n49 VSS.t360 26.321
R1291 VSS.t197 VSS.n837 51.5764
R1292 VSS.t248 VSS.n733 51.5764
R1293 VSS.t171 VSS.n6 49.0025
R1294 VSS.n166 VSS.t304 26.1613
R1295 VSS.t309 VSS.n27 26.2524
R1296 VSS.n115 VSS.t314 26.2524
R1297 VSS.t316 VSS.n116 26.1049
R1298 VSS.n120 VSS.t324 26.1544
R1299 VSS.t326 VSS.n119 26.1051
R1300 VSS.n110 VSS.t339 26.2515
R1301 VSS.n111 VSS.t344 26.2522
R1302 VSS.t346 VSS.n112 26.105
R1303 VSS.n104 VSS.t353 26.1544
R1304 VSS.t357 VSS.n103 48.8187
R1305 VSS.n50 VSS.t359 26.1544
R1306 VSS.n105 VSS.t363 26.2656
R1307 VSS.t364 VSS.n108 47.2102
R1308 VSS.n107 VSS.t371 26.2524
R1309 VSS.n28 VSS.t376 26.2635
R1310 VSS.n30 VSS.t377 47.2102
R1311 VSS.n36 VSS.t380 26.2522
R1312 VSS.t383 VSS.n51 26.2515
R1313 VSS.n52 VSS.t385 26.2522
R1314 VSS.n31 VSS.t386 26.106
R1315 VSS.n53 VSS.t390 26.2591
R1316 VSS.t393 VSS.n54 26.1544
R1317 VSS.n55 VSS.t396 26.2522
R1318 VSS.t399 VSS.n95 26.2515
R1319 VSS.n94 VSS.t401 26.2522
R1320 VSS.t403 VSS.n96 26.2515
R1321 VSS.n33 VSS.t405 26.2591
R1322 VSS.t408 VSS.n152 26.1611
R1323 VSS.t13 VSS.t213 47.1434
R1324 VSS.t331 VSS.n118 26.1058
R1325 VSS.t355 VSS.n103 26.0019
R1326 VSS.n51 VSS.t381 26.106
R1327 VSS.t3231 VSS.n0 45.7928
R1328 VSS.n9 VSS.t3273 45.7928
R1329 VSS.t3184 VSS.n78 45.7034
R1330 VSS.n90 VSS.t251 45.7034
R1331 VSS.n2 VSS.t3255 44.8359
R1332 VSS.n27 VSS.t306 26.1049
R1333 VSS.n115 VSS.t311 26.1049
R1334 VSS.t73 VSS.n116 0.121858
R1335 VSS.n208 VSS.t322 58.3202
R1336 VSS.t73 VSS.n118 0.121819
R1337 VSS.n110 VSS.t336 26.1058
R1338 VSS.t73 VSS.n111 0.121827
R1339 VSS.t73 VSS.n112 0.121887
R1340 VSS.n234 VSS.t351 58.3202
R1341 VSS.n105 VSS.t361 26.1048
R1342 VSS.n326 VSS.t364 58.3202
R1343 VSS.n107 VSS.t368 26.1049
R1344 VSS.n28 VSS.t373 26.1048
R1345 VSS.t3294 VSS.t711 42.8576
R1346 VSS.t3260 VSS.n782 42.8576
R1347 VSS.n905 VSS.t233 42.8576
R1348 VSS.t140 VSS.t478 42.8576
R1349 VSS.t213 VSS.n831 42.8576
R1350 VSS.t16 VSS.t260 42.8576
R1351 VSS.t319 VSS.n116 26.2591
R1352 VSS.n120 VSS.t73 0.219018
R1353 VSS.n104 VSS.t73 0.219018
R1354 VSS.t119 VSS.t54 42.0417
R1355 VSS.n124 VSS.t2 1.60795
R1356 VSS.n947 VSS.t3230 41.4948
R1357 VSS.n951 VSS.t3241 40.8632
R1358 VSS.t3205 VSS.n795 40.8632
R1359 VSS.n796 VSS.t3267 40.8632
R1360 VSS.t3243 VSS.n799 40.8632
R1361 VSS.n790 VSS.t301 40.8632
R1362 VSS.t212 VSS.n734 38.6824
R1363 VSS.n745 VSS.n743 38.6824
R1364 VSS.t3316 VSS.n918 38.5719
R1365 VSS.t3319 VSS.n773 38.5719
R1366 VSS.n780 VSS.t3301 38.5719
R1367 VSS.n911 VSS.t3304 38.5719
R1368 VSS.t727 VSS.t261 38.5719
R1369 VSS.t129 VSS.n942 38.5719
R1370 VSS.t133 VSS.n755 38.5719
R1371 VSS.t3310 VSS.n935 38.5719
R1372 VSS.t3313 VSS.n762 38.5719
R1373 VSS.n828 VSS.t3246 38.5719
R1374 VSS.t3250 VSS.n829 38.5719
R1375 VSS.t487 VSS.t22 38.5719
R1376 VSS.n217 VSS.t3280 53.1692
R1377 VSS.t230 VSS.n818 37.5005
R1378 VSS.n852 VSS.t173 37.5005
R1379 VSS.t27 VSS.n842 37.5005
R1380 VSS.n841 VSS.t30 37.5005
R1381 VSS.n717 VSS.t89 37.5005
R1382 VSS.t3215 VSS.n726 37.5005
R1383 VSS.t247 VSS.n947 37.1968
R1384 VSS.n950 VSS.t3225 36.5352
R1385 VSS.n45 VSS.t3210 36.5352
R1386 VSS.t285 VSS.n29 36.5352
R1387 VSS.t220 VSS.n41 36.5343
R1388 VSS.t78 VSS.n800 36.5343
R1389 VSS.t208 VSS.t245 34.3845
R1390 VSS.n825 VSS.t82 34.2862
R1391 VSS.n830 VSS.t255 34.2862
R1392 VSS.t3181 VSS.t27 33.3338
R1393 VSS.t176 VSS.t64 33.3338
R1394 VSS.n803 VSS.t214 31.469
R1395 VSS.t3204 VSS.n838 30.0865
R1396 VSS.n738 VSS.t3274 30.0865
R1397 VSS.n741 VSS.t3227 30.0865
R1398 VSS.n742 VSS.t242 30.0865
R1399 VSS.n743 VSS.t3321 30.0865
R1400 VSS.n744 VSS.t289 30.0865
R1401 VSS.n746 VSS.t195 30.0865
R1402 VSS.n771 VSS.t110 30.0005
R1403 VSS.t191 VSS.n862 30.0005
R1404 VSS.n135 VSS.t703 12.9737
R1405 VSS.n750 VSS.t3237 30.0005
R1406 VSS.n44 VSS.t3202 29.2733
R1407 VSS.n853 VSS.t287 29.1672
R1408 VSS.t3229 VSS.t60 29.1672
R1409 VSS.t264 VSS.n11 28.6008
R1410 VSS.n74 VSS.t3302 28.5605
R1411 VSS.t3303 VSS.n74 28.5605
R1412 VSS.t3311 VSS.n18 28.5605
R1413 VSS.n18 VSS.t3312 28.5605
R1414 VSS.n20 VSS.t3247 28.5605
R1415 VSS.t3248 VSS.n20 28.5605
R1416 VSS.t28 VSS.n22 28.1692
R1417 VSS.n22 VSS.t29 28.1692
R1418 VSS.n46 VSS.t3308 16.4142
R1419 VSS.n47 VSS.t62 16.4133
R1420 VSS.n101 VSS.t73 4.37804
R1421 VSS.n802 VSS.t3209 27.4346
R1422 VSS.n165 VSS.t72 16.2305
R1423 VSS.t3282 VSS.n102 38.7878
R1424 VSS.t3208 VSS.n236 16.2314
R1425 VSS.n128 VSS.t3233 41.4415
R1426 VSS.t186 VSS.n205 41.4177
R1427 VSS.t29 VSS.t3219 25.0005
R1428 VSS.t80 VSS.t2 24.8979
R1429 VSS.t258 VSS.n797 23.4002
R1430 VSS.t259 VSS.n40 22.0103
R1431 VSS.n237 VSS.t3234 13.9422
R1432 VSS.n190 VSS.t73 3.37712
R1433 VSS.n186 VSS.t73 3.37712
R1434 VSS.t73 VSS.n164 3.37595
R1435 VSS.n740 VSS.t298 21.4905
R1436 VSS.n810 VSS.t3200 21.2044
R1437 VSS.t103 VSS.n43 21.2044
R1438 VSS.t3306 VSS.n39 21.2035
R1439 VSS.t89 VSS.t3226 20.8338
R1440 VSS.n76 VSS.t3192 19.9891
R1441 VSS.t99 VSS.n102 12.7723
R1442 VSS.t3257 VSS.n42 18.7838
R1443 VSS.n798 VSS.t3283 18.7838
R1444 VSS.n38 VSS.t279 18.7838
R1445 VSS.t74 VSS.n952 18.7828
R1446 VSS.n178 VSS.t3275 20.3745
R1447 VSS.n809 VSS.t252 18.5589
R1448 VSS.n172 VSS.t3238 29.5272
R1449 VSS.n808 VSS.t283 18.5589
R1450 VSS.n801 VSS.t3203 18.5589
R1451 VSS.n164 VSS.t276 29.5281
R1452 VSS.t11 VSS.n237 29.5272
R1453 VSS.t3221 VSS.n190 29.5272
R1454 VSS.t192 VSS.n186 29.5272
R1455 VSS.t3239 VSS.n951 17.4635
R1456 VSS.n795 VSS.t3263 17.4635
R1457 VSS.t3265 VSS.n796 17.4635
R1458 VSS.n799 VSS.t3236 17.4635
R1459 VSS.t3224 VSS.n790 17.4635
R1460 VSS.t3285 VSS.t25 17.1434
R1461 VSS.n109 VSS.n327 5.64438
R1462 VSS.n109 VSS.n328 5.64438
R1463 VSS.n177 VSS.t73 10.0581
R1464 VSS.n812 VSS.t73 17.0005
R1465 VSS.n809 VSS.t73 17.0005
R1466 VSS.n208 VSS.t73 0.405951
R1467 VSS.n172 VSS.t73 3.37712
R1468 VSS.n234 VSS.t73 0.405951
R1469 VSS.t73 VSS.n242 5.6463
R1470 VSS.t73 VSS.n808 17.0005
R1471 VSS.t73 VSS.n807 17.0005
R1472 VSS.t73 VSS.n794 17.0005
R1473 VSS.t73 VSS.n804 17.0005
R1474 VSS.t73 VSS.n47 4.37804
R1475 VSS.t73 VSS.n46 4.37826
R1476 VSS.t73 VSS.n797 17.0005
R1477 VSS.t73 VSS.n803 17.0005
R1478 VSS.t73 VSS.n802 17.0005
R1479 VSS.t73 VSS.n801 17.0005
R1480 VSS.n300 VSS.t73 4.38592
R1481 VSS.t73 VSS.n792 17.0005
R1482 VSS.t73 VSS.n102 2.99072
R1483 VSS.t73 VSS.n237 3.37712
R1484 VSS.n877 VSS.t2620 17.0005
R1485 VSS.n26 VSS.n310 5.64438
R1486 VSS.n311 VSS.n26 5.64438
R1487 VSS.n308 VSS.n23 5.64438
R1488 VSS.n23 VSS.n309 5.64438
R1489 VSS.n24 VSS.n306 5.64438
R1490 VSS.n307 VSS.n24 5.64438
R1491 VSS.t224 VSS.n592 17.0005
R1492 VSS.n219 VSS.n25 5.64438
R1493 VSS.n25 VSS.n220 5.64438
R1494 VSS.t165 VSS.t54 4.25075
R1495 VSS.n931 VSS.t54 17.0005
R1496 VSS.n180 VSS.t54 0.666899
R1497 VSS.n217 VSS.t54 0.666899
R1498 VSS.n930 VSS.t54 17.0005
R1499 VSS.n929 VSS.t54 17.0005
R1500 VSS.n928 VSS.t54 17.0005
R1501 VSS.t54 VSS.n121 9.30898
R1502 VSS.t54 VSS.n764 17.0005
R1503 VSS.t54 VSS.n114 3.4099
R1504 VSS.t54 VSS.n97 8.48179
R1505 VSS.t54 VSS.n765 17.0005
R1506 VSS.t54 VSS.n771 17.0005
R1507 VSS.t54 VSS.n199 12.2561
R1508 VSS.t54 VSS.n766 17.0005
R1509 VSS.t54 VSS.n214 0.649813
R1510 VSS.t54 VSS.n767 17.0005
R1511 VSS.t54 VSS.n203 0.649813
R1512 VSS.t54 VSS.n768 17.0005
R1513 VSS.n215 VSS.t54 0.649813
R1514 VSS.t54 VSS.n769 17.0005
R1515 VSS.n216 VSS.t54 0.649813
R1516 VSS.t54 VSS.n770 17.0005
R1517 VSS.n182 VSS.t54 0.649813
R1518 VSS.n925 VSS.t54 17.0005
R1519 VSS.n926 VSS.t54 17.0005
R1520 VSS.n927 VSS.t54 17.0005
R1521 VSS.n906 VSS.t54 17.0005
R1522 VSS.n131 VSS.t54 9.30721
R1523 VSS.n126 VSS.t54 9.63482
R1524 VSS.n130 VSS.t54 9.63482
R1525 VSS.n127 VSS.t54 9.63483
R1526 VSS.t54 VSS.n781 17.0005
R1527 VSS.t54 VSS.n783 17.0005
R1528 VSS.t54 VSS.n782 17.0005
R1529 VSS.n910 VSS.t54 17.0005
R1530 VSS.t54 VSS.n911 17.0005
R1531 VSS.t54 VSS.n780 17.0005
R1532 VSS.n912 VSS.t54 17.0005
R1533 VSS.t54 VSS.n913 17.0005
R1534 VSS.n914 VSS.t54 17.0005
R1535 VSS.t54 VSS.n915 17.0005
R1536 VSS.t54 VSS.n775 17.0005
R1537 VSS.t54 VSS.n779 17.0005
R1538 VSS.t54 VSS.n776 17.0005
R1539 VSS.t54 VSS.n778 17.0005
R1540 VSS.t54 VSS.n777 17.0005
R1541 VSS.n916 VSS.t54 17.0005
R1542 VSS.t54 VSS.n917 17.0005
R1543 VSS.t54 VSS.n772 17.0005
R1544 VSS.t54 VSS.n774 17.0005
R1545 VSS.t54 VSS.n773 17.0005
R1546 VSS.t54 VSS.n196 0.649813
R1547 VSS.n918 VSS.t54 17.0005
R1548 VSS.t54 VSS.n919 17.0005
R1549 VSS.n920 VSS.t54 17.0005
R1550 VSS.n922 VSS.t54 17.0005
R1551 VSS.n923 VSS.t54 17.0005
R1552 VSS.n205 VSS.t54 0.649813
R1553 VSS.n903 VSS.t54 17.0005
R1554 VSS.n904 VSS.t54 17.0005
R1555 VSS.n905 VSS.t54 17.0005
R1556 VSS.n132 VSS.t54 9.96246
R1557 VSS.t54 VSS.n868 17.0005
R1558 VSS.n867 VSS.t54 17.0005
R1559 VSS.t54 VSS.n863 17.0005
R1560 VSS.t54 VSS.n866 17.0005
R1561 VSS.n865 VSS.t54 17.0005
R1562 VSS.t54 VSS.n864 17.0005
R1563 VSS.t54 VSS.n173 9.63482
R1564 VSS.t54 VSS.n136 9.63482
R1565 VSS.t54 VSS.n137 9.30721
R1566 VSS.t54 VSS.n170 9.30721
R1567 VSS.t54 VSS.n139 9.30721
R1568 VSS.t54 VSS.n167 9.63482
R1569 VSS.t54 VSS.n168 9.30721
R1570 VSS.t54 VSS.n142 9.30721
R1571 VSS.t54 VSS.n157 9.30721
R1572 VSS.t54 VSS.n145 9.63482
R1573 VSS.t54 VSS.n156 9.63482
R1574 VSS.t54 VSS.n146 9.63482
R1575 VSS.t54 VSS.n154 9.63482
R1576 VSS.t54 VSS.n153 9.30721
R1577 VSS.t54 VSS.n151 9.63482
R1578 VSS.t54 VSS.n859 17.0005
R1579 VSS.t54 VSS.n862 17.0005
R1580 VSS.t54 VSS.n861 17.0005
R1581 VSS.t54 VSS.n860 17.0005
R1582 VSS.t2 VSS.n937 17.0005
R1583 VSS.t2 VSS.n936 17.0005
R1584 VSS.t2 VSS.n822 17.0005
R1585 VSS.t2 VSS.n827 17.0005
R1586 VSS.n826 VSS.t2 17.0005
R1587 VSS.t2 VSS.n823 17.0005
R1588 VSS.t2 VSS.n825 17.0005
R1589 VSS.t2 VSS.n824 17.0005
R1590 VSS.t2 VSS.n762 17.0005
R1591 VSS.t2 VSS.n935 17.0005
R1592 VSS.n938 VSS.t2 17.0005
R1593 VSS.t2 VSS.n939 17.0005
R1594 VSS.t2 VSS.n757 17.0005
R1595 VSS.t2 VSS.n761 17.0005
R1596 VSS.t2 VSS.n758 17.0005
R1597 VSS.t2 VSS.n760 17.0005
R1598 VSS.t2 VSS.n759 17.0005
R1599 VSS.n940 VSS.t2 17.0005
R1600 VSS.t2 VSS.n941 17.0005
R1601 VSS.t2 VSS.n754 17.0005
R1602 VSS.t2 VSS.n756 17.0005
R1603 VSS.t2 VSS.n755 17.0005
R1604 VSS.n181 VSS.t2 0.649813
R1605 VSS.n942 VSS.t2 17.0005
R1606 VSS.t2 VSS.n943 17.0005
R1607 VSS.n161 VSS.t2 7.34144
R1608 VSS.t2 VSS.n944 17.0005
R1609 VSS.n211 VSS.t2 0.649813
R1610 VSS.t2 VSS.n751 17.0005
R1611 VSS.t2 VSS.n753 17.0005
R1612 VSS.t2 VSS.n752 17.0005
R1613 VSS.n212 VSS.t2 0.649813
R1614 VSS.t2 VSS.n723 17.0005
R1615 VSS.t2 VSS.n750 17.0005
R1616 VSS.t2 VSS.n850 17.0005
R1617 VSS.t2 VSS.n834 17.0005
R1618 VSS.t2 VSS.n833 17.0005
R1619 VSS.t2 VSS.n832 17.0005
R1620 VSS.t2 VSS.n831 17.0005
R1621 VSS.t2 VSS.n830 17.0005
R1622 VSS.t2 VSS.n829 17.0005
R1623 VSS.t2 VSS.n828 17.0005
R1624 VSS.t2 VSS.n123 13.894
R1625 VSS.t2 VSS.n835 17.0005
R1626 VSS.t2 VSS.n836 17.0005
R1627 VSS.t2 VSS.n837 17.0005
R1628 VSS.t2 VSS.n838 17.0005
R1629 VSS.t2 VSS.n839 17.0005
R1630 VSS.t2 VSS.n840 17.0005
R1631 VSS.t2 VSS.n841 17.0005
R1632 VSS.t2 VSS.n842 17.0005
R1633 VSS.t2 VSS.n843 17.0005
R1634 VSS.t2 VSS.n844 17.0005
R1635 VSS.t2 VSS.n845 17.0005
R1636 VSS.t2 VSS.n846 17.0005
R1637 VSS.t2 VSS.n847 17.0005
R1638 VSS.t2 VSS.n848 17.0005
R1639 VSS.t2 VSS.n849 17.0005
R1640 VSS.t2 VSS.n853 17.0005
R1641 VSS.t2 VSS.n819 17.0005
R1642 VSS.t2 VSS.n852 17.0005
R1643 VSS.t2 VSS.n820 17.0005
R1644 VSS.t2 VSS.n851 17.0005
R1645 VSS.t2 VSS.n821 17.0005
R1646 VSS.t2 VSS.n854 17.0005
R1647 VSS.t2 VSS.n856 17.0005
R1648 VSS.t2 VSS.n818 17.0005
R1649 VSS.t2 VSS.n855 17.0005
R1650 VSS.t2 VSS.n749 17.0005
R1651 VSS.t2 VSS.n725 17.0005
R1652 VSS.t2 VSS.n748 17.0005
R1653 VSS.t2 VSS.n726 17.0005
R1654 VSS.t2 VSS.n747 17.0005
R1655 VSS.t2 VSS.n727 17.0005
R1656 VSS.t2 VSS.n744 17.0005
R1657 VSS.t2 VSS.n728 17.0005
R1658 VSS.t2 VSS.n743 17.0005
R1659 VSS.t2 VSS.n729 17.0005
R1660 VSS.t2 VSS.n742 17.0005
R1661 VSS.t2 VSS.n730 17.0005
R1662 VSS.t2 VSS.n732 17.0005
R1663 VSS.t2 VSS.n741 17.0005
R1664 VSS.t2 VSS.n733 17.0005
R1665 VSS.t2 VSS.n740 17.0005
R1666 VSS.t2 VSS.n200 14.5507
R1667 VSS.t2 VSS.n734 17.0005
R1668 VSS.t2 VSS.n739 17.0005
R1669 VSS.t2 VSS.n735 17.0005
R1670 VSS.t2 VSS.n738 17.0005
R1671 VSS.t2 VSS.n736 17.0005
R1672 VSS.t2 VSS.n737 17.0005
R1673 VSS.t2 VSS.n689 17.0005
R1674 VSS.n946 VSS.t2 17.0005
R1675 VSS.n945 VSS.t2 17.0005
R1676 VSS.t2 VSS.n719 17.0005
R1677 VSS.t2 VSS.n722 17.0005
R1678 VSS.t2 VSS.n720 17.0005
R1679 VSS.t2 VSS.n721 17.0005
R1680 VSS.t463 VSS.n690 0.0583051
R1681 VSS.t2 VSS.n713 17.0005
R1682 VSS.t2 VSS.n712 17.0005
R1683 VSS.t2 VSS.n718 17.0005
R1684 VSS.t2 VSS.n714 17.0005
R1685 VSS.t2 VSS.n717 17.0005
R1686 VSS.t2 VSS.n715 17.0005
R1687 VSS.t2 VSS.n716 17.0005
R1688 VSS.t2 VSS.n201 16.0236
R1689 VSS.n805 VSS.t215 16.6566
R1690 VSS.n128 VSS.t54 0.625031
R1691 VSS.t250 VSS.n811 15.8498
R1692 VSS.t3272 VSS.n793 15.0429
R1693 VSS.n176 VSS.t169 14.5841
R1694 VSS.t3240 VSS.n949 14.1658
R1695 VSS.n857 VSS.t395 14.1658
R1696 VSS.t370 VSS.n785 14.1658
R1697 VSS.n880 VSS.n879 14.1658
R1698 VSS.n881 VSS.t3142 14.1658
R1699 VSS.n955 VSS.n954 14.1658
R1700 VSS.n934 VSS.t284 14.1658
R1701 VSS.n949 VSS.t61 13.5005
R1702 VSS.t537 VSS.n711 13.5005
R1703 VSS.n884 VSS.t789 13.5005
R1704 VSS.n885 VSS.t1173 13.5005
R1705 VSS.n886 VSS.t1463 13.5005
R1706 VSS.n888 VSS.t1855 13.5005
R1707 VSS.t2247 VSS.n889 13.5005
R1708 VSS.t2631 VSS.n709 13.5005
R1709 VSS.n956 VSS.t2919 13.5005
R1710 VSS.t10 VSS.n785 13.5005
R1711 VSS.t201 VSS.n902 13.5005
R1712 VSS.n901 VSS.n787 13.5005
R1713 VSS.n872 VSS.n786 13.5005
R1714 VSS.n895 VSS.n894 13.5005
R1715 VSS.n893 VSS.n875 13.5005
R1716 VSS.n882 VSS.n874 13.5005
R1717 VSS.n878 VSS.n880 13.5005
R1718 VSS.n857 VSS.t438 13.5005
R1719 VSS.n869 VSS.t755 13.5005
R1720 VSS.t1012 VSS.n900 13.5005
R1721 VSS.n899 VSS.t1304 13.5005
R1722 VSS.t1686 VSS.n870 13.5005
R1723 VSS.t2078 VSS.n892 13.5005
R1724 VSS.n891 VSS.t2470 13.5005
R1725 VSS.n881 VSS.t2763 13.5005
R1726 VSS.n954 VSS.t2821 13.5005
R1727 VSS.n890 VSS.n710 13.5005
R1728 VSS.n887 VSS.n873 13.5005
R1729 VSS.n897 VSS.n896 13.5005
R1730 VSS.t1367 VSS.n898 13.5005
R1731 VSS.n883 VSS.n763 13.5005
R1732 VSS.n933 VSS.t581 13.5005
R1733 VSS.t147 VSS.n934 13.5005
R1734 VSS.n793 VSS.t270 13.4291
R1735 VSS.t267 VSS.n175 11.4038
R1736 VSS.n804 VSS.t3201 12.9107
R1737 VSS.t120 VSS.t8 12.8945
R1738 VSS.t149 VSS.n720 12.8945
R1739 VSS.n862 VSS.t3191 12.8576
R1740 VSS.t295 VSS.n925 12.8576
R1741 VSS.n196 VSS.t3318 28.5605
R1742 VSS.n212 VSS.t207 28.5605
R1743 VSS.n181 VSS.t130 28.5605
R1744 VSS.n181 VSS.t131 28.5605
R1745 VSS.n811 VSS.t3276 12.6222
R1746 VSS.t3199 VSS.n805 11.8153
R1747 VSS.t54 VSS.t646 9.30761
R1748 VSS.t167 VSS.n812 8.87624
R1749 VSS.t217 VSS.n834 8.57193
R1750 VSS.t170 VSS.t150 8.57193
R1751 VSS.t2620 VSS.n329 3.31921
R1752 VSS.t3179 VSS.n109 8.50199
R1753 VSS.t2507 VSS.n26 8.50198
R1754 VSS.n23 VSS.t2115 8.50198
R1755 VSS.t1723 VSS.n24 8.50198
R1756 VSS.n25 VSS.t1049 8.50198
R1757 VSS.n385 VSS.t3176 0.130189
R1758 VSS.t3174 VSS.n109 8.501
R1759 VSS.n384 VSS.t3171 0.130189
R1760 VSS.t3169 VSS.n109 8.501
R1761 VSS.n383 VSS.t3166 0.130189
R1762 VSS.t3164 VSS.n109 8.501
R1763 VSS.n382 VSS.t3161 0.130189
R1764 VSS.t3159 VSS.n109 8.501
R1765 VSS.n381 VSS.t3156 0.130189
R1766 VSS.t3154 VSS.n109 8.501
R1767 VSS.n380 VSS.t3151 0.130189
R1768 VSS.t3149 VSS.n109 8.501
R1769 VSS.n379 VSS.t3146 0.130189
R1770 VSS.t3144 VSS.n327 0.0362711
R1771 VSS.n378 VSS.t3141 0.0793054
R1772 VSS.t3139 VSS.n109 8.501
R1773 VSS.n377 VSS.t3136 0.130189
R1774 VSS.t3134 VSS.n109 8.501
R1775 VSS.n376 VSS.t3131 0.130189
R1776 VSS.t3129 VSS.n109 8.501
R1777 VSS.n375 VSS.t3126 0.130189
R1778 VSS.t3124 VSS.n109 8.501
R1779 VSS.n374 VSS.t3121 0.130189
R1780 VSS.t3119 VSS.n109 8.501
R1781 VSS.n373 VSS.t3116 0.130189
R1782 VSS.t3114 VSS.n109 8.501
R1783 VSS.n372 VSS.t3111 0.130189
R1784 VSS.t3109 VSS.n109 8.501
R1785 VSS.n371 VSS.t3106 0.130189
R1786 VSS.t3104 VSS.n109 8.501
R1787 VSS.n370 VSS.t3101 0.130189
R1788 VSS.t3099 VSS.n109 8.501
R1789 VSS.n369 VSS.t3096 0.130189
R1790 VSS.t3094 VSS.n109 8.501
R1791 VSS.n368 VSS.t3091 0.130189
R1792 VSS.t3089 VSS.n109 8.501
R1793 VSS.n367 VSS.t3086 0.130189
R1794 VSS.t3084 VSS.n109 8.501
R1795 VSS.n366 VSS.t3081 0.130189
R1796 VSS.t3079 VSS.n109 8.501
R1797 VSS.n365 VSS.t3076 0.130189
R1798 VSS.t3074 VSS.n109 8.501
R1799 VSS.n364 VSS.t3071 0.130189
R1800 VSS.t3069 VSS.n328 0.0362711
R1801 VSS.n363 VSS.t3066 0.0793054
R1802 VSS.n109 VSS.t3064 8.501
R1803 VSS.t3061 VSS.n362 0.130189
R1804 VSS.t3059 VSS.n109 8.501
R1805 VSS.t3056 VSS.n361 0.130189
R1806 VSS.t3054 VSS.n109 8.501
R1807 VSS.t3051 VSS.n360 0.130189
R1808 VSS.t3049 VSS.n109 8.501
R1809 VSS.t3046 VSS.n359 0.130189
R1810 VSS.t3044 VSS.n109 8.501
R1811 VSS.t3041 VSS.n358 0.130189
R1812 VSS.t3039 VSS.n109 8.501
R1813 VSS.t3036 VSS.n357 0.130189
R1814 VSS.t3034 VSS.n109 8.501
R1815 VSS.t3031 VSS.n356 0.130189
R1816 VSS.t3029 VSS.n109 8.501
R1817 VSS.t3026 VSS.n355 0.130189
R1818 VSS.t3024 VSS.n109 8.501
R1819 VSS.t3021 VSS.n354 0.130189
R1820 VSS.t3019 VSS.n109 8.501
R1821 VSS.t3016 VSS.n353 0.130189
R1822 VSS.t3014 VSS.n109 8.501
R1823 VSS.t3011 VSS.n352 0.130189
R1824 VSS.t3009 VSS.n109 8.501
R1825 VSS.t3006 VSS.n351 0.130189
R1826 VSS.t3004 VSS.n109 8.501
R1827 VSS.t3001 VSS.n350 0.130189
R1828 VSS.t2999 VSS.n109 8.501
R1829 VSS.t2996 VSS.n349 0.130189
R1830 VSS.n109 VSS.t2994 8.501
R1831 VSS.t2991 VSS.n348 0.130189
R1832 VSS.t2989 VSS.n109 8.501
R1833 VSS.t2986 VSS.n347 0.130189
R1834 VSS.t2984 VSS.n109 8.501
R1835 VSS.t2981 VSS.n346 0.130189
R1836 VSS.t2979 VSS.n109 8.501
R1837 VSS.t2976 VSS.n345 0.130189
R1838 VSS.t2974 VSS.n109 8.501
R1839 VSS.t2971 VSS.n344 0.130189
R1840 VSS.t2969 VSS.n109 8.501
R1841 VSS.t2966 VSS.n343 0.130189
R1842 VSS.t2964 VSS.n109 8.501
R1843 VSS.t2961 VSS.n342 0.130189
R1844 VSS.t2959 VSS.n109 8.501
R1845 VSS.t2956 VSS.n341 0.130189
R1846 VSS.t2954 VSS.n109 8.501
R1847 VSS.t2951 VSS.n340 0.130189
R1848 VSS.t2949 VSS.n109 8.501
R1849 VSS.t2946 VSS.n339 0.130189
R1850 VSS.t2944 VSS.n109 8.501
R1851 VSS.t2941 VSS.n338 0.130189
R1852 VSS.t2939 VSS.n109 8.501
R1853 VSS.t2936 VSS.n337 0.130189
R1854 VSS.t2934 VSS.n109 8.501
R1855 VSS.t2931 VSS.n336 0.130189
R1856 VSS.t2929 VSS.n109 8.501
R1857 VSS.n335 VSS.t2926 0.130189
R1858 VSS.t2924 VSS.n109 8.501
R1859 VSS.n334 VSS.t2921 0.130189
R1860 VSS.t2916 VSS.n333 0.215686
R1861 VSS.t2914 VSS.n109 8.501
R1862 VSS.n332 VSS.t2911 0.130189
R1863 VSS.t2909 VSS.n109 8.501
R1864 VSS.n331 VSS.t2906 0.130189
R1865 VSS.t2904 VSS.n109 8.501
R1866 VSS.n109 VSS.n330 3.33079
R1867 VSS.n705 VSS.t307 0.292902
R1868 VSS.n706 VSS.t73 3.32876
R1869 VSS.t312 VSS.t73 8.501
R1870 VSS.n707 VSS.t73 3.32876
R1871 VSS.t317 VSS.t73 8.501
R1872 VSS.n708 VSS.t73 3.32876
R1873 VSS.t168 VSS.n209 0.822541
R1874 VSS.n699 VSS.t73 3.32876
R1875 VSS.t327 VSS.t73 8.501
R1876 VSS.n700 VSS.t73 3.32876
R1877 VSS.t332 VSS.t73 8.501
R1878 VSS.n701 VSS.t73 3.32876
R1879 VSS.t337 VSS.t73 8.501
R1880 VSS.n702 VSS.t73 3.32876
R1881 VSS.t342 VSS.t73 8.501
R1882 VSS.n703 VSS.t73 3.32876
R1883 VSS.t347 VSS.t73 8.501
R1884 VSS.n704 VSS.t73 3.32876
R1885 VSS.n695 VSS.t73 1.99111
R1886 VSS.t73 VSS.n696 3.32876
R1887 VSS.t356 VSS.n242 0.0333775
R1888 VSS.n697 VSS.t73 0.340584
R1889 VSS.n698 VSS.t73 3.32876
R1890 VSS.t219 VSS.n386 0.918574
R1891 VSS.n387 VSS.t73 3.32876
R1892 VSS.n285 VSS.t73 5.6463
R1893 VSS.t73 VSS.n388 4.20253
R1894 VSS.t374 VSS.t73 8.501
R1895 VSS.n389 VSS.t73 3.32876
R1896 VSS.n393 VSS.t2620 4.20253
R1897 VSS.n451 VSS.t2504 0.130189
R1898 VSS.t2502 VSS.n26 8.501
R1899 VSS.n450 VSS.t2499 0.130189
R1900 VSS.t2497 VSS.n26 8.501
R1901 VSS.n449 VSS.t2494 0.130189
R1902 VSS.t2492 VSS.n26 8.501
R1903 VSS.n448 VSS.t2489 0.130189
R1904 VSS.t2487 VSS.n26 8.501
R1905 VSS.n447 VSS.t2484 0.130189
R1906 VSS.t2482 VSS.n26 8.501
R1907 VSS.n446 VSS.t2479 0.130189
R1908 VSS.t2477 VSS.n26 8.501
R1909 VSS.n445 VSS.t2474 0.130189
R1910 VSS.t2472 VSS.n310 0.0362711
R1911 VSS.n444 VSS.t2469 0.0793054
R1912 VSS.n26 VSS.t2467 8.501
R1913 VSS.t2464 VSS.n443 0.130189
R1914 VSS.t2462 VSS.n26 8.501
R1915 VSS.t2459 VSS.n442 0.130189
R1916 VSS.t2457 VSS.n26 8.501
R1917 VSS.t2454 VSS.n441 0.130189
R1918 VSS.t2452 VSS.n26 8.501
R1919 VSS.t2449 VSS.n440 0.130189
R1920 VSS.t2447 VSS.n26 8.501
R1921 VSS.t2444 VSS.n439 0.130189
R1922 VSS.t2442 VSS.n26 8.501
R1923 VSS.t2439 VSS.n438 0.130189
R1924 VSS.t2437 VSS.n26 8.501
R1925 VSS.t2434 VSS.n437 0.130189
R1926 VSS.t2432 VSS.n26 8.501
R1927 VSS.t2429 VSS.n436 0.130189
R1928 VSS.t2427 VSS.n26 8.501
R1929 VSS.t2424 VSS.n435 0.130189
R1930 VSS.t2422 VSS.n26 8.501
R1931 VSS.t2419 VSS.n434 0.130189
R1932 VSS.t2417 VSS.n26 8.501
R1933 VSS.t2414 VSS.n433 0.130189
R1934 VSS.t2412 VSS.n26 8.501
R1935 VSS.t2409 VSS.n432 0.130189
R1936 VSS.t2407 VSS.n26 8.501
R1937 VSS.t2404 VSS.n431 0.130189
R1938 VSS.t2402 VSS.n26 8.501
R1939 VSS.t2399 VSS.n430 0.130189
R1940 VSS.t2397 VSS.n311 0.0362711
R1941 VSS.t2394 VSS.n429 0.0793054
R1942 VSS.t2392 VSS.n26 8.501
R1943 VSS.t2389 VSS.n428 0.130189
R1944 VSS.t2387 VSS.n26 8.501
R1945 VSS.t2384 VSS.n427 0.130189
R1946 VSS.t2382 VSS.n26 8.501
R1947 VSS.t2379 VSS.n426 0.130189
R1948 VSS.t2377 VSS.n26 8.501
R1949 VSS.t2374 VSS.n425 0.130189
R1950 VSS.t2372 VSS.n26 8.501
R1951 VSS.t2369 VSS.n424 0.130189
R1952 VSS.t2367 VSS.n26 8.501
R1953 VSS.t2364 VSS.n423 0.130189
R1954 VSS.t2362 VSS.n26 8.501
R1955 VSS.t2359 VSS.n422 0.130189
R1956 VSS.t2357 VSS.n26 8.501
R1957 VSS.t2354 VSS.n421 0.130189
R1958 VSS.t2352 VSS.n26 8.501
R1959 VSS.t2349 VSS.n420 0.130189
R1960 VSS.t2347 VSS.n26 8.501
R1961 VSS.t2344 VSS.n419 0.130189
R1962 VSS.t2342 VSS.n26 8.501
R1963 VSS.t2339 VSS.n418 0.130189
R1964 VSS.t2337 VSS.n26 8.501
R1965 VSS.t2334 VSS.n417 0.130189
R1966 VSS.t2332 VSS.n26 8.501
R1967 VSS.t2329 VSS.n416 0.130189
R1968 VSS.t2327 VSS.n26 8.501
R1969 VSS.t2324 VSS.n415 0.130189
R1970 VSS.t2319 VSS.n414 0.130189
R1971 VSS.t2317 VSS.n26 8.501
R1972 VSS.t2314 VSS.n413 0.130189
R1973 VSS.t2312 VSS.n26 8.501
R1974 VSS.t2309 VSS.n412 0.130189
R1975 VSS.t2307 VSS.n26 8.501
R1976 VSS.t2304 VSS.n411 0.130189
R1977 VSS.t2302 VSS.n26 8.501
R1978 VSS.t2299 VSS.n410 0.130189
R1979 VSS.t2297 VSS.n26 8.501
R1980 VSS.t2294 VSS.n409 0.130189
R1981 VSS.t2292 VSS.n26 8.501
R1982 VSS.t2289 VSS.n408 0.130189
R1983 VSS.t2287 VSS.n26 8.501
R1984 VSS.t2284 VSS.n407 0.130189
R1985 VSS.t2282 VSS.n26 8.501
R1986 VSS.t2279 VSS.n406 0.130189
R1987 VSS.t2277 VSS.n26 8.501
R1988 VSS.t2274 VSS.n405 0.130189
R1989 VSS.t2272 VSS.n26 8.501
R1990 VSS.t2269 VSS.n404 0.130189
R1991 VSS.t2267 VSS.n26 8.501
R1992 VSS.t2264 VSS.n403 0.130189
R1993 VSS.t2262 VSS.n26 8.501
R1994 VSS.t2259 VSS.n402 0.130189
R1995 VSS.t2257 VSS.n26 8.501
R1996 VSS.t2254 VSS.n401 0.130189
R1997 VSS.t2252 VSS.n26 8.501
R1998 VSS.t2249 VSS.n400 0.130189
R1999 VSS.t2247 VSS.n26 8.501
R2000 VSS.t2244 VSS.n399 0.130189
R2001 VSS.t2242 VSS.n26 8.501
R2002 VSS.t2239 VSS.n398 0.130189
R2003 VSS.t2237 VSS.n26 8.501
R2004 VSS.t2234 VSS.n397 0.130189
R2005 VSS.t2232 VSS.n26 8.501
R2006 VSS.n396 VSS.n26 3.33079
R2007 VSS.n508 VSS.t2112 0.130189
R2008 VSS.t2110 VSS.n23 8.501
R2009 VSS.n507 VSS.t2107 0.130189
R2010 VSS.t2105 VSS.n23 8.501
R2011 VSS.n506 VSS.t2102 0.130189
R2012 VSS.t2100 VSS.n23 8.501
R2013 VSS.n505 VSS.t2097 0.130189
R2014 VSS.t2095 VSS.n23 8.501
R2015 VSS.n504 VSS.t2092 0.130189
R2016 VSS.t2090 VSS.n23 8.501
R2017 VSS.n503 VSS.t2087 0.130189
R2018 VSS.t2085 VSS.n23 8.501
R2019 VSS.n502 VSS.t2082 0.130189
R2020 VSS.t2080 VSS.n308 0.0362711
R2021 VSS.n501 VSS.t2077 0.0793054
R2022 VSS.t2075 VSS.n23 8.501
R2023 VSS.n500 VSS.t2072 0.130189
R2024 VSS.t2070 VSS.n23 8.501
R2025 VSS.n499 VSS.t2067 0.130189
R2026 VSS.t2065 VSS.n23 8.501
R2027 VSS.n498 VSS.t2062 0.130189
R2028 VSS.t2060 VSS.n23 8.501
R2029 VSS.n497 VSS.t2057 0.130189
R2030 VSS.t2055 VSS.n23 8.501
R2031 VSS.n496 VSS.t2052 0.130189
R2032 VSS.t2050 VSS.n23 8.501
R2033 VSS.n495 VSS.t2047 0.130189
R2034 VSS.t2045 VSS.n23 8.501
R2035 VSS.n494 VSS.t2042 0.130189
R2036 VSS.t2040 VSS.n23 8.501
R2037 VSS.n493 VSS.t2037 0.130189
R2038 VSS.t2035 VSS.n23 8.501
R2039 VSS.n492 VSS.t2032 0.130189
R2040 VSS.t2030 VSS.n23 8.501
R2041 VSS.n491 VSS.t2027 0.130189
R2042 VSS.t2025 VSS.n23 8.501
R2043 VSS.n490 VSS.t2022 0.130189
R2044 VSS.t2020 VSS.n23 8.501
R2045 VSS.n489 VSS.t2017 0.130189
R2046 VSS.t2015 VSS.n23 8.501
R2047 VSS.n488 VSS.t2012 0.130189
R2048 VSS.t2010 VSS.n23 8.501
R2049 VSS.n487 VSS.t2007 0.130189
R2050 VSS.t2005 VSS.n309 0.0362711
R2051 VSS.n486 VSS.t2002 0.0793054
R2052 VSS.n23 VSS.t2000 8.501
R2053 VSS.n485 VSS.t1997 0.130189
R2054 VSS.t1995 VSS.n23 8.501
R2055 VSS.n484 VSS.t1992 0.130189
R2056 VSS.t1990 VSS.n23 8.501
R2057 VSS.n483 VSS.t1987 0.130189
R2058 VSS.t1985 VSS.n23 8.501
R2059 VSS.n482 VSS.t1982 0.130189
R2060 VSS.t1980 VSS.n23 8.501
R2061 VSS.n481 VSS.t1977 0.130189
R2062 VSS.t1975 VSS.n23 8.501
R2063 VSS.n480 VSS.t1972 0.130189
R2064 VSS.t1970 VSS.n23 8.501
R2065 VSS.n479 VSS.t1967 0.130189
R2066 VSS.t1965 VSS.n23 8.501
R2067 VSS.n478 VSS.t1962 0.130189
R2068 VSS.t1960 VSS.n23 8.501
R2069 VSS.n477 VSS.t1957 0.130189
R2070 VSS.t1955 VSS.n23 8.501
R2071 VSS.n476 VSS.t1952 0.130189
R2072 VSS.t1950 VSS.n23 8.501
R2073 VSS.n475 VSS.t1947 0.130189
R2074 VSS.t1945 VSS.n23 8.501
R2075 VSS.n474 VSS.t1942 0.130189
R2076 VSS.t1940 VSS.n23 8.501
R2077 VSS.n473 VSS.t1937 0.130189
R2078 VSS.t1935 VSS.n23 8.501
R2079 VSS.n472 VSS.t1932 0.130189
R2080 VSS.n471 VSS.t1927 0.130189
R2081 VSS.t1925 VSS.n23 8.501
R2082 VSS.n470 VSS.t1922 0.130189
R2083 VSS.t1920 VSS.n23 8.501
R2084 VSS.n469 VSS.t1917 0.130189
R2085 VSS.t1915 VSS.n23 8.501
R2086 VSS.n468 VSS.t1912 0.130189
R2087 VSS.t1910 VSS.n23 8.501
R2088 VSS.n467 VSS.t1907 0.130189
R2089 VSS.t1905 VSS.n23 8.501
R2090 VSS.n466 VSS.t1902 0.130189
R2091 VSS.t1900 VSS.n23 8.501
R2092 VSS.n465 VSS.t1897 0.130189
R2093 VSS.t1895 VSS.n23 8.501
R2094 VSS.n464 VSS.t1892 0.130189
R2095 VSS.t1890 VSS.n23 8.501
R2096 VSS.n463 VSS.t1887 0.130189
R2097 VSS.t1885 VSS.n23 8.501
R2098 VSS.n462 VSS.t1882 0.130189
R2099 VSS.t1880 VSS.n23 8.501
R2100 VSS.n461 VSS.t1877 0.130189
R2101 VSS.t1875 VSS.n23 8.501
R2102 VSS.n460 VSS.t1872 0.130189
R2103 VSS.t1870 VSS.n23 8.501
R2104 VSS.n459 VSS.t1867 0.130189
R2105 VSS.t1865 VSS.n23 8.501
R2106 VSS.n458 VSS.t1862 0.130189
R2107 VSS.t1860 VSS.n23 8.501
R2108 VSS.n457 VSS.t1857 0.130189
R2109 VSS.t1855 VSS.n23 8.501
R2110 VSS.t1852 VSS.n456 0.130189
R2111 VSS.t1850 VSS.n23 8.501
R2112 VSS.t1847 VSS.n455 0.130189
R2113 VSS.t1845 VSS.n23 8.501
R2114 VSS.t1842 VSS.n454 0.130189
R2115 VSS.t1840 VSS.n23 8.501
R2116 VSS.n453 VSS.n23 3.33079
R2117 VSS.n565 VSS.t1720 0.130189
R2118 VSS.t1718 VSS.n24 8.501
R2119 VSS.n564 VSS.t1715 0.130189
R2120 VSS.t1713 VSS.n24 8.501
R2121 VSS.n563 VSS.t1710 0.130189
R2122 VSS.t1708 VSS.n24 8.501
R2123 VSS.n562 VSS.t1705 0.130189
R2124 VSS.t1703 VSS.n24 8.501
R2125 VSS.n561 VSS.t1700 0.130189
R2126 VSS.t1698 VSS.n24 8.501
R2127 VSS.n560 VSS.t1695 0.130189
R2128 VSS.t1693 VSS.n24 8.501
R2129 VSS.n559 VSS.t1690 0.130189
R2130 VSS.t1688 VSS.n306 0.0362711
R2131 VSS.n558 VSS.t1685 0.0793054
R2132 VSS.t1683 VSS.n24 8.501
R2133 VSS.n557 VSS.t1680 0.130189
R2134 VSS.t1678 VSS.n24 8.501
R2135 VSS.n556 VSS.t1675 0.130189
R2136 VSS.t1673 VSS.n24 8.501
R2137 VSS.n555 VSS.t1670 0.130189
R2138 VSS.t1668 VSS.n24 8.501
R2139 VSS.n554 VSS.t1665 0.130189
R2140 VSS.t1663 VSS.n24 8.501
R2141 VSS.n553 VSS.t1660 0.130189
R2142 VSS.t1658 VSS.n24 8.501
R2143 VSS.n552 VSS.t1655 0.130189
R2144 VSS.t1653 VSS.n24 8.501
R2145 VSS.n551 VSS.t1650 0.130189
R2146 VSS.t1648 VSS.n24 8.501
R2147 VSS.n550 VSS.t1645 0.130189
R2148 VSS.t1643 VSS.n24 8.501
R2149 VSS.n549 VSS.t1640 0.130189
R2150 VSS.t1638 VSS.n24 8.501
R2151 VSS.n548 VSS.t1635 0.130189
R2152 VSS.t1633 VSS.n24 8.501
R2153 VSS.n547 VSS.t1630 0.130189
R2154 VSS.t1628 VSS.n24 8.501
R2155 VSS.n546 VSS.t1625 0.130189
R2156 VSS.t1623 VSS.n24 8.501
R2157 VSS.n545 VSS.t1620 0.130189
R2158 VSS.t1618 VSS.n24 8.501
R2159 VSS.n544 VSS.t1615 0.130189
R2160 VSS.t1613 VSS.n307 0.0362711
R2161 VSS.n543 VSS.t1610 0.0793054
R2162 VSS.t1608 VSS.n24 8.501
R2163 VSS.n542 VSS.t1605 0.130189
R2164 VSS.t1603 VSS.n24 8.501
R2165 VSS.n541 VSS.t1600 0.130189
R2166 VSS.t1598 VSS.n24 8.501
R2167 VSS.n540 VSS.t1595 0.130189
R2168 VSS.t1593 VSS.n24 8.501
R2169 VSS.n539 VSS.t1590 0.130189
R2170 VSS.t1588 VSS.n24 8.501
R2171 VSS.n538 VSS.t1585 0.130189
R2172 VSS.t1583 VSS.n24 8.501
R2173 VSS.n537 VSS.t1580 0.130189
R2174 VSS.t1578 VSS.n24 8.501
R2175 VSS.n536 VSS.t1575 0.130189
R2176 VSS.t1573 VSS.n24 8.501
R2177 VSS.n535 VSS.t1570 0.130189
R2178 VSS.t1568 VSS.n24 8.501
R2179 VSS.n534 VSS.t1565 0.130189
R2180 VSS.t1563 VSS.n24 8.501
R2181 VSS.n533 VSS.t1560 0.130189
R2182 VSS.t1558 VSS.n24 8.501
R2183 VSS.n532 VSS.t1555 0.130189
R2184 VSS.t1553 VSS.n24 8.501
R2185 VSS.n531 VSS.t1550 0.130189
R2186 VSS.t1548 VSS.n24 8.501
R2187 VSS.n530 VSS.t1545 0.130189
R2188 VSS.t1543 VSS.n24 8.501
R2189 VSS.n529 VSS.t1540 0.130189
R2190 VSS.t1535 VSS.n528 0.130189
R2191 VSS.t1533 VSS.n24 8.501
R2192 VSS.n527 VSS.t1530 0.130189
R2193 VSS.t1528 VSS.n24 8.501
R2194 VSS.n526 VSS.t1525 0.130189
R2195 VSS.t1523 VSS.n24 8.501
R2196 VSS.n525 VSS.t1520 0.130189
R2197 VSS.t1518 VSS.n24 8.501
R2198 VSS.n524 VSS.t1515 0.130189
R2199 VSS.t1513 VSS.n24 8.501
R2200 VSS.n523 VSS.t1510 0.130189
R2201 VSS.t1508 VSS.n24 8.501
R2202 VSS.n522 VSS.t1505 0.130189
R2203 VSS.t1503 VSS.n24 8.501
R2204 VSS.n521 VSS.t1500 0.130189
R2205 VSS.t1498 VSS.n24 8.501
R2206 VSS.n520 VSS.t1495 0.130189
R2207 VSS.t1493 VSS.n24 8.501
R2208 VSS.n519 VSS.t1490 0.130189
R2209 VSS.t1488 VSS.n24 8.501
R2210 VSS.n518 VSS.t1485 0.130189
R2211 VSS.t1483 VSS.n24 8.501
R2212 VSS.n517 VSS.t1480 0.130189
R2213 VSS.t1478 VSS.n24 8.501
R2214 VSS.n516 VSS.t1475 0.130189
R2215 VSS.t1473 VSS.n24 8.501
R2216 VSS.n515 VSS.t1470 0.130189
R2217 VSS.t1468 VSS.n24 8.501
R2218 VSS.n514 VSS.t1465 0.130189
R2219 VSS.t1463 VSS.n24 8.501
R2220 VSS.t1460 VSS.n513 0.130189
R2221 VSS.t1458 VSS.n24 8.501
R2222 VSS.t1455 VSS.n512 0.130189
R2223 VSS.t1453 VSS.n24 8.501
R2224 VSS.t1450 VSS.n511 0.130189
R2225 VSS.t1448 VSS.n24 8.501
R2226 VSS.n510 VSS.n24 3.33079
R2227 VSS.t224 VSS.t225 8.50908
R2228 VSS.n649 VSS.t1046 0.130189
R2229 VSS.t1044 VSS.n25 8.501
R2230 VSS.n648 VSS.t1041 0.130189
R2231 VSS.t1039 VSS.n25 8.501
R2232 VSS.n647 VSS.t1036 0.130189
R2233 VSS.t1034 VSS.n25 8.501
R2234 VSS.n646 VSS.t1031 0.130189
R2235 VSS.t1029 VSS.n25 8.501
R2236 VSS.n645 VSS.t1026 0.130189
R2237 VSS.t1024 VSS.n25 8.501
R2238 VSS.n644 VSS.t1021 0.130189
R2239 VSS.t1019 VSS.n25 8.501
R2240 VSS.n643 VSS.t1016 0.130189
R2241 VSS.t1014 VSS.n219 0.0362711
R2242 VSS.n642 VSS.t1011 0.0793054
R2243 VSS.t1009 VSS.n25 8.501
R2244 VSS.n641 VSS.t1006 0.130189
R2245 VSS.t1004 VSS.n25 8.501
R2246 VSS.n640 VSS.t1001 0.130189
R2247 VSS.t999 VSS.n25 8.501
R2248 VSS.n639 VSS.t996 0.130189
R2249 VSS.t994 VSS.n25 8.501
R2250 VSS.n638 VSS.t991 0.130189
R2251 VSS.t989 VSS.n25 8.501
R2252 VSS.n637 VSS.t986 0.130189
R2253 VSS.t984 VSS.n25 8.501
R2254 VSS.n636 VSS.t981 0.130189
R2255 VSS.t979 VSS.n25 8.501
R2256 VSS.n635 VSS.t976 0.130189
R2257 VSS.t974 VSS.n25 8.501
R2258 VSS.n634 VSS.t971 0.130189
R2259 VSS.t969 VSS.n25 8.501
R2260 VSS.n633 VSS.t966 0.130189
R2261 VSS.t964 VSS.n25 8.501
R2262 VSS.n632 VSS.t961 0.130189
R2263 VSS.t959 VSS.n25 8.501
R2264 VSS.n631 VSS.t956 0.130189
R2265 VSS.t954 VSS.n25 8.501
R2266 VSS.n630 VSS.t951 0.130189
R2267 VSS.t949 VSS.n25 8.501
R2268 VSS.n629 VSS.t946 0.130189
R2269 VSS.t944 VSS.n25 8.501
R2270 VSS.n628 VSS.t941 0.130189
R2271 VSS.t939 VSS.n220 0.0362711
R2272 VSS.n627 VSS.t936 0.0793054
R2273 VSS.n25 VSS.t934 8.501
R2274 VSS.n626 VSS.t931 0.130189
R2275 VSS.t929 VSS.n25 8.501
R2276 VSS.n625 VSS.t926 0.130189
R2277 VSS.t924 VSS.n25 8.501
R2278 VSS.n624 VSS.t921 0.130189
R2279 VSS.t919 VSS.n25 8.501
R2280 VSS.n623 VSS.t916 0.130189
R2281 VSS.t914 VSS.n25 8.501
R2282 VSS.n622 VSS.t911 0.130189
R2283 VSS.t909 VSS.n25 8.501
R2284 VSS.n621 VSS.t906 0.130189
R2285 VSS.t904 VSS.n25 8.501
R2286 VSS.n620 VSS.t901 0.130189
R2287 VSS.t899 VSS.n25 8.501
R2288 VSS.n619 VSS.t896 0.130189
R2289 VSS.t894 VSS.n25 8.501
R2290 VSS.n618 VSS.t891 0.130189
R2291 VSS.t889 VSS.n25 8.501
R2292 VSS.n617 VSS.t886 0.130189
R2293 VSS.t884 VSS.n25 8.501
R2294 VSS.n616 VSS.t881 0.130189
R2295 VSS.t879 VSS.n25 8.501
R2296 VSS.n615 VSS.t876 0.130189
R2297 VSS.t874 VSS.n25 8.501
R2298 VSS.n614 VSS.t871 0.130189
R2299 VSS.t869 VSS.n25 8.501
R2300 VSS.n613 VSS.t866 0.130189
R2301 VSS.n612 VSS.t861 0.130189
R2302 VSS.t859 VSS.n25 8.501
R2303 VSS.n611 VSS.t856 0.130189
R2304 VSS.t854 VSS.n25 8.501
R2305 VSS.n610 VSS.t851 0.130189
R2306 VSS.t849 VSS.n25 8.501
R2307 VSS.n609 VSS.t846 0.130189
R2308 VSS.t844 VSS.n25 8.501
R2309 VSS.n608 VSS.t841 0.130189
R2310 VSS.t839 VSS.n25 8.501
R2311 VSS.n607 VSS.t836 0.130189
R2312 VSS.t834 VSS.n25 8.501
R2313 VSS.n606 VSS.t831 0.130189
R2314 VSS.t829 VSS.n25 8.501
R2315 VSS.n605 VSS.t826 0.130189
R2316 VSS.t824 VSS.n25 8.501
R2317 VSS.n604 VSS.t821 0.130189
R2318 VSS.t819 VSS.n25 8.501
R2319 VSS.n603 VSS.t816 0.130189
R2320 VSS.t814 VSS.n25 8.501
R2321 VSS.n602 VSS.t811 0.130189
R2322 VSS.t809 VSS.n25 8.501
R2323 VSS.n601 VSS.t806 0.130189
R2324 VSS.t804 VSS.n25 8.501
R2325 VSS.n600 VSS.t801 0.130189
R2326 VSS.t799 VSS.n25 8.501
R2327 VSS.n599 VSS.t796 0.130189
R2328 VSS.t794 VSS.n25 8.501
R2329 VSS.n598 VSS.t791 0.130189
R2330 VSS.t789 VSS.n25 8.501
R2331 VSS.t786 VSS.n597 0.130189
R2332 VSS.t784 VSS.n25 8.501
R2333 VSS.t781 VSS.n596 0.130189
R2334 VSS.t779 VSS.n25 8.501
R2335 VSS.t776 VSS.n595 0.130189
R2336 VSS.t774 VSS.n25 8.501
R2337 VSS.n594 VSS.n25 3.33079
R2338 VSS.t696 VSS.t54 8.501
R2339 VSS.n658 VSS.t54 3.33079
R2340 VSS.t691 VSS.t54 8.501
R2341 VSS.n657 VSS.t54 3.33079
R2342 VSS.t593 VSS.t54 8.501
R2343 VSS.n656 VSS.t54 3.33079
R2344 VSS.t588 VSS.t54 8.501
R2345 VSS.n655 VSS.t54 3.33079
R2346 VSS.t582 VSS.n218 0.219244
R2347 VSS.t579 VSS.t54 8.501
R2348 VSS.n654 VSS.t54 3.33079
R2349 VSS.t574 VSS.t54 8.501
R2350 VSS.n653 VSS.t54 3.33079
R2351 VSS.t569 VSS.t54 8.501
R2352 VSS.n652 VSS.t54 3.33079
R2353 VSS.t564 VSS.t54 8.501
R2354 VSS.n651 VSS.t54 3.33079
R2355 VSS.t559 VSS.t54 8.501
R2356 VSS.n650 VSS.t54 3.33079
R2357 VSS.t46 VSS.n659 0.789075
R2358 VSS.t552 VSS.t54 8.501
R2359 VSS.n665 VSS.t54 0.688563
R2360 VSS.n664 VSS.t54 2.31581
R2361 VSS.n663 VSS.t54 2.31585
R2362 VSS.n662 VSS.t54 2.31585
R2363 VSS.n661 VSS.t54 2.31585
R2364 VSS.n660 VSS.t54 2.31585
R2365 VSS.n666 VSS.t54 3.33087
R2366 VSS.t54 VSS.t530 8.501
R2367 VSS.t527 VSS.n669 0.130189
R2368 VSS.t525 VSS.t54 8.501
R2369 VSS.n668 VSS.t54 3.33079
R2370 VSS.t236 VSS.n675 0.662918
R2371 VSS.n674 VSS.t54 2.31501
R2372 VSS.t715 VSS.n673 0.129991
R2373 VSS.t712 VSS.n204 0.331034
R2374 VSS.n204 VSS.t54 1.74963
R2375 VSS.t707 VSS.n672 0.130189
R2376 VSS.t705 VSS.t54 8.501
R2377 VSS.t601 VSS.n671 0.123414
R2378 VSS.t598 VSS.t54 8.501
R2379 VSS.n670 VSS.t595 0.130189
R2380 VSS.t96 VSS.n213 0.527482
R2381 VSS.t187 VSS.n676 0.130189
R2382 VSS.n678 VSS.t735 0.132379
R2383 VSS.n677 VSS.t297 0.129991
R2384 VSS.t731 VSS.t54 8.501
R2385 VSS.t126 VSS.n679 0.130189
R2386 VSS.n685 VSS.t2 1.00519
R2387 VSS.t2 VSS.t83 8.501
R2388 VSS.t483 VSS.n684 0.238078
R2389 VSS.t142 VSS.n207 0.331034
R2390 VSS.t132 VSS.n683 0.130189
R2391 VSS.t128 VSS.t2 8.501
R2392 VSS.t102 VSS.n682 0.130189
R2393 VSS.t471 VSS.t2 8.501
R2394 VSS.t153 VSS.n681 0.129991
R2395 VSS.n257 VSS.t2 4.20315
R2396 VSS.t7 VSS.t2 0.423698
R2397 VSS.t92 VSS.n688 0.893133
R2398 VSS.n206 VSS.t2 1.60022
R2399 VSS.n206 VSS.t44 0.291793
R2400 VSS.n690 VSS.t2 5.64879
R2401 VSS.t419 VSS.n694 0.624348
R2402 VSS.n693 VSS.t2 3.33079
R2403 VSS.t414 VSS.t2 8.501
R2404 VSS.n692 VSS.t2 3.33079
R2405 VSS.t2322 VSS.n26 8.5005
R2406 VSS.n23 VSS.t1930 8.5005
R2407 VSS.n24 VSS.t1538 8.5005
R2408 VSS.n25 VSS.t864 8.5005
R2409 VSS.n378 VSS.n109 4.20468
R2410 VSS.n363 VSS.n109 4.20468
R2411 VSS.t370 VSS.n388 0.153604
R2412 VSS.t2882 VSS.n390 0.17801
R2413 VSS.t2620 VSS.t2764 8.47111
R2414 VSS.t2885 VSS.n187 0.119605
R2415 VSS.t2620 VSS.n187 4.177
R2416 VSS.n255 VSS.t2620 4.177
R2417 VSS.t2768 VSS.n255 0.119605
R2418 VSS.t2620 VSS.n391 3.30696
R2419 VSS.t2890 VSS.n312 0.17801
R2420 VSS.t2893 VSS.n188 0.119605
R2421 VSS.t2620 VSS.n188 4.177
R2422 VSS.n254 VSS.t2620 4.177
R2423 VSS.t2776 VSS.n254 0.119605
R2424 VSS.t2620 VSS.n392 3.30696
R2425 VSS.t2898 VSS.n253 0.119605
R2426 VSS.n253 VSS.t2620 4.177
R2427 VSS.t2782 VSS.n393 0.083315
R2428 VSS.n299 VSS.t2620 3.30696
R2429 VSS.t2758 VSS.n195 0.177814
R2430 VSS.t2746 VSS.n313 0.177814
R2431 VSS.t2740 VSS.n314 0.177814
R2432 VSS.t2734 VSS.n298 0.177814
R2433 VSS.t2729 VSS.n315 0.177814
R2434 VSS.t2723 VSS.n316 0.177814
R2435 VSS.t2620 VSS.t2718 8.47111
R2436 VSS.t2717 VSS.n297 0.177814
R2437 VSS.t2712 VSS.n317 0.17801
R2438 VSS.t2706 VSS.n296 0.17801
R2439 VSS.t2702 VSS.n318 0.177814
R2440 VSS.t2696 VSS.n319 0.177814
R2441 VSS.t2690 VSS.n295 0.177814
R2442 VSS.t2685 VSS.n320 0.177814
R2443 VSS.t2679 VSS.n294 0.177814
R2444 VSS.n284 VSS.t2620 3.30696
R2445 VSS.n321 VSS.t2668 0.17801
R2446 VSS.n293 VSS.t2662 0.17801
R2447 VSS.t2657 VSS.n322 0.17801
R2448 VSS.t2651 VSS.n323 0.17801
R2449 VSS.t2645 VSS.n292 0.17801
R2450 VSS.n291 VSS.t2641 0.177814
R2451 VSS.n394 VSS.t2620 4.177
R2452 VSS.n394 VSS.t2639 0.119605
R2453 VSS.n290 VSS.t2620 3.30696
R2454 VSS.n324 VSS.t2633 0.177814
R2455 VSS.n289 VSS.t2620 3.30688
R2456 VSS.n325 VSS.t2625 0.177814
R2457 VSS.n444 VSS.n26 4.20468
R2458 VSS.n26 VSS.n429 4.20468
R2459 VSS.n501 VSS.n23 4.20468
R2460 VSS.n486 VSS.n23 4.20468
R2461 VSS.n24 VSS.n558 4.20468
R2462 VSS.n543 VSS.n24 4.20468
R2463 VSS.t1215 VSS.n566 0.119605
R2464 VSS.n566 VSS.t224 4.177
R2465 VSS.t1217 VSS.n263 0.119605
R2466 VSS.t1219 VSS.n567 0.119605
R2467 VSS.n263 VSS.t224 4.177
R2468 VSS.n567 VSS.t224 4.177
R2469 VSS.n568 VSS.t224 3.30696
R2470 VSS.t1225 VSS.n245 0.235242
R2471 VSS.n184 VSS.t224 3.30696
R2472 VSS.n245 VSS.t224 2.72093
R2473 VSS.t1227 VSS.n569 0.119605
R2474 VSS.n569 VSS.t224 4.177
R2475 VSS.t1229 VSS.n570 0.119605
R2476 VSS.t1231 VSS.n571 0.17801
R2477 VSS.n570 VSS.t224 4.177
R2478 VSS.n572 VSS.t224 3.30688
R2479 VSS.t1233 VSS.t224 8.47111
R2480 VSS.t1237 VSS.n238 0.177814
R2481 VSS.t1238 VSS.t224 8.47111
R2482 VSS.t1243 VSS.n202 0.2914
R2483 VSS.n202 VSS.t224 2.29759
R2484 VSS.t1246 VSS.n262 0.2914
R2485 VSS.t1249 VSS.n233 0.235242
R2486 VSS.n233 VSS.t224 2.72093
R2487 VSS.t1251 VSS.n573 0.119605
R2488 VSS.n573 VSS.t224 4.177
R2489 VSS.t1253 VSS.t224 8.47111
R2490 VSS.n222 VSS.t224 3.30696
R2491 VSS.t1256 VSS.t224 8.47111
R2492 VSS.t1257 VSS.n574 0.17801
R2493 VSS.t1259 VSS.t224 8.47111
R2494 VSS.n575 VSS.t224 3.30688
R2495 VSS.t1262 VSS.t224 8.47111
R2496 VSS.n576 VSS.t224 3.30688
R2497 VSS.t1265 VSS.n198 0.119605
R2498 VSS.t1267 VSS.n577 0.17801
R2499 VSS.n198 VSS.t224 4.177
R2500 VSS.n303 VSS.t224 2.72093
R2501 VSS.t1269 VSS.t224 8.47111
R2502 VSS.t1271 VSS.n303 0.235242
R2503 VSS.t1272 VSS.t224 8.47111
R2504 VSS.t1274 VSS.n241 0.17801
R2505 VSS.t1275 VSS.n578 0.119605
R2506 VSS.n578 VSS.t224 4.177
R2507 VSS.n264 VSS.t224 3.30688
R2508 VSS.t1279 VSS.n579 0.119605
R2509 VSS.n579 VSS.t224 4.177
R2510 VSS.t1282 VSS.n288 0.177814
R2511 VSS.t1283 VSS.t224 8.47111
R2512 VSS.t1285 VSS.n221 0.177814
R2513 VSS.t1286 VSS.n244 0.119605
R2514 VSS.t1288 VSS.n304 0.2914
R2515 VSS.n244 VSS.t224 4.177
R2516 VSS.n192 VSS.t224 2.29759
R2517 VSS.n185 VSS.t224 2.29759
R2518 VSS.n232 VSS.t224 2.29759
R2519 VSS.t1302 VSS.n580 0.119605
R2520 VSS.n580 VSS.t224 4.177
R2521 VSS.n871 VSS.t224 8.47111
R2522 VSS.n581 VSS.t1305 0.119605
R2523 VSS.t224 VSS.n581 4.177
R2524 VSS.t224 VSS.n265 3.30688
R2525 VSS.n582 VSS.t1309 0.119605
R2526 VSS.t224 VSS.n582 4.177
R2527 VSS.n287 VSS.t1312 0.17801
R2528 VSS.t224 VSS.t1313 8.47111
R2529 VSS.n191 VSS.t224 3.30696
R2530 VSS.n583 VSS.t224 3.30688
R2531 VSS.t1439 VSS.t224 8.47111
R2532 VSS.n584 VSS.t224 3.30688
R2533 VSS.n271 VSS.t224 3.30688
R2534 VSS.t1214 VSS.t224 8.47111
R2535 VSS.n585 VSS.t224 4.177
R2536 VSS.t1365 VSS.n585 0.119605
R2537 VSS.t224 VSS.n266 4.177
R2538 VSS.n266 VSS.t1211 0.119605
R2539 VSS.t224 VSS.n586 4.177
R2540 VSS.n586 VSS.t1208 0.119605
R2541 VSS.t224 VSS.n267 4.177
R2542 VSS.n267 VSS.t1206 0.119605
R2543 VSS.n239 VSS.t224 4.177
R2544 VSS.t1204 VSS.n239 0.119605
R2545 VSS.n587 VSS.t224 4.177
R2546 VSS.t1201 VSS.n587 0.119605
R2547 VSS.n268 VSS.t224 4.177
R2548 VSS.n268 VSS.t1200 0.119605
R2549 VSS.t224 VSS.n240 4.177
R2550 VSS.n240 VSS.t1198 0.119605
R2551 VSS.t224 VSS.n223 3.30696
R2552 VSS.t224 VSS.n224 3.30696
R2553 VSS.t1192 VSS.n225 0.177814
R2554 VSS.t1190 VSS.n259 0.119605
R2555 VSS.n259 VSS.t224 4.177
R2556 VSS.t224 VSS.n588 4.177
R2557 VSS.n588 VSS.t1188 0.119605
R2558 VSS.n226 VSS.t1186 0.177814
R2559 VSS.t1184 VSS.n227 0.177814
R2560 VSS.t1182 VSS.n260 0.119605
R2561 VSS.n260 VSS.t224 4.177
R2562 VSS.t224 VSS.n589 4.177
R2563 VSS.n589 VSS.t1180 0.119605
R2564 VSS.n228 VSS.t1178 0.177814
R2565 VSS.t1176 VSS.n229 0.177814
R2566 VSS.t1174 VSS.n261 0.119605
R2567 VSS.n261 VSS.t224 4.177
R2568 VSS.n590 VSS.t224 4.177
R2569 VSS.t1172 VSS.n590 0.119605
R2570 VSS.t1170 VSS.n230 0.177814
R2571 VSS.t1168 VSS.n231 0.177814
R2572 VSS.n269 VSS.t224 4.177
R2573 VSS.t1164 VSS.n591 0.119605
R2574 VSS.n591 VSS.t224 4.177
R2575 VSS.n642 VSS.n25 4.20468
R2576 VSS.n627 VSS.n25 4.20468
R2577 VSS.n686 VSS.t2 2.74283
R2578 VSS.n235 VSS.t2 4.177
R2579 VSS.t118 VSS.n235 0.119605
R2580 VSS.t277 VSS.n270 0.17801
R2581 VSS.t9 VSS.n257 0.0820912
R2582 VSS.n183 VSS.t2 1.72288
R2583 VSS.t113 VSS.n243 0.2914
R2584 VSS.t2 VSS.t228 1.00423
R2585 VSS.n687 VSS.t2 4.177
R2586 VSS.n807 VSS.t231 8.06935
R2587 VSS.n792 VSS.t97 8.06935
R2588 VSS.t165 VSS.t695 7.1604
R2589 VSS.t3195 VSS.t53 7.1604
R2590 VSS.t3 VSS.t163 7.1604
R2591 VSS.t33 VSS.n948 7.1604
R2592 VSS.t39 VSS.t2 0.736746
R2593 VSS.n179 VSS.t2 0.56246
R2594 VSS.n385 VSS.n109 3.33079
R2595 VSS.n109 VSS.n384 3.33079
R2596 VSS.n383 VSS.n109 3.33079
R2597 VSS.n109 VSS.n382 3.33079
R2598 VSS.n381 VSS.n109 3.33079
R2599 VSS.n109 VSS.n380 3.33079
R2600 VSS.n379 VSS.n109 3.33079
R2601 VSS.n109 VSS.n377 3.33079
R2602 VSS.n376 VSS.n109 3.33079
R2603 VSS.n109 VSS.n375 3.33079
R2604 VSS.n374 VSS.n109 3.33079
R2605 VSS.n109 VSS.n373 3.33079
R2606 VSS.n372 VSS.n109 3.33079
R2607 VSS.n109 VSS.n371 3.33079
R2608 VSS.n370 VSS.n109 3.33079
R2609 VSS.n109 VSS.n369 3.33079
R2610 VSS.n368 VSS.n109 3.33079
R2611 VSS.n109 VSS.n367 3.33079
R2612 VSS.n366 VSS.n109 3.33079
R2613 VSS.n109 VSS.n365 3.33079
R2614 VSS.n364 VSS.n109 3.33079
R2615 VSS.n109 VSS.n362 3.33079
R2616 VSS.n361 VSS.n109 3.33079
R2617 VSS.n360 VSS.n109 3.33079
R2618 VSS.n359 VSS.n109 3.33079
R2619 VSS.n358 VSS.n109 3.33079
R2620 VSS.n357 VSS.n109 3.33079
R2621 VSS.n356 VSS.n109 3.33079
R2622 VSS.n355 VSS.n109 3.33079
R2623 VSS.n354 VSS.n109 3.33079
R2624 VSS.n353 VSS.n109 3.33079
R2625 VSS.n352 VSS.n109 3.33079
R2626 VSS.n351 VSS.n109 3.33079
R2627 VSS.n350 VSS.n109 3.33079
R2628 VSS.n349 VSS.n109 3.33079
R2629 VSS.n348 VSS.n109 3.33079
R2630 VSS.n347 VSS.n109 3.33079
R2631 VSS.n346 VSS.n109 3.33079
R2632 VSS.n345 VSS.n109 3.33079
R2633 VSS.n344 VSS.n109 3.33079
R2634 VSS.n343 VSS.n109 3.33079
R2635 VSS.n342 VSS.n109 3.33079
R2636 VSS.n341 VSS.n109 3.33079
R2637 VSS.n340 VSS.n109 3.33079
R2638 VSS.n339 VSS.n109 3.33079
R2639 VSS.n338 VSS.n109 3.33079
R2640 VSS.n337 VSS.n109 3.33079
R2641 VSS.n336 VSS.n109 3.33079
R2642 VSS.n335 VSS.n109 3.33079
R2643 VSS.n109 VSS.n334 3.33079
R2644 VSS.n332 VSS.n109 3.33079
R2645 VSS.n109 VSS.n331 3.33079
R2646 VSS.t2902 VSS.n330 0.0863258
R2647 VSS.n706 VSS.t308 0.0896992
R2648 VSS.t313 VSS.n707 0.0896992
R2649 VSS.t318 VSS.n708 0.0896992
R2650 VSS.t323 VSS.n699 0.0896992
R2651 VSS.t328 VSS.n700 0.0896992
R2652 VSS.t333 VSS.n701 0.0896992
R2653 VSS.t338 VSS.n702 0.0896992
R2654 VSS.t343 VSS.n703 0.0896992
R2655 VSS.t348 VSS.n704 0.0896992
R2656 VSS.t352 VSS.n696 0.0896992
R2657 VSS.t362 VSS.n698 0.0896992
R2658 VSS.t365 VSS.n387 0.0896992
R2659 VSS.n389 VSS.t375 0.0896992
R2660 VSS.n876 VSS.t2620 5.61485
R2661 VSS.t2620 VSS.n390 3.30688
R2662 VSS.t2770 VSS.n391 0.118193
R2663 VSS.t2620 VSS.t2771 5.61485
R2664 VSS.t2620 VSS.n312 3.30688
R2665 VSS.t2778 VSS.n392 0.118193
R2666 VSS.t2620 VSS.t2779 5.61485
R2667 VSS.t2760 VSS.n299 0.118193
R2668 VSS.n195 VSS.t2620 3.30696
R2669 VSS.n305 VSS.t2620 2.29748
R2670 VSS.t2620 VSS.n286 2.72098
R2671 VSS.t2753 VSS.n286 0.175395
R2672 VSS.t2751 VSS.n258 0.286604
R2673 VSS.n247 VSS.t2748 0.175395
R2674 VSS.n247 VSS.t2620 2.72098
R2675 VSS.n313 VSS.t2620 3.30696
R2676 VSS.t2743 VSS.n283 0.175554
R2677 VSS.t2620 VSS.n283 2.7209
R2678 VSS.t2741 VSS.t2620 5.61485
R2679 VSS.n314 VSS.t2620 3.30696
R2680 VSS.t2737 VSS.n282 0.175554
R2681 VSS.t2620 VSS.n282 2.7209
R2682 VSS.t2735 VSS.t2620 5.61485
R2683 VSS.n298 VSS.t2620 3.30696
R2684 VSS.t2731 VSS.n248 0.175554
R2685 VSS.t2620 VSS.n248 2.7209
R2686 VSS.n315 VSS.t2620 3.30696
R2687 VSS.t2727 VSS.n281 0.175714
R2688 VSS.n281 VSS.t2620 2.72082
R2689 VSS.t2620 VSS.t2724 5.61485
R2690 VSS.n316 VSS.t2620 3.30696
R2691 VSS.t2721 VSS.n280 0.175714
R2692 VSS.n280 VSS.t2620 2.72082
R2693 VSS.n297 VSS.t2620 3.30696
R2694 VSS.t2715 VSS.n249 0.175714
R2695 VSS.n249 VSS.t2620 2.72082
R2696 VSS.n317 VSS.t2620 3.30688
R2697 VSS.t2710 VSS.n279 0.175554
R2698 VSS.n279 VSS.t2620 2.7209
R2699 VSS.t2707 VSS.t2620 5.61485
R2700 VSS.n296 VSS.t2620 3.30688
R2701 VSS.t2704 VSS.n250 0.175554
R2702 VSS.n250 VSS.t2620 2.7209
R2703 VSS.n318 VSS.t2620 3.30696
R2704 VSS.t2699 VSS.n278 0.175395
R2705 VSS.n278 VSS.t2620 2.72098
R2706 VSS.t2697 VSS.t2620 5.61485
R2707 VSS.n319 VSS.t2620 3.30696
R2708 VSS.t2693 VSS.n277 0.175395
R2709 VSS.n277 VSS.t2620 2.72098
R2710 VSS.t2691 VSS.t2620 5.61485
R2711 VSS.n295 VSS.t2620 3.30696
R2712 VSS.t2687 VSS.n251 0.175395
R2713 VSS.n251 VSS.t2620 2.72098
R2714 VSS.n320 VSS.t2620 3.30696
R2715 VSS.t2682 VSS.n276 0.175714
R2716 VSS.n276 VSS.t2620 2.72082
R2717 VSS.t2680 VSS.t2620 5.61485
R2718 VSS.n294 VSS.t2620 3.30696
R2719 VSS.t2676 VSS.t2620 5.61485
R2720 VSS.t2675 VSS.n284 0.118193
R2721 VSS.t2620 VSS.t2673 5.61485
R2722 VSS.t2671 VSS.n275 0.175554
R2723 VSS.n275 VSS.t2620 2.7209
R2724 VSS.t2620 VSS.t2669 5.61485
R2725 VSS.t2620 VSS.n321 3.30688
R2726 VSS.t2665 VSS.n274 0.175554
R2727 VSS.n274 VSS.t2620 2.7209
R2728 VSS.t2620 VSS.t2663 5.61485
R2729 VSS.t2620 VSS.n293 3.30688
R2730 VSS.t2659 VSS.n252 0.175554
R2731 VSS.n252 VSS.t2620 2.7209
R2732 VSS.t2620 VSS.n322 3.30688
R2733 VSS.n273 VSS.t2655 0.175395
R2734 VSS.n273 VSS.t2620 2.72098
R2735 VSS.t2652 VSS.t2620 5.61485
R2736 VSS.t2620 VSS.n323 3.30688
R2737 VSS.n272 VSS.t2649 0.175395
R2738 VSS.n272 VSS.t2620 2.72098
R2739 VSS.t2646 VSS.t2620 5.61485
R2740 VSS.t2620 VSS.n292 3.30688
R2741 VSS.n246 VSS.t2643 0.175395
R2742 VSS.n246 VSS.t2620 2.72098
R2743 VSS.n291 VSS.t2620 3.30696
R2744 VSS.t2638 VSS.t2620 5.61485
R2745 VSS.t2636 VSS.n290 0.118193
R2746 VSS.n193 VSS.t2635 0.175554
R2747 VSS.t2620 VSS.n193 2.7209
R2748 VSS.n324 VSS.t2620 3.30696
R2749 VSS.t2630 VSS.t2620 5.61485
R2750 VSS.n289 VSS.t2628 0.118323
R2751 VSS.t2620 VSS.n194 2.72098
R2752 VSS.t2626 VSS.n194 0.175395
R2753 VSS.n325 VSS.t2620 3.30696
R2754 VSS.t2620 VSS.t2623 5.61485
R2755 VSS.n329 VSS.t2622 0.106161
R2756 VSS.n414 VSS.n26 3.33079
R2757 VSS.n451 VSS.n26 3.33079
R2758 VSS.n26 VSS.n450 3.33079
R2759 VSS.n26 VSS.n448 3.33079
R2760 VSS.n447 VSS.n26 3.33079
R2761 VSS.n26 VSS.n446 3.33079
R2762 VSS.n445 VSS.n26 3.33079
R2763 VSS.n26 VSS.n443 3.33079
R2764 VSS.n442 VSS.n26 3.33079
R2765 VSS.n441 VSS.n26 3.33079
R2766 VSS.n440 VSS.n26 3.33079
R2767 VSS.n439 VSS.n26 3.33079
R2768 VSS.n438 VSS.n26 3.33079
R2769 VSS.n437 VSS.n26 3.33079
R2770 VSS.n436 VSS.n26 3.33079
R2771 VSS.n435 VSS.n26 3.33079
R2772 VSS.n434 VSS.n26 3.33079
R2773 VSS.n433 VSS.n26 3.33079
R2774 VSS.n432 VSS.n26 3.33079
R2775 VSS.n431 VSS.n26 3.33079
R2776 VSS.n430 VSS.n26 3.33079
R2777 VSS.n428 VSS.n26 3.33079
R2778 VSS.n427 VSS.n26 3.33079
R2779 VSS.n426 VSS.n26 3.33079
R2780 VSS.n425 VSS.n26 3.33079
R2781 VSS.n424 VSS.n26 3.33079
R2782 VSS.n423 VSS.n26 3.33079
R2783 VSS.n422 VSS.n26 3.33079
R2784 VSS.n421 VSS.n26 3.33079
R2785 VSS.n420 VSS.n26 3.33079
R2786 VSS.n419 VSS.n26 3.33079
R2787 VSS.n418 VSS.n26 3.33079
R2788 VSS.n417 VSS.n26 3.33079
R2789 VSS.n416 VSS.n26 3.33079
R2790 VSS.n415 VSS.n26 3.33079
R2791 VSS.n413 VSS.n26 3.33079
R2792 VSS.n412 VSS.n26 3.33079
R2793 VSS.n411 VSS.n26 3.33079
R2794 VSS.n410 VSS.n26 3.33079
R2795 VSS.n409 VSS.n26 3.33079
R2796 VSS.n408 VSS.n26 3.33079
R2797 VSS.n407 VSS.n26 3.33079
R2798 VSS.n406 VSS.n26 3.33079
R2799 VSS.n405 VSS.n26 3.33079
R2800 VSS.n404 VSS.n26 3.33079
R2801 VSS.n403 VSS.n26 3.33079
R2802 VSS.n402 VSS.n26 3.33079
R2803 VSS.n401 VSS.n26 3.33079
R2804 VSS.n400 VSS.n26 3.33079
R2805 VSS.n399 VSS.n26 3.33079
R2806 VSS.n398 VSS.n26 3.33079
R2807 VSS.n397 VSS.n26 3.33079
R2808 VSS.t2230 VSS.n396 0.0863258
R2809 VSS.n23 VSS.n471 3.33079
R2810 VSS.n23 VSS.n508 3.33079
R2811 VSS.n507 VSS.n23 3.33079
R2812 VSS.n505 VSS.n23 3.33079
R2813 VSS.n23 VSS.n504 3.33079
R2814 VSS.n503 VSS.n23 3.33079
R2815 VSS.n23 VSS.n502 3.33079
R2816 VSS.n23 VSS.n500 3.33079
R2817 VSS.n499 VSS.n23 3.33079
R2818 VSS.n23 VSS.n498 3.33079
R2819 VSS.n497 VSS.n23 3.33079
R2820 VSS.n23 VSS.n496 3.33079
R2821 VSS.n495 VSS.n23 3.33079
R2822 VSS.n23 VSS.n494 3.33079
R2823 VSS.n493 VSS.n23 3.33079
R2824 VSS.n23 VSS.n492 3.33079
R2825 VSS.n491 VSS.n23 3.33079
R2826 VSS.n23 VSS.n490 3.33079
R2827 VSS.n489 VSS.n23 3.33079
R2828 VSS.n23 VSS.n488 3.33079
R2829 VSS.n487 VSS.n23 3.33079
R2830 VSS.n23 VSS.n485 3.33079
R2831 VSS.n484 VSS.n23 3.33079
R2832 VSS.n23 VSS.n483 3.33079
R2833 VSS.n482 VSS.n23 3.33079
R2834 VSS.n23 VSS.n481 3.33079
R2835 VSS.n480 VSS.n23 3.33079
R2836 VSS.n23 VSS.n479 3.33079
R2837 VSS.n478 VSS.n23 3.33079
R2838 VSS.n23 VSS.n477 3.33079
R2839 VSS.n476 VSS.n23 3.33079
R2840 VSS.n23 VSS.n475 3.33079
R2841 VSS.n474 VSS.n23 3.33079
R2842 VSS.n23 VSS.n473 3.33079
R2843 VSS.n472 VSS.n23 3.33079
R2844 VSS.n470 VSS.n23 3.33079
R2845 VSS.n23 VSS.n469 3.33079
R2846 VSS.n468 VSS.n23 3.33079
R2847 VSS.n23 VSS.n467 3.33079
R2848 VSS.n466 VSS.n23 3.33079
R2849 VSS.n23 VSS.n465 3.33079
R2850 VSS.n464 VSS.n23 3.33079
R2851 VSS.n23 VSS.n463 3.33079
R2852 VSS.n462 VSS.n23 3.33079
R2853 VSS.n23 VSS.n461 3.33079
R2854 VSS.n460 VSS.n23 3.33079
R2855 VSS.n23 VSS.n459 3.33079
R2856 VSS.n458 VSS.n23 3.33079
R2857 VSS.n23 VSS.n457 3.33079
R2858 VSS.n456 VSS.n23 3.33079
R2859 VSS.n455 VSS.n23 3.33079
R2860 VSS.n454 VSS.n23 3.33079
R2861 VSS.t1838 VSS.n453 0.0863258
R2862 VSS.n528 VSS.n24 3.33079
R2863 VSS.n565 VSS.n24 3.33079
R2864 VSS.n24 VSS.n564 3.33079
R2865 VSS.n24 VSS.n562 3.33079
R2866 VSS.n561 VSS.n24 3.33079
R2867 VSS.n24 VSS.n560 3.33079
R2868 VSS.n559 VSS.n24 3.33079
R2869 VSS.n557 VSS.n24 3.33079
R2870 VSS.n24 VSS.n556 3.33079
R2871 VSS.n555 VSS.n24 3.33079
R2872 VSS.n24 VSS.n554 3.33079
R2873 VSS.n553 VSS.n24 3.33079
R2874 VSS.n24 VSS.n552 3.33079
R2875 VSS.n551 VSS.n24 3.33079
R2876 VSS.n24 VSS.n550 3.33079
R2877 VSS.n549 VSS.n24 3.33079
R2878 VSS.n24 VSS.n548 3.33079
R2879 VSS.n547 VSS.n24 3.33079
R2880 VSS.n24 VSS.n546 3.33079
R2881 VSS.n545 VSS.n24 3.33079
R2882 VSS.n24 VSS.n544 3.33079
R2883 VSS.n24 VSS.n542 3.33079
R2884 VSS.n541 VSS.n24 3.33079
R2885 VSS.n24 VSS.n540 3.33079
R2886 VSS.n539 VSS.n24 3.33079
R2887 VSS.n24 VSS.n538 3.33079
R2888 VSS.n537 VSS.n24 3.33079
R2889 VSS.n24 VSS.n536 3.33079
R2890 VSS.n535 VSS.n24 3.33079
R2891 VSS.n24 VSS.n534 3.33079
R2892 VSS.n533 VSS.n24 3.33079
R2893 VSS.n24 VSS.n532 3.33079
R2894 VSS.n531 VSS.n24 3.33079
R2895 VSS.n24 VSS.n530 3.33079
R2896 VSS.n529 VSS.n24 3.33079
R2897 VSS.n527 VSS.n24 3.33079
R2898 VSS.n24 VSS.n526 3.33079
R2899 VSS.n525 VSS.n24 3.33079
R2900 VSS.n24 VSS.n524 3.33079
R2901 VSS.n523 VSS.n24 3.33079
R2902 VSS.n24 VSS.n522 3.33079
R2903 VSS.n521 VSS.n24 3.33079
R2904 VSS.n24 VSS.n520 3.33079
R2905 VSS.n519 VSS.n24 3.33079
R2906 VSS.n24 VSS.n518 3.33079
R2907 VSS.n517 VSS.n24 3.33079
R2908 VSS.n24 VSS.n516 3.33079
R2909 VSS.n515 VSS.n24 3.33079
R2910 VSS.n24 VSS.n514 3.33079
R2911 VSS.n513 VSS.n24 3.33079
R2912 VSS.n512 VSS.n24 3.33079
R2913 VSS.n511 VSS.n24 3.33079
R2914 VSS.t1446 VSS.n510 0.0863258
R2915 VSS.t1222 VSS.n568 0.118193
R2916 VSS.t1223 VSS.n184 0.118193
R2917 VSS.n571 VSS.t224 3.30688
R2918 VSS.t1235 VSS.n572 0.118323
R2919 VSS.n238 VSS.t224 3.30696
R2920 VSS.n302 VSS.t224 2.72098
R2921 VSS.t1240 VSS.n302 0.175395
R2922 VSS.t1241 VSS.t224 5.61485
R2923 VSS.n262 VSS.t224 2.29759
R2924 VSS.t1254 VSS.n222 0.118193
R2925 VSS.n574 VSS.t224 3.30688
R2926 VSS.t1261 VSS.n575 0.118323
R2927 VSS.t1264 VSS.n576 0.118323
R2928 VSS.n577 VSS.t224 3.30688
R2929 VSS.n241 VSS.t224 3.30688
R2930 VSS.t1277 VSS.n264 0.118323
R2931 VSS.n288 VSS.t224 3.30696
R2932 VSS.n221 VSS.t224 3.30696
R2933 VSS.t1292 VSS.n192 0.232176
R2934 VSS.t1295 VSS.n185 0.232176
R2935 VSS.t1298 VSS.n232 0.232176
R2936 VSS.n117 VSS.t224 2.72098
R2937 VSS.t1301 VSS.n117 0.175395
R2938 VSS.t1307 VSS.n265 0.118323
R2939 VSS.t224 VSS.n287 3.30688
R2940 VSS.t224 VSS.n301 2.7209
R2941 VSS.t1315 VSS.n301 0.175554
R2942 VSS.n191 VSS.t1316 0.118193
R2943 VSS.n583 VSS.t1319 0.118323
R2944 VSS.n584 VSS.t1322 0.118323
R2945 VSS.n271 VSS.t1324 0.118323
R2946 VSS.t1210 VSS.t224 5.61485
R2947 VSS.t224 VSS.t1203 5.61485
R2948 VSS.t224 VSS.t1197 5.61485
R2949 VSS.t1195 VSS.n223 0.118193
R2950 VSS.t1193 VSS.n224 0.118193
R2951 VSS.n225 VSS.t224 3.30696
R2952 VSS.t1187 VSS.t224 5.61485
R2953 VSS.n226 VSS.t224 3.30696
R2954 VSS.n227 VSS.t224 3.30696
R2955 VSS.t1179 VSS.t224 5.61485
R2956 VSS.n228 VSS.t224 3.30696
R2957 VSS.n229 VSS.t224 3.30696
R2958 VSS.t1171 VSS.t224 5.61485
R2959 VSS.n230 VSS.t224 3.30696
R2960 VSS.n231 VSS.t224 3.30696
R2961 VSS.n25 VSS.n612 3.33079
R2962 VSS.n25 VSS.n649 3.33079
R2963 VSS.n648 VSS.n25 3.33079
R2964 VSS.n25 VSS.n647 3.33079
R2965 VSS.n646 VSS.n25 3.33079
R2966 VSS.n25 VSS.n645 3.33079
R2967 VSS.n644 VSS.n25 3.33079
R2968 VSS.n25 VSS.n643 3.33079
R2969 VSS.n25 VSS.n641 3.33079
R2970 VSS.n640 VSS.n25 3.33079
R2971 VSS.n25 VSS.n639 3.33079
R2972 VSS.n638 VSS.n25 3.33079
R2973 VSS.n25 VSS.n637 3.33079
R2974 VSS.n636 VSS.n25 3.33079
R2975 VSS.n25 VSS.n635 3.33079
R2976 VSS.n634 VSS.n25 3.33079
R2977 VSS.n25 VSS.n633 3.33079
R2978 VSS.n632 VSS.n25 3.33079
R2979 VSS.n25 VSS.n631 3.33079
R2980 VSS.n630 VSS.n25 3.33079
R2981 VSS.n25 VSS.n629 3.33079
R2982 VSS.n628 VSS.n25 3.33079
R2983 VSS.n25 VSS.n626 3.33079
R2984 VSS.n625 VSS.n25 3.33079
R2985 VSS.n25 VSS.n624 3.33079
R2986 VSS.n623 VSS.n25 3.33079
R2987 VSS.n25 VSS.n622 3.33079
R2988 VSS.n621 VSS.n25 3.33079
R2989 VSS.n25 VSS.n620 3.33079
R2990 VSS.n619 VSS.n25 3.33079
R2991 VSS.n25 VSS.n618 3.33079
R2992 VSS.n617 VSS.n25 3.33079
R2993 VSS.n25 VSS.n616 3.33079
R2994 VSS.n615 VSS.n25 3.33079
R2995 VSS.n25 VSS.n614 3.33079
R2996 VSS.n613 VSS.n25 3.33079
R2997 VSS.n611 VSS.n25 3.33079
R2998 VSS.n25 VSS.n610 3.33079
R2999 VSS.n609 VSS.n25 3.33079
R3000 VSS.n25 VSS.n608 3.33079
R3001 VSS.n607 VSS.n25 3.33079
R3002 VSS.n25 VSS.n606 3.33079
R3003 VSS.n605 VSS.n25 3.33079
R3004 VSS.n25 VSS.n604 3.33079
R3005 VSS.n603 VSS.n25 3.33079
R3006 VSS.n25 VSS.n602 3.33079
R3007 VSS.n601 VSS.n25 3.33079
R3008 VSS.n25 VSS.n600 3.33079
R3009 VSS.n599 VSS.n25 3.33079
R3010 VSS.n25 VSS.n598 3.33079
R3011 VSS.n597 VSS.n25 3.33079
R3012 VSS.n596 VSS.n25 3.33079
R3013 VSS.t772 VSS.n594 0.0863258
R3014 VSS.t694 VSS.n658 0.0863258
R3015 VSS.t689 VSS.n657 0.0863258
R3016 VSS.t591 VSS.n656 0.0863258
R3017 VSS.t586 VSS.n655 0.0863258
R3018 VSS.t577 VSS.n654 0.0863258
R3019 VSS.t572 VSS.n653 0.0863258
R3020 VSS.t567 VSS.n652 0.0863258
R3021 VSS.t562 VSS.n651 0.0863258
R3022 VSS.t557 VSS.n650 0.0863258
R3023 VSS.n666 VSS.t533 0.0861948
R3024 VSS.t54 VSS.n669 3.33079
R3025 VSS.t523 VSS.n668 0.0863258
R3026 VSS.t54 VSS.n673 3.33087
R3027 VSS.t54 VSS.n672 3.33079
R3028 VSS.t54 VSS.n671 3.33348
R3029 VSS.n670 VSS.t54 3.33079
R3030 VSS.t54 VSS.n676 3.33079
R3031 VSS.n678 VSS.t54 3.32992
R3032 VSS.t54 VSS.n677 3.33087
R3033 VSS.n679 VSS.t54 3.33079
R3034 VSS.t2 VSS.n683 3.33079
R3035 VSS.t2 VSS.n682 3.33079
R3036 VSS.t2 VSS.n681 3.33087
R3037 VSS.n189 VSS.t2 2.29755
R3038 VSS.t42 VSS.n210 0.739498
R3039 VSS.t2 VSS.n270 3.30688
R3040 VSS.n256 VSS.t2 2.7209
R3041 VSS.t421 VSS.n256 0.175554
R3042 VSS.t122 VSS.t2 5.61485
R3043 VSS.t121 VSS.t2 5.61485
R3044 VSS.n243 VSS.t2 2.29759
R3045 VSS.n693 VSS.t417 0.0863258
R3046 VSS.t412 VSS.n692 0.0863258
R3047 VSS.t67 VSS.n733 4.29849
R3048 VSS.t70 VSS.t183 4.28621
R3049 VSS.t224 VSS.t1325 5.6474
R3050 VSS.t53 VSS.t54 4.251
R3051 VSS.t2 VSS.t163 4.2505
R3052 VSS.t488 VSS.n686 0.103376
R3053 VSS.n788 VSS.t73 4.20455
R3054 VSS.t54 VSS.n218 2.33245
R3055 VSS.t2 VSS.t481 3.33079
R3056 VSS.t2 VSS.n99 0.758327
R3057 VSS.t2 VSS.n207 1.74963
R3058 VSS.n684 VSS.t2 2.31516
R3059 VSS.n705 VSS.t73 1.99111
R3060 VSS.t350 VSS.n695 0.490798
R3061 VSS.n953 VSS.t73 2.59384
R3062 VSS.n951 VSS.t73 2.59384
R3063 VSS.n176 VSS.t73 2.18341
R3064 VSS.n813 VSS.t73 2.59384
R3065 VSS.n811 VSS.t73 2.59384
R3066 VSS.t73 VSS.n793 2.59384
R3067 VSS.t73 VSS.n806 2.59384
R3068 VSS.t73 VSS.n805 2.59384
R3069 VSS.t73 VSS.n795 2.59384
R3070 VSS.t73 VSS.n796 2.59384
R3071 VSS.n799 VSS.t73 2.59384
R3072 VSS.n326 VSS.t73 0.405951
R3073 VSS.n175 VSS.t3207 15.3713
R3074 VSS.t73 VSS.n791 2.59384
R3075 VSS.t73 VSS.n790 2.59384
R3076 VSS.t2 VSS.n724 2.2978
R3077 VSS.n858 VSS.t54 2.29759
R3078 VSS.t54 VSS.n93 0.589392
R3079 VSS.t73 VSS.n789 1.72288
R3080 VSS.n213 VSS.t54 1.01983
R3081 VSS.t2 VSS.t158 1.51792
R3082 VSS.t39 VSS.t65 1.37665
R3083 VSS.t98 VSS.t12 1.27154
R3084 VSS.n685 VSS.t3249 0.0731213
R3085 VSS.t54 VSS.t625 1.2046
R3086 VSS.n100 VSS.t446 0.438708
R3087 VSS.t1 VSS.t92 1.11946
R3088 VSS.t3240 VSS.t303 1.11715
R3089 VSS.n697 VSS.t104 0.944599
R3090 VSS.n386 VSS.t79 1.14365
R3091 VSS.n99 VSS.t450 0.0825838
R3092 VSS.t193 VSS.t398 1.08583
R3093 VSS.t2 VSS.n694 0.88984
R3094 VSS.t609 VSS.t614 1.07852
R3095 VSS.t632 VSS.n92 0.210357
R3096 VSS.t77 VSS.n731 1.07836
R3097 VSS.n814 VSS.t63 1.07483
R3098 VSS.t106 VSS.t4 1.07248
R3099 VSS.t116 VSS.n680 0.895801
R3100 VSS.t426 VSS.n688 0.0539506
R3101 VSS.n814 VSS.t216 1.05272
R3102 VSS.n731 VSS.t37 1.04595
R3103 VSS.n817 VSS.t434 1.03988
R3104 VSS.t387 VSS.n122 0.123618
R3105 VSS.t106 VSS.t37 1.02562
R3106 VSS.t426 VSS.t430 1.02171
R3107 VSS.t442 VSS.n100 0.193871
R3108 VSS.t442 VSS.t441 1.01679
R3109 VSS.t629 VSS.t632 1.01616
R3110 VSS.t620 VSS.t618 1.01575
R3111 VSS.t641 VSS.n93 0.134759
R3112 VSS.t618 VSS.t614 1.01531
R3113 VSS.n92 VSS.t636 0.422214
R3114 VSS.t387 VSS.t109 1.01399
R3115 VSS.t18 VSS.t21 1.0102
R3116 VSS.t18 VSS.t14 1.00129
R3117 VSS.t288 VSS.n210 0.117009
R3118 VSS.t288 VSS.t121 0.983807
R3119 VSS.n675 VSS.t54 0.808249
R3120 VSS.t187 VSS.n784 0.966635
R3121 VSS.n122 VSS.t382 0.439889
R3122 VSS.t185 VSS.n659 0.0542522
R3123 VSS.t555 VSS.t185 0.927759
R3124 VSS.t430 VSS.n817 0.91777
R3125 VSS.t253 VSS.n209 0.836992
R3126 VSS.n816 VSS.t438 0.903993
R3127 VSS.n210 VSS.t2 0.662952
R3128 VSS.n784 VSS.t201 0.867707
R3129 VSS.t549 VSS.n665 0.701242
R3130 VSS.n816 VSS.t434 0.835048
R3131 VSS.n815 VSS.t216 0.832955
R3132 VSS.t552 VSS.t69 0.832211
R3133 VSS.n665 VSS.t69 0.0686903
R3134 VSS.t73 VSS.n34 0.816197
R3135 VSS.t201 VSS.n675 0.890194
R3136 VSS.t7 VSS.t8 0.787488
R3137 VSS.t620 VSS.t625 0.730534
R3138 VSS.n209 VSS.t73 0.514708
R3139 VSS.t61 VSS.n694 0.806022
R3140 VSS.n815 VSS.t284 0.681336
R3141 VSS.t14 VSS.t3249 0.673066
R3142 VSS.n932 VSS.t54 0.666899
R3143 VSS.t54 VSS.n56 0.666899
R3144 VSS.t54 VSS.n73 0.666899
R3145 VSS.t2 VSS.n21 0.666899
R3146 VSS.t2 VSS.n22 0.666899
R3147 VSS.t2 VSS.n4 0.666899
R3148 VSS.t2 VSS.n1 0.666899
R3149 VSS.t2 VSS.n2 0.666899
R3150 VSS.t2 VSS.n17 0.666899
R3151 VSS.t2 VSS.n10 0.666899
R3152 VSS.t2 VSS.n7 0.666899
R3153 VSS.t2 VSS.n6 0.666899
R3154 VSS.n956 VSS.n709 0.66578
R3155 VSS.n889 VSS.n709 0.66578
R3156 VSS.n889 VSS.n888 0.66578
R3157 VSS.n888 VSS.n886 0.66578
R3158 VSS.n886 VSS.n885 0.66578
R3159 VSS.n885 VSS.n884 0.66578
R3160 VSS.n884 VSS.n711 0.66578
R3161 VSS.n949 VSS.n711 0.66578
R3162 VSS.n880 VSS.n874 0.66578
R3163 VSS.n893 VSS.n874 0.66578
R3164 VSS.n894 VSS.n893 0.66578
R3165 VSS.n894 VSS.n786 0.66578
R3166 VSS.n901 VSS.n786 0.66578
R3167 VSS.n902 VSS.n901 0.66578
R3168 VSS.n902 VSS.n785 0.66578
R3169 VSS.n891 VSS.n881 0.66578
R3170 VSS.n892 VSS.n891 0.66578
R3171 VSS.n892 VSS.n870 0.66578
R3172 VSS.n899 VSS.n870 0.66578
R3173 VSS.n900 VSS.n899 0.66578
R3174 VSS.n900 VSS.n869 0.66578
R3175 VSS.n869 VSS.n857 0.66578
R3176 VSS.n954 VSS.n710 0.66578
R3177 VSS.n873 VSS.n710 0.66578
R3178 VSS.n897 VSS.n873 0.66578
R3179 VSS.n898 VSS.n897 0.66578
R3180 VSS.n898 VSS.n763 0.66578
R3181 VSS.n933 VSS.n763 0.66578
R3182 VSS.n934 VSS.n933 0.66578
R3183 VSS.n784 VSS.t54 0.664177
R3184 VSS.t2 VSS.n817 0.663193
R3185 VSS.t2 VSS.n3 0.655024
R3186 VSS.t54 VSS.n89 0.649813
R3187 VSS.t54 VSS.n91 0.649813
R3188 VSS.t54 VSS.n90 0.649813
R3189 VSS.t54 VSS.n77 0.649813
R3190 VSS.t54 VSS.n78 0.649813
R3191 VSS.t54 VSS.n79 0.649813
R3192 VSS.n98 VSS.t661 243.139
R3193 VSS.t54 VSS.n82 0.649813
R3194 VSS.t54 VSS.n80 0.649813
R3195 VSS.t54 VSS.n81 0.649813
R3196 VSS.t54 VSS.n88 0.649813
R3197 VSS.t54 VSS.n87 0.649813
R3198 VSS.t54 VSS.n86 0.649813
R3199 VSS.t54 VSS.n85 0.649813
R3200 VSS.t54 VSS.n83 0.649813
R3201 VSS.t54 VSS.n84 0.649813
R3202 VSS.t54 VSS.n76 0.649813
R3203 VSS.n924 VSS.t54 0.649813
R3204 VSS.n907 VSS.t54 0.649813
R3205 VSS.n908 VSS.t54 0.649813
R3206 VSS.n909 VSS.t54 0.649813
R3207 VSS.t54 VSS.n75 0.649813
R3208 VSS.t54 VSS.n74 0.649813
R3209 VSS.n921 VSS.t54 0.649813
R3210 VSS.t54 VSS.n57 0.649813
R3211 VSS.t54 VSS.n71 0.649813
R3212 VSS.t54 VSS.n58 0.649813
R3213 VSS.t54 VSS.n70 0.649813
R3214 VSS.t54 VSS.n59 0.649813
R3215 VSS.t54 VSS.n69 0.649813
R3216 VSS.t54 VSS.n60 0.649813
R3217 VSS.t54 VSS.n68 0.649813
R3218 VSS.t54 VSS.n61 0.649813
R3219 VSS.t54 VSS.n67 0.649813
R3220 VSS.t54 VSS.n62 0.649813
R3221 VSS.t54 VSS.n66 0.649813
R3222 VSS.t54 VSS.n63 0.649813
R3223 VSS.t54 VSS.n65 0.649813
R3224 VSS.t54 VSS.n64 0.649813
R3225 VSS.t54 VSS.n72 0.649813
R3226 VSS.t2 VSS.n19 0.649813
R3227 VSS.t2 VSS.n18 0.649813
R3228 VSS.t2 VSS.n20 0.649813
R3229 VSS.t2 VSS.n5 0.648101
R3230 VSS.t2 VSS.n0 0.648101
R3231 VSS.t2 VSS.n16 0.648101
R3232 VSS.t2 VSS.n15 0.648101
R3233 VSS.t2 VSS.n11 0.648101
R3234 VSS.t2 VSS.n12 0.648101
R3235 VSS.t2 VSS.n13 0.648101
R3236 VSS.t2 VSS.n14 0.648101
R3237 VSS.n947 VSS.t2 0.648101
R3238 VSS.t2 VSS.n9 0.648101
R3239 VSS.t2 VSS.n8 0.648101
R3240 VSS.t158 VSS.t463 0.632695
R3241 VSS.n815 VSS.t73 0.631148
R3242 VSS.t395 VSS.n34 0.627512
R3243 VSS.t755 VSS.t625 0.62033
R3244 VSS.t158 VSS.t44 0.615116
R3245 VSS.t86 VSS.n685 0.50331
R3246 VSS.n816 VSS.t2 0.604857
R3247 VSS.n858 VSS.t3196 0.592147
R3248 VSS.n659 VSS.t54 0.489162
R3249 VSS.t268 VSS.n789 0.561482
R3250 VSS.t48 VSS.n213 0.503296
R3251 VSS.t2 VSS.t18 0.506127
R3252 VSS.t2 VSS.n100 0.21748
R3253 VSS.t2 VSS.n688 0.427278
R3254 VSS.t54 VSS.n92 0.198083
R3255 VSS.n680 VSS.t609 0.0540951
R3256 VSS.n814 VSS.t73 0.462505
R3257 VSS.t2 VSS.t106 0.462054
R3258 VSS.t126 VSS.n858 0.455439
R3259 VSS.n724 VSS.t153 0.455159
R3260 VSS.n34 VSS.t398 0.453486
R3261 VSS.n386 VSS.t73 0.371012
R3262 VSS.t66 VSS.n189 0.231606
R3263 VSS.t302 VSS.n166 47.2101
R3264 VSS.n952 VSS.t73 0.405951
R3265 VSS.n950 VSS.t73 0.405951
R3266 VSS.n115 VSS.t73 0.121827
R3267 VSS.n810 VSS.t73 0.405951
R3268 VSS.t322 VSS.n120 47.2102
R3269 VSS.t341 VSS.n111 26.1051
R3270 VSS.t351 VSS.n104 47.2102
R3271 VSS.n50 VSS.t358 47.2102
R3272 VSS.t73 VSS.n39 0.405951
R3273 VSS.t73 VSS.n40 0.405951
R3274 VSS.t73 VSS.n45 0.405951
R3275 VSS.t73 VSS.n41 0.405951
R3276 VSS.t73 VSS.n44 0.405951
R3277 VSS.t73 VSS.n42 0.405951
R3278 VSS.t73 VSS.n43 0.405951
R3279 VSS.n800 VSS.t73 0.405951
R3280 VSS.n798 VSS.t73 0.405951
R3281 VSS.n108 VSS.t73 0.219019
R3282 VSS.t73 VSS.n28 0.121878
R3283 VSS.t73 VSS.n29 0.405951
R3284 VSS.t73 VSS.n38 0.405951
R3285 VSS.t73 VSS.n37 0.405951
R3286 VSS.t73 VSS.n30 0.219018
R3287 VSS.t73 VSS.n36 0.121828
R3288 VSS.n52 VSS.t384 26.1053
R3289 VSS.t73 VSS.n31 0.12182
R3290 VSS.t73 VSS.n35 0.405951
R3291 VSS.n54 VSS.t392 47.2102
R3292 VSS.t73 VSS.n33 0.12186
R3293 VSS.t73 VSS.n32 0.405951
R3294 VSS.n152 VSS.t407 47.2101
R3295 VSS.t63 VSS.n697 1.10057
R3296 VSS.n705 VSS.t3240 0.439548
R3297 VSS.t275 VSS.n695 0.292902
R3298 VSS.t2 VSS.n731 0.396392
R3299 VSS.t4 VSS.n724 0.387477
R3300 VSS.t2623 VSS.t2624 0.36115
R3301 VSS.t2676 VSS.t2675 0.36115
R3302 VSS.n276 VSS.t2681 0.175714
R3303 VSS.t2688 VSS.t2687 0.36115
R3304 VSS.t2694 VSS.t2693 0.36115
R3305 VSS.t2700 VSS.t2699 0.36115
R3306 VSS.t2760 VSS.t2759 0.36115
R3307 VSS.t1241 VSS.t1240 0.36115
R3308 VSS.t1223 VSS.t1222 0.36115
R3309 VSS.t2635 VSS.t2636 0.36115
R3310 VSS.t2663 VSS.t2664 0.36115
R3311 VSS.t2669 VSS.t2670 0.36115
R3312 VSS.t2709 VSS.t2707 0.36115
R3313 VSS.n249 VSS.t2713 0.175714
R3314 VSS.n280 VSS.t2719 0.175714
R3315 VSS.n281 VSS.t2725 0.175714
R3316 VSS.t2733 VSS.t2731 0.36115
R3317 VSS.t2739 VSS.t2737 0.36115
R3318 VSS.t2745 VSS.t2743 0.36115
R3319 VSS.t2778 VSS.t2779 0.36115
R3320 VSS.t2770 VSS.t2771 0.36115
R3321 VSS.t1315 VSS.t1316 0.36115
R3322 VSS.t257 VSS.t42 0.360811
R3323 VSS.t2646 VSS.t2647 0.360811
R3324 VSS.t2652 VSS.t2653 0.360811
R3325 VSS.t2658 VSS.n252 0.175554
R3326 VSS.t2664 VSS.n274 0.175554
R3327 VSS.t2670 VSS.n275 0.175554
R3328 VSS.t2656 VSS.t2655 0.360811
R3329 VSS.t2650 VSS.t2649 0.360811
R3330 VSS.t2644 VSS.t2643 0.360811
R3331 VSS.t2634 VSS.n193 0.175554
R3332 VSS.t2628 VSS.t2627 0.360811
R3333 VSS.t2678 VSS.t2676 0.360811
R3334 VSS.t2684 VSS.t2682 0.360811
R3335 VSS.t2692 VSS.t2691 0.360811
R3336 VSS.t2698 VSS.t2697 0.360811
R3337 VSS.n250 VSS.t2703 0.175554
R3338 VSS.n279 VSS.t2709 0.175554
R3339 VSS.t2716 VSS.t2715 0.360811
R3340 VSS.t2722 VSS.t2721 0.360811
R3341 VSS.t2725 VSS.t2724 0.360811
R3342 VSS.t2728 VSS.t2727 0.360811
R3343 VSS.n248 VSS.t2730 0.175554
R3344 VSS.n282 VSS.t2736 0.175554
R3345 VSS.n283 VSS.t2742 0.175554
R3346 VSS.t2749 VSS.t2748 0.360811
R3347 VSS.t2753 VSS.t2751 0.360811
R3348 VSS.t2755 VSS.t2754 0.360811
R3349 VSS.t1236 VSS.t1235 0.360811
R3350 VSS.t1300 VSS.t1298 0.360811
R3351 VSS.n301 VSS.t1314 0.175554
R3352 VSS.t421 VSS.t122 0.360811
R3353 VSS.t423 VSS.n256 0.175554
R3354 VSS.t49 VSS.t199 0.360811
R3355 VSS.t2665 VSS.t2667 0.360471
R3356 VSS.t2659 VSS.t2661 0.360471
R3357 VSS.t2653 VSS.n273 0.175395
R3358 VSS.t2647 VSS.n272 0.175395
R3359 VSS.t2642 VSS.n246 0.175395
R3360 VSS.n194 VSS.t2627 0.175395
R3361 VSS.t2622 VSS.t2623 0.360471
R3362 VSS.t2681 VSS.t2680 0.360471
R3363 VSS.n251 VSS.t2686 0.175395
R3364 VSS.n277 VSS.t2692 0.175395
R3365 VSS.n278 VSS.t2698 0.175395
R3366 VSS.t2705 VSS.t2704 0.360471
R3367 VSS.t2711 VSS.t2710 0.360471
R3368 VSS.t2735 VSS.t2736 0.360471
R3369 VSS.t2741 VSS.t2742 0.360471
R3370 VSS.t2747 VSS.n247 0.175395
R3371 VSS.n286 VSS.t2754 0.175395
R3372 VSS.n302 VSS.t1239 0.175395
R3373 VSS.n117 VSS.t1300 0.175395
R3374 VSS.t2671 VSS.t2673 0.360471
R3375 VSS.t455 VSS.n99 0.249036
R3376 VSS.t83 VSS.t81 0.344868
R3377 VSS.n207 VSS.t135 0.328647
R3378 VSS.n674 VSS.t236 0.437347
R3379 VSS.n660 VSS.t537 0.433869
R3380 VSS.n661 VSS.t540 0.433869
R3381 VSS.n662 VSS.t543 0.433869
R3382 VSS.n663 VSS.t546 0.433869
R3383 VSS.n789 VSS.t98 0.33986
R3384 VSS.t718 VSS.n674 0.238295
R3385 VSS.n204 VSS.t710 0.328647
R3386 VSS.t81 VSS.n684 0.0932196
R3387 VSS.t546 VSS.n664 0.235876
R3388 VSS.t535 VSS.n660 0.235729
R3389 VSS.t537 VSS.n661 0.235729
R3390 VSS.t540 VSS.n662 0.235729
R3391 VSS.t543 VSS.n663 0.235729
R3392 VSS.t549 VSS.n664 0.422459
R3393 VSS.n686 VSS.t40 0.207204
R3394 VSS.t483 VSS.t481 0.31236
R3395 VSS.t581 VSS.n218 0.216505
R3396 VSS.t1324 VSS.t1325 0.311525
R3397 VSS.t303 VSS.t73 0.309604
R3398 VSS.n333 VSS.t2917 0.0850573
R3399 VSS.t2637 VSS.t2638 0.301114
R3400 VSS.t2797 VSS.t2640 0.301114
R3401 VSS.t2656 VSS.n322 0.118323
R3402 VSS.t2650 VSS.n323 0.118323
R3403 VSS.t2644 VSS.n292 0.118323
R3404 VSS.n289 VSS.t2629 0.17801
R3405 VSS.n241 VSS.t1273 0.118323
R3406 VSS.t1166 VSS.n269 0.420219
R3407 VSS.t1176 VSS.t1177 0.301114
R3408 VSS.t1184 VSS.t1185 0.301114
R3409 VSS.t1192 VSS.t1193 0.301114
R3410 VSS.t1203 VSS.t1204 0.301114
R3411 VSS.n317 VSS.t2711 0.118323
R3412 VSS.n296 VSS.t2705 0.118323
R3413 VSS.n312 VSS.t2773 0.118323
R3414 VSS.n390 VSS.t2765 0.118323
R3415 VSS.t1244 VSS.n202 0.232176
R3416 VSS.t1247 VSS.n262 0.232176
R3417 VSS.t1289 VSS.n304 0.232176
R3418 VSS.n192 VSS.t1291 0.2914
R3419 VSS.n185 VSS.t1294 0.2914
R3420 VSS.n232 VSS.t1297 0.2914
R3421 VSS.t1442 VSS.n271 0.17801
R3422 VSS.n876 VSS.t2762 0.301114
R3423 VSS.t1232 VSS.n571 0.118323
R3424 VSS.n572 VSS.t1234 0.17801
R3425 VSS.t1268 VSS.n577 0.118323
R3426 VSS.t2629 VSS.t2630 0.301114
R3427 VSS.t2645 VSS.t2646 0.301114
R3428 VSS.t2651 VSS.t2652 0.301114
R3429 VSS.t2657 VSS.t2658 0.301114
R3430 VSS.n321 VSS.t2667 0.118323
R3431 VSS.n293 VSS.t2661 0.118323
R3432 VSS.t2641 VSS.t2642 0.301114
R3433 VSS.t2625 VSS.t2626 0.301114
R3434 VSS.t1169 VSS.t1168 0.301114
R3435 VSS.t1171 VSS.t1170 0.301114
R3436 VSS.t1174 VSS.t1175 0.301114
R3437 VSS.t1182 VSS.t1183 0.301114
R3438 VSS.t1190 VSS.t1191 0.301114
R3439 VSS.t1209 VSS.t1210 0.301114
R3440 VSS.t1197 VSS.t1198 0.301114
R3441 VSS.t1194 VSS.t1195 0.301114
R3442 VSS.t1186 VSS.t1187 0.301114
R3443 VSS.t1178 VSS.t1179 0.301114
R3444 VSS.t2680 VSS.t2679 0.301114
R3445 VSS.t2686 VSS.t2685 0.301114
R3446 VSS.t2703 VSS.t2702 0.301114
R3447 VSS.t2697 VSS.t2696 0.301114
R3448 VSS.t2691 VSS.t2690 0.301114
R3449 VSS.t2735 VSS.t2734 0.301114
R3450 VSS.t2741 VSS.t2740 0.301114
R3451 VSS.t2747 VSS.t2746 0.301114
R3452 VSS.n258 VSS.t2749 0.28702
R3453 VSS.n305 VSS.t2755 0.231785
R3454 VSS.t1239 VSS.t1238 0.301114
R3455 VSS.t1254 VSS.t1253 0.301114
R3456 VSS.t1258 VSS.n574 0.118323
R3457 VSS.n575 VSS.t1260 0.17801
R3458 VSS.n576 VSS.t1263 0.17801
R3459 VSS.t1278 VSS.n264 0.17801
R3460 VSS.t1281 VSS.t1280 0.301114
R3461 VSS.t1284 VSS.t1283 0.301114
R3462 VSS.t1302 VSS.t1301 0.301114
R3463 VSS.t1321 VSS.n584 0.17801
R3464 VSS.t1318 VSS.n583 0.17801
R3465 VSS.t1311 VSS.n287 0.118323
R3466 VSS.n265 VSS.t1308 0.17801
R3467 VSS.t118 VSS.t66 0.301114
R3468 VSS.t257 VSS.n270 0.118323
R3469 VSS.n243 VSS.t49 0.232176
R3470 VSS.n290 VSS.t2637 0.177814
R3471 VSS.t2668 VSS.t2669 0.300775
R3472 VSS.t2624 VSS.n325 0.118193
R3473 VSS.t2632 VSS.n324 0.118193
R3474 VSS.t2638 VSS.t2639 0.300775
R3475 VSS.t2640 VSS.n291 0.118193
R3476 VSS.t2662 VSS.t2663 0.300775
R3477 VSS.t2633 VSS.t2634 0.300775
R3478 VSS.n568 VSS.t1220 0.177814
R3479 VSS.n231 VSS.t1166 0.118193
R3480 VSS.n230 VSS.t1169 0.118193
R3481 VSS.t1172 VSS.t1171 0.300775
R3482 VSS.t1175 VSS.n229 0.118193
R3483 VSS.t1183 VSS.n227 0.118193
R3484 VSS.t1191 VSS.n225 0.118193
R3485 VSS.t1177 VSS.n228 0.118193
R3486 VSS.t1179 VSS.t1180 0.300775
R3487 VSS.t1185 VSS.n226 0.118193
R3488 VSS.t1187 VSS.t1188 0.300775
R3489 VSS.n224 VSS.t1194 0.177814
R3490 VSS.n223 VSS.t1196 0.177814
R3491 VSS.t1210 VSS.t1211 0.300775
R3492 VSS.t1202 VSS.t1203 0.300775
R3493 VSS.t1196 VSS.t1197 0.300775
R3494 VSS.n284 VSS.t2674 0.177814
R3495 VSS.n294 VSS.t2678 0.118193
R3496 VSS.n320 VSS.t2684 0.118193
R3497 VSS.n295 VSS.t2688 0.118193
R3498 VSS.n319 VSS.t2694 0.118193
R3499 VSS.n318 VSS.t2700 0.118193
R3500 VSS.t2707 VSS.t2706 0.300775
R3501 VSS.t2713 VSS.t2712 0.300775
R3502 VSS.n297 VSS.t2716 0.118193
R3503 VSS.n316 VSS.t2722 0.118193
R3504 VSS.t2723 VSS.t2724 0.300775
R3505 VSS.n315 VSS.t2728 0.118193
R3506 VSS.t2729 VSS.t2730 0.300775
R3507 VSS.n298 VSS.t2733 0.118193
R3508 VSS.n314 VSS.t2739 0.118193
R3509 VSS.n313 VSS.t2745 0.118193
R3510 VSS.t2759 VSS.n195 0.118193
R3511 VSS.t2762 VSS.n299 0.177814
R3512 VSS.t2779 VSS.t2898 0.300775
R3513 VSS.n392 VSS.t2777 0.177814
R3514 VSS.t2773 VSS.t2774 0.300775
R3515 VSS.t2771 VSS.t2890 0.300775
R3516 VSS.n391 VSS.t2769 0.177814
R3517 VSS.t2765 VSS.t2766 0.300775
R3518 VSS.t1224 VSS.n184 0.177814
R3519 VSS.t1233 VSS.t1232 0.300775
R3520 VSS.n238 VSS.t1236 0.118193
R3521 VSS.t1243 VSS.t1241 0.300775
R3522 VSS.t1246 VSS.t1244 0.300775
R3523 VSS.t1249 VSS.t1247 0.300775
R3524 VSS.t1255 VSS.n222 0.177814
R3525 VSS.t1259 VSS.t1258 0.300775
R3526 VSS.t1262 VSS.t1261 0.300775
R3527 VSS.t1265 VSS.t1264 0.300775
R3528 VSS.t1269 VSS.t1268 0.300775
R3529 VSS.t1273 VSS.t1272 0.300775
R3530 VSS.t1277 VSS.t1276 0.300775
R3531 VSS.n288 VSS.t1281 0.118193
R3532 VSS.n221 VSS.t1284 0.118193
R3533 VSS.t1291 VSS.t1289 0.300775
R3534 VSS.t1294 VSS.t1292 0.300775
R3535 VSS.t1297 VSS.t1295 0.300775
R3536 VSS.t1322 VSS.t1442 0.300775
R3537 VSS.t1319 VSS.t1439 0.300775
R3538 VSS.n191 VSS.t1436 0.177814
R3539 VSS.t1313 VSS.t1314 0.300775
R3540 VSS.t1310 VSS.t1311 0.300775
R3541 VSS.t1307 VSS.t1306 0.300775
R3542 VSS.t9 VSS.t121 0.300775
R3543 VSS.n329 VSS.t2621 0.160265
R3544 VSS.t73 VSS.t12 0.24961
R3545 VSS.n189 VSS.t21 0.418191
R3546 VSS.t1250 VSS.n233 0.235599
R3547 VSS.t1226 VSS.n245 0.235599
R3548 VSS.t1220 VSS.n567 0.360183
R3549 VSS.t1333 VSS.n261 0.119605
R3550 VSS.t1340 VSS.n260 0.119605
R3551 VSS.t1347 VSS.n259 0.119605
R3552 VSS.t1356 VSS.t1201 0.241078
R3553 VSS.n585 VSS.t1213 0.119605
R3554 VSS.t2757 VSS.n305 0.291785
R3555 VSS.t2885 VSS.t2767 0.241078
R3556 VSS.t2893 VSS.t2775 0.241078
R3557 VSS.n253 VSS.t2781 0.119605
R3558 VSS.t1436 VSS.t1318 0.241078
R3559 VSS.t1439 VSS.t1321 0.241078
R3560 VSS.t199 VSS.n183 0.340085
R3561 VSS.t202 VSS.n687 0.119605
R3562 VSS.n394 VSS.t2797 0.119605
R3563 VSS.n303 VSS.t1270 0.235599
R3564 VSS.n269 VSS.t1165 0.119605
R3565 VSS.n591 VSS.t1163 0.119605
R3566 VSS.t1165 VSS.t1164 0.241078
R3567 VSS.t1332 VSS.n590 0.119605
R3568 VSS.n587 VSS.t1202 0.119605
R3569 VSS.n239 VSS.t1205 0.119605
R3570 VSS.t1213 VSS.t1214 0.241078
R3571 VSS.t1212 VSS.t1365 0.241078
R3572 VSS.n266 VSS.t1212 0.119605
R3573 VSS.n586 VSS.t1209 0.119605
R3574 VSS.t1207 VSS.t1208 0.241078
R3575 VSS.t1205 VSS.t1206 0.241078
R3576 VSS.n267 VSS.t1207 0.119605
R3577 VSS.n268 VSS.t1356 0.119605
R3578 VSS.t1199 VSS.t1200 0.241078
R3579 VSS.n240 VSS.t1199 0.119605
R3580 VSS.t1189 VSS.t1347 0.241078
R3581 VSS.n588 VSS.t1189 0.119605
R3582 VSS.t1181 VSS.t1340 0.241078
R3583 VSS.n589 VSS.t1181 0.119605
R3584 VSS.t2718 VSS.t2717 0.241078
R3585 VSS.t2758 VSS.t2757 0.241078
R3586 VSS.t2767 VSS.n255 0.119605
R3587 VSS.t2775 VSS.n254 0.119605
R3588 VSS.t2781 VSS.t2782 0.241078
R3589 VSS.t2776 VSS.t2777 0.241078
R3590 VSS.t2774 VSS.n188 0.119605
R3591 VSS.t2768 VSS.t2769 0.241078
R3592 VSS.t2766 VSS.n187 0.119605
R3593 VSS.t2764 VSS.t2882 0.241078
R3594 VSS.t1216 VSS.n566 0.119605
R3595 VSS.t1217 VSS.t1216 0.241078
R3596 VSS.t1218 VSS.n263 0.119605
R3597 VSS.t1219 VSS.t1218 0.241078
R3598 VSS.t1225 VSS.t1224 0.241078
R3599 VSS.t1227 VSS.t1226 0.241078
R3600 VSS.t1228 VSS.n569 0.119605
R3601 VSS.t1229 VSS.t1228 0.241078
R3602 VSS.t1230 VSS.n570 0.119605
R3603 VSS.t1231 VSS.t1230 0.241078
R3604 VSS.t1234 VSS.t1233 0.241078
R3605 VSS.t1238 VSS.t1237 0.241078
R3606 VSS.t1251 VSS.t1250 0.241078
R3607 VSS.t1252 VSS.n573 0.119605
R3608 VSS.t1253 VSS.t1252 0.241078
R3609 VSS.t1256 VSS.t1255 0.241078
R3610 VSS.t1257 VSS.t1256 0.241078
R3611 VSS.t1263 VSS.t1262 0.241078
R3612 VSS.t1266 VSS.n198 0.119605
R3613 VSS.t1267 VSS.t1266 0.241078
R3614 VSS.t1270 VSS.t1269 0.241078
R3615 VSS.t1272 VSS.t1271 0.241078
R3616 VSS.t1275 VSS.t1274 0.241078
R3617 VSS.t1276 VSS.n578 0.119605
R3618 VSS.t1279 VSS.t1278 0.241078
R3619 VSS.t1280 VSS.n579 0.119605
R3620 VSS.t1283 VSS.t1282 0.241078
R3621 VSS.t1286 VSS.t1285 0.241078
R3622 VSS.t1287 VSS.n244 0.119605
R3623 VSS.t1288 VSS.t1287 0.241078
R3624 VSS.t1303 VSS.n580 0.119605
R3625 VSS.n871 VSS.t1303 0.241078
R3626 VSS.t1312 VSS.t1313 0.241078
R3627 VSS.n582 VSS.t1310 0.119605
R3628 VSS.t1308 VSS.t1309 0.241078
R3629 VSS.n581 VSS.t1306 0.119605
R3630 VSS.t228 VSS.t202 0.241078
R3631 VSS.t40 VSS.n235 0.360183
R3632 VSS.n687 VSS.t113 0.360183
R3633 VSS.t2719 VSS.n877 0.240486
R3634 VSS.t455 VSS.t456 0.232473
R3635 VSS.t10 VSS.t423 0.230486
R3636 VSS.t733 VSS.t735 0.227075
R3637 VSS.t367 VSS.n387 0.135296
R3638 VSS.t79 VSS.n698 0.135296
R3639 VSS.t354 VSS.n696 0.135296
R3640 VSS.t350 VSS.n704 0.135296
R3641 VSS.t345 VSS.n703 0.135296
R3642 VSS.t340 VSS.n702 0.135296
R3643 VSS.t335 VSS.n701 0.135296
R3644 VSS.t330 VSS.n700 0.135296
R3645 VSS.t325 VSS.n699 0.135296
R3646 VSS.t320 VSS.n708 0.135296
R3647 VSS.t315 VSS.n707 0.135296
R3648 VSS.n389 VSS.t268 0.135296
R3649 VSS.t718 VSS.t716 0.227075
R3650 VSS.t705 VSS.t600 0.227075
R3651 VSS.t469 VSS.t471 0.227075
R3652 VSS.t310 VSS.n706 0.135296
R3653 VSS.t2902 VSS.t2904 0.226736
R3654 VSS.t2909 VSS.t2907 0.226736
R3655 VSS.t2912 VSS.t2914 0.226736
R3656 VSS.t3072 VSS.t3074 0.226736
R3657 VSS.t3079 VSS.t3077 0.226736
R3658 VSS.t3082 VSS.t3084 0.226736
R3659 VSS.t3089 VSS.t3087 0.226736
R3660 VSS.t3092 VSS.t3094 0.226736
R3661 VSS.t3099 VSS.t3097 0.226736
R3662 VSS.t3102 VSS.t3104 0.226736
R3663 VSS.t3109 VSS.t3107 0.226736
R3664 VSS.t3112 VSS.t3114 0.226736
R3665 VSS.t3119 VSS.t3117 0.226736
R3666 VSS.t3122 VSS.t3124 0.226736
R3667 VSS.t3129 VSS.t3127 0.226736
R3668 VSS.t3132 VSS.t3134 0.226736
R3669 VSS.t3139 VSS.t3137 0.226736
R3670 VSS.t3147 VSS.t3149 0.226736
R3671 VSS.t3154 VSS.t3152 0.226736
R3672 VSS.t3157 VSS.t3159 0.226736
R3673 VSS.t3164 VSS.t3162 0.226736
R3674 VSS.t3167 VSS.t3169 0.226736
R3675 VSS.t3174 VSS.t3172 0.226736
R3676 VSS.t3177 VSS.t3179 0.226736
R3677 VSS.t2999 VSS.t2997 0.226736
R3678 VSS.t3004 VSS.t3002 0.226736
R3679 VSS.t3009 VSS.t3007 0.226736
R3680 VSS.t3014 VSS.t3012 0.226736
R3681 VSS.t3019 VSS.t3017 0.226736
R3682 VSS.t3024 VSS.t3022 0.226736
R3683 VSS.t3029 VSS.t3027 0.226736
R3684 VSS.t3034 VSS.t3032 0.226736
R3685 VSS.t3039 VSS.t3037 0.226736
R3686 VSS.t3044 VSS.t3042 0.226736
R3687 VSS.t3049 VSS.t3047 0.226736
R3688 VSS.t3054 VSS.t3052 0.226736
R3689 VSS.t3059 VSS.t3057 0.226736
R3690 VSS.t3064 VSS.t3062 0.226736
R3691 VSS.t2987 VSS.t2989 0.226736
R3692 VSS.t2982 VSS.t2984 0.226736
R3693 VSS.t2977 VSS.t2979 0.226736
R3694 VSS.t2972 VSS.t2974 0.226736
R3695 VSS.t2967 VSS.t2969 0.226736
R3696 VSS.t2962 VSS.t2964 0.226736
R3697 VSS.t2957 VSS.t2959 0.226736
R3698 VSS.t2952 VSS.t2954 0.226736
R3699 VSS.t2947 VSS.t2949 0.226736
R3700 VSS.t2942 VSS.t2944 0.226736
R3701 VSS.t2937 VSS.t2939 0.226736
R3702 VSS.t2932 VSS.t2934 0.226736
R3703 VSS.t2927 VSS.t2929 0.226736
R3704 VSS.t2924 VSS.t2922 0.226736
R3705 VSS.t2232 VSS.t2230 0.226736
R3706 VSS.t2237 VSS.t2235 0.226736
R3707 VSS.t2242 VSS.t2240 0.226736
R3708 VSS.t2247 VSS.t2245 0.226736
R3709 VSS.t2252 VSS.t2250 0.226736
R3710 VSS.t2257 VSS.t2255 0.226736
R3711 VSS.t2262 VSS.t2260 0.226736
R3712 VSS.t2267 VSS.t2265 0.226736
R3713 VSS.t2272 VSS.t2270 0.226736
R3714 VSS.t2277 VSS.t2275 0.226736
R3715 VSS.t2282 VSS.t2280 0.226736
R3716 VSS.t2287 VSS.t2285 0.226736
R3717 VSS.t2292 VSS.t2290 0.226736
R3718 VSS.t2297 VSS.t2295 0.226736
R3719 VSS.t2302 VSS.t2300 0.226736
R3720 VSS.t2307 VSS.t2305 0.226736
R3721 VSS.t2312 VSS.t2310 0.226736
R3722 VSS.t2317 VSS.t2315 0.226736
R3723 VSS.t2327 VSS.t2325 0.226736
R3724 VSS.t2332 VSS.t2330 0.226736
R3725 VSS.t2337 VSS.t2335 0.226736
R3726 VSS.t2342 VSS.t2340 0.226736
R3727 VSS.t2347 VSS.t2345 0.226736
R3728 VSS.t2352 VSS.t2350 0.226736
R3729 VSS.t2357 VSS.t2355 0.226736
R3730 VSS.t2362 VSS.t2360 0.226736
R3731 VSS.t2367 VSS.t2365 0.226736
R3732 VSS.t2372 VSS.t2370 0.226736
R3733 VSS.t2377 VSS.t2375 0.226736
R3734 VSS.t2382 VSS.t2380 0.226736
R3735 VSS.t2387 VSS.t2385 0.226736
R3736 VSS.t2392 VSS.t2390 0.226736
R3737 VSS.t2402 VSS.t2400 0.226736
R3738 VSS.t2407 VSS.t2405 0.226736
R3739 VSS.t2412 VSS.t2410 0.226736
R3740 VSS.t2417 VSS.t2415 0.226736
R3741 VSS.t2422 VSS.t2420 0.226736
R3742 VSS.t2427 VSS.t2425 0.226736
R3743 VSS.t2432 VSS.t2430 0.226736
R3744 VSS.t2437 VSS.t2435 0.226736
R3745 VSS.t2442 VSS.t2440 0.226736
R3746 VSS.t2447 VSS.t2445 0.226736
R3747 VSS.t2452 VSS.t2450 0.226736
R3748 VSS.t2457 VSS.t2455 0.226736
R3749 VSS.t2462 VSS.t2460 0.226736
R3750 VSS.t2467 VSS.t2465 0.226736
R3751 VSS.t2475 VSS.t2477 0.226736
R3752 VSS.t2482 VSS.t2480 0.226736
R3753 VSS.t2485 VSS.t2487 0.226736
R3754 VSS.t2492 VSS.t2490 0.226736
R3755 VSS.t2495 VSS.t2497 0.226736
R3756 VSS.t2502 VSS.t2500 0.226736
R3757 VSS.t2505 VSS.t2507 0.226736
R3758 VSS.t1840 VSS.t1838 0.226736
R3759 VSS.t1845 VSS.t1843 0.226736
R3760 VSS.t1850 VSS.t1848 0.226736
R3761 VSS.t1855 VSS.t1853 0.226736
R3762 VSS.t1860 VSS.t1858 0.226736
R3763 VSS.t1863 VSS.t1865 0.226736
R3764 VSS.t1870 VSS.t1868 0.226736
R3765 VSS.t1873 VSS.t1875 0.226736
R3766 VSS.t1880 VSS.t1878 0.226736
R3767 VSS.t1883 VSS.t1885 0.226736
R3768 VSS.t1890 VSS.t1888 0.226736
R3769 VSS.t1893 VSS.t1895 0.226736
R3770 VSS.t1900 VSS.t1898 0.226736
R3771 VSS.t1903 VSS.t1905 0.226736
R3772 VSS.t1910 VSS.t1908 0.226736
R3773 VSS.t1913 VSS.t1915 0.226736
R3774 VSS.t1920 VSS.t1918 0.226736
R3775 VSS.t1923 VSS.t1925 0.226736
R3776 VSS.t1933 VSS.t1935 0.226736
R3777 VSS.t1940 VSS.t1938 0.226736
R3778 VSS.t1943 VSS.t1945 0.226736
R3779 VSS.t1950 VSS.t1948 0.226736
R3780 VSS.t1953 VSS.t1955 0.226736
R3781 VSS.t1960 VSS.t1958 0.226736
R3782 VSS.t1963 VSS.t1965 0.226736
R3783 VSS.t1970 VSS.t1968 0.226736
R3784 VSS.t1973 VSS.t1975 0.226736
R3785 VSS.t1980 VSS.t1978 0.226736
R3786 VSS.t1983 VSS.t1985 0.226736
R3787 VSS.t1990 VSS.t1988 0.226736
R3788 VSS.t1993 VSS.t1995 0.226736
R3789 VSS.t2000 VSS.t1998 0.226736
R3790 VSS.t2008 VSS.t2010 0.226736
R3791 VSS.t2015 VSS.t2013 0.226736
R3792 VSS.t2018 VSS.t2020 0.226736
R3793 VSS.t2025 VSS.t2023 0.226736
R3794 VSS.t2028 VSS.t2030 0.226736
R3795 VSS.t2035 VSS.t2033 0.226736
R3796 VSS.t2038 VSS.t2040 0.226736
R3797 VSS.t2045 VSS.t2043 0.226736
R3798 VSS.t2048 VSS.t2050 0.226736
R3799 VSS.t2055 VSS.t2053 0.226736
R3800 VSS.t2058 VSS.t2060 0.226736
R3801 VSS.t2065 VSS.t2063 0.226736
R3802 VSS.t2068 VSS.t2070 0.226736
R3803 VSS.t2075 VSS.t2073 0.226736
R3804 VSS.t2085 VSS.t2083 0.226736
R3805 VSS.t2088 VSS.t2090 0.226736
R3806 VSS.t2095 VSS.t2093 0.226736
R3807 VSS.t2098 VSS.t2100 0.226736
R3808 VSS.t2105 VSS.t2103 0.226736
R3809 VSS.t2108 VSS.t2110 0.226736
R3810 VSS.t2115 VSS.t2113 0.226736
R3811 VSS.t1448 VSS.t1446 0.226736
R3812 VSS.t1453 VSS.t1451 0.226736
R3813 VSS.t1458 VSS.t1456 0.226736
R3814 VSS.t1463 VSS.t1461 0.226736
R3815 VSS.t1468 VSS.t1466 0.226736
R3816 VSS.t1471 VSS.t1473 0.226736
R3817 VSS.t1478 VSS.t1476 0.226736
R3818 VSS.t1481 VSS.t1483 0.226736
R3819 VSS.t1488 VSS.t1486 0.226736
R3820 VSS.t1491 VSS.t1493 0.226736
R3821 VSS.t1498 VSS.t1496 0.226736
R3822 VSS.t1501 VSS.t1503 0.226736
R3823 VSS.t1508 VSS.t1506 0.226736
R3824 VSS.t1511 VSS.t1513 0.226736
R3825 VSS.t1518 VSS.t1516 0.226736
R3826 VSS.t1521 VSS.t1523 0.226736
R3827 VSS.t1528 VSS.t1526 0.226736
R3828 VSS.t1531 VSS.t1533 0.226736
R3829 VSS.t1541 VSS.t1543 0.226736
R3830 VSS.t1548 VSS.t1546 0.226736
R3831 VSS.t1551 VSS.t1553 0.226736
R3832 VSS.t1558 VSS.t1556 0.226736
R3833 VSS.t1561 VSS.t1563 0.226736
R3834 VSS.t1568 VSS.t1566 0.226736
R3835 VSS.t1571 VSS.t1573 0.226736
R3836 VSS.t1578 VSS.t1576 0.226736
R3837 VSS.t1581 VSS.t1583 0.226736
R3838 VSS.t1588 VSS.t1586 0.226736
R3839 VSS.t1591 VSS.t1593 0.226736
R3840 VSS.t1598 VSS.t1596 0.226736
R3841 VSS.t1601 VSS.t1603 0.226736
R3842 VSS.t1608 VSS.t1606 0.226736
R3843 VSS.t1618 VSS.t1616 0.226736
R3844 VSS.t1621 VSS.t1623 0.226736
R3845 VSS.t1628 VSS.t1626 0.226736
R3846 VSS.t1631 VSS.t1633 0.226736
R3847 VSS.t1638 VSS.t1636 0.226736
R3848 VSS.t1641 VSS.t1643 0.226736
R3849 VSS.t1648 VSS.t1646 0.226736
R3850 VSS.t1651 VSS.t1653 0.226736
R3851 VSS.t1658 VSS.t1656 0.226736
R3852 VSS.t1661 VSS.t1663 0.226736
R3853 VSS.t1668 VSS.t1666 0.226736
R3854 VSS.t1671 VSS.t1673 0.226736
R3855 VSS.t1678 VSS.t1676 0.226736
R3856 VSS.t1681 VSS.t1683 0.226736
R3857 VSS.t1691 VSS.t1693 0.226736
R3858 VSS.t1698 VSS.t1696 0.226736
R3859 VSS.t1701 VSS.t1703 0.226736
R3860 VSS.t1708 VSS.t1706 0.226736
R3861 VSS.t1711 VSS.t1713 0.226736
R3862 VSS.t1718 VSS.t1716 0.226736
R3863 VSS.t1721 VSS.t1723 0.226736
R3864 VSS.t774 VSS.t772 0.226736
R3865 VSS.t779 VSS.t777 0.226736
R3866 VSS.t784 VSS.t782 0.226736
R3867 VSS.t789 VSS.t787 0.226736
R3868 VSS.t794 VSS.t792 0.226736
R3869 VSS.t797 VSS.t799 0.226736
R3870 VSS.t804 VSS.t802 0.226736
R3871 VSS.t807 VSS.t809 0.226736
R3872 VSS.t814 VSS.t812 0.226736
R3873 VSS.t817 VSS.t819 0.226736
R3874 VSS.t824 VSS.t822 0.226736
R3875 VSS.t827 VSS.t829 0.226736
R3876 VSS.t834 VSS.t832 0.226736
R3877 VSS.t837 VSS.t839 0.226736
R3878 VSS.t844 VSS.t842 0.226736
R3879 VSS.t847 VSS.t849 0.226736
R3880 VSS.t854 VSS.t852 0.226736
R3881 VSS.t857 VSS.t859 0.226736
R3882 VSS.t867 VSS.t869 0.226736
R3883 VSS.t874 VSS.t872 0.226736
R3884 VSS.t877 VSS.t879 0.226736
R3885 VSS.t884 VSS.t882 0.226736
R3886 VSS.t887 VSS.t889 0.226736
R3887 VSS.t894 VSS.t892 0.226736
R3888 VSS.t897 VSS.t899 0.226736
R3889 VSS.t904 VSS.t902 0.226736
R3890 VSS.t907 VSS.t909 0.226736
R3891 VSS.t914 VSS.t912 0.226736
R3892 VSS.t917 VSS.t919 0.226736
R3893 VSS.t924 VSS.t922 0.226736
R3894 VSS.t927 VSS.t929 0.226736
R3895 VSS.t934 VSS.t932 0.226736
R3896 VSS.t942 VSS.t944 0.226736
R3897 VSS.t949 VSS.t947 0.226736
R3898 VSS.t952 VSS.t954 0.226736
R3899 VSS.t959 VSS.t957 0.226736
R3900 VSS.t962 VSS.t964 0.226736
R3901 VSS.t969 VSS.t967 0.226736
R3902 VSS.t972 VSS.t974 0.226736
R3903 VSS.t979 VSS.t977 0.226736
R3904 VSS.t982 VSS.t984 0.226736
R3905 VSS.t989 VSS.t987 0.226736
R3906 VSS.t992 VSS.t994 0.226736
R3907 VSS.t999 VSS.t997 0.226736
R3908 VSS.t1002 VSS.t1004 0.226736
R3909 VSS.t1009 VSS.t1007 0.226736
R3910 VSS.t1019 VSS.t1017 0.226736
R3911 VSS.t1022 VSS.t1024 0.226736
R3912 VSS.t1029 VSS.t1027 0.226736
R3913 VSS.t1032 VSS.t1034 0.226736
R3914 VSS.t1039 VSS.t1037 0.226736
R3915 VSS.t1042 VSS.t1044 0.226736
R3916 VSS.t1049 VSS.t1047 0.226736
R3917 VSS.t559 VSS.t557 0.226736
R3918 VSS.t564 VSS.t562 0.226736
R3919 VSS.t569 VSS.t567 0.226736
R3920 VSS.t574 VSS.t572 0.226736
R3921 VSS.t579 VSS.t577 0.226736
R3922 VSS.t525 VSS.t523 0.226736
R3923 VSS.t530 VSS.t528 0.226736
R3924 VSS.t116 VSS.t737 0.226736
R3925 VSS.t731 VSS.t729 0.226736
R3926 VSS.t596 VSS.t598 0.226736
R3927 VSS.t694 VSS.t696 0.226736
R3928 VSS.t689 VSS.t691 0.226736
R3929 VSS.t591 VSS.t593 0.226736
R3930 VSS.t586 VSS.t588 0.226736
R3931 VSS.t414 VSS.t412 0.226736
R3932 VSS.t417 VSS.t419 0.226736
R3933 VSS.t710 VSS.t708 0.226736
R3934 VSS.t135 VSS.t476 0.226736
R3935 VSS.t128 VSS.t473 0.226736
R3936 VSS.t533 VSS.t535 0.224575
R3937 VSS.t277 VSS.t488 0.223765
R3938 VSS.t3196 VSS.n678 0.087772
R3939 VSS.t708 VSS.n672 0.0863258
R3940 VSS.t476 VSS.n683 0.0863258
R3941 VSS.t122 VSS.t420 0.218325
R3942 VSS.n335 VSS.t2927 0.0863258
R3943 VSS.n336 VSS.t2932 0.0863258
R3944 VSS.n337 VSS.t2937 0.0863258
R3945 VSS.n338 VSS.t2942 0.0863258
R3946 VSS.n339 VSS.t2947 0.0863258
R3947 VSS.n340 VSS.t2952 0.0863258
R3948 VSS.n341 VSS.t2957 0.0863258
R3949 VSS.n342 VSS.t2962 0.0863258
R3950 VSS.n343 VSS.t2967 0.0863258
R3951 VSS.n344 VSS.t2972 0.0863258
R3952 VSS.n345 VSS.t2977 0.0863258
R3953 VSS.n346 VSS.t2982 0.0863258
R3954 VSS.n347 VSS.t2987 0.0863258
R3955 VSS.n348 VSS.t2992 0.0863258
R3956 VSS.t585 VSS.n655 0.130189
R3957 VSS.t590 VSS.n656 0.130189
R3958 VSS.t688 VSS.n657 0.130189
R3959 VSS.t693 VSS.n658 0.130189
R3960 VSS.n670 VSS.t596 0.0863258
R3961 VSS.n628 VSS.t942 0.0863258
R3962 VSS.n630 VSS.t952 0.0863258
R3963 VSS.n632 VSS.t962 0.0863258
R3964 VSS.n634 VSS.t972 0.0863258
R3965 VSS.n636 VSS.t982 0.0863258
R3966 VSS.n638 VSS.t992 0.0863258
R3967 VSS.n640 VSS.t1002 0.0863258
R3968 VSS.n529 VSS.t1541 0.0863258
R3969 VSS.n531 VSS.t1551 0.0863258
R3970 VSS.n533 VSS.t1561 0.0863258
R3971 VSS.n535 VSS.t1571 0.0863258
R3972 VSS.n537 VSS.t1581 0.0863258
R3973 VSS.n539 VSS.t1591 0.0863258
R3974 VSS.n541 VSS.t1601 0.0863258
R3975 VSS.n487 VSS.t2008 0.0863258
R3976 VSS.n489 VSS.t2018 0.0863258
R3977 VSS.n491 VSS.t2028 0.0863258
R3978 VSS.n493 VSS.t2038 0.0863258
R3979 VSS.n495 VSS.t2048 0.0863258
R3980 VSS.n497 VSS.t2058 0.0863258
R3981 VSS.n499 VSS.t2068 0.0863258
R3982 VSS.n445 VSS.t2475 0.0863258
R3983 VSS.n447 VSS.t2485 0.0863258
R3984 VSS.n449 VSS.t2495 0.0863258
R3985 VSS.n451 VSS.t2505 0.0863258
R3986 VSS.t2500 VSS.n450 0.0863258
R3987 VSS.t2490 VSS.n448 0.0863258
R3988 VSS.t2480 VSS.n446 0.0863258
R3989 VSS.t2465 VSS.n443 0.0863258
R3990 VSS.t2320 VSS.n414 0.0863258
R3991 VSS.n396 VSS.t2229 0.130189
R3992 VSS.t2235 VSS.n397 0.0863258
R3993 VSS.t2240 VSS.n398 0.0863258
R3994 VSS.t2245 VSS.n399 0.0863258
R3995 VSS.n458 VSS.t1863 0.0863258
R3996 VSS.n460 VSS.t1873 0.0863258
R3997 VSS.n462 VSS.t1883 0.0863258
R3998 VSS.n464 VSS.t1893 0.0863258
R3999 VSS.n466 VSS.t1903 0.0863258
R4000 VSS.n468 VSS.t1913 0.0863258
R4001 VSS.n470 VSS.t1923 0.0863258
R4002 VSS.n472 VSS.t1933 0.0863258
R4003 VSS.n474 VSS.t1943 0.0863258
R4004 VSS.n476 VSS.t1953 0.0863258
R4005 VSS.n478 VSS.t1963 0.0863258
R4006 VSS.n480 VSS.t1973 0.0863258
R4007 VSS.n482 VSS.t1983 0.0863258
R4008 VSS.n484 VSS.t1993 0.0863258
R4009 VSS.t1998 VSS.n485 0.0863258
R4010 VSS.t1988 VSS.n483 0.0863258
R4011 VSS.t1978 VSS.n481 0.0863258
R4012 VSS.t1968 VSS.n479 0.0863258
R4013 VSS.t1958 VSS.n477 0.0863258
R4014 VSS.t1948 VSS.n475 0.0863258
R4015 VSS.t1938 VSS.n473 0.0863258
R4016 VSS.t1928 VSS.n471 0.0863258
R4017 VSS.t1918 VSS.n469 0.0863258
R4018 VSS.t1908 VSS.n467 0.0863258
R4019 VSS.t1898 VSS.n465 0.0863258
R4020 VSS.t1888 VSS.n463 0.0863258
R4021 VSS.t1878 VSS.n461 0.0863258
R4022 VSS.t1868 VSS.n459 0.0863258
R4023 VSS.t1858 VSS.n457 0.0863258
R4024 VSS.n453 VSS.t1837 0.130189
R4025 VSS.t1843 VSS.n454 0.0863258
R4026 VSS.t1848 VSS.n455 0.0863258
R4027 VSS.t1853 VSS.n456 0.0863258
R4028 VSS.n515 VSS.t1471 0.0863258
R4029 VSS.n517 VSS.t1481 0.0863258
R4030 VSS.n519 VSS.t1491 0.0863258
R4031 VSS.n521 VSS.t1501 0.0863258
R4032 VSS.n523 VSS.t1511 0.0863258
R4033 VSS.n525 VSS.t1521 0.0863258
R4034 VSS.n527 VSS.t1531 0.0863258
R4035 VSS.t1526 VSS.n526 0.0863258
R4036 VSS.t1516 VSS.n524 0.0863258
R4037 VSS.t1506 VSS.n522 0.0863258
R4038 VSS.t1496 VSS.n520 0.0863258
R4039 VSS.t1486 VSS.n518 0.0863258
R4040 VSS.t1476 VSS.n516 0.0863258
R4041 VSS.t1466 VSS.n514 0.0863258
R4042 VSS.n510 VSS.t1445 0.130189
R4043 VSS.t1451 VSS.n511 0.0863258
R4044 VSS.t1456 VSS.n512 0.0863258
R4045 VSS.t1461 VSS.n513 0.0863258
R4046 VSS.n599 VSS.t797 0.0863258
R4047 VSS.n601 VSS.t807 0.0863258
R4048 VSS.n603 VSS.t817 0.0863258
R4049 VSS.n605 VSS.t827 0.0863258
R4050 VSS.n607 VSS.t837 0.0863258
R4051 VSS.n609 VSS.t847 0.0863258
R4052 VSS.n611 VSS.t857 0.0863258
R4053 VSS.n613 VSS.t867 0.0863258
R4054 VSS.n615 VSS.t877 0.0863258
R4055 VSS.n617 VSS.t887 0.0863258
R4056 VSS.n619 VSS.t897 0.0863258
R4057 VSS.n621 VSS.t907 0.0863258
R4058 VSS.n623 VSS.t917 0.0863258
R4059 VSS.n625 VSS.t927 0.0863258
R4060 VSS.t932 VSS.n626 0.0863258
R4061 VSS.t922 VSS.n624 0.0863258
R4062 VSS.t912 VSS.n622 0.0863258
R4063 VSS.t902 VSS.n620 0.0863258
R4064 VSS.t892 VSS.n618 0.0863258
R4065 VSS.t882 VSS.n616 0.0863258
R4066 VSS.t872 VSS.n614 0.0863258
R4067 VSS.t862 VSS.n612 0.0863258
R4068 VSS.t852 VSS.n610 0.0863258
R4069 VSS.t842 VSS.n608 0.0863258
R4070 VSS.t832 VSS.n606 0.0863258
R4071 VSS.t822 VSS.n604 0.0863258
R4072 VSS.t812 VSS.n602 0.0863258
R4073 VSS.t802 VSS.n600 0.0863258
R4074 VSS.t792 VSS.n598 0.0863258
R4075 VSS.n594 VSS.t771 0.130189
R4076 VSS.t777 VSS.n595 0.0863258
R4077 VSS.t782 VSS.n596 0.0863258
R4078 VSS.t787 VSS.n597 0.0863258
R4079 VSS.t2250 VSS.n400 0.0863258
R4080 VSS.t2255 VSS.n401 0.0863258
R4081 VSS.t2260 VSS.n402 0.0863258
R4082 VSS.t2265 VSS.n403 0.0863258
R4083 VSS.t2270 VSS.n404 0.0863258
R4084 VSS.t2275 VSS.n405 0.0863258
R4085 VSS.t2280 VSS.n406 0.0863258
R4086 VSS.t2285 VSS.n407 0.0863258
R4087 VSS.t2290 VSS.n408 0.0863258
R4088 VSS.t2295 VSS.n409 0.0863258
R4089 VSS.t2300 VSS.n410 0.0863258
R4090 VSS.t2305 VSS.n411 0.0863258
R4091 VSS.t2310 VSS.n412 0.0863258
R4092 VSS.t2315 VSS.n413 0.0863258
R4093 VSS.t2325 VSS.n415 0.0863258
R4094 VSS.t2330 VSS.n416 0.0863258
R4095 VSS.t2335 VSS.n417 0.0863258
R4096 VSS.t2340 VSS.n418 0.0863258
R4097 VSS.t2345 VSS.n419 0.0863258
R4098 VSS.t2350 VSS.n420 0.0863258
R4099 VSS.t2355 VSS.n421 0.0863258
R4100 VSS.t2360 VSS.n422 0.0863258
R4101 VSS.t2365 VSS.n423 0.0863258
R4102 VSS.t2370 VSS.n424 0.0863258
R4103 VSS.t2375 VSS.n425 0.0863258
R4104 VSS.t2380 VSS.n426 0.0863258
R4105 VSS.t2385 VSS.n427 0.0863258
R4106 VSS.t2390 VSS.n428 0.0863258
R4107 VSS.t2400 VSS.n430 0.0863258
R4108 VSS.t2405 VSS.n431 0.0863258
R4109 VSS.t2410 VSS.n432 0.0863258
R4110 VSS.t2415 VSS.n433 0.0863258
R4111 VSS.t2420 VSS.n434 0.0863258
R4112 VSS.t2425 VSS.n435 0.0863258
R4113 VSS.t2430 VSS.n436 0.0863258
R4114 VSS.t2435 VSS.n437 0.0863258
R4115 VSS.t2440 VSS.n438 0.0863258
R4116 VSS.t2445 VSS.n439 0.0863258
R4117 VSS.t2450 VSS.n440 0.0863258
R4118 VSS.t2455 VSS.n441 0.0863258
R4119 VSS.t2460 VSS.n442 0.0863258
R4120 VSS.n364 VSS.t3072 0.0863258
R4121 VSS.n366 VSS.t3082 0.0863258
R4122 VSS.n368 VSS.t3092 0.0863258
R4123 VSS.n370 VSS.t3102 0.0863258
R4124 VSS.n372 VSS.t3112 0.0863258
R4125 VSS.n374 VSS.t3122 0.0863258
R4126 VSS.n376 VSS.t3132 0.0863258
R4127 VSS.n379 VSS.t3147 0.0863258
R4128 VSS.n381 VSS.t3157 0.0863258
R4129 VSS.n383 VSS.t3167 0.0863258
R4130 VSS.n385 VSS.t3177 0.0863258
R4131 VSS.t3172 VSS.n384 0.0863258
R4132 VSS.t3162 VSS.n382 0.0863258
R4133 VSS.t3152 VSS.n380 0.0863258
R4134 VSS.t3137 VSS.n377 0.0863258
R4135 VSS.t3127 VSS.n375 0.0863258
R4136 VSS.t3117 VSS.n373 0.0863258
R4137 VSS.t3107 VSS.n371 0.0863258
R4138 VSS.t3097 VSS.n369 0.0863258
R4139 VSS.t3087 VSS.n367 0.0863258
R4140 VSS.t3077 VSS.n365 0.0863258
R4141 VSS.t3062 VSS.n362 0.0863258
R4142 VSS.t2997 VSS.n349 0.0863258
R4143 VSS.t3002 VSS.n350 0.0863258
R4144 VSS.t3007 VSS.n351 0.0863258
R4145 VSS.t3012 VSS.n352 0.0863258
R4146 VSS.t3017 VSS.n353 0.0863258
R4147 VSS.t3022 VSS.n354 0.0863258
R4148 VSS.t3027 VSS.n355 0.0863258
R4149 VSS.t3032 VSS.n356 0.0863258
R4150 VSS.t3037 VSS.n357 0.0863258
R4151 VSS.t3042 VSS.n358 0.0863258
R4152 VSS.t3047 VSS.n359 0.0863258
R4153 VSS.t3052 VSS.n360 0.0863258
R4154 VSS.t3057 VSS.n361 0.0863258
R4155 VSS.n503 VSS.t2088 0.0863258
R4156 VSS.n505 VSS.t2098 0.0863258
R4157 VSS.n507 VSS.t2108 0.0863258
R4158 VSS.t2113 VSS.n508 0.0863258
R4159 VSS.t2103 VSS.n506 0.0863258
R4160 VSS.t2093 VSS.n504 0.0863258
R4161 VSS.t2083 VSS.n502 0.0863258
R4162 VSS.t2073 VSS.n500 0.0863258
R4163 VSS.t2063 VSS.n498 0.0863258
R4164 VSS.t2053 VSS.n496 0.0863258
R4165 VSS.t2043 VSS.n494 0.0863258
R4166 VSS.t2033 VSS.n492 0.0863258
R4167 VSS.t2023 VSS.n490 0.0863258
R4168 VSS.t2013 VSS.n488 0.0863258
R4169 VSS.n545 VSS.t1621 0.0863258
R4170 VSS.n547 VSS.t1631 0.0863258
R4171 VSS.n549 VSS.t1641 0.0863258
R4172 VSS.n551 VSS.t1651 0.0863258
R4173 VSS.n553 VSS.t1661 0.0863258
R4174 VSS.n555 VSS.t1671 0.0863258
R4175 VSS.n557 VSS.t1681 0.0863258
R4176 VSS.n559 VSS.t1691 0.0863258
R4177 VSS.n561 VSS.t1701 0.0863258
R4178 VSS.n563 VSS.t1711 0.0863258
R4179 VSS.n565 VSS.t1721 0.0863258
R4180 VSS.t1716 VSS.n564 0.0863258
R4181 VSS.t1706 VSS.n562 0.0863258
R4182 VSS.t1696 VSS.n560 0.0863258
R4183 VSS.t1676 VSS.n556 0.0863258
R4184 VSS.t1666 VSS.n554 0.0863258
R4185 VSS.t1656 VSS.n552 0.0863258
R4186 VSS.t1646 VSS.n550 0.0863258
R4187 VSS.t1636 VSS.n548 0.0863258
R4188 VSS.t1626 VSS.n546 0.0863258
R4189 VSS.t1616 VSS.n544 0.0863258
R4190 VSS.t1606 VSS.n542 0.0863258
R4191 VSS.t1596 VSS.n540 0.0863258
R4192 VSS.t1586 VSS.n538 0.0863258
R4193 VSS.t1576 VSS.n536 0.0863258
R4194 VSS.t1566 VSS.n534 0.0863258
R4195 VSS.t1556 VSS.n532 0.0863258
R4196 VSS.t1546 VSS.n530 0.0863258
R4197 VSS.n528 VSS.t1536 0.0863258
R4198 VSS.t737 VSS.n679 0.0863258
R4199 VSS.n644 VSS.t1022 0.0863258
R4200 VSS.n646 VSS.t1032 0.0863258
R4201 VSS.n648 VSS.t1042 0.0863258
R4202 VSS.t1047 VSS.n649 0.0863258
R4203 VSS.t1037 VSS.n647 0.0863258
R4204 VSS.t1027 VSS.n645 0.0863258
R4205 VSS.t1017 VSS.n643 0.0863258
R4206 VSS.t1007 VSS.n641 0.0863258
R4207 VSS.t997 VSS.n639 0.0863258
R4208 VSS.t987 VSS.n637 0.0863258
R4209 VSS.t977 VSS.n635 0.0863258
R4210 VSS.t967 VSS.n633 0.0863258
R4211 VSS.t957 VSS.n631 0.0863258
R4212 VSS.t947 VSS.n629 0.0863258
R4213 VSS.t729 VSS.n676 0.0863258
R4214 VSS.t528 VSS.n669 0.0863258
R4215 VSS.n668 VSS.t522 0.130189
R4216 VSS.n650 VSS.t555 0.130189
R4217 VSS.n651 VSS.t561 0.130189
R4218 VSS.n652 VSS.t566 0.130189
R4219 VSS.n653 VSS.t571 0.130189
R4220 VSS.n654 VSS.t576 0.130189
R4221 VSS.t473 VSS.n682 0.0863258
R4222 VSS.n693 VSS.t416 0.130189
R4223 VSS.n692 VSS.t411 0.130189
R4224 VSS.t2901 VSS.n330 0.130189
R4225 VSS.n332 VSS.t2912 0.0863258
R4226 VSS.t2907 VSS.n331 0.0863258
R4227 VSS.t2922 VSS.n334 0.0863258
R4228 VSS.n677 VSS.t733 0.0861948
R4229 VSS.t365 VSS.t219 0.217986
R4230 VSS.t362 VSS.t104 0.217986
R4231 VSS.t352 VSS.t275 0.217986
R4232 VSS.t348 VSS.t347 0.217986
R4233 VSS.t343 VSS.t342 0.217986
R4234 VSS.t338 VSS.t337 0.217986
R4235 VSS.t333 VSS.t332 0.217986
R4236 VSS.t328 VSS.t327 0.217986
R4237 VSS.t323 VSS.t253 0.217986
R4238 VSS.t318 VSS.t317 0.217986
R4239 VSS.t313 VSS.t312 0.217986
R4240 VSS.t375 VSS.t374 0.217986
R4241 VSS.n673 VSS.t716 0.0861948
R4242 VSS.t532 VSS.n666 0.129991
R4243 VSS.n681 VSS.t469 0.0861948
R4244 VSS.t308 VSS.t307 0.217986
R4245 VSS.t2821 VSS.t2673 0.210825
R4246 VSS.t2992 VSS.n955 0.210486
R4247 VSS.n890 VSS.t2320 0.210486
R4248 VSS.t1928 VSS.n887 0.210486
R4249 VSS.n896 VSS.t1536 0.210486
R4250 VSS.t862 VSS.n883 0.210486
R4251 VSS.t1163 VSS.t225 0.209938
R4252 VSS.n671 VSS.t600 0.0818513
R4253 VSS.t73 VSS.t193 0.204291
R4254 VSS.t2630 VSS.t2631 0.190486
R4255 VSS.n206 VSS.t466 0.209788
R4256 VSS.n592 VSS.t1305 0.180789
R4257 VSS.t2631 VSS.t2632 0.170825
R4258 VSS.t2763 VSS.t2764 0.170789
R4259 VSS.n787 VSS.t937 0.170789
R4260 VSS.t1611 VSS.n895 0.170789
R4261 VSS.n875 VSS.t2003 0.170789
R4262 VSS.t2395 VSS.n882 0.170789
R4263 VSS.t2718 VSS.n878 0.170789
R4264 VSS.n879 VSS.t3067 0.170789
R4265 VSS.n872 VSS.t1259 0.170789
R4266 VSS.n93 VSS.t647 0.439398
R4267 VSS.t372 VSS.n388 0.0836055
R4268 VSS.n393 VSS.t2783 0.0836055
R4269 VSS.t420 VSS.n257 0.0823774
R4270 VSS.t3067 VSS.n363 0.07903
R4271 VSS.t2395 VSS.n429 0.07903
R4272 VSS.t2003 VSS.n486 0.07903
R4273 VSS.n543 VSS.t1611 0.07903
R4274 VSS.t937 VSS.n627 0.07903
R4275 VSS.t1367 VSS.t1214 0.150789
R4276 VSS.t395 VSS.n788 0.149321
R4277 VSS.t481 VSS.t147 0.144148
R4278 VSS.t2919 VSS.t2917 0.135506
R4279 VSS.t1173 VSS.t1332 0.130789
R4280 VSS.t2763 VSS.n876 0.130486
R4281 VSS.t1173 VSS.t1333 0.110789
R4282 VSS.t370 VSS.n285 0.175751
R4283 VSS.t1304 VSS.n592 0.1105
R4284 VSS.n328 VSS.n879 0.081538
R4285 VSS.n327 VSS.t3142 0.181538
R4286 VSS.n311 VSS.n882 0.081538
R4287 VSS.n310 VSS.t2470 0.181538
R4288 VSS.n309 VSS.n875 0.081538
R4289 VSS.t2078 VSS.n308 0.181538
R4290 VSS.n895 VSS.n307 0.081538
R4291 VSS.n306 VSS.t1686 0.181538
R4292 VSS.n220 VSS.n787 0.081538
R4293 VSS.t1012 VSS.n219 0.181538
R4294 VSS.n285 VSS.t369 0.0333775
R4295 VSS.t462 VSS.n712 0.093
R4296 VSS.t2821 VSS.t2674 0.090789
R4297 VSS.t1215 VSS.t1367 0.090789
R4298 VSS.n242 VSS.t284 0.155751
R4299 VSS.n690 VSS.t462 0.0296542
R4300 VSS.t2904 VSS.t2906 0.0855
R4301 VSS.t2911 VSS.t2909 0.0855
R4302 VSS.t2914 VSS.t2916 0.0855
R4303 VSS.t369 VSS.t367 0.0855
R4304 VSS.t372 VSS.t374 0.0855
R4305 VSS.t3071 VSS.t3069 0.0855
R4306 VSS.t3074 VSS.t3076 0.0855
R4307 VSS.t3081 VSS.t3079 0.0855
R4308 VSS.t3084 VSS.t3086 0.0855
R4309 VSS.t3091 VSS.t3089 0.0855
R4310 VSS.t3094 VSS.t3096 0.0855
R4311 VSS.t3101 VSS.t3099 0.0855
R4312 VSS.t3104 VSS.t3106 0.0855
R4313 VSS.t3111 VSS.t3109 0.0855
R4314 VSS.t3114 VSS.t3116 0.0855
R4315 VSS.t3121 VSS.t3119 0.0855
R4316 VSS.t3124 VSS.t3126 0.0855
R4317 VSS.t3131 VSS.t3129 0.0855
R4318 VSS.t3134 VSS.t3136 0.0855
R4319 VSS.t3141 VSS.t3139 0.0855
R4320 VSS.t3146 VSS.t3144 0.0855
R4321 VSS.t3149 VSS.t3151 0.0855
R4322 VSS.t3156 VSS.t3154 0.0855
R4323 VSS.t3159 VSS.t3161 0.0855
R4324 VSS.t3166 VSS.t3164 0.0855
R4325 VSS.t3169 VSS.t3171 0.0855
R4326 VSS.t3176 VSS.t3174 0.0855
R4327 VSS.t2996 VSS.t2994 0.0855
R4328 VSS.t3001 VSS.t2999 0.0855
R4329 VSS.t3006 VSS.t3004 0.0855
R4330 VSS.t3011 VSS.t3009 0.0855
R4331 VSS.t3016 VSS.t3014 0.0855
R4332 VSS.t3021 VSS.t3019 0.0855
R4333 VSS.t3026 VSS.t3024 0.0855
R4334 VSS.t3031 VSS.t3029 0.0855
R4335 VSS.t3036 VSS.t3034 0.0855
R4336 VSS.t3041 VSS.t3039 0.0855
R4337 VSS.t3046 VSS.t3044 0.0855
R4338 VSS.t3051 VSS.t3049 0.0855
R4339 VSS.t3056 VSS.t3054 0.0855
R4340 VSS.t3061 VSS.t3059 0.0855
R4341 VSS.t3064 VSS.t3066 0.0855
R4342 VSS.t2989 VSS.t2991 0.0855
R4343 VSS.t2984 VSS.t2986 0.0855
R4344 VSS.t2979 VSS.t2981 0.0855
R4345 VSS.t2974 VSS.t2976 0.0855
R4346 VSS.t2969 VSS.t2971 0.0855
R4347 VSS.t2964 VSS.t2966 0.0855
R4348 VSS.t2959 VSS.t2961 0.0855
R4349 VSS.t2954 VSS.t2956 0.0855
R4350 VSS.t2949 VSS.t2951 0.0855
R4351 VSS.t2944 VSS.t2946 0.0855
R4352 VSS.t2939 VSS.t2941 0.0855
R4353 VSS.t2934 VSS.t2936 0.0855
R4354 VSS.t2929 VSS.t2931 0.0855
R4355 VSS.t2926 VSS.t2924 0.0855
R4356 VSS.t2919 VSS.t2921 0.0855
R4357 VSS.t2234 VSS.t2232 0.0855
R4358 VSS.t2239 VSS.t2237 0.0855
R4359 VSS.t2244 VSS.t2242 0.0855
R4360 VSS.t2249 VSS.t2247 0.0855
R4361 VSS.t2254 VSS.t2252 0.0855
R4362 VSS.t2259 VSS.t2257 0.0855
R4363 VSS.t2264 VSS.t2262 0.0855
R4364 VSS.t2269 VSS.t2267 0.0855
R4365 VSS.t2274 VSS.t2272 0.0855
R4366 VSS.t2279 VSS.t2277 0.0855
R4367 VSS.t2284 VSS.t2282 0.0855
R4368 VSS.t2289 VSS.t2287 0.0855
R4369 VSS.t2294 VSS.t2292 0.0855
R4370 VSS.t2299 VSS.t2297 0.0855
R4371 VSS.t2304 VSS.t2302 0.0855
R4372 VSS.t2309 VSS.t2307 0.0855
R4373 VSS.t2314 VSS.t2312 0.0855
R4374 VSS.t2319 VSS.t2317 0.0855
R4375 VSS.t2324 VSS.t2322 0.0855
R4376 VSS.t2329 VSS.t2327 0.0855
R4377 VSS.t2334 VSS.t2332 0.0855
R4378 VSS.t2339 VSS.t2337 0.0855
R4379 VSS.t2344 VSS.t2342 0.0855
R4380 VSS.t2349 VSS.t2347 0.0855
R4381 VSS.t2354 VSS.t2352 0.0855
R4382 VSS.t2359 VSS.t2357 0.0855
R4383 VSS.t2364 VSS.t2362 0.0855
R4384 VSS.t2369 VSS.t2367 0.0855
R4385 VSS.t2374 VSS.t2372 0.0855
R4386 VSS.t2379 VSS.t2377 0.0855
R4387 VSS.t2384 VSS.t2382 0.0855
R4388 VSS.t2389 VSS.t2387 0.0855
R4389 VSS.t2394 VSS.t2392 0.0855
R4390 VSS.t2399 VSS.t2397 0.0855
R4391 VSS.t2404 VSS.t2402 0.0855
R4392 VSS.t2409 VSS.t2407 0.0855
R4393 VSS.t2414 VSS.t2412 0.0855
R4394 VSS.t2419 VSS.t2417 0.0855
R4395 VSS.t2424 VSS.t2422 0.0855
R4396 VSS.t2429 VSS.t2427 0.0855
R4397 VSS.t2434 VSS.t2432 0.0855
R4398 VSS.t2439 VSS.t2437 0.0855
R4399 VSS.t2444 VSS.t2442 0.0855
R4400 VSS.t2449 VSS.t2447 0.0855
R4401 VSS.t2454 VSS.t2452 0.0855
R4402 VSS.t2459 VSS.t2457 0.0855
R4403 VSS.t2464 VSS.t2462 0.0855
R4404 VSS.t2467 VSS.t2469 0.0855
R4405 VSS.t2474 VSS.t2472 0.0855
R4406 VSS.t2477 VSS.t2479 0.0855
R4407 VSS.t2484 VSS.t2482 0.0855
R4408 VSS.t2487 VSS.t2489 0.0855
R4409 VSS.t2494 VSS.t2492 0.0855
R4410 VSS.t2497 VSS.t2499 0.0855
R4411 VSS.t2504 VSS.t2502 0.0855
R4412 VSS.t1842 VSS.t1840 0.0855
R4413 VSS.t1847 VSS.t1845 0.0855
R4414 VSS.t1852 VSS.t1850 0.0855
R4415 VSS.t1855 VSS.t1857 0.0855
R4416 VSS.t1862 VSS.t1860 0.0855
R4417 VSS.t1865 VSS.t1867 0.0855
R4418 VSS.t1872 VSS.t1870 0.0855
R4419 VSS.t1875 VSS.t1877 0.0855
R4420 VSS.t1882 VSS.t1880 0.0855
R4421 VSS.t1885 VSS.t1887 0.0855
R4422 VSS.t1892 VSS.t1890 0.0855
R4423 VSS.t1895 VSS.t1897 0.0855
R4424 VSS.t1902 VSS.t1900 0.0855
R4425 VSS.t1905 VSS.t1907 0.0855
R4426 VSS.t1912 VSS.t1910 0.0855
R4427 VSS.t1915 VSS.t1917 0.0855
R4428 VSS.t1922 VSS.t1920 0.0855
R4429 VSS.t1925 VSS.t1927 0.0855
R4430 VSS.t1932 VSS.t1930 0.0855
R4431 VSS.t1935 VSS.t1937 0.0855
R4432 VSS.t1942 VSS.t1940 0.0855
R4433 VSS.t1945 VSS.t1947 0.0855
R4434 VSS.t1952 VSS.t1950 0.0855
R4435 VSS.t1955 VSS.t1957 0.0855
R4436 VSS.t1962 VSS.t1960 0.0855
R4437 VSS.t1965 VSS.t1967 0.0855
R4438 VSS.t1972 VSS.t1970 0.0855
R4439 VSS.t1975 VSS.t1977 0.0855
R4440 VSS.t1982 VSS.t1980 0.0855
R4441 VSS.t1985 VSS.t1987 0.0855
R4442 VSS.t1992 VSS.t1990 0.0855
R4443 VSS.t1995 VSS.t1997 0.0855
R4444 VSS.t2000 VSS.t2002 0.0855
R4445 VSS.t2007 VSS.t2005 0.0855
R4446 VSS.t2010 VSS.t2012 0.0855
R4447 VSS.t2017 VSS.t2015 0.0855
R4448 VSS.t2020 VSS.t2022 0.0855
R4449 VSS.t2027 VSS.t2025 0.0855
R4450 VSS.t2030 VSS.t2032 0.0855
R4451 VSS.t2037 VSS.t2035 0.0855
R4452 VSS.t2040 VSS.t2042 0.0855
R4453 VSS.t2047 VSS.t2045 0.0855
R4454 VSS.t2050 VSS.t2052 0.0855
R4455 VSS.t2057 VSS.t2055 0.0855
R4456 VSS.t2060 VSS.t2062 0.0855
R4457 VSS.t2067 VSS.t2065 0.0855
R4458 VSS.t2070 VSS.t2072 0.0855
R4459 VSS.t2077 VSS.t2075 0.0855
R4460 VSS.t2080 VSS.t2082 0.0855
R4461 VSS.t2087 VSS.t2085 0.0855
R4462 VSS.t2090 VSS.t2092 0.0855
R4463 VSS.t2097 VSS.t2095 0.0855
R4464 VSS.t2100 VSS.t2102 0.0855
R4465 VSS.t2107 VSS.t2105 0.0855
R4466 VSS.t2110 VSS.t2112 0.0855
R4467 VSS.t1450 VSS.t1448 0.0855
R4468 VSS.t1455 VSS.t1453 0.0855
R4469 VSS.t1460 VSS.t1458 0.0855
R4470 VSS.t1463 VSS.t1465 0.0855
R4471 VSS.t1470 VSS.t1468 0.0855
R4472 VSS.t1473 VSS.t1475 0.0855
R4473 VSS.t1480 VSS.t1478 0.0855
R4474 VSS.t1483 VSS.t1485 0.0855
R4475 VSS.t1490 VSS.t1488 0.0855
R4476 VSS.t1493 VSS.t1495 0.0855
R4477 VSS.t1500 VSS.t1498 0.0855
R4478 VSS.t1503 VSS.t1505 0.0855
R4479 VSS.t1510 VSS.t1508 0.0855
R4480 VSS.t1513 VSS.t1515 0.0855
R4481 VSS.t1520 VSS.t1518 0.0855
R4482 VSS.t1523 VSS.t1525 0.0855
R4483 VSS.t1530 VSS.t1528 0.0855
R4484 VSS.t1533 VSS.t1535 0.0855
R4485 VSS.t1540 VSS.t1538 0.0855
R4486 VSS.t1543 VSS.t1545 0.0855
R4487 VSS.t1550 VSS.t1548 0.0855
R4488 VSS.t1553 VSS.t1555 0.0855
R4489 VSS.t1560 VSS.t1558 0.0855
R4490 VSS.t1563 VSS.t1565 0.0855
R4491 VSS.t1570 VSS.t1568 0.0855
R4492 VSS.t1573 VSS.t1575 0.0855
R4493 VSS.t1580 VSS.t1578 0.0855
R4494 VSS.t1583 VSS.t1585 0.0855
R4495 VSS.t1590 VSS.t1588 0.0855
R4496 VSS.t1593 VSS.t1595 0.0855
R4497 VSS.t1600 VSS.t1598 0.0855
R4498 VSS.t1603 VSS.t1605 0.0855
R4499 VSS.t1610 VSS.t1608 0.0855
R4500 VSS.t1613 VSS.t1615 0.0855
R4501 VSS.t1620 VSS.t1618 0.0855
R4502 VSS.t1623 VSS.t1625 0.0855
R4503 VSS.t1630 VSS.t1628 0.0855
R4504 VSS.t1633 VSS.t1635 0.0855
R4505 VSS.t1640 VSS.t1638 0.0855
R4506 VSS.t1643 VSS.t1645 0.0855
R4507 VSS.t1650 VSS.t1648 0.0855
R4508 VSS.t1653 VSS.t1655 0.0855
R4509 VSS.t1660 VSS.t1658 0.0855
R4510 VSS.t1663 VSS.t1665 0.0855
R4511 VSS.t1670 VSS.t1668 0.0855
R4512 VSS.t1673 VSS.t1675 0.0855
R4513 VSS.t1680 VSS.t1678 0.0855
R4514 VSS.t1683 VSS.t1685 0.0855
R4515 VSS.t1690 VSS.t1688 0.0855
R4516 VSS.t1693 VSS.t1695 0.0855
R4517 VSS.t1700 VSS.t1698 0.0855
R4518 VSS.t1703 VSS.t1705 0.0855
R4519 VSS.t1710 VSS.t1708 0.0855
R4520 VSS.t1713 VSS.t1715 0.0855
R4521 VSS.t1720 VSS.t1718 0.0855
R4522 VSS.t776 VSS.t774 0.0855
R4523 VSS.t781 VSS.t779 0.0855
R4524 VSS.t786 VSS.t784 0.0855
R4525 VSS.t789 VSS.t791 0.0855
R4526 VSS.t796 VSS.t794 0.0855
R4527 VSS.t799 VSS.t801 0.0855
R4528 VSS.t806 VSS.t804 0.0855
R4529 VSS.t809 VSS.t811 0.0855
R4530 VSS.t816 VSS.t814 0.0855
R4531 VSS.t819 VSS.t821 0.0855
R4532 VSS.t826 VSS.t824 0.0855
R4533 VSS.t829 VSS.t831 0.0855
R4534 VSS.t836 VSS.t834 0.0855
R4535 VSS.t839 VSS.t841 0.0855
R4536 VSS.t846 VSS.t844 0.0855
R4537 VSS.t849 VSS.t851 0.0855
R4538 VSS.t856 VSS.t854 0.0855
R4539 VSS.t859 VSS.t861 0.0855
R4540 VSS.t866 VSS.t864 0.0855
R4541 VSS.t869 VSS.t871 0.0855
R4542 VSS.t876 VSS.t874 0.0855
R4543 VSS.t879 VSS.t881 0.0855
R4544 VSS.t886 VSS.t884 0.0855
R4545 VSS.t889 VSS.t891 0.0855
R4546 VSS.t896 VSS.t894 0.0855
R4547 VSS.t899 VSS.t901 0.0855
R4548 VSS.t906 VSS.t904 0.0855
R4549 VSS.t909 VSS.t911 0.0855
R4550 VSS.t916 VSS.t914 0.0855
R4551 VSS.t919 VSS.t921 0.0855
R4552 VSS.t926 VSS.t924 0.0855
R4553 VSS.t929 VSS.t931 0.0855
R4554 VSS.t934 VSS.t936 0.0855
R4555 VSS.t941 VSS.t939 0.0855
R4556 VSS.t944 VSS.t946 0.0855
R4557 VSS.t951 VSS.t949 0.0855
R4558 VSS.t954 VSS.t956 0.0855
R4559 VSS.t961 VSS.t959 0.0855
R4560 VSS.t964 VSS.t966 0.0855
R4561 VSS.t971 VSS.t969 0.0855
R4562 VSS.t974 VSS.t976 0.0855
R4563 VSS.t981 VSS.t979 0.0855
R4564 VSS.t984 VSS.t986 0.0855
R4565 VSS.t991 VSS.t989 0.0855
R4566 VSS.t994 VSS.t996 0.0855
R4567 VSS.t1001 VSS.t999 0.0855
R4568 VSS.t1004 VSS.t1006 0.0855
R4569 VSS.t1011 VSS.t1009 0.0855
R4570 VSS.t1014 VSS.t1016 0.0855
R4571 VSS.t1021 VSS.t1019 0.0855
R4572 VSS.t1024 VSS.t1026 0.0855
R4573 VSS.t1031 VSS.t1029 0.0855
R4574 VSS.t1034 VSS.t1036 0.0855
R4575 VSS.t1041 VSS.t1039 0.0855
R4576 VSS.t1044 VSS.t1046 0.0855
R4577 VSS.t561 VSS.t559 0.0855
R4578 VSS.t566 VSS.t564 0.0855
R4579 VSS.t571 VSS.t569 0.0855
R4580 VSS.t576 VSS.t574 0.0855
R4581 VSS.t581 VSS.t579 0.0855
R4582 VSS.t527 VSS.t525 0.0855
R4583 VSS.t530 VSS.t532 0.0855
R4584 VSS.t46 VSS.t552 0.0855
R4585 VSS.t696 VSS.t48 0.0855
R4586 VSS.t297 VSS.t731 0.0855
R4587 VSS.t715 VSS.t712 0.0855
R4588 VSS.t595 VSS.t96 0.0855
R4589 VSS.t691 VSS.t693 0.0855
R4590 VSS.t593 VSS.t688 0.0855
R4591 VSS.t588 VSS.t590 0.0855
R4592 VSS.t582 VSS.t585 0.0855
R4593 VSS.t102 VSS.t471 0.0855
R4594 VSS.t416 VSS.t414 0.0855
R4595 VSS.t312 VSS.t310 0.0855
R4596 VSS.t317 VSS.t315 0.0855
R4597 VSS.t327 VSS.t325 0.0855
R4598 VSS.t332 VSS.t330 0.0855
R4599 VSS.t337 VSS.t335 0.0855
R4600 VSS.t342 VSS.t340 0.0855
R4601 VSS.t347 VSS.t345 0.0855
R4602 VSS.t354 VSS.t356 0.0855
R4603 VSS.t707 VSS.t705 0.0855
R4604 VSS.t132 VSS.t128 0.0855
R4605 VSS.n788 VSS.t109 0.0793031
R4606 VSS.t598 VSS.t601 0.07425
R4607 VSS.t83 VSS.t86 0.07425
R4608 VSS.t168 VSS.t320 0.07425
R4609 VSS.t147 VSS.t142 0.07175
R4610 VSS.t1260 VSS.n872 0.070789
R4611 VSS.n183 VSS.t10 0.470042
R4612 VSS.n642 VSS.t1012 0.149319
R4613 VSS.n501 VSS.t2078 0.149319
R4614 VSS.t2470 VSS.n444 0.149319
R4615 VSS.n378 VSS.t3142 0.149319
R4616 VSS.n558 VSS.t1686 0.149319
R4617 VSS.t1304 VSS.n871 0.070789
R4618 VSS.n166 VSS.t73 0.219075
R4619 VSS.t73 VSS.n175 2.20311
R4620 VSS.t755 VSS.t629 0.053
R4621 VSS.t438 VSS.t441 0.053
R4622 VSS.n712 VSS.t61 0.0505
R4623 VSS.t466 VSS.t77 0.03925
R4624 VSS.t2321 VSS.n26 109.993
R4625 VSS.n26 VSS.t2491 109.992
R4626 VSS.n26 VSS.t2441 109.992
R4627 VSS.n26 VSS.t2391 109.992
R4628 VSS.n26 VSS.t2271 109.992
R4629 VSS.n26 VSS.t2251 109.992
R4630 VSS.n23 VSS.t2064 109.992
R4631 VSS.n23 VSS.t2034 109.992
R4632 VSS.t2019 VSS.n23 109.992
R4633 VSS.n23 VSS.t1899 109.992
R4634 VSS.n23 VSS.t1849 109.992
R4635 VSS.n24 VSS.t1717 109.992
R4636 VSS.n24 VSS.t1707 109.992
R4637 VSS.n24 VSS.t1697 109.992
R4638 VSS.n24 VSS.t1667 109.992
R4639 VSS.t1602 VSS.n24 109.992
R4640 VSS.t1582 VSS.n24 109.992
R4641 VSS.n24 VSS.t1507 109.992
R4642 VSS.n24 VSS.t1457 109.992
R4643 VSS.n25 VSS.t1028 109.992
R4644 VSS.t1023 VSS.n25 109.992
R4645 VSS.t1013 VSS.n25 109.992
R4646 VSS.t1003 VSS.n25 109.992
R4647 VSS.t983 VSS.n25 109.992
R4648 VSS.n25 VSS.t938 109.992
R4649 VSS.n25 VSS.t893 109.992
R4650 VSS.n25 VSS.t813 109.992
R4651 VSS.n25 VSS.t793 109.992
R4652 VSS.n25 VSS.t778 109.992
R4653 VSS VSS.n956 0.01986
R4654 VSS.n955 VSS.t2994 0.01675
R4655 VSS.t2322 VSS.n890 0.01675
R4656 VSS.n887 VSS.t1930 0.01675
R4657 VSS.n896 VSS.t1538 0.01675
R4658 VSS.n883 VSS.t864 0.01675
R4659 VSS.t274 VSS.n172 13.9422
R4660 VSS.n877 VSS.n878 0.0105
R4661 VSS.n109 VSS.t2918 183.806
R4662 VSS.t3148 VSS.n109 183.805
R4663 VSS.n109 VSS.t3118 183.805
R4664 VSS.t3093 VSS.n109 183.844
R4665 VSS.n109 VSS.t3053 183.805
R4666 VSS.n109 VSS.t2998 183.805
R4667 VSS.t2933 VSS.n109 183.805
R4668 VSS.n109 VSS.t2908 183.805
R4669 VSS.t3322 VSS.n300 16.4429
R4670 VSS.n23 VSS.n506 4.29336
R4671 VSS.n563 VSS.n24 4.29335
R4672 VSS.n449 VSS.n26 4.29334
R4673 VSS.n595 VSS.n25 4.29334
R4674 VSS.n333 VSS.n109 2.79821
R4675 VSS.n304 VSS.t224 2.56777
R4676 VSS.n258 VSS.t2620 2.28095
R4677 VSS.n680 VSS.t54 1.20944
R4678 VSS.t54 VSS.t618 1.08827
R4679 VSS.t73 VSS.n122 1.0698
R4680 VSS.t54 VSS.n98 1.06837
R4681 VSS.t2 VSS.t1 1.04895
R4682 VSS.t73 VSS.n48 1.00733
C0 a_22480_14726# sg13cmos5l_or3_1_2.X 0.01004f
C1 a_16068_14040# a_16587_13844# 0.20773f
C2 clock_i a_15790_15238# 0.41989f
C3 sg13cmos5l_dfrbpq_1_2.CLK sg13cmos5l_buf_1_0.X 1.87305f
C4 sg13cmos5l_dfrbpq_1_7.D a_25766_14922# 0.16736f
C5 a_5408_15366# a_5495_15315# 0.03131f
C6 a_5495_15549# a_5694_15486# 0.08889f
C7 a_20964_14488# a_22129_14845# 0.25046f
C8 a_21252_14909# a_21483_14495# 0.07823f
C9 a_27022_13239# VDD 0.16299f
C10 a_21934_15423# VDD 0.16107f
C11 sg13cmos5l_or3_1_2.C sg13cmos5l_dfrbpq_1_3.Q 0.11847f
C12 a_18610_16374# sg13cmos5l_dlygate4sd3_1_7.A 0.06016f
C13 a_20938_14452# sg13cmos5l_or3_1_2.A 0.0156f
C14 a_16068_14040# a_16356_13735# 0.24435f
C15 sg13cmos5l_nor2_1_3.B a_16175_14854# 0.02386f
C16 a_22223_14845# a_22129_14845# 0.16704f
C17 a_1192_9948# VDD 0.18614f
C18 sg13cmos5l_buf_16_2.X sg13cmos5l_or3_1_1.X 0.02312f
C19 a_3894_16020# a_3782_15996# 0.3854f
C20 a_19436_15960# counter_value_o[3] 0.1598f
C21 sg13cmos5l_dfrbpq_1_6.D a_20974_15423# 0.03685f
C22 sg13cmos5l_dlygate4sd3_1_5.A sg13cmos5l_dfrbpq_1_1.D 0.10582f
C23 a_17327_13799# a_17233_13799# 0.16704f
C24 sg13cmos5l_o21ai_1_2.B1 sg13cmos5l_dfrbpq_1_7.Q 0.63253f
C25 sg13cmos5l_dfrbpq_1_3.D counter_value_o[3] 0.01244f
C26 sg13cmos5l_dlygate4sd3_1_10.X sg13cmos5l_a21oi_1_0.A1 0.77741f
C27 a_9732_15552# a_10020_15247# 0.24435f
C28 sg13cmos5l_o21ai_1_3.A2 a_25006_14751# 0.02253f
C29 a_25768_13854# sg13cmos5l_dfrbpq_1_5.D 0.047f
C30 sg13cmos5l_inv_1_0.Y sg13cmos5l_xor2_1_1.B 0.01953f
C31 a_25129_13726# sg13cmos5l_o21ai_1_3.Y 0.05387f
C32 a_27310_15423# sg13cmos5l_o21ai_1_2.B1 0.10722f
C33 sg13cmos5l_dfrbpq_1_7.D a_25878_16020# 0.13574f
C34 a_8982_15302# sg13cmos5l_nor2_1_1.B 0.1109f
C35 a_8176_14726# a_8586_14484# 0.07015f
C36 clock_i a_3782_15996# 0.01804f
C37 sg13cmos5l_dfrbpq_1_3.Q a_24156_15242# 0.01194f
C38 sg13cmos5l_dlygate4sd3_1_6.X sg13cmos5l_dlygate4sd3_1_11.X 0.25886f
C39 a_8600_15238# a_8870_15238# 0.18796f
C40 sg13cmos5l_dfrbpq_1_2.Q a_22330_15202# 0.01071f
C41 sg13cmos5l_dlygate4sd3_1_1.X VDD 0.43966f
C42 sg13cmos5l_o21ai_1_2.B1 a_24992_13854# 0.01896f
C43 a_37484_15960# VDD 0.22843f
C44 sg13cmos5l_nor2_1_3.B sg13cmos5l_dfrbpq_1_2.D 0.15034f
C45 a_19265_15424# sg13cmos5l_buf_16_2.A 0.05051f
C46 enable_i VDD 0.25464f
C47 sg13cmos5l_dfrbpq_1_6.RESET_B a_21381_14495# 0.0383f
C48 sg13cmos5l_o21ai_1_2.Y sg13cmos5l_o21ai_1_3.Y 0.01033f
C49 sg13cmos5l_xnor2_1_1.A a_17142_16020# 0.01234f
C50 sg13cmos5l_dfrbpq_1_6.D sg13cmos5l_or3_1_2.X 0.04422f
C51 sg13cmos5l_xor2_1_0.B sg13cmos5l_buf_1_0.X 0.01407f
C52 a_6374_14922# a_6660_14488# 0.26205f
C53 a_9368_14525# a_9638_14484# 0.18796f
C54 sg13cmos5l_dlygate4sd3_1_1.X a_6296_15238# 0.05125f
C55 a_10251_15356# sg13cmos5l_dfrbpq_1_2.CLK 0.0277f
C56 sg13cmos5l_inv_1_0.Y a_15486_15486# 0.01761f
C57 sg13cmos5l_dfrbpq_1_2.Q a_19265_15424# 0.01065f
C58 a_27503_13799# VDD 0.1944f
C59 a_26218_13945# a_25958_13722# 0.45119f
C60 a_4624_15454# sg13cmos5l_xnor2_1_0.A 0.01236f
C61 sg13cmos5l_inv_1_0.Y sg13cmos5l_buf_1_0.X 0.56032f
C62 a_18106_15960# VDD 0.26968f
C63 a_11248_15454# sg13cmos5l_tiehi_0.L_HI 0.09962f
C64 a_10991_15311# sg13cmos5l_dfrbpq_1_2.CLK 0.01384f
C65 sg13cmos5l_o21ai_1_3.B1 sg13cmos5l_o21ai_1_3.Y 0.29742f
C66 clock_i sg13cmos5l_nand4_1_0.Y 0.35896f
C67 sg13cmos5l_dfrbpq_1_6.D sg13cmos5l_or3_1_2.A 0.02527f
C68 a_26661_13701# a_26763_13844# 0.36168f
C69 a_9732_15552# sg13cmos5l_dlygate4sd3_1_11.A 0.05037f
C70 sg13cmos5l_dfrbpq_1_7.D VDD 0.34174f
C71 a_20974_15423# VDD 0.15921f
C72 sg13cmos5l_xor2_1_1.A a_7179_14495# 0.06303f
C73 sg13cmos5l_o21ai_1_2.B1 a_26052_14488# 0.01317f
C74 a_6660_14488# a_7077_14495# 0.28418f
C75 a_7916_15960# clock_i 0.01035f
C76 a_18106_15960# sg13cmos5l_o21ai_1_2.A1 0.01097f
C77 reset_n_i VDD 0.14588f
C78 sg13cmos5l_inv_1_0.Y a_15496_14570# 0.0318f
C79 sg13cmos5l_dlygate4sd3_1_5.A a_5034_15532# 0.14618f
C80 sg13cmos5l_dfrbpq_1_6.Q sg13cmos5l_dfrbpq_1_7.Q 2.07207f
C81 a_27311_14845# sg13cmos5l_dfrbpq_1_7.Q 0.01278f
C82 sg13cmos5l_dfrbpq_1_7.RESET_B sg13cmos5l_dfrbpq_1_5.D 0.13602f
C83 a_37484_15960# a_37192_16082# 0.01635f
C84 a_9946_13943# sg13cmos5l_tiehi_0.L_HI 0.04367f
C85 sg13cmos5l_xor2_1_0.B a_8156_15532# 0.03235f
C86 a_32492_15960# sg13cmos5l_dfrbpq_1_7.Q 0.19611f
C87 sg13cmos5l_inv_1_0.Y sg13cmos5l_dfrbpq_1_2.CLK 2.93724f
C88 sg13cmos5l_dfrbpq_1_6.Q a_27310_15423# 0.02659f
C89 sg13cmos5l_inv_1_0.Y a_7919_14845# 0.02336f
C90 a_15680_13854# sg13cmos5l_dfrbpq_1_2.D 0.03873f
C91 sg13cmos5l_dfrbpq_1_1.RESET_B sg13cmos5l_xor2_1_1.A 0.02726f
C92 a_17222_14922# VDD 0.53043f
C93 sg13cmos5l_o21ai_1_3.A2 sg13cmos5l_o21ai_1_2.A2 0.07078f
C94 a_25006_14751# sg13cmos5l_o21ai_1_2.Y 0.04493f
C95 sg13cmos5l_dfrbpq_1_3.RESET_B a_17825_16262# 0.01512f
C96 VDD a_24821_15532# 0.18147f
C97 sg13cmos5l_dfrbpq_1_3.D sg13cmos5l_buf_16_2.A 0.15471f
C98 sg13cmos5l_inv_1_0.Y a_10318_14751# 0.01536f
C99 sg13cmos5l_dfrbpq_1_6.D a_20864_16082# 0.01243f
C100 a_15287_15549# VDD 0.09717f
C101 a_20182_14862# VDD 0.01265f
C102 a_26026_14452# a_25766_14922# 0.45119f
C103 a_10251_15356# a_10991_15311# 0.17382f
C104 a_6906_12935# sg13cmos5l_xor2_1_1.B 0.22489f
C105 a_17796_14909# a_17222_14922# 0.18486f
C106 a_20182_14862# sg13cmos5l_o21ai_1_1.Y 0.06577f
C107 a_6678_15302# sg13cmos5l_dlygate4sd3_1_3.X 0.10798f
C108 sg13cmos5l_buf_16_2.X sg13cmos5l_o21ai_1_3.A2 0.65357f
C109 sg13cmos5l_or3_1_2.X VDD 0.40378f
C110 VDD a_25288_15366# 0.13621f
C111 sg13cmos5l_dfrbpq_1_5.RESET_B a_26218_13945# 0.21784f
C112 a_18080_15366# VDD 0.0795f
C113 a_27409_13799# sg13cmos5l_dlygate4sd3_1_20.A 0.02047f
C114 sg13cmos5l_or3_1_2.X sg13cmos5l_o21ai_1_1.Y 0.03377f
C115 a_12212_15202# sg13cmos5l_nand4_1_0.Y 0.07127f
C116 sg13cmos5l_a21oi_1_1.Y a_21850_16237# 0.03499f
C117 sg13cmos5l_xnor2_1_1.A sg13cmos5l_dfrbpq_1_2.CLK 0.02677f
C118 sg13cmos5l_dlygate4sd3_1_11.X a_9706_15457# 0.0149f
C119 a_26571_14495# a_25766_14922# 0.07916f
C120 sg13cmos5l_or3_1_2.X a_20507_15532# 0.0653f
C121 sg13cmos5l_o21ai_1_2.A1 a_20182_14862# 0.05715f
C122 sg13cmos5l_dfrbpq_1_6.Q sg13cmos5l_dfrbpq_1_3.Q 0.33771f
C123 sg13cmos5l_dlygate4sd3_1_5.A sg13cmos5l_nor2_1_0.B 0.0449f
C124 a_19436_15960# sg13cmos5l_dfrbpq_1_2.Q 0.19604f
C125 a_16760_16037# a_17030_15996# 0.18796f
C126 sg13cmos5l_dlygate4sd3_1_5.A a_2824_16082# 0.03945f
C127 sg13cmos5l_o21ai_1_2.A1 sg13cmos5l_or3_1_2.X 0.03009f
C128 a_32200_16082# VDD 0.16543f
C129 sg13cmos5l_dlygate4sd3_1_11.X a_7179_14495# 0.01018f
C130 a_21381_14495# a_21370_15202# 0.01088f
C131 a_27503_13799# a_27760_13942# 0.23043f
C132 sg13cmos5l_dfrbpq_1_2.CLK a_16068_14040# 0.04814f
C133 VDD a_3512_16037# 0.25815f
C134 a_1192_3900# sg13cmos5l_buf_1_0.X 0.15884f
C135 VDD a_6184_14570# 0.17524f
C136 sg13cmos5l_o21ai_1_2.B1 sg13cmos5l_or3_1_1.X 0.02614f
C137 sg13cmos5l_dfrbpq_1_6.RESET_B sg13cmos5l_inv_1_0.Y 0.02659f
C138 sg13cmos5l_dfrbpq_1_3.RESET_B sg13cmos5l_inv_1_0.Y 0.03922f
C139 sg13cmos5l_a21oi_1_1.Y a_21929_16334# 0.01284f
C140 a_26842_15202# VDD 0.26046f
C141 a_26052_14488# a_26469_14495# 0.28418f
C142 sg13cmos5l_nor2_1_0.Y sg13cmos5l_nor2_1_0.B 0.11428f
C143 a_3082_15457# sg13cmos5l_xnor2_1_0.Y 0.02568f
C144 a_8870_15238# VDD 0.20514f
C145 sg13cmos5l_or3_1_2.A VDD 0.43504f
C146 a_18106_15960# sg13cmos5l_dlygate4sd3_1_7.A 0.30305f
C147 a_19049_16334# counter_value_o[3] 0.03907f
C148 sg13cmos5l_o21ai_1_1.Y sg13cmos5l_or3_1_2.A 0.16612f
C149 sg13cmos5l_dlygate4sd3_1_5.A sg13cmos5l_dfrbpq_1_1.RESET_B 0.71675f
C150 a_8096_13854# sg13cmos5l_xor2_1_1.A 0.0167f
C151 sg13cmos5l_a21oi_1_0.A1 VDD 0.18973f
C152 a_26052_14488# a_27311_14845# 0.01412f
C153 sg13cmos5l_dlygate4sd3_1_8.X a_19546_15202# 0.02404f
C154 VDD a_24502_13718# 0.01062f
C155 sg13cmos5l_o21ai_1_2.A1 sg13cmos5l_or3_1_2.A 0.10163f
C156 sg13cmos5l_dfrbpq_1_3.RESET_B a_18027_14495# 0.2802f
C157 sg13cmos5l_a21oi_1_2.Y a_25496_16037# 0.28821f
C158 sg13cmos5l_xnor2_1_0.A sg13cmos5l_nand4_1_0.Y 0.13952f
C159 sg13cmos5l_dlygate4sd3_1_11.A VDD 0.79314f
C160 a_9638_14484# VDD 0.20772f
C161 sg13cmos5l_o21ai_1_2.A1 sg13cmos5l_a21oi_1_0.A1 0.14191f
C162 a_7550_15242# sg13cmos5l_xnor2_1_0.A 0.01787f
C163 a_27568_14726# a_27311_14845# 0.23043f
C164 sg13cmos5l_dfrbpq_1_6.Q sg13cmos5l_a21oi_1_2.Y 0.01212f
C165 sg13cmos5l_dfrbpq_1_5.RESET_B a_26441_16334# 0.01808f
C166 sg13cmos5l_dlygate4sd3_1_0.A a_8870_15238# 0.04622f
C167 VDD a_26244_14040# 0.07941f
C168 sg13cmos5l_o21ai_1_2.A1 a_24502_13718# 0.06662f
C169 a_26362_16237# a_26441_16334# 0.08889f
C170 a_9732_15552# sg13cmos5l_dlygate4sd3_1_11.X 0.02596f
C171 sg13cmos5l_dfrbpq_1_0.RESET_B sg13cmos5l_nor2_1_0.B 0.02225f
C172 sg13cmos5l_dfrbpq_1_3.RESET_B sg13cmos5l_xnor2_1_1.A 0.84561f
C173 a_10149_13765# a_10025_13668# 0.08186f
C174 a_20864_16082# VDD 0.06822f
C175 sg13cmos5l_dlygate4sd3_1_6.X sg13cmos5l_dfrbpq_1_2.CLK 0.03264f
C176 sg13cmos5l_o21ai_1_2.A2 sg13cmos5l_o21ai_1_2.Y 0.02117f
C177 sg13cmos5l_inv_1_0.Y a_18027_14495# 0.01124f
C178 counter_value_o[6] a_32492_15960# 0.15504f
C179 a_26746_16237# a_26949_16033# 0.02453f
C180 a_3108_15552# a_3525_15213# 0.28324f
C181 sg13cmos5l_dfrbpq_1_2.Q sg13cmos5l_o21ai_1_2.A2 0.2212f
C182 sg13cmos5l_dfrbpq_1_3.RESET_B a_17508_14488# 0.29091f
C183 sg13cmos5l_dfrbpq_1_6.RESET_B a_21370_15202# 0.01494f
C184 a_4367_15311# a_4273_15311# 0.16704f
C185 sg13cmos5l_buf_16_2.X sg13cmos5l_buf_16_2.A 0.05473f
C186 a_11658_15532# VDD 0.28583f
C187 sg13cmos5l_or3_1_1.X a_25496_16037# 0.03298f
C188 a_26026_14452# VDD 0.09582f
C189 sg13cmos5l_xnor2_1_1.A sg13cmos5l_inv_1_0.Y 0.03219f
C190 a_3525_15213# sg13cmos5l_xnor2_1_0.A 0.01694f
C191 sg13cmos5l_or3_1_3.X a_24265_14508# 0.12635f
C192 sg13cmos5l_xor2_1_1.A VDD 0.70281f
C193 sg13cmos5l_buf_16_2.X sg13cmos5l_o21ai_1_2.Y 0.06549f
C194 sg13cmos5l_or3_1_2.B a_15287_15315# 0.02555f
C195 sg13cmos5l_dfrbpq_1_7.D a_25697_15424# 0.04134f
C196 sg13cmos5l_dfrbpq_1_6.Q sg13cmos5l_or3_1_1.X 0.0237f
C197 a_27112_16082# VDD 0.1205f
C198 a_26571_14495# VDD 0.20535f
C199 sg13cmos5l_dlygate4sd3_1_15.A VDD 0.43248f
C200 a_9736_13854# VDD 0.15262f
C201 a_7354_13690# VDD 0.29152f
C202 sg13cmos5l_dfrbpq_1_2.Q sg13cmos5l_buf_16_2.X 0.06792f
C203 sg13cmos5l_dfrbpq_1_7.D sg13cmos5l_dfrbpq_1_7.Q 0.01245f
C204 sg13cmos5l_dfrbpq_1_6.Q counter_value_o[5] 0.01348f
C205 a_15782_13722# a_16068_14040# 0.26205f
C206 sg13cmos5l_inv_1_0.Y a_17508_14488# 0.03851f
C207 a_26565_16033# VDD 0.06431f
C208 a_2822_15234# VDD 0.54212f
C209 a_4481_14750# sg13cmos5l_buf_1_0.X 0.01108f
C210 sg13cmos5l_buf_16_2.X sg13cmos5l_o21ai_1_3.B1 0.02258f
C211 sg13cmos5l_dlygate4sd3_1_0.A sg13cmos5l_xor2_1_1.A 0.02168f
C212 sg13cmos5l_or3_1_2.B sg13cmos5l_dfrbpq_1_2.D 0.06785f
C213 a_15287_15549# sg13cmos5l_dfrbpq_1_2.RESET_B 0.01474f
C214 counter_value_o[7] a_37484_15960# 0.15504f
C215 a_18767_14845# VDD 0.17826f
C216 a_6374_14922# a_7077_14495# 0.02431f
C217 sg13cmos5l_dfrbpq_1_5.RESET_B sg13cmos5l_buf_16_2.X 0.12863f
C218 a_17508_14488# a_18027_14495# 0.20754f
C219 a_21929_16334# counter_value_o[4] 0.01305f
C220 sg13cmos5l_inv_1_0.Y sg13cmos5l_dfrbpq_1_1.D 0.14677f
C221 sg13cmos5l_dlygate4sd3_1_19.X VDD 0.16776f
C222 a_4481_14750# sg13cmos5l_dfrbpq_1_2.CLK 0.01266f
C223 a_26446_15423# sg13cmos5l_dfrbpq_1_5.D 0.10638f
C224 sg13cmos5l_o21ai_1_2.B1 sg13cmos5l_o21ai_1_3.A2 0.0321f
C225 a_20938_14452# a_21381_14495# 0.02241f
C226 sg13cmos5l_o21ai_1_2.A1 a_18767_14845# 0.02197f
C227 sg13cmos5l_dlygate4sd3_1_6.X sg13cmos5l_inv_1_0.Y 0.0183f
C228 sg13cmos5l_dlygate4sd3_1_5.A VDD 1.33557f
C229 a_20280_14464# VDD 0.01867f
C230 sg13cmos5l_buf_16_2.X a_19024_14726# 0.01003f
C231 sg13cmos5l_dlygate4sd3_1_11.X VDD 0.36865f
C232 sg13cmos5l_o21ai_1_1.Y a_20280_14464# 0.01087f
C233 sg13cmos5l_o21ai_1_2.A1 sg13cmos5l_dlygate4sd3_1_19.X 0.01268f
C234 a_7358_12972# VDD 0.01074f
C235 a_20964_14488# a_22223_14845# 0.01412f
C236 a_6958_13911# sg13cmos5l_dlygate4sd3_1_1.X 0.10678f
C237 a_16587_13844# VDD 0.21282f
C238 sg13cmos5l_nor2_1_0.B sg13cmos5l_buf_1_0.X 0.01998f
C239 sg13cmos5l_buf_1_0.X a_7179_14495# 0.02565f
C240 sg13cmos5l_nor2_1_0.Y VDD 0.33763f
C241 a_16587_13844# a_17327_13799# 0.17382f
C242 sg13cmos5l_dlygate4sd3_1_18.X VDD 0.27276f
C243 sg13cmos5l_a21oi_1_0.A1 sg13cmos5l_dfrbpq_1_2.RESET_B 0.01692f
C244 sg13cmos5l_or3_1_2.B sg13cmos5l_buf_16_2.A 0.10859f
C245 a_22480_14726# a_22890_14484# 0.07015f
C246 a_38536_13058# VDD 0.13374f
C247 sg13cmos5l_dlygate4sd3_1_1.X sg13cmos5l_xnor2_1_0.A 0.01961f
C248 sg13cmos5l_dlygate4sd3_1_8.X sg13cmos5l_xnor2_1_1.A 0.11805f
C249 a_18610_16374# counter_value_o[3] 0.01401f
C250 sg13cmos5l_dlygate4sd3_1_5.A sg13cmos5l_dlygate4sd3_1_0.A 0.14969f
C251 sg13cmos5l_dlygate4sd3_1_5.A a_6296_15238# 0.30694f
C252 sg13cmos5l_o21ai_1_3.A2 a_25121_14750# 0.0215f
C253 sg13cmos5l_dlygate4sd3_1_0.A sg13cmos5l_dlygate4sd3_1_11.X 0.02357f
C254 a_17482_14452# a_17925_14495# 0.02241f
C255 sg13cmos5l_dfrbpq_1_2.CLK sg13cmos5l_nor2_1_0.B 0.14191f
C256 sg13cmos5l_dfrbpq_1_2.CLK a_7179_14495# 0.02524f
C257 a_38720_3986# VDD 0.0582f
C258 sg13cmos5l_buf_16_2.A a_15790_15238# 1.05269f
C259 sg13cmos5l_dfrbpq_1_2.Q sg13cmos5l_or3_1_2.C 0.25937f
C260 sg13cmos5l_or3_1_3.X VDD 0.19324f
C261 a_25766_15996# a_25496_16037# 0.18796f
C262 a_3095_16071# a_3095_16301# 0.08186f
C263 a_8870_15238# a_8982_15302# 0.3854f
C264 clock_i a_3512_16037# 0.01948f
C265 a_7179_14495# a_7919_14845# 0.17382f
C266 sg13cmos5l_dfrbpq_1_2.Q sg13cmos5l_or3_1_2.B 0.01437f
C267 sg13cmos5l_a21oi_1_0.Y sg13cmos5l_inv_1_0.Y 0.14436f
C268 sg13cmos5l_a21oi_1_0.A1 sg13cmos5l_a21oi_1_0.A2 0.19597f
C269 a_17925_14495# sg13cmos5l_buf_16_2.X 0.2043f
C270 sg13cmos5l_dfrbpq_1_0.RESET_B VDD 1.13398f
C271 a_6568_13854# VDD 0.13953f
C272 a_9750_14508# sg13cmos5l_tiehi_0.L_HI 0.05932f
C273 a_25766_14922# sg13cmos5l_dfrbpq_1_5.D 0.01996f
C274 sg13cmos5l_dfrbpq_1_1.RESET_B sg13cmos5l_dfrbpq_1_2.CLK 0.03043f
C275 sg13cmos5l_or3_1_2.X sg13cmos5l_dfrbpq_1_3.Q 0.17637f
C276 a_21865_13726# a_22061_14020# 0.01485f
C277 a_7985_15288# sg13cmos5l_xor2_1_0.X 0.17338f
C278 sg13cmos5l_dfrbpq_1_1.RESET_B a_7919_14845# 0.10879f
C279 sg13cmos5l_a21oi_1_0.A1 clock_i 0.03361f
C280 a_18582_15302# sg13cmos5l_buf_16_2.A 0.01329f
C281 sg13cmos5l_nor2_1_3.B a_16140_14750# 0.14915f
C282 sg13cmos5l_dfrbpq_1_6.RESET_B a_20938_14452# 0.17304f
C283 a_26469_14495# a_26561_15424# 0.01281f
C284 a_17825_16262# sg13cmos5l_dlygate4sd3_1_10.X 0.01204f
C285 a_16163_16265# a_16760_16037# 0.04211f
C286 a_25129_13726# a_25223_14020# 0.02103f
C287 sg13cmos5l_dfrbpq_1_6.Q sg13cmos5l_o21ai_1_3.A2 0.10568f
C288 sg13cmos5l_dlygate4sd3_1_11.A clock_i 0.17286f
C289 sg13cmos5l_dfrbpq_1_7.D a_25582_15423# 0.03849f
C290 sg13cmos5l_dfrbpq_1_3.RESET_B sg13cmos5l_dlygate4sd3_1_10.X 0.07865f
C291 a_10149_15213# sg13cmos5l_tiehi_0.L_HI 0.0353f
C292 a_9732_15552# sg13cmos5l_dfrbpq_1_2.CLK 0.08235f
C293 sg13cmos5l_dfrbpq_1_6.RESET_B a_22480_14726# 0.09622f
C294 sg13cmos5l_a21oi_1_2.Y a_24821_15532# 0.09955f
C295 a_4273_15311# a_3108_15552# 0.25046f
C296 sg13cmos5l_o21ai_1_2.B1 sg13cmos5l_o21ai_1_2.Y 0.54791f
C297 a_17142_16020# VDD 0.15913f
C298 sg13cmos5l_xor2_1_1.B VDD 0.54986f
C299 sg13cmos5l_dfrbpq_1_7.D sg13cmos5l_or3_1_1.X 0.51125f
C300 a_3029_14854# sg13cmos5l_xnor2_1_0.A 0.02572f
C301 a_25958_13722# a_26763_13844# 0.07916f
C302 a_26244_14040# a_26661_13701# 0.28324f
C303 sg13cmos5l_a21oi_1_2.Y a_25288_15366# 0.01132f
C304 a_4273_15311# sg13cmos5l_xnor2_1_0.A 0.02284f
C305 sg13cmos5l_nand4_1_0.Y sg13cmos5l_xor2_1_0.X 0.01471f
C306 sg13cmos5l_dlygate4sd3_1_5.A a_4367_15311# 0.04104f
C307 sg13cmos5l_dfrbpq_1_7.Q sg13cmos5l_dlygate4sd3_1_15.A 0.02434f
C308 sg13cmos5l_or3_1_2.B a_16485_13701# 0.01817f
C309 a_6660_14488# a_6948_14909# 0.24435f
C310 sg13cmos5l_inv_1_0.Y sg13cmos5l_nor2_1_0.B 0.10378f
C311 sg13cmos5l_inv_1_0.Y a_7179_14495# 0.01181f
C312 a_7916_15960# counter_value_o[1] 0.15509f
C313 a_27310_15423# sg13cmos5l_dlygate4sd3_1_15.A 0.02224f
C314 a_25582_15423# a_25288_15366# 0.01555f
C315 a_15208_15996# sg13cmos5l_inv_1_0.Y 0.02075f
C316 sg13cmos5l_dfrbpq_1_7.RESET_B a_26446_15423# 0.04894f
C317 a_14549_15238# VDD 0.47777f
C318 a_25402_14448# a_25766_14922# 0.01503f
C319 sg13cmos5l_o21ai_1_2.Y a_25121_14750# 0.05036f
C320 a_23752_15366# VDD 0.16918f
C321 a_9732_15552# a_10251_15356# 0.20773f
C322 counter_value_o[6] a_32200_16082# 0.02116f
C323 a_12212_15202# sg13cmos5l_dlygate4sd3_1_11.A 0.02261f
C324 sg13cmos5l_dfrbpq_1_5.RESET_B sg13cmos5l_o21ai_1_2.B1 0.0364f
C325 sg13cmos5l_nand4_1_0.Y sg13cmos5l_buf_16_2.A 0.16519f
C326 sg13cmos5l_inv_1_0.Y sg13cmos5l_nor2_1_1.Y 0.08799f
C327 sg13cmos5l_inv_1_0.Y a_9368_14525# 0.01906f
C328 sg13cmos5l_inv_1_0.Y sg13cmos5l_dfrbpq_1_1.RESET_B 0.05793f
C329 a_15486_15486# VDD 0.09802f
C330 a_9732_15552# a_10991_15311# 0.01412f
C331 a_16587_13844# sg13cmos5l_dfrbpq_1_2.RESET_B 0.28334f
C332 sg13cmos5l_or3_1_1.X a_25288_15366# 0.01048f
C333 sg13cmos5l_xnor2_1_1.A sg13cmos5l_dlygate4sd3_1_10.X 1.42025f
C334 VDD sg13cmos5l_dfrbpq_1_5.D 0.33423f
C335 sg13cmos5l_dfrbpq_1_3.RESET_B a_18970_16237# 0.0423f
C336 VDD a_24704_15366# 0.06494f
C337 VDD sg13cmos5l_buf_1_0.X 4.62689f
C338 sg13cmos5l_dfrbpq_1_7.Q sg13cmos5l_dlygate4sd3_1_19.X 0.01354f
C339 a_11248_15454# sg13cmos5l_nand4_1_0.Y 0.01016f
C340 sg13cmos5l_dfrbpq_1_6.D sg13cmos5l_dfrbpq_1_6.RESET_B 0.54621f
C341 a_21381_14495# VDD 0.25468f
C342 sg13cmos5l_dfrbpq_1_0.RESET_B a_4367_15311# 0.10868f
C343 a_18970_16237# a_19173_16033# 0.02453f
C344 a_2540_15960# a_2824_16082# 0.01225f
C345 a_7448_15242# sg13cmos5l_xor2_1_1.A 0.01342f
C346 a_19546_15202# VDD 0.27797f
C347 sg13cmos5l_dfrbpq_1_5.RESET_B a_26763_13844# 0.29586f
C348 VDD a_3123_14484# 0.01309f
C349 a_25080_12952# sg13cmos5l_o21ai_1_3.Y 0.01087f
C350 a_15496_14570# VDD 0.17232f
C351 a_22890_14484# VDD 0.29788f
C352 sg13cmos5l_dlygate4sd3_1_11.X a_8982_15302# 0.01155f
C353 a_26026_14452# a_26052_14488# 0.24169f
C354 sg13cmos5l_dfrbpq_1_2.CLK VDD 2.35211f
C355 sg13cmos5l_a21oi_1_0.Y a_15809_16344# 0.01012f
C356 sg13cmos5l_dlygate4sd3_1_5.A clock_i 0.17304f
C357 sg13cmos5l_buf_16_2.X a_20964_14488# 0.08885f
C358 a_27503_13799# a_27409_13799# 0.16704f
C359 sg13cmos5l_dlygate4sd3_1_0.A sg13cmos5l_buf_1_0.X 0.13774f
C360 sg13cmos5l_dlygate4sd3_1_5.A a_5408_15366# 0.01695f
C361 VDD a_7919_14845# 0.17959f
C362 VDD a_3294_15934# 0.09594f
C363 a_6634_14452# sg13cmos5l_dlygate4sd3_1_1.X 0.02513f
C364 sg13cmos5l_dfrbpq_1_1.RESET_B a_6566_15238# 0.05363f
C365 sg13cmos5l_dfrbpq_1_6.D sg13cmos5l_inv_1_0.Y 0.06215f
C366 sg13cmos5l_buf_16_2.X sg13cmos5l_o21ai_1_3.Y 0.08182f
C367 sg13cmos5l_dfrbpq_1_7.RESET_B a_25766_14922# 0.10598f
C368 sg13cmos5l_dfrbpq_1_2.Q sg13cmos5l_dfrbpq_1_6.Q 0.22799f
C369 a_26052_14488# a_26571_14495# 0.20754f
C370 a_26469_14495# a_26340_14909# 0.01562f
C371 sg13cmos5l_dlygate4sd3_1_8.X a_19150_15423# 0.0675f
C372 sg13cmos5l_o21ai_1_2.A1 sg13cmos5l_dfrbpq_1_2.CLK 0.06334f
C373 a_8156_15532# VDD 0.13917f
C374 sg13cmos5l_dlygate4sd3_1_8.X sg13cmos5l_dlygate4sd3_1_10.X 0.19405f
C375 sg13cmos5l_buf_16_2.X a_22223_14845# 0.01618f
C376 a_18106_15960# counter_value_o[3] 0.01164f
C377 sg13cmos5l_dfrbpq_1_7.Q sg13cmos5l_or3_1_3.X 0.03494f
C378 a_27112_16082# a_27296_16082# 0.05762f
C379 a_8302_13911# sg13cmos5l_xor2_1_1.A 0.10833f
C380 a_12524_15960# VDD 0.22871f
C381 a_10318_14751# VDD 0.16128f
C382 sg13cmos5l_dfrbpq_1_5.RESET_B a_26469_14495# 0.02875f
C383 a_26571_14495# a_27568_14726# 0.03546f
C384 a_25766_15996# sg13cmos5l_dfrbpq_1_7.D 0.03622f
C385 sg13cmos5l_dlygate4sd3_1_0.A sg13cmos5l_dfrbpq_1_2.CLK 0.04022f
C386 VDD a_25768_13854# 0.14947f
C387 sg13cmos5l_a21oi_1_2.Y sg13cmos5l_dlygate4sd3_1_15.A 0.14023f
C388 a_9946_13943# a_10025_13668# 0.08889f
C389 sg13cmos5l_dfrbpq_1_5.RESET_B sg13cmos5l_dfrbpq_1_6.Q 0.02559f
C390 sg13cmos5l_dlygate4sd3_1_6.X a_9706_15457# 0.08167f
C391 sg13cmos5l_xor2_1_1.A sg13cmos5l_xnor2_1_0.A 0.20704f
C392 a_18970_16237# sg13cmos5l_xnor2_1_1.A 0.04298f
C393 a_10251_15356# VDD 0.21065f
C394 a_25402_14448# VDD 0.2909f
C395 a_16042_13945# a_15782_13722# 0.45119f
C396 a_17825_16262# VDD 0.20566f
C397 sg13cmos5l_dfrbpq_1_1.RESET_B sg13cmos5l_dfrbpq_1_1.D 0.12023f
C398 sg13cmos5l_dfrbpq_1_6.RESET_B VDD 1.18309f
C399 a_2822_15234# a_3108_15552# 0.26205f
C400 a_26565_16033# a_26746_16237# 0.04141f
C401 sg13cmos5l_dfrbpq_1_3.RESET_B VDD 1.2596f
C402 sg13cmos5l_dfrbpq_1_6.RESET_B sg13cmos5l_o21ai_1_1.Y 0.06289f
C403 sg13cmos5l_dfrbpq_1_3.RESET_B a_17327_13799# 0.01611f
C404 a_10991_15311# VDD 0.18638f
C405 a_19173_16033# VDD 0.06703f
C406 a_2822_15234# sg13cmos5l_xnor2_1_0.A 0.01266f
C407 sg13cmos5l_xor2_1_0.B VDD 0.6914f
C408 sg13cmos5l_dfrbpq_1_6.RESET_B sg13cmos5l_o21ai_1_2.A1 0.0199f
C409 a_2880_14523# a_3029_14854# 0.19075f
C410 sg13cmos5l_dfrbpq_1_3.RESET_B sg13cmos5l_o21ai_1_2.A1 0.0733f
C411 sg13cmos5l_a21oi_1_2.Y sg13cmos5l_dlygate4sd3_1_19.X 0.07148f
C412 sg13cmos5l_dfrbpq_1_6.RESET_B a_19534_13726# 0.04468f
C413 VDD a_24600_14040# 0.01858f
C414 sg13cmos5l_dlygate4sd3_1_10.X sg13cmos5l_a21oi_1_0.Y 0.02311f
C415 a_27022_13239# sg13cmos5l_o21ai_1_3.B1 0.12543f
C416 sg13cmos5l_or3_1_1.X sg13cmos5l_dlygate4sd3_1_15.A 0.04573f
C417 a_18767_14845# a_19434_14484# 0.09257f
C418 a_26825_16334# VDD 0.07454f
C419 a_21466_15960# sg13cmos5l_dfrbpq_1_6.RESET_B 0.04492f
C420 a_8698_13690# VDD 0.30077f
C421 sg13cmos5l_inv_1_0.Y VDD 2.61272f
C422 a_6752_13854# VDD 0.0682f
C423 sg13cmos5l_dlygate4sd3_1_5.A a_3108_15552# 0.01959f
C424 sg13cmos5l_dlygate4sd3_1_13.X a_20974_15423# 0.10667f
C425 sg13cmos5l_dlygate4sd3_1_1.A a_6932_12972# 0.0653f
C426 sg13cmos5l_inv_1_0.Y sg13cmos5l_o21ai_1_1.Y 0.69296f
C427 a_16042_13945# a_16068_14040# 0.24169f
C428 sg13cmos5l_dlygate4sd3_1_6.X a_9732_15552# 0.07885f
C429 a_4366_14751# sg13cmos5l_buf_1_0.X 0.01096f
C430 a_17710_16263# sg13cmos5l_a21oi_1_0.A1 0.11767f
C431 sg13cmos5l_dlygate4sd3_1_18.X sg13cmos5l_a21oi_1_2.Y 0.3472f
C432 sg13cmos5l_xor2_1_1.B clock_i 0.01896f
C433 sg13cmos5l_dlygate4sd3_1_0.A sg13cmos5l_xor2_1_0.B 0.15836f
C434 a_15782_13722# VDD 0.5299f
C435 sg13cmos5l_o21ai_1_2.A1 sg13cmos5l_inv_1_0.Y 0.10208f
C436 sg13cmos5l_dlygate4sd3_1_5.A sg13cmos5l_xnor2_1_0.A 1.57027f
C437 a_15287_15315# a_15287_15549# 0.08186f
C438 a_15486_15486# sg13cmos5l_dfrbpq_1_2.RESET_B 0.04697f
C439 sg13cmos5l_dlygate4sd3_1_11.X sg13cmos5l_xnor2_1_0.A 0.17547f
C440 a_18027_14495# VDD 0.20633f
C441 sg13cmos5l_inv_1_0.Y a_17796_14909# 0.01178f
C442 sg13cmos5l_dfrbpq_1_7.RESET_B VDD 1.125f
C443 a_3627_15356# a_4624_15454# 0.03412f
C444 sg13cmos5l_a21oi_1_0.A1 counter_value_o[3] 0.20911f
C445 a_8698_13690# sg13cmos5l_dlygate4sd3_1_0.A 0.29301f
C446 sg13cmos5l_nor2_1_0.Y sg13cmos5l_xnor2_1_0.A 0.17954f
C447 sg13cmos5l_inv_1_0.Y sg13cmos5l_dlygate4sd3_1_0.A 0.04334f
C448 sg13cmos5l_dlygate4sd3_1_18.X a_25582_15423# 0.10655f
C449 a_20678_14922# a_21381_14495# 0.02431f
C450 sg13cmos5l_o21ai_1_2.A1 a_18027_14495# 0.01723f
C451 a_26532_13735# a_26763_13844# 0.07823f
C452 a_27409_13799# a_26244_14040# 0.25046f
C453 a_26842_15202# a_26561_15424# 0.18796f
C454 a_2540_15960# VDD 0.19812f
C455 a_3029_14854# sg13cmos5l_xnor2_1_0.Y 0.03453f
C456 a_6374_14922# a_6948_14909# 0.18486f
C457 a_17796_14909# a_18027_14495# 0.07823f
C458 a_17925_14495# a_18673_14845# 0.01058f
C459 sg13cmos5l_xnor2_1_1.A VDD 0.83876f
C460 sg13cmos5l_dlygate4sd3_1_1.X a_6660_14488# 0.04479f
C461 a_6566_15238# VDD 0.20513f
C462 sg13cmos5l_dlygate4sd3_1_13.X sg13cmos5l_or3_1_2.X 0.16869f
C463 a_20964_14488# a_21483_14495# 0.20754f
C464 a_21381_14495# a_21252_14909# 0.01562f
C465 a_25978_15202# sg13cmos5l_o21ai_1_3.Y 0.30857f
C466 sg13cmos5l_dfrbpq_1_2.CLK sg13cmos5l_dfrbpq_1_2.RESET_B 0.08166f
C467 sg13cmos5l_dlygate4sd3_1_10.X a_19150_15423# 0.10744f
C468 a_16068_14040# VDD 0.07714f
C469 sg13cmos5l_dfrbpq_1_0.RESET_B a_3108_15552# 0.27827f
C470 a_2536_15366# VDD 0.14127f
C471 a_22129_14845# sg13cmos5l_or3_1_2.X 0.01465f
C472 sg13cmos5l_dlygate4sd3_1_18.X sg13cmos5l_or3_1_1.X 0.26847f
C473 sg13cmos5l_dfrbpq_1_3.RESET_B sg13cmos5l_dlygate4sd3_1_7.A 0.01617f
C474 sg13cmos5l_o21ai_1_2.B1 a_24520_15366# 0.01089f
C475 a_16068_14040# a_17327_13799# 0.01412f
C476 sg13cmos5l_xnor2_1_1.A sg13cmos5l_o21ai_1_2.A1 0.73587f
C477 clock_i a_15486_15486# 0.02101f
C478 sg13cmos5l_dfrbpq_1_7.D sg13cmos5l_o21ai_1_2.Y 0.0485f
C479 a_6752_13058# sg13cmos5l_dlygate4sd3_1_1.A 0.01484f
C480 a_21483_14495# a_22223_14845# 0.17382f
C481 a_26816_13058# VDD 0.0842f
C482 sg13cmos5l_dfrbpq_1_0.RESET_B sg13cmos5l_xnor2_1_0.A 0.03923f
C483 a_17994_14020# VDD 0.28451f
C484 a_27022_13239# a_27137_13238# 0.3854f
C485 a_17508_14488# VDD 0.07212f
C486 clock_i sg13cmos5l_buf_1_0.X 0.06023f
C487 a_21370_15202# VDD 0.26456f
C488 a_7077_14495# a_6948_14909# 0.01562f
C489 sg13cmos5l_o21ai_1_2.B1 sg13cmos5l_o21ai_1_3.Y 0.02129f
C490 a_17327_13799# a_17994_14020# 0.09257f
C491 a_16485_13701# a_17233_13799# 0.01058f
C492 a_21370_15202# sg13cmos5l_o21ai_1_1.Y 0.28823f
C493 a_6296_15238# a_6566_15238# 0.18796f
C494 sg13cmos5l_dfrbpq_1_3.Q a_23752_15366# 0.02042f
C495 sg13cmos5l_buf_16_2.X sg13cmos5l_o21ai_1_2.A2 0.02378f
C496 a_1192_3900# VDD 0.18614f
C497 a_38536_13058# a_38720_13058# 0.05762f
C498 a_22129_14845# sg13cmos5l_or3_1_2.A 0.016f
C499 sg13cmos5l_o21ai_1_2.A1 a_17508_14488# 0.04612f
C500 sg13cmos5l_nor2_1_1.B sg13cmos5l_tiehi_0.L_HI 0.02941f
C501 sg13cmos5l_xnor2_1_0.Y a_3512_16037# 0.28629f
C502 a_3095_16301# a_3008_16082# 0.03131f
C503 sg13cmos5l_dlygate4sd3_1_8.X VDD 0.48874f
C504 a_10149_15213# a_10897_15311# 0.01058f
C505 sg13cmos5l_dlygate4sd3_1_11.A counter_value_o[2] 0.01151f
C506 a_27503_13799# sg13cmos5l_dfrbpq_1_5.RESET_B 0.10868f
C507 sg13cmos5l_dlygate4sd3_1_1.X a_6678_15302# 0.06645f
C508 a_17508_14488# a_17796_14909# 0.24435f
C509 sg13cmos5l_dfrbpq_1_1.D VDD 0.23404f
C510 clock_i sg13cmos5l_dfrbpq_1_2.CLK 0.01481f
C511 a_25766_15996# sg13cmos5l_dlygate4sd3_1_15.A 0.01393f
C512 sg13cmos5l_xor2_1_1.B a_6958_13911# 0.05791f
C513 sg13cmos5l_dfrbpq_1_2.Q a_17222_14922# 0.01689f
C514 sg13cmos5l_dlygate4sd3_1_8.X sg13cmos5l_o21ai_1_2.A1 0.0346f
C515 sg13cmos5l_dlygate4sd3_1_6.X VDD 0.26818f
C516 sg13cmos5l_dfrbpq_1_1.RESET_B a_7179_14495# 0.27969f
C517 sg13cmos5l_dfrbpq_1_3.D a_15790_15238# 0.04007f
C518 sg13cmos5l_dfrbpq_1_7.D a_26362_16237# 0.03783f
C519 a_7136_15366# sg13cmos5l_buf_1_0.X 0.02966f
C520 sg13cmos5l_dfrbpq_1_6.RESET_B a_20678_14922# 0.07912f
C521 a_6906_12935# VDD 0.185f
C522 sg13cmos5l_xor2_1_1.B sg13cmos5l_xnor2_1_0.A 0.01949f
C523 a_19546_15202# sg13cmos5l_dfrbpq_1_3.Q 0.30964f
C524 sg13cmos5l_dfrbpq_1_6.Q a_22330_15202# 0.28298f
C525 a_12524_15960# clock_i 0.01173f
C526 a_9368_14525# sg13cmos5l_nor2_1_1.Y 0.31288f
C527 a_6296_15238# sg13cmos5l_dfrbpq_1_1.D 0.04627f
C528 a_9446_15234# sg13cmos5l_tiehi_0.L_HI 0.07601f
C529 a_9732_15552# a_9706_15457# 0.24169f
C530 sg13cmos5l_inv_1_0.Y a_5694_15486# 0.02744f
C531 a_26052_14488# sg13cmos5l_dfrbpq_1_5.D 0.0627f
C532 sg13cmos5l_dfrbpq_1_2.Q sg13cmos5l_or3_1_2.X 0.416f
C533 sg13cmos5l_dfrbpq_1_2.Q a_18080_15366# 0.03907f
C534 sg13cmos5l_xnor2_1_1.A sg13cmos5l_dlygate4sd3_1_7.A 0.02232f
C535 a_18970_16237# sg13cmos5l_dlygate4sd3_1_10.X 0.01247f
C536 sg13cmos5l_nand4_1_0.Y sg13cmos5l_tiehi_0.L_HI 0.01371f
C537 a_9098_14484# sg13cmos5l_nor2_1_1.Y 0.01356f
C538 a_3396_15247# a_3108_15552# 0.24435f
C539 a_10714_14448# sg13cmos5l_dlygate4sd3_1_11.A 0.28818f
C540 a_10318_14751# a_10433_14750# 0.3854f
C541 sg13cmos5l_inv_1_0.Y sg13cmos5l_dfrbpq_1_2.RESET_B 0.16371f
C542 a_25958_13722# a_26244_14040# 0.26205f
C543 a_3396_15247# sg13cmos5l_xnor2_1_0.A 0.01075f
C544 a_15707_15996# sg13cmos5l_a21oi_1_0.A1 0.02996f
C545 sg13cmos5l_a21oi_1_0.Y VDD 0.15629f
C546 a_12212_15202# sg13cmos5l_dfrbpq_1_2.CLK 1.06405f
C547 sg13cmos5l_o21ai_1_2.Y a_24502_13718# 0.06016f
C548 a_15782_13722# sg13cmos5l_dfrbpq_1_2.RESET_B 0.10318f
C549 sg13cmos5l_dfrbpq_1_2.Q sg13cmos5l_or3_1_2.A 0.04186f
C550 sg13cmos5l_dfrbpq_1_6.Q sg13cmos5l_o21ai_1_3.Y 0.01365f
C551 sg13cmos5l_o21ai_1_3.A2 sg13cmos5l_dlygate4sd3_1_19.X 0.01148f
C552 sg13cmos5l_dfrbpq_1_6.Q a_22223_14845# 0.0121f
C553 sg13cmos5l_inv_1_0.Y sg13cmos5l_dfrbpq_1_7.Q 0.04493f
C554 sg13cmos5l_xor2_1_0.B clock_i 0.05344f
C555 sg13cmos5l_a21oi_1_0.Y sg13cmos5l_o21ai_1_2.A1 0.80604f
C556 a_20680_16082# a_20864_16082# 0.05762f
C557 a_27706_15202# VDD 0.2905f
C558 sg13cmos5l_xnor2_1_0.A sg13cmos5l_buf_1_0.X 0.32986f
C559 a_10025_13668# sg13cmos5l_tiehi_0.L_HI 0.01098f
C560 a_5034_15532# VDD 0.27978f
C561 a_25006_14751# a_25121_14750# 0.3854f
C562 a_22049_15424# VDD 0.21129f
C563 a_9446_15234# a_10149_15213# 0.02453f
C564 sg13cmos5l_or3_1_2.B a_17584_13942# 0.01425f
C565 a_2880_14523# sg13cmos5l_nor2_1_0.Y 0.02001f
C566 sg13cmos5l_dfrbpq_1_5.RESET_B a_26842_15202# 0.03038f
C567 a_6660_14488# a_7825_14845# 0.25046f
C568 sg13cmos5l_dfrbpq_1_2.CLK a_3108_15552# 0.06411f
C569 a_3627_15356# a_3525_15213# 0.36168f
C570 sg13cmos5l_dfrbpq_1_6.RESET_B sg13cmos5l_dfrbpq_1_3.Q 0.12389f
C571 sg13cmos5l_inv_1_0.Y clock_i 0.18074f
C572 a_21185_16262# sg13cmos5l_dfrbpq_1_6.RESET_B 0.02115f
C573 sg13cmos5l_xnor2_1_1.A sg13cmos5l_dfrbpq_1_2.RESET_B 0.1828f
C574 sg13cmos5l_or3_1_2.C a_21865_13726# 0.16506f
C575 sg13cmos5l_dlygate4sd3_1_19.X a_24915_15260# 0.01158f
C576 a_4481_14750# VDD 0.21181f
C577 sg13cmos5l_buf_16_2.X sg13cmos5l_or3_1_2.C 0.11186f
C578 a_10149_15213# sg13cmos5l_nand4_1_0.Y 0.01599f
C579 sg13cmos5l_dfrbpq_1_7.RESET_B sg13cmos5l_dfrbpq_1_7.Q 0.02108f
C580 a_18200_15238# VDD 0.27928f
C581 a_2822_15234# sg13cmos5l_xnor2_1_0.Y 0.03943f
C582 sg13cmos5l_or3_1_2.B a_21865_13726# 0.16762f
C583 a_17925_14495# a_17222_14922# 0.02431f
C584 sg13cmos5l_or3_1_2.B sg13cmos5l_buf_16_2.X 0.10412f
C585 sg13cmos5l_or3_1_1.X sg13cmos5l_dfrbpq_1_5.D 0.04336f
C586 a_16068_14040# sg13cmos5l_dfrbpq_1_2.RESET_B 0.27036f
C587 sg13cmos5l_dfrbpq_1_2.CLK sg13cmos5l_xnor2_1_0.A 0.14514f
C588 a_28170_14020# sg13cmos5l_dlygate4sd3_1_20.A 0.0916f
C589 sg13cmos5l_inv_1_0.Y a_10433_14750# 0.01795f
C590 sg13cmos5l_o21ai_1_2.A1 a_18200_15238# 0.01458f
C591 a_20938_14452# VDD 0.09499f
C592 a_24359_14508# a_24265_14508# 0.02103f
C593 sg13cmos5l_buf_1_10.X a_2536_13058# 0.03073f
C594 sg13cmos5l_dfrbpq_1_5.RESET_B a_26244_14040# 0.28612f
C595 VDD a_26446_15423# 0.1597f
C596 a_19150_15423# VDD 0.16007f
C597 sg13cmos5l_xnor2_1_1.A sg13cmos5l_a21oi_1_0.A2 0.01929f
C598 sg13cmos5l_dlygate4sd3_1_10.X VDD 0.38249f
C599 sg13cmos5l_inv_1_0.Y sg13cmos5l_dfrbpq_1_3.Q 0.05916f
C600 sg13cmos5l_a21oi_1_1.Y sg13cmos5l_dfrbpq_1_6.RESET_B 0.15755f
C601 a_22480_14726# VDD 0.14174f
C602 a_11248_15454# a_11658_15532# 0.07015f
C603 a_9706_15457# VDD 0.09416f
C604 sg13cmos5l_nor2_1_0.Y a_3626_14484# 0.01431f
C605 sg13cmos5l_dlygate4sd3_1_5.A sg13cmos5l_xnor2_1_0.Y 0.03231f
C606 a_17142_16020# a_17710_16263# 0.01641f
C607 sg13cmos5l_xnor2_1_1.A clock_i 0.04477f
C608 sg13cmos5l_o21ai_1_2.B1 sg13cmos5l_o21ai_1_2.A2 0.37107f
C609 VDD sg13cmos5l_nor2_1_0.B 0.43139f
C610 sg13cmos5l_dlygate4sd3_1_10.X sg13cmos5l_o21ai_1_2.A1 0.37005f
C611 VDD a_2824_16082# 0.12403f
C612 VDD a_7179_14495# 0.20693f
C613 a_6374_14922# sg13cmos5l_dlygate4sd3_1_1.X 0.03248f
C614 a_15208_15996# VDD 0.2397f
C615 sg13cmos5l_dlygate4sd3_1_11.X sg13cmos5l_xor2_1_0.X 0.05573f
C616 sg13cmos5l_nor2_1_0.Y sg13cmos5l_xnor2_1_0.Y 0.05815f
C617 a_15818_14484# sg13cmos5l_dfrbpq_1_2.D 0.01686f
C618 a_8600_15238# VDD 0.26131f
C619 a_18767_14845# sg13cmos5l_buf_16_2.A 0.01963f
C620 sg13cmos5l_buf_16_2.X a_21483_14495# 0.02977f
C621 sg13cmos5l_dlygate4sd3_1_5.A counter_value_o[1] 0.02273f
C622 sg13cmos5l_xor2_1_1.A a_6660_14488# 0.01925f
C623 VDD sg13cmos5l_nor2_1_1.Y 0.27034f
C624 a_7073_13912# sg13cmos5l_xor2_1_1.A 0.03183f
C625 sg13cmos5l_dfrbpq_1_1.RESET_B VDD 1.12066f
C626 a_9368_14525# VDD 0.26062f
C627 sg13cmos5l_a21oi_1_1.Y sg13cmos5l_inv_1_0.Y 0.13382f
C628 a_15208_15996# sg13cmos5l_o21ai_1_2.A1 0.15564f
C629 a_26469_14495# a_27217_14845# 0.01058f
C630 a_26340_14909# a_26571_14495# 0.07823f
C631 sg13cmos5l_or3_1_1.X a_25768_13854# 0.02112f
C632 sg13cmos5l_buf_16_2.X sg13cmos5l_o21ai_1_2.B1 0.16245f
C633 a_24808_16082# sg13cmos5l_dlygate4sd3_1_15.A 0.0113f
C634 sg13cmos5l_dlygate4sd3_1_1.X sg13cmos5l_dlygate4sd3_1_3.X 0.02972f
C635 sg13cmos5l_inv_1_0.Y sg13cmos5l_a21oi_1_2.Y 0.31647f
C636 sg13cmos5l_dlygate4sd3_1_19.X sg13cmos5l_o21ai_1_2.Y 0.06149f
C637 a_9946_13943# a_9736_13854# 0.02249f
C638 sg13cmos5l_dfrbpq_1_5.RESET_B a_26571_14495# 0.05974f
C639 a_7073_13912# a_7354_13690# 0.18796f
C640 a_27311_14845# a_27217_14845# 0.16704f
C641 sg13cmos5l_dfrbpq_1_7.RESET_B a_26052_14488# 0.3036f
C642 sg13cmos5l_dfrbpq_1_5.RESET_B sg13cmos5l_dlygate4sd3_1_15.A 0.10649f
C643 sg13cmos5l_dlygate4sd3_1_0.A a_8600_15238# 0.06478f
C644 a_26746_16237# a_26825_16334# 0.08889f
C645 a_25115_15996# a_25496_16037# 0.02543f
C646 a_6752_13854# a_6958_13911# 0.01604f
C647 sg13cmos5l_or3_1_1.X a_25402_14448# 0.03528f
C648 sg13cmos5l_or3_1_2.B sg13cmos5l_or3_1_2.C 0.12886f
C649 a_3095_16071# sg13cmos5l_dfrbpq_1_0.RESET_B 0.01315f
C650 a_25766_14922# VDD 0.52401f
C651 sg13cmos5l_dlygate4sd3_1_0.A sg13cmos5l_nor2_1_1.Y 0.01836f
C652 a_24265_14508# VDD 0.24905f
C653 a_9732_15552# VDD 0.07297f
C654 sg13cmos5l_dfrbpq_1_0.RESET_B sg13cmos5l_xnor2_1_0.Y 0.3546f
C655 a_22053_16033# a_22216_16082# 0.03352f
C656 sg13cmos5l_dfrbpq_1_1.RESET_B a_6296_15238# 0.0213f
C657 a_6634_14452# sg13cmos5l_xor2_1_1.B 0.03276f
C658 a_22053_16033# VDD 0.06487f
C659 sg13cmos5l_dlygate4sd3_1_6.X a_8982_15302# 0.01966f
C660 sg13cmos5l_dfrbpq_1_7.RESET_B a_27568_14726# 0.09622f
C661 a_26362_16237# a_26565_16033# 0.02453f
C662 sg13cmos5l_inv_1_0.Y sg13cmos5l_xnor2_1_0.A 0.37327f
C663 sg13cmos5l_dlygate4sd3_1_18.X sg13cmos5l_o21ai_1_2.Y 0.01347f
C664 a_4367_15311# a_5034_15532# 0.09257f
C665 a_20864_16082# a_21070_16263# 0.01604f
C666 sg13cmos5l_buf_16_2.X a_26763_13844# 0.04221f
C667 sg13cmos5l_o21ai_1_2.A1 a_24265_14508# 0.17368f
C668 a_18970_16237# VDD 0.09206f
C669 sg13cmos5l_buf_16_2.X a_25121_14750# 0.01001f
C670 sg13cmos5l_dfrbpq_1_6.D VDD 0.31496f
C671 sg13cmos5l_xor2_1_1.A a_6932_12972# 0.01007f
C672 sg13cmos5l_dfrbpq_1_6.D sg13cmos5l_o21ai_1_1.Y 0.08815f
C673 a_23752_15366# sg13cmos5l_o21ai_1_3.A2 0.0188f
C674 sg13cmos5l_dlygate4sd3_1_10.X sg13cmos5l_dlygate4sd3_1_7.A 0.19842f
C675 sg13cmos5l_dlygate4sd3_1_8.X sg13cmos5l_dfrbpq_1_3.Q 0.02766f
C676 a_19024_14726# a_18767_14845# 0.23043f
C677 a_25878_16020# VDD 0.15964f
C678 sg13cmos5l_inv_1_0.Y sg13cmos5l_or3_1_1.X 0.03519f
C679 sg13cmos5l_or3_1_3.X sg13cmos5l_o21ai_1_2.Y 0.02241f
C680 a_4366_14751# a_4481_14750# 0.3854f
C681 a_8096_13854# VDD 0.10312f
C682 sg13cmos5l_dfrbpq_1_6.Q sg13cmos5l_o21ai_1_2.A2 0.02839f
C683 sg13cmos5l_dfrbpq_1_7.D sg13cmos5l_o21ai_1_3.Y 0.32182f
C684 a_14549_15238# a_15287_15315# 0.01732f
C685 a_27978_14484# VDD 0.28589f
C686 a_17030_15996# sg13cmos5l_a21oi_1_0.A1 0.01103f
C687 a_16760_16037# sg13cmos5l_a21oi_1_0.A1 0.01041f
C688 sg13cmos5l_a21oi_1_0.Y sg13cmos5l_a21oi_1_0.A2 0.05261f
C689 a_2880_14523# sg13cmos5l_buf_1_0.X 0.24737f
C690 a_21483_14495# sg13cmos5l_or3_1_2.C 0.02994f
C691 sg13cmos5l_or3_1_2.X a_22330_15202# 0.04076f
C692 a_16042_13945# VDD 0.09634f
C693 sg13cmos5l_buf_16_2.X a_26469_14495# 0.23882f
C694 a_3082_15457# a_3525_15213# 0.02241f
C695 a_15486_15486# a_15287_15315# 0.02453f
C696 a_27500_15960# VDD 0.22382f
C697 sg13cmos5l_a21oi_1_0.Y clock_i 0.01849f
C698 a_27706_15202# sg13cmos5l_dfrbpq_1_7.Q 0.29783f
C699 a_6634_14452# sg13cmos5l_buf_1_0.X 0.01925f
C700 sg13cmos5l_a21oi_1_1.Y sg13cmos5l_dlygate4sd3_1_8.X 0.01568f
C701 a_18470_15238# a_18200_15238# 0.18796f
C702 sg13cmos5l_dfrbpq_1_6.Q sg13cmos5l_buf_16_2.X 0.43053f
C703 a_20678_14922# a_20938_14452# 0.45119f
C704 a_26532_13735# a_26244_14040# 0.24435f
C705 sg13cmos5l_dlygate4sd3_1_5.A a_6678_15302# 0.01077f
C706 a_20964_14488# sg13cmos5l_or3_1_2.X 0.01726f
C707 a_3396_15247# sg13cmos5l_xnor2_1_0.Y 0.01794f
C708 a_5408_15366# a_5034_15532# 0.01702f
C709 a_17825_16262# a_17710_16263# 0.3854f
C710 a_22223_14845# sg13cmos5l_or3_1_2.X 0.04581f
C711 sg13cmos5l_dfrbpq_1_3.RESET_B a_17710_16263# 0.01087f
C712 a_16485_13701# a_16587_13844# 0.36168f
C713 a_22216_16082# VDD 0.13496f
C714 a_2720_15366# sg13cmos5l_nor2_1_0.Y 0.03662f
C715 sg13cmos5l_dfrbpq_1_1.RESET_B a_5694_15486# 0.05445f
C716 a_5495_15549# a_5495_15315# 0.08186f
C717 a_21381_14495# a_22129_14845# 0.01058f
C718 a_27418_12936# VDD 0.2877f
C719 sg13cmos5l_dfrbpq_1_1.D sg13cmos5l_xnor2_1_0.A 0.04564f
C720 sg13cmos5l_o21ai_1_1.Y VDD 0.29683f
C721 a_17327_13799# VDD 0.18786f
C722 sg13cmos5l_xnor2_1_0.Y sg13cmos5l_buf_1_0.X 0.09015f
C723 a_20964_14488# sg13cmos5l_or3_1_2.A 0.05709f
C724 a_20507_15532# VDD 0.16152f
C725 a_17825_16262# counter_value_o[3] 0.01017f
C726 a_16485_13701# a_16356_13735# 0.01562f
C727 sg13cmos5l_dlygate4sd3_1_11.A a_12032_15366# 0.01452f
C728 sg13cmos5l_o21ai_1_2.A1 VDD 2.19402f
C729 a_38536_10034# VDD 0.1399f
C730 sg13cmos5l_buf_16_2.A a_14549_15238# 0.04112f
C731 a_19534_13726# VDD 1.76782f
C732 sg13cmos5l_o21ai_1_2.A1 sg13cmos5l_o21ai_1_1.Y 0.01273f
C733 sg13cmos5l_or3_1_2.B sg13cmos5l_nand4_1_0.Y 0.02528f
C734 a_3894_16020# sg13cmos5l_nor2_1_0.B 0.13345f
C735 a_19173_16033# counter_value_o[3] 0.04355f
C736 a_7077_14495# a_7825_14845# 0.01058f
C737 a_12524_15960# counter_value_o[2] 0.15504f
C738 a_10149_15213# a_10020_15247# 0.01562f
C739 sg13cmos5l_xor2_1_1.B a_6660_14488# 0.01917f
C740 a_25958_13722# sg13cmos5l_dfrbpq_1_5.D 0.17539f
C741 a_7073_13912# sg13cmos5l_xor2_1_1.B 0.04339f
C742 sg13cmos5l_dlygate4sd3_1_0.A VDD 0.92236f
C743 a_6296_15238# VDD 0.25771f
C744 a_21466_15960# VDD 0.26411f
C745 sg13cmos5l_o21ai_1_2.A1 a_19534_13726# 0.02581f
C746 a_3095_16071# a_3294_15934# 0.08889f
C747 a_3294_15934# sg13cmos5l_xnor2_1_0.Y 0.03909f
C748 clock_i sg13cmos5l_nor2_1_0.B 0.01417f
C749 a_7919_14845# a_8586_14484# 0.09257f
C750 sg13cmos5l_dfrbpq_1_2.CLK sg13cmos5l_xor2_1_0.X 0.01798f
C751 sg13cmos5l_dfrbpq_1_3.D a_17222_14922# 0.17355f
C752 a_15208_15996# clock_i 0.01167f
C753 sg13cmos5l_dfrbpq_1_2.Q a_23752_15366# 0.02301f
C754 sg13cmos5l_dlygate4sd3_1_11.A sg13cmos5l_tiehi_0.L_HI 0.02077f
C755 a_9638_14484# sg13cmos5l_tiehi_0.L_HI 0.05822f
C756 a_38536_3986# a_38720_3986# 0.05762f
C757 a_10714_14448# sg13cmos5l_dfrbpq_1_2.CLK 0.01104f
C758 sg13cmos5l_dfrbpq_1_6.Q a_27425_15424# 0.0435f
C759 a_8156_15532# sg13cmos5l_xor2_1_0.X 0.06519f
C760 a_37192_16082# VDD 0.16348f
C761 a_11658_15532# a_12032_15366# 0.01702f
C762 clock_i sg13cmos5l_dfrbpq_1_1.RESET_B 0.03647f
C763 a_19546_15202# sg13cmos5l_buf_16_2.A 0.01898f
C764 sg13cmos5l_inv_1_0.Y a_2880_14523# 0.06988f
C765 sg13cmos5l_dfrbpq_1_6.D a_20678_14922# 0.17579f
C766 sg13cmos5l_inv_1_0.Y sg13cmos5l_o21ai_1_3.A2 0.02185f
C767 sg13cmos5l_dfrbpq_1_2.CLK sg13cmos5l_buf_16_2.A 0.7015f
C768 a_25129_13726# a_25768_13854# 0.01625f
C769 a_12524_15960# a_12232_16082# 0.01635f
C770 a_9446_15234# sg13cmos5l_nor2_1_1.B 0.02784f
C771 a_9750_14508# a_9638_14484# 0.3854f
C772 sg13cmos5l_xor2_1_1.B a_6932_12972# 0.01186f
C773 sg13cmos5l_dfrbpq_1_2.Q a_19546_15202# 0.03685f
C774 a_27760_13942# VDD 0.13745f
C775 a_26218_13945# a_26244_14040# 0.24169f
C776 sg13cmos5l_buf_1_0.X a_6660_14488# 0.0207f
C777 sg13cmos5l_nand4_1_0.Y a_7985_15288# 0.02663f
C778 sg13cmos5l_xnor2_1_1.A counter_value_o[3] 0.05496f
C779 sg13cmos5l_xor2_1_1.A a_7077_14495# 0.04625f
C780 sg13cmos5l_dlygate4sd3_1_7.A VDD 0.29553f
C781 a_11248_15454# sg13cmos5l_dfrbpq_1_2.CLK 0.0111f
C782 a_16042_13945# sg13cmos5l_dfrbpq_1_2.RESET_B 0.20053f
C783 sg13cmos5l_dfrbpq_1_2.Q sg13cmos5l_dfrbpq_1_2.CLK 0.01688f
C784 sg13cmos5l_dfrbpq_1_6.Q a_25978_15202# 0.01183f
C785 sg13cmos5l_dfrbpq_1_5.RESET_B sg13cmos5l_dfrbpq_1_5.D 0.1033f
C786 sg13cmos5l_dfrbpq_1_7.RESET_B a_26561_15424# 0.01672f
C787 a_38632_13854# VDD 0.13882f
C788 a_4481_14750# sg13cmos5l_xnor2_1_0.A 0.01038f
C789 a_10149_15213# sg13cmos5l_dlygate4sd3_1_11.A 0.02575f
C790 sg13cmos5l_inv_1_0.Y sg13cmos5l_dlygate4sd3_1_13.X 0.08305f
C791 a_19904_15366# VDD 0.0835f
C792 sg13cmos5l_xnor2_1_1.A a_16175_14854# 0.02301f
C793 sg13cmos5l_dfrbpq_1_3.D sg13cmos5l_a21oi_1_0.A1 0.10201f
C794 sg13cmos5l_dlygate4sd3_1_7.A sg13cmos5l_o21ai_1_2.A1 0.04023f
C795 sg13cmos5l_inv_1_0.Y sg13cmos5l_dfrbpq_1_2.D 0.08502f
C796 a_27978_14484# sg13cmos5l_dfrbpq_1_7.Q 0.08285f
C797 a_37484_15960# sg13cmos5l_dlygate4sd3_1_20.A 0.19269f
C798 a_9736_13854# sg13cmos5l_tiehi_0.L_HI 0.01198f
C799 sg13cmos5l_dfrbpq_1_2.CLK a_6660_14488# 0.08933f
C800 a_20974_15423# a_21089_15424# 0.3854f
C801 sg13cmos5l_xor2_1_0.B sg13cmos5l_xor2_1_0.X 0.05286f
C802 a_4367_15311# VDD 0.17422f
C803 sg13cmos5l_buf_1_10.X a_1192_9948# 0.15983f
C804 sg13cmos5l_dfrbpq_1_6.Q sg13cmos5l_o21ai_1_2.B1 0.05829f
C805 a_6660_14488# a_7919_14845# 0.01412f
C806 a_21934_15423# a_21728_15366# 0.01604f
C807 a_15782_13722# sg13cmos5l_dfrbpq_1_2.D 0.17324f
C808 sg13cmos5l_inv_1_0.Y sg13cmos5l_xnor2_1_0.Y 0.02883f
C809 sg13cmos5l_inv_1_0.Y a_8586_14484# 0.03667f
C810 a_3627_15356# a_2822_15234# 0.07916f
C811 sg13cmos5l_xor2_1_0.B counter_value_o[1] 0.09405f
C812 sg13cmos5l_dfrbpq_1_7.D sg13cmos5l_buf_16_2.X 0.01278f
C813 a_4366_14751# VDD 0.17054f
C814 a_9446_15234# sg13cmos5l_nand4_1_0.Y 0.01797f
C815 sg13cmos5l_dfrbpq_1_3.RESET_B sg13cmos5l_buf_16_2.A 0.18248f
C816 a_3108_15552# sg13cmos5l_nor2_1_0.B 0.01927f
C817 a_5694_15486# VDD 0.09746f
C818 a_25402_14448# sg13cmos5l_o21ai_1_2.Y 0.30333f
C819 a_17482_14452# a_17222_14922# 0.45119f
C820 sg13cmos5l_dfrbpq_1_6.D sg13cmos5l_dfrbpq_1_3.Q 0.02733f
C821 sg13cmos5l_inv_1_0.Y a_10714_14448# 0.01818f
C822 a_27503_13799# sg13cmos5l_dlygate4sd3_1_20.A 0.01883f
C823 a_21929_16334# a_21850_16237# 0.08889f
C824 sg13cmos5l_dfrbpq_1_2.RESET_B VDD 1.26148f
C825 sg13cmos5l_xnor2_1_0.A sg13cmos5l_nor2_1_0.B 0.0289f
C826 a_26052_14488# a_25766_14922# 0.26205f
C827 a_20678_14922# VDD 0.52335f
C828 a_10251_15356# a_11248_15454# 0.03412f
C829 sg13cmos5l_dlygate4sd3_1_5.A sg13cmos5l_dlygate4sd3_1_3.X 0.01356f
C830 a_17327_13799# sg13cmos5l_dfrbpq_1_2.RESET_B 0.10868f
C831 a_20678_14922# sg13cmos5l_o21ai_1_1.Y 0.03307f
C832 sg13cmos5l_dfrbpq_1_6.RESET_B sg13cmos5l_dfrbpq_1_2.Q 0.02145f
C833 a_18470_15238# VDD 0.20535f
C834 sg13cmos5l_dfrbpq_1_3.RESET_B sg13cmos5l_dfrbpq_1_2.Q 0.06482f
C835 VDD a_25697_15424# 0.20526f
C836 sg13cmos5l_dlygate4sd3_1_11.X a_7077_14495# 0.01038f
C837 sg13cmos5l_o21ai_1_2.Y a_24600_14040# 0.01087f
C838 sg13cmos5l_dlygate4sd3_1_5.A a_3627_15356# 0.02226f
C839 sg13cmos5l_o21ai_1_2.A1 sg13cmos5l_dfrbpq_1_2.RESET_B 0.02983f
C840 sg13cmos5l_dlygate4sd3_1_11.X sg13cmos5l_tiehi_0.L_HI 0.02404f
C841 sg13cmos5l_inv_1_0.Y sg13cmos5l_buf_16_2.A 0.12683f
C842 a_10991_15311# a_11248_15454# 0.23043f
C843 sg13cmos5l_or3_1_2.X a_21089_15424# 0.01474f
C844 sg13cmos5l_o21ai_1_2.A1 a_20678_14922# 0.02211f
C845 sg13cmos5l_dfrbpq_1_1.RESET_B sg13cmos5l_xnor2_1_0.A 0.02196f
C846 a_17142_16020# a_17030_15996# 0.3854f
C847 a_21252_14909# sg13cmos5l_o21ai_1_1.Y 0.02439f
C848 sg13cmos5l_inv_1_0.Y sg13cmos5l_o21ai_1_2.Y 0.01472f
C849 sg13cmos5l_dfrbpq_1_7.Q VDD 1.53244f
C850 sg13cmos5l_o21ai_1_2.A1 a_18470_15238# 0.04894f
C851 a_27503_13799# a_28170_14020# 0.09257f
C852 sg13cmos5l_dfrbpq_1_2.CLK a_16485_13701# 0.20963f
C853 a_15707_15996# sg13cmos5l_inv_1_0.Y 0.01372f
C854 a_16163_16265# sg13cmos5l_a21oi_1_0.A1 0.01832f
C855 VDD a_3894_16020# 0.16343f
C856 sg13cmos5l_or3_1_2.X a_21865_13726# 0.12621f
C857 sg13cmos5l_a21oi_1_0.A2 VDD 0.19778f
C858 sg13cmos5l_buf_16_2.X sg13cmos5l_or3_1_2.X 0.0253f
C859 sg13cmos5l_a21oi_1_1.Y sg13cmos5l_dfrbpq_1_6.D 0.03789f
C860 a_27310_15423# VDD 0.16048f
C861 a_8982_15302# VDD 0.16067f
C862 sg13cmos5l_dfrbpq_1_2.Q sg13cmos5l_inv_1_0.Y 0.88366f
C863 clock_i VDD 1.90569f
C864 sg13cmos5l_o21ai_1_2.A1 sg13cmos5l_a21oi_1_0.A2 0.01809f
C865 sg13cmos5l_o21ai_1_2.A2 a_24502_13718# 0.04917f
C866 a_5408_15366# VDD 0.07564f
C867 VDD a_24992_13854# 0.07943f
C868 sg13cmos5l_dfrbpq_1_3.RESET_B a_19024_14726# 0.09623f
C869 a_21865_13726# sg13cmos5l_or3_1_2.A 0.21307f
C870 sg13cmos5l_inv_1_0.Y a_24808_16082# 0.03237f
C871 sg13cmos5l_buf_16_2.X sg13cmos5l_or3_1_2.A 1.14136f
C872 sg13cmos5l_o21ai_1_2.A1 clock_i 0.03583f
C873 sg13cmos5l_inv_1_0.Y a_6660_14488# 0.02667f
C874 sg13cmos5l_dlygate4sd3_1_19.X a_25006_14751# 0.10789f
C875 a_8302_13911# a_8096_13854# 0.01604f
C876 a_10433_14750# VDD 0.20207f
C877 sg13cmos5l_xnor2_1_1.A sg13cmos5l_buf_16_2.A 0.1665f
C878 a_27568_14726# a_27978_14484# 0.07015f
C879 sg13cmos5l_dfrbpq_1_2.Q a_18027_14495# 0.05775f
C880 sg13cmos5l_buf_1_10.X reset_n_i 0.01058f
C881 sg13cmos5l_dfrbpq_1_5.RESET_B a_26825_16334# 0.01106f
C882 sg13cmos5l_dlygate4sd3_1_0.A a_8982_15302# 0.01467f
C883 VDD a_26661_13701# 0.25342f
C884 a_26565_16033# a_26441_16334# 0.08186f
C885 sg13cmos5l_dfrbpq_1_0.RESET_B a_3627_15356# 0.27963f
C886 a_16372_16020# a_16163_16265# 0.01485f
C887 a_24128_14570# VDD 0.0783f
C888 sg13cmos5l_dlygate4sd3_1_0.A clock_i 0.36382f
C889 sg13cmos5l_or3_1_2.C a_20122_15238# 0.01867f
C890 a_27500_15960# a_27296_16082# 0.01689f
C891 sg13cmos5l_dfrbpq_1_3.Q VDD 1.6166f
C892 a_6374_14922# sg13cmos5l_xor2_1_1.B 0.04818f
C893 a_21185_16262# VDD 0.2066f
C894 sg13cmos5l_dfrbpq_1_7.RESET_B a_26340_14909# 0.02267f
C895 a_25115_15996# sg13cmos5l_dlygate4sd3_1_15.A 0.10845f
C896 a_7136_15366# VDD 0.07948f
C897 sg13cmos5l_dfrbpq_1_2.Q sg13cmos5l_xnor2_1_1.A 0.05727f
C898 a_2540_15960# counter_value_o[0] 0.15504f
C899 sg13cmos5l_buf_16_2.X a_26244_14040# 0.05219f
C900 counter_value_o[7] VDD 0.11661f
C901 sg13cmos5l_dfrbpq_1_7.RESET_B sg13cmos5l_dfrbpq_1_5.RESET_B 0.2463f
C902 a_26362_16237# sg13cmos5l_dfrbpq_1_7.RESET_B 0.04678f
C903 sg13cmos5l_dfrbpq_1_3.RESET_B a_17925_14495# 0.0371f
C904 sg13cmos5l_dfrbpq_1_6.RESET_B a_21070_16263# 0.02119f
C905 a_12212_15202# VDD 1.78911f
C906 a_26052_14488# VDD 0.07361f
C907 sg13cmos5l_xor2_1_1.B sg13cmos5l_dlygate4sd3_1_3.X 0.35093f
C908 a_18027_14495# a_19024_14726# 0.03546f
C909 a_20182_14862# sg13cmos5l_or3_1_2.C 0.08799f
C910 sg13cmos5l_dlygate4sd3_1_8.X sg13cmos5l_buf_16_2.A 0.07337f
C911 a_21466_15960# a_21185_16262# 0.18796f
C912 sg13cmos5l_dfrbpq_1_2.Q a_17994_14020# 0.0782f
C913 sg13cmos5l_a21oi_1_1.Y VDD 0.42327f
C914 sg13cmos5l_or3_1_2.B a_15287_15549# 0.02872f
C915 sg13cmos5l_dfrbpq_1_2.Q a_17508_14488# 0.02916f
C916 sg13cmos5l_dfrbpq_1_7.D a_25978_15202# 0.01772f
C917 a_27296_16082# VDD 0.06629f
C918 a_26816_13058# sg13cmos5l_o21ai_1_3.B1 0.01615f
C919 a_27568_14726# VDD 0.13691f
C920 sg13cmos5l_a21oi_1_1.Y a_20507_15532# 0.1047f
C921 sg13cmos5l_dlygate4sd3_1_10.X counter_value_o[3] 0.33517f
C922 sg13cmos5l_dlygate4sd3_1_20.A a_26244_14040# 0.01847f
C923 sg13cmos5l_a21oi_1_2.Y VDD 0.20791f
C924 a_10149_13765# VDD 0.07638f
C925 a_8302_13911# VDD 0.16104f
C926 sg13cmos5l_buf_16_2.X a_26026_14452# 0.0137f
C927 a_3082_15457# a_2822_15234# 0.45119f
C928 a_15782_13722# a_16485_13701# 0.02453f
C929 sg13cmos5l_dfrbpq_1_2.Q sg13cmos5l_dlygate4sd3_1_8.X 0.23453f
C930 sg13cmos5l_inv_1_0.Y a_17925_14495# 0.01369f
C931 a_6958_13911# VDD 0.15817f
C932 a_3108_15552# VDD 0.09715f
C933 a_26746_16237# VDD 0.0937f
C934 sg13cmos5l_dfrbpq_1_7.D sg13cmos5l_o21ai_1_2.B1 0.01933f
C935 a_6374_14922# sg13cmos5l_buf_1_0.X 0.0282f
C936 a_18080_15366# a_15790_15238# 0.0182f
C937 a_22053_16033# counter_value_o[4] 0.01129f
C938 counter_value_o[6] VDD 0.12256f
C939 sg13cmos5l_or3_1_2.C sg13cmos5l_or3_1_2.A 1.12372f
C940 sg13cmos5l_buf_16_2.X a_26571_14495# 0.05345f
C941 a_21466_15960# sg13cmos5l_a21oi_1_1.Y 0.28648f
C942 a_25582_15423# VDD 0.16037f
C943 a_26446_15423# a_26561_15424# 0.3854f
C944 a_27500_15960# counter_value_o[5] 0.15495f
C945 a_25115_15996# sg13cmos5l_dlygate4sd3_1_18.X 0.05371f
C946 sg13cmos5l_or3_1_2.B sg13cmos5l_or3_1_2.A 0.12991f
C947 counter_value_o[7] a_37192_16082# 0.02116f
C948 a_19434_14484# VDD 0.27994f
C949 a_2540_15960# a_2248_16082# 0.01635f
C950 sg13cmos5l_xnor2_1_0.A VDD 0.55635f
C951 a_24520_15366# a_24704_15366# 0.05762f
C952 a_3627_15356# a_3396_15247# 0.07823f
C953 a_27503_13799# a_26763_13844# 0.17382f
C954 sg13cmos5l_or3_1_2.A a_21728_15366# 0.01243f
C955 a_17925_14495# a_18027_14495# 0.3643f
C956 a_6566_15238# a_6678_15302# 0.3854f
C957 sg13cmos5l_dlygate4sd3_1_5.A a_3082_15457# 0.01417f
C958 sg13cmos5l_o21ai_1_3.Y sg13cmos5l_dfrbpq_1_5.D 0.49607f
C959 a_20678_14922# a_21252_14909# 0.18486f
C960 a_20964_14488# a_21381_14495# 0.28418f
C961 sg13cmos5l_o21ai_1_2.A1 a_19434_14484# 0.01125f
C962 sg13cmos5l_dlygate4sd3_1_3.X sg13cmos5l_buf_1_0.X 0.09706f
C963 sg13cmos5l_buf_1_0.X a_7077_14495# 0.01195f
C964 a_21483_14495# sg13cmos5l_or3_1_2.X 0.02227f
C965 sg13cmos5l_buf_16_2.X a_18767_14845# 0.01335f
C966 a_16068_14040# a_16485_13701# 0.28324f
C967 sg13cmos5l_or3_1_1.X VDD 0.51544f
C968 a_2536_15366# a_2720_15366# 0.05762f
C969 a_19265_15424# a_19546_15202# 0.18796f
C970 a_24808_13058# VDD 0.16729f
C971 a_19904_15366# sg13cmos5l_dfrbpq_1_3.Q 0.06655f
C972 sg13cmos5l_dfrbpq_1_3.D a_17142_16020# 0.10885f
C973 a_15707_15996# sg13cmos5l_a21oi_1_0.Y 0.10165f
C974 a_16587_13844# a_17584_13942# 0.03412f
C975 sg13cmos5l_o21ai_1_2.A1 sg13cmos5l_or3_1_1.X 0.03925f
C976 counter_value_o[5] VDD 0.09858f
C977 clock_i sg13cmos5l_dfrbpq_1_2.RESET_B 0.0999f
C978 a_6634_14452# sg13cmos5l_dfrbpq_1_1.RESET_B 0.17292f
C979 sg13cmos5l_dlygate4sd3_1_11.A a_10897_15311# 0.01808f
C980 sg13cmos5l_dfrbpq_1_2.CLK a_7077_14495# 0.22511f
C981 a_22223_14845# a_22890_14484# 0.09257f
C982 a_38720_13058# VDD 0.05774f
C983 sg13cmos5l_o21ai_1_2.A1 a_24808_13058# 0.03869f
C984 a_21483_14495# sg13cmos5l_or3_1_2.A 0.04059f
C985 a_3512_16037# a_3782_15996# 0.18796f
C986 sg13cmos5l_dfrbpq_1_2.CLK sg13cmos5l_tiehi_0.L_HI 0.03606f
C987 a_3627_15356# sg13cmos5l_dfrbpq_1_2.CLK 0.01148f
C988 a_27310_15423# sg13cmos5l_dfrbpq_1_7.Q 0.01065f
C989 a_9446_15234# a_10020_15247# 0.18486f
C990 a_17508_14488# a_17925_14495# 0.28418f
C991 sg13cmos5l_o21ai_1_3.A2 a_24265_14508# 0.01883f
C992 a_6760_16082# VDD 0.17311f
C993 a_26842_15202# sg13cmos5l_o21ai_1_2.B1 0.06201f
C994 sg13cmos5l_buf_16_2.A a_18200_15238# 0.01854f
C995 a_25766_15996# a_25878_16020# 0.3854f
C996 sg13cmos5l_xnor2_1_0.Y sg13cmos5l_nor2_1_0.B 0.0687f
C997 sg13cmos5l_dfrbpq_1_0.RESET_B a_3082_15457# 0.19471f
C998 clock_i a_3894_16020# 0.01189f
C999 a_8176_14726# a_7919_14845# 0.23043f
C1000 sg13cmos5l_a21oi_1_0.A2 clock_i 0.01176f
C1001 sg13cmos5l_dfrbpq_1_7.D sg13cmos5l_dfrbpq_1_6.Q 0.0219f
C1002 sg13cmos5l_o21ai_1_2.B1 a_24502_13718# 0.0245f
C1003 a_6906_12935# a_6932_12972# 0.21976f
C1004 a_8600_15238# sg13cmos5l_xor2_1_0.X 0.31379f
C1005 sg13cmos5l_dfrbpq_1_2.Q a_18200_15238# 0.2982f
C1006 counter_value_o[4] a_22216_16082# 0.02116f
C1007 a_19150_15423# sg13cmos5l_buf_16_2.A 0.0193f
C1008 counter_value_o[4] VDD 0.09598f
C1009 sg13cmos5l_dlygate4sd3_1_10.X sg13cmos5l_buf_16_2.A 0.01419f
C1010 sg13cmos5l_dfrbpq_1_6.RESET_B a_20964_14488# 0.29003f
C1011 sg13cmos5l_xnor2_1_1.A a_17030_15996# 0.01268f
C1012 sg13cmos5l_xnor2_1_1.A a_16760_16037# 0.01393f
C1013 a_25129_13726# a_25325_14020# 0.01485f
C1014 a_4367_15311# a_3108_15552# 0.01412f
C1015 a_10251_15356# sg13cmos5l_tiehi_0.L_HI 0.27963f
C1016 sg13cmos5l_inv_1_0.Y a_6374_14922# 0.01052f
C1017 a_9750_14508# a_10318_14751# 0.01641f
C1018 a_10149_15213# sg13cmos5l_dfrbpq_1_2.CLK 0.21535f
C1019 sg13cmos5l_dfrbpq_1_6.RESET_B a_22223_14845# 0.10879f
C1020 a_24982_13350# sg13cmos5l_o21ai_1_2.A1 0.07629f
C1021 sg13cmos5l_dfrbpq_1_2.Q sg13cmos5l_dlygate4sd3_1_10.X 0.02979f
C1022 a_4367_15311# sg13cmos5l_xnor2_1_0.A 0.01376f
C1023 sg13cmos5l_dfrbpq_1_6.D sg13cmos5l_dlygate4sd3_1_13.X 0.12493f
C1024 sg13cmos5l_nand4_1_0.Y a_8870_15238# 0.01127f
C1025 a_4273_15311# a_3525_15213# 0.01058f
C1026 a_17710_16263# VDD 0.15986f
C1027 a_10991_15311# sg13cmos5l_tiehi_0.L_HI 0.10868f
C1028 sg13cmos5l_dfrbpq_1_6.Q sg13cmos5l_or3_1_2.X 0.1149f
C1029 sg13cmos5l_dfrbpq_1_3.D sg13cmos5l_dfrbpq_1_2.CLK 0.08618f
C1030 sg13cmos5l_inv_1_0.Y a_20964_14488# 0.0234f
C1031 sg13cmos5l_or3_1_2.C a_20280_14464# 0.01044f
C1032 a_4366_14751# sg13cmos5l_xnor2_1_0.A 0.10864f
C1033 a_26244_14040# a_26763_13844# 0.20773f
C1034 a_25766_15996# VDD 0.20366f
C1035 sg13cmos5l_inv_1_0.Y a_7077_14495# 0.01315f
C1036 sg13cmos5l_inv_1_0.Y a_16140_14750# 0.01813f
C1037 sg13cmos5l_dlygate4sd3_1_5.A a_4624_15454# 0.03749f
C1038 counter_value_o[3] VDD 0.08452f
C1039 sg13cmos5l_dfrbpq_1_5.RESET_B a_26446_15423# 0.02259f
C1040 sg13cmos5l_inv_1_0.Y sg13cmos5l_tiehi_0.L_HI 0.03478f
C1041 sg13cmos5l_dlygate4sd3_1_11.A sg13cmos5l_nand4_1_0.Y 1.08046f
C1042 a_32492_15960# a_32200_16082# 0.01635f
C1043 sg13cmos5l_or3_1_2.B a_16587_13844# 0.02396f
C1044 sg13cmos5l_dfrbpq_1_6.Q a_26842_15202# 0.01056f
C1045 a_6906_12935# a_6752_13058# 0.01858f
C1046 sg13cmos5l_dlygate4sd3_1_5.A a_4762_14448# 0.28823f
C1047 a_6660_14488# a_7179_14495# 0.20754f
C1048 sg13cmos5l_inv_1_0.Y a_8176_14726# 0.01323f
C1049 sg13cmos5l_o21ai_1_2.B1 sg13cmos5l_dlygate4sd3_1_15.A 0.04503f
C1050 sg13cmos5l_dlygate4sd3_1_5.A a_5495_15315# 0.02705f
C1051 a_25582_15423# a_25697_15424# 0.3854f
C1052 sg13cmos5l_o21ai_1_2.A1 counter_value_o[3] 0.87043f
C1053 reset_n_i a_1192_9948# 0.19796f
C1054 a_2880_14523# VDD 0.1978f
C1055 sg13cmos5l_dfrbpq_1_7.RESET_B sg13cmos5l_o21ai_1_3.Y 0.03322f
C1056 sg13cmos5l_o21ai_1_3.A2 VDD 0.67461f
C1057 a_10149_15213# a_10251_15356# 0.36168f
C1058 counter_value_o[6] sg13cmos5l_dfrbpq_1_7.Q 0.01279f
C1059 VDD a_26561_15424# 0.20687f
C1060 sg13cmos5l_dfrbpq_1_1.RESET_B a_6660_14488# 0.27855f
C1061 a_7073_13912# sg13cmos5l_dfrbpq_1_1.RESET_B 0.01497f
C1062 a_6634_14452# VDD 0.09577f
C1063 sg13cmos5l_inv_1_0.Y a_9750_14508# 0.01414f
C1064 a_15287_15315# VDD 0.07397f
C1065 sg13cmos5l_o21ai_1_2.A1 sg13cmos5l_o21ai_1_3.A2 1.1527f
C1066 sg13cmos5l_or3_1_1.X a_25697_15424# 0.02955f
C1067 sg13cmos5l_xnor2_1_1.A a_16140_14750# 0.09726f
C1068 sg13cmos5l_dfrbpq_1_3.RESET_B sg13cmos5l_dfrbpq_1_3.D 0.26463f
C1069 sg13cmos5l_inv_1_0.Y sg13cmos5l_nor2_1_3.B 0.08924f
C1070 sg13cmos5l_a21oi_1_1.Y sg13cmos5l_dfrbpq_1_3.Q 0.08518f
C1071 counter_value_o[2] VDD 0.11504f
C1072 sg13cmos5l_or3_1_2.X a_21934_15423# 0.01897f
C1073 a_11658_15532# sg13cmos5l_nand4_1_0.Y 0.01074f
C1074 sg13cmos5l_a21oi_1_1.Y a_21185_16262# 0.02116f
C1075 a_26340_14909# a_25766_14922# 0.18486f
C1076 sg13cmos5l_xor2_1_1.A sg13cmos5l_nand4_1_0.Y 0.03936f
C1077 sg13cmos5l_dfrbpq_1_0.RESET_B a_4624_15454# 0.09962f
C1078 sg13cmos5l_o21ai_1_2.B1 sg13cmos5l_dlygate4sd3_1_19.X 0.0213f
C1079 a_19436_15960# a_19173_16033# 0.01511f
C1080 sg13cmos5l_dfrbpq_1_7.Q sg13cmos5l_or3_1_1.X 0.01737f
C1081 sg13cmos5l_dlygate4sd3_1_13.X VDD 0.19023f
C1082 sg13cmos5l_dfrbpq_1_6.D sg13cmos5l_dfrbpq_1_2.Q 0.02805f
C1083 a_7544_16362# sg13cmos5l_xor2_1_0.B 0.01437f
C1084 a_6374_14922# sg13cmos5l_dfrbpq_1_1.D 0.1704f
C1085 sg13cmos5l_dfrbpq_1_2.D VDD 0.39208f
C1086 sg13cmos5l_buf_16_2.X sg13cmos5l_dfrbpq_1_5.D 0.02645f
C1087 sg13cmos5l_dfrbpq_1_5.RESET_B a_25766_14922# 0.01642f
C1088 a_26026_14452# a_26469_14495# 0.02241f
C1089 sg13cmos5l_dlygate4sd3_1_13.X a_20507_15532# 0.06946f
C1090 sg13cmos5l_dlygate4sd3_1_11.X a_7985_15288# 0.07494f
C1091 sg13cmos5l_a21oi_1_0.Y a_16760_16037# 0.28741f
C1092 sg13cmos5l_buf_16_2.X a_21381_14495# 0.20982f
C1093 a_21934_15423# sg13cmos5l_or3_1_2.A 0.13493f
C1094 sg13cmos5l_dlygate4sd3_1_5.A a_5495_15549# 0.0298f
C1095 a_3095_16071# VDD 0.09456f
C1096 sg13cmos5l_dfrbpq_1_3.D sg13cmos5l_inv_1_0.Y 0.03539f
C1097 VDD a_8586_14484# 0.27646f
C1098 VDD sg13cmos5l_xnor2_1_0.Y 0.42459f
C1099 sg13cmos5l_dfrbpq_1_1.RESET_B a_6678_15302# 0.02797f
C1100 a_26469_14495# a_26571_14495# 0.3643f
C1101 a_19434_14484# sg13cmos5l_dfrbpq_1_3.Q 0.07596f
C1102 sg13cmos5l_dlygate4sd3_1_8.X a_19265_15424# 0.04918f
C1103 sg13cmos5l_xor2_1_0.X VDD 0.16725f
C1104 VDD a_25129_13726# 0.26112f
C1105 sg13cmos5l_buf_16_2.X a_22890_14484# 0.01262f
C1106 a_25496_16037# sg13cmos5l_dlygate4sd3_1_15.A 0.01592f
C1107 sg13cmos5l_dlygate4sd3_1_7.A counter_value_o[3] 0.01208f
C1108 sg13cmos5l_dlygate4sd3_1_1.A sg13cmos5l_xor2_1_1.A 0.33129f
C1109 a_8417_13912# a_8698_13690# 0.18796f
C1110 a_12232_16082# VDD 0.14881f
C1111 counter_value_o[1] VDD 0.07375f
C1112 a_10714_14448# VDD 0.28495f
C1113 a_26571_14495# a_27311_14845# 0.17382f
C1114 sg13cmos5l_dfrbpq_1_6.Q sg13cmos5l_dlygate4sd3_1_15.A 0.19429f
C1115 sg13cmos5l_o21ai_1_2.B1 sg13cmos5l_or3_1_3.X 0.12497f
C1116 VDD a_25958_13722# 0.52459f
C1117 sg13cmos5l_o21ai_1_2.A1 a_25129_13726# 0.16915f
C1118 a_9446_15234# sg13cmos5l_dlygate4sd3_1_11.X 0.0295f
C1119 sg13cmos5l_dlygate4sd3_1_0.A a_8586_14484# 0.08149f
C1120 a_26949_16033# a_27112_16082# 0.03352f
C1121 sg13cmos5l_dlygate4sd3_1_6.X sg13cmos5l_tiehi_0.L_HI 0.24772f
C1122 a_7354_13690# sg13cmos5l_dlygate4sd3_1_1.A 0.28282f
C1123 a_20680_16082# VDD 0.13468f
C1124 sg13cmos5l_dlygate4sd3_1_5.A sg13cmos5l_nand4_1_0.Y 0.14901f
C1125 sg13cmos5l_buf_16_2.A VDD 2.88712f
C1126 sg13cmos5l_dlygate4sd3_1_11.X sg13cmos5l_nand4_1_0.Y 0.66968f
C1127 sg13cmos5l_dfrbpq_1_7.RESET_B a_26441_16334# 0.02001f
C1128 sg13cmos5l_dlygate4sd3_1_0.A sg13cmos5l_xor2_1_0.X 0.03202f
C1129 a_19436_15960# sg13cmos5l_xnor2_1_1.A 0.01832f
C1130 sg13cmos5l_dfrbpq_1_3.D sg13cmos5l_xnor2_1_1.A 0.01824f
C1131 sg13cmos5l_dlygate4sd3_1_5.A a_7916_15960# 0.02157f
C1132 sg13cmos5l_o21ai_1_2.Y VDD 0.40886f
C1133 a_15707_15996# VDD 0.16164f
C1134 sg13cmos5l_dlygate4sd3_1_0.A counter_value_o[1] 0.01805f
C1135 a_2822_15234# a_3525_15213# 0.02453f
C1136 sg13cmos5l_or3_1_2.B a_14549_15238# 0.26262f
C1137 sg13cmos5l_o21ai_1_2.A1 sg13cmos5l_buf_16_2.A 0.21709f
C1138 sg13cmos5l_dlygate4sd3_1_10.X a_17030_15996# 0.0117f
C1139 sg13cmos5l_dfrbpq_1_3.RESET_B a_17482_14452# 0.17453f
C1140 a_19534_13726# sg13cmos5l_buf_16_2.A 0.42879f
C1141 sg13cmos5l_dfrbpq_1_6.RESET_B a_21089_15424# 0.05429f
C1142 a_22049_15424# a_22330_15202# 0.18796f
C1143 a_11248_15454# VDD 0.14093f
C1144 sg13cmos5l_o21ai_1_2.A1 sg13cmos5l_o21ai_1_2.Y 0.17629f
C1145 sg13cmos5l_dlygate4sd3_1_6.X a_9750_14508# 0.10926f
C1146 sg13cmos5l_dfrbpq_1_2.Q VDD 1.30726f
C1147 a_3108_15552# sg13cmos5l_xnor2_1_0.A 0.06284f
C1148 sg13cmos5l_buf_1_10.X sg13cmos5l_buf_1_0.X 0.15181f
C1149 counter_value_o[0] VDD 0.1181f
C1150 sg13cmos5l_dfrbpq_1_2.Q sg13cmos5l_o21ai_1_1.Y 0.02584f
C1151 sg13cmos5l_o21ai_1_2.A2 a_24600_14040# 0.01248f
C1152 sg13cmos5l_buf_16_2.X a_25402_14448# 0.01493f
C1153 sg13cmos5l_or3_1_2.X a_20974_15423# 0.02704f
C1154 sg13cmos5l_dfrbpq_1_6.RESET_B sg13cmos5l_buf_16_2.X 0.07723f
C1155 VDD sg13cmos5l_o21ai_1_3.B1 0.57709f
C1156 sg13cmos5l_dfrbpq_1_6.D a_21070_16263# 0.10665f
C1157 sg13cmos5l_or3_1_1.X sg13cmos5l_a21oi_1_2.Y 0.11251f
C1158 sg13cmos5l_dfrbpq_1_2.Q sg13cmos5l_o21ai_1_2.A1 0.1098f
C1159 a_21381_14495# sg13cmos5l_or3_1_2.C 0.01119f
C1160 a_18767_14845# a_18673_14845# 0.16704f
C1161 a_24808_16082# VDD 0.14534f
C1162 sg13cmos5l_xor2_1_1.B a_6948_14909# 0.01496f
C1163 VDD a_6660_14488# 0.07288f
C1164 a_16175_14854# sg13cmos5l_dfrbpq_1_2.RESET_B 0.01421f
C1165 a_9946_13943# VDD 0.10048f
C1166 a_7073_13912# VDD 0.20174f
C1167 sg13cmos5l_dfrbpq_1_2.Q a_17796_14909# 0.01198f
C1168 sg13cmos5l_dlygate4sd3_1_5.A a_3525_15213# 0.0168f
C1169 sg13cmos5l_dfrbpq_1_6.Q sg13cmos5l_dlygate4sd3_1_18.X 0.02307f
C1170 a_27296_16082# counter_value_o[5] 0.01377f
C1171 a_16042_13945# a_16485_13701# 0.02241f
C1172 a_19436_15960# sg13cmos5l_dlygate4sd3_1_8.X 0.02637f
C1173 sg13cmos5l_o21ai_1_2.A1 sg13cmos5l_o21ai_1_3.B1 0.13297f
C1174 sg13cmos5l_inv_1_0.Y a_17482_14452# 0.01069f
C1175 sg13cmos5l_dfrbpq_1_5.RESET_B VDD 1.2307f
C1176 a_26362_16237# VDD 0.09323f
C1177 a_4762_14448# sg13cmos5l_buf_1_0.X 0.01244f
C1178 counter_value_o[4] sg13cmos5l_dfrbpq_1_3.Q 0.01574f
C1179 sg13cmos5l_dlygate4sd3_1_13.X a_20609_15260# 0.01276f
C1180 sg13cmos5l_or3_1_1.X a_25582_15423# 0.04916f
C1181 sg13cmos5l_or3_1_2.B sg13cmos5l_dfrbpq_1_2.CLK 0.06935f
C1182 sg13cmos5l_inv_1_0.Y sg13cmos5l_buf_16_2.X 0.70189f
C1183 a_19024_14726# VDD 0.13765f
C1184 a_27503_13799# a_26244_14040# 0.01412f
C1185 a_16163_16265# sg13cmos5l_xnor2_1_1.A 0.21794f
C1186 a_25978_15202# sg13cmos5l_dfrbpq_1_5.D 0.08391f
C1187 sg13cmos5l_dfrbpq_1_2.CLK a_15790_15238# 0.03565f
C1188 a_20938_14452# a_20964_14488# 0.24169f
C1189 sg13cmos5l_o21ai_1_2.A1 a_19024_14726# 0.0146f
C1190 a_27409_13799# a_26661_13701# 0.01058f
C1191 a_2248_16082# VDD 0.16554f
C1192 a_6374_14922# a_7179_14495# 0.07916f
C1193 sg13cmos5l_buf_16_2.X a_18027_14495# 0.01725f
C1194 sg13cmos5l_dfrbpq_1_7.RESET_B sg13cmos5l_buf_16_2.X 0.07641f
C1195 sg13cmos5l_dfrbpq_1_2.D sg13cmos5l_dfrbpq_1_2.RESET_B 0.13407f
C1196 a_6678_15302# VDD 0.15906f
C1197 a_21381_14495# a_21483_14495# 0.3643f
C1198 a_26446_15423# sg13cmos5l_o21ai_1_3.Y 0.01671f
C1199 a_19150_15423# a_19265_15424# 0.3854f
C1200 a_6932_12972# VDD 0.13919f
C1201 a_19173_16033# a_19049_16334# 0.08186f
C1202 a_16485_13701# VDD 0.29093f
C1203 sg13cmos5l_dfrbpq_1_0.RESET_B a_3525_15213# 0.0353f
C1204 a_20182_14862# sg13cmos5l_or3_1_2.A 0.02431f
C1205 sg13cmos5l_buf_1_0.X a_6948_14909# 0.02279f
C1206 sg13cmos5l_o21ai_1_3.A2 a_24992_13854# 0.02338f
C1207 a_2720_15366# VDD 0.07036f
C1208 sg13cmos5l_o21ai_1_2.B1 sg13cmos5l_dfrbpq_1_5.D 0.04515f
C1209 sg13cmos5l_or3_1_2.X sg13cmos5l_or3_1_2.A 0.23492f
C1210 a_6374_14922# sg13cmos5l_dfrbpq_1_1.RESET_B 0.07552f
C1211 a_22480_14726# a_22223_14845# 0.23043f
C1212 a_27137_13238# VDD 0.20382f
C1213 a_27418_12936# a_27137_13238# 0.18796f
C1214 a_17925_14495# VDD 0.2523f
C1215 a_9706_15457# sg13cmos5l_tiehi_0.L_HI 0.17004f
C1216 sg13cmos5l_dfrbpq_1_6.RESET_B sg13cmos5l_or3_1_2.C 0.02299f
C1217 a_7077_14495# a_7179_14495# 0.3643f
C1218 a_21070_16263# VDD 0.15923f
C1219 counter_value_o[2] clock_i 0.01351f
C1220 a_17584_13942# a_17994_14020# 0.07015f
C1221 a_17482_14452# a_17508_14488# 0.24169f
C1222 a_3627_15356# sg13cmos5l_nor2_1_0.B 0.0644f
C1223 sg13cmos5l_dfrbpq_1_3.Q sg13cmos5l_o21ai_1_3.A2 0.30231f
C1224 a_21089_15424# a_21370_15202# 0.18796f
C1225 a_38536_3986# VDD 0.1399f
C1226 sg13cmos5l_o21ai_1_2.A1 a_17925_14495# 0.0186f
C1227 sg13cmos5l_nand4_1_0.Y a_14549_15238# 0.23996f
C1228 sg13cmos5l_dfrbpq_1_2.CLK sg13cmos5l_nor2_1_1.B 0.02926f
C1229 a_7179_14495# a_8176_14726# 0.03546f
C1230 a_3095_16301# a_3294_15934# 0.02453f
C1231 a_2824_16082# a_3008_16082# 0.05762f
C1232 sg13cmos5l_dlygate4sd3_1_5.A sg13cmos5l_dlygate4sd3_1_1.X 0.13806f
C1233 a_27760_13942# sg13cmos5l_dfrbpq_1_5.RESET_B 0.09962f
C1234 sg13cmos5l_dfrbpq_1_1.RESET_B a_7077_14495# 0.03606f
C1235 a_17508_14488# sg13cmos5l_buf_16_2.X 0.04769f
C1236 a_17925_14495# a_17796_14909# 0.01562f
C1237 sg13cmos5l_dlygate4sd3_1_1.A sg13cmos5l_xor2_1_1.B 0.12323f
C1238 sg13cmos5l_tiehi_0.L_HI sg13cmos5l_nor2_1_1.Y 0.01755f
C1239 sg13cmos5l_dfrbpq_1_3.RESET_B a_15790_15238# 0.05781f
C1240 a_9368_14525# sg13cmos5l_tiehi_0.L_HI 0.02009f
C1241 sg13cmos5l_buf_16_2.A sg13cmos5l_dfrbpq_1_2.RESET_B 0.19149f
C1242 sg13cmos5l_buf_1_10.X sg13cmos5l_inv_1_0.Y 0.06721f
C1243 sg13cmos5l_dfrbpq_1_7.D sg13cmos5l_dlygate4sd3_1_15.A 0.05668f
C1244 sg13cmos5l_inv_1_0.Y sg13cmos5l_or3_1_2.C 0.07296f
C1245 clock_i sg13cmos5l_xnor2_1_0.Y 0.01238f
C1246 a_21865_13726# a_21959_14020# 0.02103f
C1247 a_7985_15288# a_8156_15532# 0.21976f
C1248 a_10991_15311# a_10897_15311# 0.16704f
C1249 sg13cmos5l_dfrbpq_1_1.RESET_B a_8176_14726# 0.09622f
C1250 a_18470_15238# sg13cmos5l_buf_16_2.A 0.01482f
C1251 sg13cmos5l_or3_1_2.B sg13cmos5l_inv_1_0.Y 0.24746f
C1252 sg13cmos5l_nand4_1_0.Y sg13cmos5l_buf_1_0.X 0.08619f
C1253 a_25766_14922# sg13cmos5l_o21ai_1_3.Y 0.04872f
C1254 a_6752_13058# VDD 0.09507f
C1255 sg13cmos5l_dfrbpq_1_2.Q a_24054_15242# 0.01835f
C1256 sg13cmos5l_xnor2_1_1.A a_19049_16334# 0.01763f
C1257 a_6026_15532# sg13cmos5l_dfrbpq_1_1.D 0.01407f
C1258 a_9732_15552# sg13cmos5l_tiehi_0.L_HI 0.28721f
C1259 sg13cmos5l_or3_1_2.B a_15782_13722# 0.0234f
C1260 a_10149_15213# a_9706_15457# 0.02241f
C1261 sg13cmos5l_inv_1_0.Y a_4762_14448# 0.01033f
C1262 sg13cmos5l_inv_1_0.Y a_15790_15238# 0.01922f
C1263 sg13cmos5l_dfrbpq_1_6.RESET_B a_21483_14495# 0.28122f
C1264 sg13cmos5l_dfrbpq_1_6.D a_20964_14488# 0.01097f
C1265 sg13cmos5l_dfrbpq_1_2.Q a_18470_15238# 0.01548f
C1266 a_16163_16265# sg13cmos5l_a21oi_1_0.Y 0.01612f
C1267 sg13cmos5l_dfrbpq_1_2.CLK sg13cmos5l_nand4_1_0.Y 0.50608f
C1268 a_15707_15996# sg13cmos5l_a21oi_1_0.A2 0.09645f
C1269 a_3396_15247# a_3525_15213# 0.01562f
C1270 a_17030_15996# VDD 0.20537f
C1271 a_16760_16037# VDD 0.26187f
C1272 a_10714_14448# a_10433_14750# 0.18796f
C1273 clock_i sg13cmos5l_buf_16_2.A 0.07775f
C1274 a_2880_14523# sg13cmos5l_xnor2_1_0.A 0.10071f
C1275 a_25958_13722# a_26661_13701# 0.02453f
C1276 a_15707_15996# clock_i 0.03074f
C1277 sg13cmos5l_a21oi_1_1.Y sg13cmos5l_dlygate4sd3_1_13.X 0.07843f
C1278 a_16760_16037# sg13cmos5l_o21ai_1_2.A1 0.01816f
C1279 sg13cmos5l_o21ai_1_2.Y a_24992_13854# 0.01307f
C1280 sg13cmos5l_xor2_1_0.B a_7985_15288# 0.25289f
C1281 sg13cmos5l_or3_1_2.B a_16068_14040# 0.03519f
C1282 sg13cmos5l_dfrbpq_1_6.Q a_22890_14484# 0.08835f
C1283 counter_value_o[0] clock_i 0.04197f
C1284 a_26842_15202# sg13cmos5l_dlygate4sd3_1_15.A 0.2971f
C1285 sg13cmos5l_xnor2_1_1.A a_15790_15238# 0.10279f
C1286 sg13cmos5l_dlygate4sd3_1_19.X a_24821_15532# 0.0273f
C1287 sg13cmos5l_xor2_1_1.B a_7066_16366# 0.01544f
C1288 sg13cmos5l_dfrbpq_1_5.RESET_B sg13cmos5l_dfrbpq_1_7.Q 0.02805f
C1289 sg13cmos5l_dlygate4sd3_1_11.X a_10020_15247# 0.02005f
C1290 sg13cmos5l_dfrbpq_1_3.Q sg13cmos5l_buf_16_2.A 0.16799f
C1291 sg13cmos5l_inv_1_0.Y sg13cmos5l_o21ai_1_2.B1 0.14179f
C1292 a_2536_14570# VDD 0.15649f
C1293 sg13cmos5l_dfrbpq_1_7.RESET_B a_25978_15202# 0.02411f
C1294 sg13cmos5l_inv_1_0.Y sg13cmos5l_nor2_1_1.B 0.10775f
C1295 a_25402_14448# a_25121_14750# 0.18796f
C1296 a_22330_15202# VDD 0.29383f
C1297 a_9732_15552# a_10149_15213# 0.28324f
C1298 a_24265_14508# a_25006_14751# 0.01693f
C1299 a_9446_15234# a_10251_15356# 0.07916f
C1300 sg13cmos5l_or3_1_2.B a_17994_14020# 0.01534f
C1301 a_11658_15532# sg13cmos5l_dlygate4sd3_1_11.A 0.08655f
C1302 sg13cmos5l_dfrbpq_1_2.CLK a_3525_15213# 0.20136f
C1303 a_21850_16237# sg13cmos5l_dfrbpq_1_6.RESET_B 0.04633f
C1304 sg13cmos5l_xor2_1_1.B sg13cmos5l_dlygate4sd3_1_1.X 0.28605f
C1305 a_10251_15356# sg13cmos5l_nand4_1_0.Y 0.029f
C1306 a_6374_14922# VDD 0.52792f
C1307 a_12032_15366# VDD 0.08232f
C1308 a_3108_15552# sg13cmos5l_xnor2_1_0.Y 0.0418f
C1309 sg13cmos5l_dfrbpq_1_2.Q a_24128_14570# 0.02432f
C1310 a_16485_13701# sg13cmos5l_dfrbpq_1_2.RESET_B 0.03808f
C1311 sg13cmos5l_dfrbpq_1_7.RESET_B sg13cmos5l_o21ai_1_2.B1 0.02376f
C1312 sg13cmos5l_dfrbpq_1_2.Q sg13cmos5l_dfrbpq_1_3.Q 0.80464f
C1313 a_16163_16265# sg13cmos5l_dlygate4sd3_1_10.X 0.15293f
C1314 a_12212_15202# sg13cmos5l_buf_16_2.A 0.40557f
C1315 VDD a_24520_15366# 0.12538f
C1316 a_10991_15311# sg13cmos5l_nand4_1_0.Y 0.0141f
C1317 a_21929_16334# sg13cmos5l_dfrbpq_1_6.RESET_B 0.01142f
C1318 sg13cmos5l_a21oi_1_1.Y a_20680_16082# 0.0128f
C1319 sg13cmos5l_xnor2_1_0.A sg13cmos5l_xnor2_1_0.Y 0.07049f
C1320 a_20964_14488# VDD 0.07489f
C1321 a_24461_14508# a_24265_14508# 0.01485f
C1322 sg13cmos5l_xor2_1_0.B sg13cmos5l_nand4_1_0.Y 0.03944f
C1323 a_20964_14488# sg13cmos5l_o21ai_1_1.Y 0.03249f
C1324 sg13cmos5l_dlygate4sd3_1_18.X a_25288_15366# 0.03152f
C1325 sg13cmos5l_dfrbpq_1_5.RESET_B a_26661_13701# 0.04378f
C1326 a_19265_15424# VDD 0.20678f
C1327 VDD sg13cmos5l_o21ai_1_3.Y 0.45784f
C1328 VDD sg13cmos5l_dlygate4sd3_1_3.X 0.37603f
C1329 a_7916_15960# sg13cmos5l_xor2_1_0.B 0.03181f
C1330 VDD a_7077_14495# 0.24368f
C1331 a_16140_14750# VDD 0.19236f
C1332 sg13cmos5l_or3_1_3.X a_24821_15532# 0.05589f
C1333 a_22223_14845# VDD 0.19213f
C1334 sg13cmos5l_dlygate4sd3_1_11.X a_8870_15238# 0.01368f
C1335 sg13cmos5l_tiehi_0.L_HI VDD 1.1807f
C1336 a_3627_15356# VDD 0.20443f
C1337 sg13cmos5l_buf_16_2.X a_20938_14452# 0.04062f
C1338 sg13cmos5l_o21ai_1_2.A1 sg13cmos5l_o21ai_1_3.Y 0.3888f
C1339 sg13cmos5l_a21oi_1_1.Y sg13cmos5l_dfrbpq_1_2.Q 0.02777f
C1340 VDD a_8176_14726# 0.13605f
C1341 VDD a_3008_16082# 0.06385f
C1342 sg13cmos5l_o21ai_1_2.A1 a_16140_14750# 0.26387f
C1343 a_26052_14488# a_26340_14909# 0.24435f
C1344 sg13cmos5l_or3_1_1.X a_25129_13726# 0.12616f
C1345 sg13cmos5l_dlygate4sd3_1_8.X a_18582_15302# 0.12026f
C1346 a_7953_15556# VDD 0.0107f
C1347 a_24982_13350# sg13cmos5l_o21ai_1_3.A2 0.06486f
C1348 a_19434_14484# sg13cmos5l_buf_16_2.A 0.06354f
C1349 sg13cmos5l_buf_16_2.X a_22480_14726# 0.0128f
C1350 sg13cmos5l_dlygate4sd3_1_1.X sg13cmos5l_buf_1_0.X 0.02645f
C1351 sg13cmos5l_dlygate4sd3_1_11.A sg13cmos5l_dlygate4sd3_1_11.X 0.0164f
C1352 a_7354_13690# sg13cmos5l_xor2_1_1.A 0.08117f
C1353 a_9750_14508# VDD 0.15995f
C1354 sg13cmos5l_dfrbpq_1_5.RESET_B a_26052_14488# 0.02145f
C1355 sg13cmos5l_or3_1_1.X a_25958_13722# 0.01006f
C1356 sg13cmos5l_dlygate4sd3_1_0.A sg13cmos5l_tiehi_0.L_HI 0.01923f
C1357 VDD a_26218_13945# 0.09514f
C1358 sg13cmos5l_dfrbpq_1_6.Q sg13cmos5l_inv_1_0.Y 1.12116f
C1359 enable_i sg13cmos5l_buf_1_0.X 0.0337f
C1360 sg13cmos5l_dfrbpq_1_0.RESET_B a_3512_16037# 0.03487f
C1361 a_9946_13943# a_10149_13765# 0.02453f
C1362 sg13cmos5l_nor2_1_3.B VDD 0.28357f
C1363 sg13cmos5l_dfrbpq_1_7.RESET_B a_26469_14495# 0.04133f
C1364 a_6678_15302# a_7136_15366# 0.01604f
C1365 a_26949_16033# a_26825_16334# 0.08186f
C1366 sg13cmos5l_dlygate4sd3_1_1.X sg13cmos5l_dfrbpq_1_2.CLK 0.01211f
C1367 sg13cmos5l_o21ai_1_2.A2 a_24265_14508# 0.19981f
C1368 a_7073_13912# a_6958_13911# 0.3854f
C1369 sg13cmos5l_or3_1_1.X sg13cmos5l_o21ai_1_2.Y 0.05149f
C1370 a_18610_16374# sg13cmos5l_xnor2_1_1.A 0.05764f
C1371 a_25006_14751# VDD 0.16088f
C1372 a_10149_15213# VDD 0.24859f
C1373 a_22508_15960# a_22216_16082# 0.01635f
C1374 sg13cmos5l_dfrbpq_1_7.RESET_B sg13cmos5l_dfrbpq_1_6.Q 0.02441f
C1375 sg13cmos5l_o21ai_1_2.A1 sg13cmos5l_nor2_1_3.B 0.03755f
C1376 a_26746_16237# sg13cmos5l_dfrbpq_1_5.RESET_B 0.0432f
C1377 sg13cmos5l_dlygate4sd3_1_6.X sg13cmos5l_nor2_1_1.B 0.03955f
C1378 a_22508_15960# VDD 0.2284f
C1379 sg13cmos5l_dfrbpq_1_7.RESET_B a_27311_14845# 0.10879f
C1380 a_18716_15976# VDD 0.01784f
C1381 a_27425_15424# a_27706_15202# 0.18796f
C1382 a_4624_15454# a_5034_15532# 0.07015f
C1383 sg13cmos5l_dlygate4sd3_1_10.X a_19049_16334# 0.02889f
C1384 sg13cmos5l_dlygate4sd3_1_5.A sg13cmos5l_xor2_1_1.A 0.01283f
C1385 a_21185_16262# a_21070_16263# 0.3854f
C1386 sg13cmos5l_o21ai_1_2.A1 a_25006_14751# 0.01473f
C1387 a_19436_15960# VDD 0.21399f
C1388 sg13cmos5l_dfrbpq_1_3.D VDD 0.35223f
C1389 sg13cmos5l_dlygate4sd3_1_11.X sg13cmos5l_xor2_1_1.A 0.13463f
C1390 sg13cmos5l_buf_16_2.X a_25766_14922# 0.01792f
C1391 a_18716_15976# sg13cmos5l_o21ai_1_2.A1 0.01038f
C1392 sg13cmos5l_buf_16_2.X a_24265_14508# 0.01035f
C1393 sg13cmos5l_or3_1_1.X sg13cmos5l_o21ai_1_3.B1 0.01003f
C1394 a_19024_14726# a_19434_14484# 0.07015f
C1395 a_20938_14452# sg13cmos5l_or3_1_2.C 0.01248f
C1396 sg13cmos5l_dfrbpq_1_3.D sg13cmos5l_o21ai_1_2.A1 0.02367f
C1397 a_26441_16334# VDD 0.07319f
C1398 a_4762_14448# a_4481_14750# 0.18796f
C1399 a_8417_13912# VDD 0.22073f
C1400 sg13cmos5l_dlygate4sd3_1_5.A a_2822_15234# 0.03169f
C1401 sg13cmos5l_dlygate4sd3_1_6.X a_9446_15234# 0.21332f
C1402 sg13cmos5l_dfrbpq_1_6.D sg13cmos5l_buf_16_2.X 0.01832f
C1403 sg13cmos5l_dlygate4sd3_1_18.X sg13cmos5l_dlygate4sd3_1_15.A 0.09344f
C1404 a_17142_16020# sg13cmos5l_a21oi_1_0.A1 0.0126f
C1405 sg13cmos5l_a21oi_1_1.Y a_21070_16263# 0.01491f
C1406 a_15680_13854# VDD 0.08654f
C1407 sg13cmos5l_nor2_1_0.Y a_2822_15234# 0.17396f
C1408 sg13cmos5l_dlygate4sd3_1_6.X sg13cmos5l_nand4_1_0.Y 0.05042f
C1409 a_15486_15486# a_15287_15549# 0.08889f
C1410 a_25115_15996# VDD 0.17004f
C1411 a_3627_15356# a_4367_15311# 0.17382f
C1412 a_8417_13912# sg13cmos5l_dlygate4sd3_1_0.A 0.01189f
C1413 a_15208_15996# sg13cmos5l_or3_1_2.B 0.19329f
C1414 a_20678_14922# a_20964_14488# 0.26205f
C1415 sg13cmos5l_dfrbpq_1_2.CLK a_10020_15247# 0.01199f
C1416 a_26532_13735# a_26661_13701# 0.01562f
C1417 sg13cmos5l_dlygate4sd3_1_5.A sg13cmos5l_dlygate4sd3_1_11.X 0.19824f
C1418 a_2880_14523# sg13cmos5l_xnor2_1_0.Y 0.12711f
C1419 a_17508_14488# a_18673_14845# 0.25046f
C1420 a_16163_16265# VDD 0.2475f
C1421 sg13cmos5l_inv_1_0.Y sg13cmos5l_dlygate4sd3_1_1.X 0.08189f
C1422 a_16140_14750# sg13cmos5l_dfrbpq_1_2.RESET_B 0.02869f
C1423 a_6752_13854# sg13cmos5l_dlygate4sd3_1_1.X 0.01252f
C1424 sg13cmos5l_dlygate4sd3_1_5.A sg13cmos5l_nor2_1_0.Y 0.01332f
C1425 a_20964_14488# a_21252_14909# 0.24435f
C1426 sg13cmos5l_dfrbpq_1_7.Q a_24520_15366# 0.03338f
C1427 a_18582_15302# a_19150_15423# 0.01641f
C1428 a_25697_15424# sg13cmos5l_o21ai_1_3.Y 0.03916f
C1429 a_23864_14850# sg13cmos5l_o21ai_1_2.A2 0.01437f
C1430 a_18970_16237# a_19049_16334# 0.08889f
C1431 a_17825_16262# a_18106_15960# 0.18796f
C1432 sg13cmos5l_dfrbpq_1_0.RESET_B a_2822_15234# 0.09858f
C1433 a_24982_13350# sg13cmos5l_o21ai_1_3.B1 0.02671f
C1434 sg13cmos5l_o21ai_1_3.A2 a_25129_13726# 0.17428f
C1435 a_3082_15457# VDD 0.11394f
C1436 sg13cmos5l_dfrbpq_1_3.RESET_B a_18106_15960# 0.0144f
C1437 sg13cmos5l_o21ai_1_2.A2 VDD 0.70955f
C1438 a_18716_15976# sg13cmos5l_dlygate4sd3_1_7.A 0.01087f
C1439 a_16163_16265# sg13cmos5l_o21ai_1_2.A1 0.19219f
C1440 sg13cmos5l_dfrbpq_1_7.D a_25402_14448# 0.01039f
C1441 a_6906_12935# sg13cmos5l_dlygate4sd3_1_1.A 0.14875f
C1442 a_21483_14495# a_22480_14726# 0.03546f
C1443 sg13cmos5l_dfrbpq_1_7.Q sg13cmos5l_o21ai_1_3.Y 0.03776f
C1444 a_25080_12952# VDD 0.01816f
C1445 a_17584_13942# VDD 0.13929f
C1446 a_27022_13239# a_26816_13058# 0.01604f
C1447 sg13cmos5l_or3_1_3.X sg13cmos5l_dlygate4sd3_1_19.X 0.43949f
C1448 a_21381_14495# sg13cmos5l_or3_1_2.A 0.04208f
C1449 sg13cmos5l_dfrbpq_1_6.RESET_B a_20974_15423# 0.05385f
C1450 a_17482_14452# VDD 0.09636f
C1451 a_21089_15424# VDD 0.20689f
C1452 a_16587_13844# a_16356_13735# 0.07823f
C1453 a_16068_14040# a_17233_13799# 0.25046f
C1454 sg13cmos5l_o21ai_1_2.A1 sg13cmos5l_o21ai_1_2.A2 0.89787f
C1455 a_17327_13799# a_17584_13942# 0.23043f
C1456 sg13cmos5l_xor2_1_1.B sg13cmos5l_xor2_1_1.A 0.2713f
C1457 sg13cmos5l_dfrbpq_1_3.Q a_22330_15202# 0.01235f
C1458 a_38720_10034# VDD 0.0583f
C1459 a_21865_13726# VDD 0.28646f
C1460 a_3782_15996# sg13cmos5l_nor2_1_0.B 0.02531f
C1461 sg13cmos5l_buf_16_2.X VDD 2.33472f
C1462 a_3294_15934# a_3512_16037# 0.01303f
C1463 clock_i sg13cmos5l_dlygate4sd3_1_3.X 0.01586f
C1464 sg13cmos5l_dfrbpq_1_2.Q counter_value_o[3] 0.01042f
C1465 a_6948_14909# a_7179_14495# 0.07823f
C1466 sg13cmos5l_dlygate4sd3_1_5.A sg13cmos5l_dfrbpq_1_0.RESET_B 0.07639f
C1467 sg13cmos5l_buf_16_2.X sg13cmos5l_o21ai_1_1.Y 0.26555f
C1468 a_12232_16082# counter_value_o[2] 0.02116f
C1469 a_9732_15552# a_10897_15311# 0.25046f
C1470 a_10251_15356# a_10020_15247# 0.07823f
C1471 sg13cmos5l_dfrbpq_1_3.RESET_B a_17222_14922# 0.07955f
C1472 sg13cmos5l_dlygate4sd3_1_1.X a_6566_15238# 0.04643f
C1473 sg13cmos5l_o21ai_1_3.A2 sg13cmos5l_o21ai_1_2.Y 0.05563f
C1474 sg13cmos5l_nor2_1_3.B sg13cmos5l_dfrbpq_1_2.RESET_B 0.08069f
C1475 a_7354_13690# sg13cmos5l_xor2_1_1.B 0.01266f
C1476 sg13cmos5l_dfrbpq_1_2.CLK a_7825_14845# 0.0117f
C1477 a_38536_10034# a_38720_10034# 0.05762f
C1478 sg13cmos5l_o21ai_1_2.A1 sg13cmos5l_buf_16_2.X 1.3404f
C1479 a_3095_16071# sg13cmos5l_xnor2_1_0.Y 0.01489f
C1480 sg13cmos5l_dfrbpq_1_0.RESET_B sg13cmos5l_nor2_1_0.Y 0.0691f
C1481 a_7919_14845# a_7825_14845# 0.16704f
C1482 sg13cmos5l_buf_16_2.X a_19534_13726# 0.99399f
C1483 sg13cmos5l_dfrbpq_1_2.Q sg13cmos5l_o21ai_1_3.A2 0.31541f
C1484 sg13cmos5l_nor2_1_1.B sg13cmos5l_nor2_1_1.Y 0.19142f
C1485 sg13cmos5l_dlygate4sd3_1_11.A sg13cmos5l_dfrbpq_1_2.CLK 0.1351f
C1486 a_9368_14525# sg13cmos5l_nor2_1_1.B 0.01809f
C1487 a_2536_13058# VDD 0.16062f
C1488 sg13cmos5l_dfrbpq_1_6.Q a_27706_15202# 0.01524f
C1489 sg13cmos5l_dfrbpq_1_6.RESET_B sg13cmos5l_or3_1_2.X 0.04064f
C1490 sg13cmos5l_o21ai_1_3.A2 sg13cmos5l_o21ai_1_3.B1 0.14961f
C1491 sg13cmos5l_dlygate4sd3_1_20.A VDD 2.43989f
C1492 a_12212_15202# a_12032_15366# 0.0182f
C1493 sg13cmos5l_dlygate4sd3_1_20.A a_27418_12936# 0.29064f
C1494 sg13cmos5l_inv_1_0.Y a_17222_14922# 0.01917f
C1495 sg13cmos5l_or3_1_2.B a_16042_13945# 0.01491f
C1496 a_9446_15234# a_9706_15457# 0.45119f
C1497 a_5495_15549# sg13cmos5l_dfrbpq_1_1.RESET_B 0.02048f
C1498 sg13cmos5l_dfrbpq_1_7.D sg13cmos5l_dfrbpq_1_7.RESET_B 0.1264f
C1499 a_7136_15366# sg13cmos5l_dlygate4sd3_1_3.X 0.01243f
C1500 a_26026_14452# sg13cmos5l_dfrbpq_1_5.D 0.02708f
C1501 a_18610_16374# sg13cmos5l_dlygate4sd3_1_10.X 0.02829f
C1502 sg13cmos5l_xor2_1_1.A sg13cmos5l_buf_1_0.X 0.12773f
C1503 sg13cmos5l_nand4_1_0.Y a_9706_15457# 0.01155f
C1504 sg13cmos5l_dlygate4sd3_1_5.A sg13cmos5l_xor2_1_1.B 0.02729f
C1505 sg13cmos5l_inv_1_0.Y a_24821_15532# 0.03576f
C1506 a_3396_15247# a_2822_15234# 0.18486f
C1507 sg13cmos5l_o21ai_1_2.B1 a_24265_14508# 0.25848f
C1508 a_19049_16334# VDD 0.07226f
C1509 a_6634_14452# a_6660_14488# 0.24169f
C1510 a_12524_15960# sg13cmos5l_dlygate4sd3_1_11.A 0.19435f
C1511 sg13cmos5l_dlygate4sd3_1_1.X sg13cmos5l_dfrbpq_1_1.D 0.14663f
C1512 enable_i a_1192_3900# 0.1951f
C1513 sg13cmos5l_dfrbpq_1_5.RESET_B a_26561_15424# 0.06532f
C1514 sg13cmos5l_dfrbpq_1_6.Q a_24258_15242# 0.01111f
C1515 sg13cmos5l_inv_1_0.Y a_20182_14862# 0.01244f
C1516 a_18027_14495# a_17222_14922# 0.07916f
C1517 sg13cmos5l_dfrbpq_1_6.RESET_B sg13cmos5l_or3_1_2.A 0.03015f
C1518 a_26052_14488# sg13cmos5l_o21ai_1_3.Y 0.01391f
C1519 sg13cmos5l_dfrbpq_1_2.Q sg13cmos5l_dlygate4sd3_1_13.X 0.04276f
C1520 a_2536_14570# sg13cmos5l_xnor2_1_0.A 0.01671f
C1521 a_28170_14020# VDD 0.28617f
C1522 a_26218_13945# a_26661_13701# 0.02241f
C1523 sg13cmos5l_inv_1_0.Y sg13cmos5l_or3_1_2.X 0.02398f
C1524 sg13cmos5l_inv_1_0.Y a_25288_15366# 0.03128f
C1525 a_17825_16262# sg13cmos5l_a21oi_1_0.A1 0.01261f
C1526 a_11658_15532# sg13cmos5l_dfrbpq_1_2.CLK 0.01149f
C1527 sg13cmos5l_dfrbpq_1_3.RESET_B sg13cmos5l_a21oi_1_0.A1 0.03891f
C1528 sg13cmos5l_o21ai_1_2.Y a_25129_13726# 0.03121f
C1529 sg13cmos5l_xor2_1_1.A sg13cmos5l_dfrbpq_1_2.CLK 0.10031f
C1530 sg13cmos5l_buf_1_10.X VDD 1.17949f
C1531 sg13cmos5l_dfrbpq_1_6.Q a_22480_14726# 0.01543f
C1532 a_10251_15356# sg13cmos5l_dlygate4sd3_1_11.A 0.03359f
C1533 a_10149_15213# a_10433_14750# 0.0115f
C1534 sg13cmos5l_or3_1_2.C VDD 0.54566f
C1535 sg13cmos5l_or3_1_2.C sg13cmos5l_o21ai_1_1.Y 0.05419f
C1536 sg13cmos5l_or3_1_2.B VDD 1.76298f
C1537 a_27425_15424# VDD 0.20643f
C1538 sg13cmos5l_inv_1_0.Y sg13cmos5l_or3_1_2.A 0.04314f
C1539 a_4624_15454# VDD 0.13981f
C1540 a_21728_15366# VDD 0.0782f
C1541 a_9446_15234# a_9732_15552# 0.26205f
C1542 sg13cmos5l_or3_1_2.B a_17327_13799# 0.01909f
C1543 a_10991_15311# sg13cmos5l_dlygate4sd3_1_11.A 0.02268f
C1544 a_21934_15423# a_22049_15424# 0.3854f
C1545 sg13cmos5l_o21ai_1_1.Y a_21728_15366# 0.03907f
C1546 sg13cmos5l_o21ai_1_2.A1 sg13cmos5l_or3_1_2.C 1.17386f
C1547 sg13cmos5l_o21ai_1_3.B1 a_25129_13726# 0.22867f
C1548 a_22508_15960# sg13cmos5l_dfrbpq_1_3.Q 0.20017f
C1549 a_3627_15356# a_3108_15552# 0.20773f
C1550 sg13cmos5l_or3_1_2.C a_19534_13726# 0.03735f
C1551 sg13cmos5l_inv_1_0.Y sg13cmos5l_a21oi_1_0.A1 0.05417f
C1552 a_21850_16237# a_22053_16033# 0.02453f
C1553 a_9732_15552# sg13cmos5l_nand4_1_0.Y 0.01137f
C1554 a_4762_14448# VDD 0.29176f
C1555 sg13cmos5l_or3_1_2.B sg13cmos5l_o21ai_1_2.A1 0.18458f
C1556 a_15790_15238# VDD 1.70049f
C1557 a_3525_15213# sg13cmos5l_nor2_1_0.B 0.05111f
C1558 a_5495_15315# VDD 0.0702f
C1559 a_17508_14488# a_17222_14922# 0.26205f
C1560 sg13cmos5l_or3_1_2.B a_19534_13726# 0.08705f
C1561 sg13cmos5l_dlygate4sd3_1_5.A sg13cmos5l_buf_1_0.X 0.09834f
C1562 sg13cmos5l_dlygate4sd3_1_11.X sg13cmos5l_buf_1_0.X 0.15524f
C1563 a_3627_15356# sg13cmos5l_xnor2_1_0.A 0.01584f
C1564 sg13cmos5l_inv_1_0.Y sg13cmos5l_dlygate4sd3_1_11.A 0.03372f
C1565 sg13cmos5l_dfrbpq_1_2.Q sg13cmos5l_buf_16_2.A 0.3708f
C1566 a_27760_13942# sg13cmos5l_dlygate4sd3_1_20.A 0.01466f
C1567 sg13cmos5l_inv_1_0.Y a_9638_14484# 0.01491f
C1568 a_21929_16334# a_22053_16033# 0.08186f
C1569 sg13cmos5l_o21ai_1_2.A1 a_15790_15238# 0.06126f
C1570 a_26469_14495# a_25766_14922# 0.02431f
C1571 sg13cmos5l_nor2_1_0.Y sg13cmos5l_buf_1_0.X 0.01708f
C1572 a_18610_16374# a_18970_16237# 0.01556f
C1573 a_17584_13942# sg13cmos5l_dfrbpq_1_2.RESET_B 0.09962f
C1574 sg13cmos5l_or3_1_1.X sg13cmos5l_o21ai_1_3.Y 0.10856f
C1575 VDD a_25978_15202# 0.25816f
C1576 a_18582_15302# VDD 0.16082f
C1577 sg13cmos5l_dfrbpq_1_5.RESET_B a_25958_13722# 0.13534f
C1578 a_16163_16265# sg13cmos5l_a21oi_1_0.A2 0.15101f
C1579 sg13cmos5l_dlygate4sd3_1_5.A sg13cmos5l_dfrbpq_1_2.CLK 0.04186f
C1580 sg13cmos5l_dfrbpq_1_6.Q a_24265_14508# 0.01771f
C1581 a_21483_14495# VDD 0.20808f
C1582 sg13cmos5l_or3_1_2.X a_21370_15202# 0.01503f
C1583 a_10991_15311# a_11658_15532# 0.09257f
C1584 sg13cmos5l_dlygate4sd3_1_11.X sg13cmos5l_dfrbpq_1_2.CLK 0.67728f
C1585 sg13cmos5l_buf_16_2.X a_20678_14922# 0.0385f
C1586 a_27760_13942# a_28170_14020# 0.07015f
C1587 sg13cmos5l_o21ai_1_2.A1 a_18582_15302# 0.05647f
C1588 sg13cmos5l_dfrbpq_1_2.CLK a_16587_13844# 0.03738f
C1589 sg13cmos5l_xnor2_1_1.A sg13cmos5l_a21oi_1_0.A1 0.02941f
C1590 VDD a_3782_15996# 0.20774f
C1591 sg13cmos5l_dlygate4sd3_1_6.X a_10020_15247# 0.01387f
C1592 VDD a_3095_16301# 0.07968f
C1593 sg13cmos5l_or3_1_3.X a_24704_15366# 0.02162f
C1594 sg13cmos5l_o21ai_1_2.B1 VDD 0.35443f
C1595 sg13cmos5l_o21ai_1_2.A1 a_21483_14495# 0.01164f
C1596 sg13cmos5l_dlygate4sd3_1_11.X a_8156_15532# 0.01061f
C1597 sg13cmos5l_nor2_1_1.B VDD 0.22197f
C1598 a_7985_15288# VDD 0.17882f
C1599 sg13cmos5l_dfrbpq_1_0.RESET_B sg13cmos5l_buf_1_0.X 0.01077f
C1600 a_6760_16082# sg13cmos5l_dlygate4sd3_1_3.X 0.03129f
C1601 sg13cmos5l_inv_1_0.Y sg13cmos5l_xor2_1_1.A 0.02474f
C1602 a_21370_15202# sg13cmos5l_or3_1_2.A 0.02794f
C1603 a_10318_14751# sg13cmos5l_dlygate4sd3_1_11.X 0.10701f
C1604 a_5495_15549# VDD 0.07701f
C1605 sg13cmos5l_o21ai_1_2.A1 sg13cmos5l_o21ai_1_2.B1 0.19548f
C1606 a_26052_14488# a_27217_14845# 0.25046f
C1607 a_27112_16082# a_26825_16334# 0.01212f
C1608 sg13cmos5l_dfrbpq_1_3.RESET_B a_18767_14845# 0.10879f
C1609 sg13cmos5l_inv_1_0.Y sg13cmos5l_dlygate4sd3_1_15.A 0.22499f
C1610 sg13cmos5l_dfrbpq_1_1.D a_6184_14570# 0.04459f
C1611 a_8302_13911# a_8417_13912# 0.3854f
C1612 sg13cmos5l_dfrbpq_1_5.RESET_B a_26340_14909# 0.01093f
C1613 a_27311_14845# a_27978_14484# 0.09257f
C1614 sg13cmos5l_dfrbpq_1_7.RESET_B a_26026_14452# 0.19251f
C1615 sg13cmos5l_dlygate4sd3_1_0.A sg13cmos5l_nor2_1_1.B 0.03112f
C1616 VDD a_26763_13844# 0.20658f
C1617 a_26746_16237# a_26441_16334# 0.01055f
C1618 sg13cmos5l_o21ai_1_2.A2 a_24128_14570# 0.03048f
C1619 a_16461_16020# a_16163_16265# 0.02103f
C1620 a_10251_15356# sg13cmos5l_dlygate4sd3_1_11.X 0.0119f
C1621 sg13cmos5l_dfrbpq_1_3.Q sg13cmos5l_o21ai_1_2.A2 0.11879f
C1622 a_25121_14750# VDD 0.20695f
C1623 a_9446_15234# VDD 0.52305f
C1624 sg13cmos5l_dfrbpq_1_0.RESET_B a_3294_15934# 0.05176f
C1625 a_24982_13350# sg13cmos5l_o21ai_1_3.Y 0.07128f
C1626 a_27500_15960# sg13cmos5l_dfrbpq_1_6.Q 0.19666f
C1627 a_21850_16237# VDD 0.09553f
C1628 sg13cmos5l_dfrbpq_1_7.RESET_B a_26571_14495# 0.28067f
C1629 sg13cmos5l_dfrbpq_1_7.RESET_B sg13cmos5l_dlygate4sd3_1_15.A 0.03425f
C1630 a_25115_15996# sg13cmos5l_a21oi_1_2.Y 0.02315f
C1631 sg13cmos5l_nand4_1_0.Y VDD 1.12224f
C1632 a_4367_15311# a_4624_15454# 0.23043f
C1633 sg13cmos5l_dlygate4sd3_1_5.A sg13cmos5l_xor2_1_0.B 0.24856f
C1634 a_2248_16082# counter_value_o[0] 0.02116f
C1635 sg13cmos5l_o21ai_1_2.A1 a_25121_14750# 0.02076f
C1636 sg13cmos5l_buf_16_2.X a_26661_13701# 0.21387f
C1637 sg13cmos5l_xor2_1_1.B sg13cmos5l_buf_1_0.X 0.38506f
C1638 sg13cmos5l_xor2_1_0.B sg13cmos5l_dlygate4sd3_1_11.X 0.18675f
C1639 a_21929_16334# a_22216_16082# 0.01212f
C1640 sg13cmos5l_dfrbpq_1_1.RESET_B sg13cmos5l_dlygate4sd3_1_1.X 0.41955f
C1641 a_7916_15960# VDD 0.22408f
C1642 a_21929_16334# VDD 0.07567f
C1643 sg13cmos5l_inv_1_0.Y sg13cmos5l_dlygate4sd3_1_19.X 0.17407f
C1644 sg13cmos5l_buf_16_2.X sg13cmos5l_dfrbpq_1_3.Q 0.02473f
C1645 sg13cmos5l_dlygate4sd3_1_10.X a_18106_15960# 0.01098f
C1646 a_26469_14495# VDD 0.24403f
C1647 sg13cmos5l_inv_1_0.Y sg13cmos5l_dlygate4sd3_1_5.A 0.07546f
C1648 a_18610_16374# sg13cmos5l_o21ai_1_2.A1 0.0735f
C1649 a_18027_14495# a_18767_14845# 0.17382f
C1650 a_20678_14922# sg13cmos5l_or3_1_2.C 0.01634f
C1651 a_25496_16037# VDD 0.25779f
C1652 sg13cmos5l_inv_1_0.Y sg13cmos5l_dlygate4sd3_1_11.X 0.0279f
C1653 a_21466_15960# a_21850_16237# 0.01303f
C1654 sg13cmos5l_or3_1_2.B sg13cmos5l_dfrbpq_1_2.RESET_B 0.06401f
C1655 sg13cmos5l_dfrbpq_1_2.Q a_17925_14495# 0.02748f
C1656 sg13cmos5l_xor2_1_1.B sg13cmos5l_dfrbpq_1_2.CLK 0.01378f
C1657 sg13cmos5l_dlygate4sd3_1_0.A sg13cmos5l_nand4_1_0.Y 0.02914f
C1658 a_5694_15486# a_5495_15315# 0.02453f
C1659 sg13cmos5l_dfrbpq_1_6.Q VDD 1.12054f
C1660 sg13cmos5l_inv_1_0.Y sg13cmos5l_nor2_1_0.Y 0.33024f
C1661 a_27137_13238# sg13cmos5l_o21ai_1_3.B1 0.01381f
C1662 a_27311_14845# VDD 0.17754f
C1663 a_15809_16344# sg13cmos5l_a21oi_1_0.A1 0.0108f
C1664 a_32492_15960# VDD 0.22838f
C1665 sg13cmos5l_inv_1_0.Y sg13cmos5l_dlygate4sd3_1_18.X 0.04861f
C1666 sg13cmos5l_or3_1_2.X a_22049_15424# 0.03844f
C1667 a_6374_14922# a_6634_14452# 0.45119f
C1668 sg13cmos5l_dlygate4sd3_1_0.A a_7916_15960# 0.1905f
C1669 a_10025_13668# VDD 0.10634f
C1670 a_3082_15457# a_3108_15552# 0.24169f
C1671 sg13cmos5l_dlygate4sd3_1_1.A VDD 0.2819f
C1672 sg13cmos5l_buf_16_2.X a_26052_14488# 0.09176f
C1673 sg13cmos5l_dfrbpq_1_2.RESET_B a_15790_15238# 0.09203f
C1674 a_15782_13722# a_16587_13844# 0.07916f
C1675 a_25115_15996# sg13cmos5l_or3_1_1.X 0.07517f
C1676 sg13cmos5l_dfrbpq_1_6.Q sg13cmos5l_o21ai_1_2.A1 0.01123f
C1677 a_3525_15213# VDD 0.25444f
C1678 a_26949_16033# VDD 0.066f
C1679 a_27425_15424# sg13cmos5l_dfrbpq_1_7.Q 0.02021f
C1680 sg13cmos5l_a21oi_1_0.Y sg13cmos5l_a21oi_1_0.A1 0.70763f
C1681 a_16140_14750# a_16175_14854# 0.19075f
C1682 a_22508_15960# counter_value_o[4] 0.15504f
C1683 sg13cmos5l_o21ai_1_3.A2 sg13cmos5l_o21ai_1_3.Y 0.5088f
C1684 a_3082_15457# sg13cmos5l_xnor2_1_0.A 0.01086f
C1685 a_27310_15423# a_27425_15424# 0.3854f
C1686 sg13cmos5l_inv_1_0.Y sg13cmos5l_or3_1_3.X 0.03005f
C1687 a_15782_13722# a_16356_13735# 0.18486f
C1688 a_2540_15960# sg13cmos5l_dlygate4sd3_1_5.A 0.19598f
C1689 sg13cmos5l_dfrbpq_1_2.CLK a_14549_15238# 0.01294f
C1690 a_26532_13735# a_25958_13722# 0.18486f
C1691 sg13cmos5l_or3_1_2.A a_22049_15424# 0.02646f
C1692 a_27760_13942# a_26763_13844# 0.03412f
C1693 sg13cmos5l_dlygate4sd3_1_5.A a_6566_15238# 0.01389f
C1694 a_6634_14452# a_7077_14495# 0.02241f
C1695 a_17508_14488# a_18767_14845# 0.01412f
C1696 sg13cmos5l_or3_1_2.B clock_i 0.03424f
C1697 a_6568_13854# a_6752_13854# 0.05762f
C1698 a_6906_12935# sg13cmos5l_xor2_1_1.A 0.06529f
C1699 a_20678_14922# a_21483_14495# 0.07916f
C1700 a_25697_15424# a_25978_15202# 0.18796f
C1701 a_18470_15238# a_18582_15302# 0.3854f
C1702 sg13cmos5l_o21ai_1_2.A1 a_18673_14845# 0.01806f
C1703 sg13cmos5l_buf_1_0.X a_3123_14484# 0.0139f
C1704 counter_value_o[7] VSS 2.57219f
C1705 counter_value_o[6] VSS 1.58629f
C1706 counter_value_o[5] VSS 1.91845f
C1707 counter_value_o[4] VSS 1.59735f
C1708 counter_value_o[3] VSS 1.70211f
C1709 counter_value_o[2] VSS 1.77117f
C1710 counter_value_o[1] VSS 1.72923f
C1711 counter_value_o[0] VSS 1.57683f
C1712 a_38720_3986# VSS 0.07631f ; **FLOATING
C1713 a_38536_3986# VSS 0.10768f ; **FLOATING
C1714 a_38720_10034# VSS 0.07628f ; **FLOATING
C1715 a_38536_10034# VSS 0.10768f ; **FLOATING
C1716 a_38720_13058# VSS 0.07556f ; **FLOATING
C1717 a_38536_13058# VSS 0.11218f ; **FLOATING
C1718 a_27137_13238# VSS 0.14216f
C1719 a_26816_13058# VSS 0.06836f ; **FLOATING
C1720 a_25080_12952# VSS 0.55604f
C1721 a_24808_13058# VSS 0.09966f ; **FLOATING
C1722 a_7358_12972# VSS 0.69259f
C1723 a_6932_12972# VSS 0.21655f
C1724 a_24982_13350# VSS 0.16835f
C1725 a_7062_13330# VSS 0.06493f
C1726 a_6752_13058# VSS 0.05139f ; **FLOATING
C1727 a_2536_13058# VSS 0.11106f ; **FLOATING
C1728 sg13cmos5l_buf_1_10.X VSS 0.25623f
C1729 a_38632_13854# VSS 0.14915f ; **FLOATING
C1730 a_27409_13799# VSS 0.06782f
C1731 a_26470_13735# VSS 0.80161f
C1732 a_26532_13735# VSS 0.63619f
C1733 a_27705_14037# VSS 0.14465f
C1734 a_26052_13722# VSS 0.01543f
C1735 a_26601_14113# VSS 0.22468f
C1736 a_26244_14040# VSS 0.20193f
C1737 a_25958_13722# VSS 0.35961f
C1738 a_25768_13854# VSS 0.07944f ; **FLOATING
C1739 a_25325_14020# VSS 0.04381f
C1740 a_25223_14020# VSS 0.2331f
C1741 a_24992_13854# VSS 0.0447f ; **FLOATING
C1742 a_24502_13718# VSS 0.77539f
C1743 a_21959_14020# VSS 0.21907f
C1744 a_17233_13799# VSS 0.20604f
C1745 a_16356_13735# VSS 0.13251f
C1746 a_17529_14037# VSS 0.07713f
C1747 a_15876_13722# VSS 0.04147f
C1748 a_16425_14113# VSS 0.50446f
C1749 a_16068_14040# VSS 0.19905f
C1750 a_15782_13722# VSS 0.55304f
C1751 a_15680_13854# VSS 0.06435f ; **FLOATING
C1752 a_10025_13668# VSS 0.07029f
C1753 a_9736_13854# VSS 0.10579f ; **FLOATING
C1754 a_8096_13854# VSS 0.05081f ; **FLOATING
C1755 a_8302_13911# VSS 0.06836f
C1756 a_7354_13690# VSS 0.02862f
C1757 a_6752_13854# VSS 0.03912f ; **FLOATING
C1758 a_6568_13854# VSS 0.10228f ; **FLOATING
C1759 a_27513_14607# VSS 0.18888f
C1760 a_26409_14531# VSS 0.10623f
C1761 a_27730_14922# VSS 0.20355f
C1762 a_27217_14845# VSS 0.14387f
C1763 a_26340_14909# VSS 0.63025f
C1764 a_26278_14909# VSS 0.59359f
C1765 a_24461_14508# VSS 0.28936f
C1766 a_25860_14922# VSS 0.17342f
C1767 a_25766_14922# VSS 0.72425f
C1768 a_25121_14750# VSS 0.18784f
C1769 a_24128_14570# VSS 0.04257f ; **FLOATING
C1770 a_23864_14850# VSS 0.82817f
C1771 a_23762_14850# VSS 0.01603f
C1772 a_21321_14531# VSS 0.50315f
C1773 a_20280_14464# VSS 1.22859f
C1774 a_22129_14845# VSS 0.34199f
C1775 a_21252_14909# VSS 0.29275f
C1776 a_21190_14909# VSS 0.1593f
C1777 a_20772_14922# VSS 0.07854f
C1778 a_20678_14922# VSS 0.38112f
C1779 a_20182_14862# VSS 0.39586f
C1780 a_17865_14531# VSS 0.60608f
C1781 a_18673_14845# VSS 0.21366f
C1782 a_17796_14909# VSS 0.03666f
C1783 a_16314_14484# VSS 0.09105f
C1784 a_15818_14484# VSS 0.33428f
C1785 a_17316_14922# VSS 0.21299f
C1786 a_16596_14832# VSS 0.39189f
C1787 a_17222_14922# VSS 0.97922f
C1788 a_16175_14854# VSS 0.19988f
C1789 a_15496_14570# VSS 0.09504f ; **FLOATING
C1790 sg13cmos5l_nor2_1_3.B VSS 0.10503f
C1791 a_9638_14484# VSS 0.25273f
C1792 a_10318_14751# VSS 0.15976f
C1793 a_7017_14531# VSS 0.21281f
C1794 a_7825_14845# VSS 0.29037f
C1795 a_6948_14909# VSS 0.53955f
C1796 a_6886_14909# VSS 0.50289f
C1797 a_6184_14570# VSS 0.09412f ; **FLOATING
C1798 a_3626_14484# VSS 2.51579f
C1799 a_6468_14922# VSS 0.22775f
C1800 a_6374_14922# VSS 1.25131f
C1801 a_4481_14750# VSS 0.14174f
C1802 a_3029_14854# VSS 0.2394f
C1803 a_2843_14832# VSS 0.53098f
C1804 a_2536_14570# VSS 0.1142f ; **FLOATING
C1805 sg13cmos5l_o21ai_1_2.B1 VSS 0.03474f
C1806 a_26842_15202# VSS 0.08799f
C1807 sg13cmos5l_dfrbpq_1_5.D VSS 0.05839f
C1808 a_25978_15202# VSS 0.50125f
C1809 a_25288_15366# VSS 0.08424f ; **FLOATING
C1810 a_24915_15260# VSS 0.2574f
C1811 a_24704_15366# VSS 0.03775f ; **FLOATING
C1812 a_24520_15366# VSS 0.08491f ; **FLOATING
C1813 a_24258_15242# VSS 0.01252f
C1814 a_24821_15532# VSS 0.16379f
C1815 a_23752_15366# VSS 0.10807f ; **FLOATING
C1816 a_21728_15366# VSS 0.04409f ; **FLOATING
C1817 a_20609_15260# VSS 0.01131f
C1818 a_21370_15202# VSS 0.24665f
C1819 a_20507_15532# VSS 0.29922f
C1820 a_19904_15366# VSS 0.04184f ; **FLOATING
C1821 sg13cmos5l_or3_1_2.X VSS 0.84453f
C1822 sg13cmos5l_dlygate4sd3_1_13.X VSS 0.15213f
C1823 a_18470_15238# VSS 0.13492f
C1824 a_18080_15366# VSS 0.04268f ; **FLOATING
C1825 a_12032_15366# VSS 0.0459f ; **FLOATING
C1826 a_10897_15311# VSS 0.06784f
C1827 a_9958_15247# VSS 0.82133f
C1828 a_10020_15247# VSS 0.53996f
C1829 a_11193_15549# VSS 0.14817f
C1830 a_9540_15234# VSS 0.06033f
C1831 a_7550_15242# VSS 0.06392f
C1832 a_7448_15242# VSS 0.06903f
C1833 a_7346_15242# VSS 0.01202f
C1834 a_10089_15625# VSS 0.05014f
C1835 a_9732_15552# VSS 0.15765f
C1836 a_9446_15234# VSS 0.6188f
C1837 sg13cmos5l_nor2_1_1.B VSS 0.18888f
C1838 a_8156_15532# VSS 0.59421f
C1839 a_7953_15556# VSS 0.15795f
C1840 a_7136_15366# VSS 0.04171f ; **FLOATING
C1841 a_6678_15302# VSS 0.19462f
C1842 a_6026_15532# VSS 0.24043f
C1843 a_6296_15238# VSS 0.08606f
C1844 sg13cmos5l_dlygate4sd3_1_1.X VSS 0.12314f
C1845 a_5495_15549# VSS 0.04959f
C1846 a_5408_15366# VSS 0.04176f ; **FLOATING
C1847 a_5694_15486# VSS 0.05852f
C1848 a_4273_15311# VSS 0.2668f
C1849 a_3334_15247# VSS 0.11557f
C1850 a_3396_15247# VSS 0.1623f
C1851 a_3465_15625# VSS 0.51285f
C1852 a_3108_15552# VSS 0.15951f
C1853 a_2822_15234# VSS 0.57608f
C1854 a_2720_15366# VSS 0.0366f ; **FLOATING
C1855 a_2536_15366# VSS 0.10207f ; **FLOATING
C1856 a_37192_16082# VSS 0.10237f ; **FLOATING
C1857 a_37484_15960# VSS 0.0535f
C1858 a_32200_16082# VSS 0.10237f ; **FLOATING
C1859 a_32492_15960# VSS 0.05268f
C1860 sg13cmos5l_dfrbpq_1_6.Q VSS 0.17729f
C1861 a_27296_16082# VSS 0.0393f ; **FLOATING
C1862 a_27112_16082# VSS 0.07752f ; **FLOATING
C1863 a_25115_15996# VSS 0.17083f
C1864 a_26746_16237# VSS 0.0564f
C1865 a_26362_16237# VSS 0.05663f
C1866 a_25217_16344# VSS 0.32003f
C1867 a_24808_16082# VSS 0.11127f ; **FLOATING
C1868 a_26825_16334# VSS 0.05243f
C1869 a_26441_16334# VSS 0.05091f
C1870 a_25878_16020# VSS 0.21095f
C1871 a_22216_16082# VSS 0.08363f ; **FLOATING
C1872 a_21850_16237# VSS 0.08298f
C1873 a_21185_16262# VSS 0.11365f
C1874 a_20864_16082# VSS 0.04024f ; **FLOATING
C1875 a_20680_16082# VSS 0.10467f ; **FLOATING
C1876 a_18970_16237# VSS 0.08274f
C1877 a_18610_16374# VSS 0.16581f
C1878 a_15707_15996# VSS 0.15633f
C1879 a_17030_15996# VSS 0.23219f
C1880 a_15809_16344# VSS 0.30825f
C1881 a_17142_16020# VSS 0.08492f
C1882 sg13cmos5l_dlygate4sd3_1_10.X VSS 0.16482f
C1883 sg13cmos5l_xnor2_1_1.A VSS 0.06086f
C1884 sg13cmos5l_a21oi_1_0.A1 VSS 0.04485f
C1885 a_12232_16082# VSS 0.11075f ; **FLOATING
C1886 a_12524_15960# VSS 0.01253f
C1887 a_7544_16362# VSS 0.09064f
C1888 a_7442_16362# VSS 2.51256f
C1889 a_7066_16366# VSS 0.0699f
C1890 a_6760_16082# VSS 0.092f ; **FLOATING
C1891 sg13cmos5l_xor2_1_1.B VSS 0.06018f
C1892 a_3894_16020# VSS 0.21745f
C1893 a_3512_16037# VSS 0.06929f
C1894 a_3294_15934# VSS 0.08425f
C1895 a_3008_16082# VSS 0.03392f ; **FLOATING
C1896 a_2824_16082# VSS 0.07923f ; **FLOATING
C1897 a_2248_16082# VSS 0.10237f ; **FLOATING
C1898 a_2540_15960# VSS 0.04237f
C1899 VSS.t2 VSS 2.25636f
C1900 VSS.t73 VSS 0.28716f
C1901 VSS.t2927 VSS 1.61487f
C1902 VSS.t2952 VSS 0.03074f
C1903 VSS.t2962 VSS 0.12507f
C1904 VSS.t2982 VSS 0.10147f
C1905 VSS.t2912 VSS 0.3521f
C1906 VSS.t303 VSS 0.08148f
C1907 VSS.t3240 VSS 0.1927f
C1908 VSS.t61 VSS 0.14412f
C1909 VSS.t412 VSS 0.12554f
C1910 VSS.t414 VSS 0.12554f
C1911 VSS.t416 VSS 0.25015f
C1912 VSS.t417 VSS 0.25015f
C1913 VSS.t44 VSS 0.95064f
C1914 VSS.t77 VSS 0.57858f
C1915 VSS.t4 VSS 0.31804f
C1916 VSS.t106 VSS 0.56765f
C1917 VSS.t37 VSS 0.72643f
C1918 VSS.t473 VSS 0.09523f
C1919 VSS.t102 VSS 0.12789f
C1920 VSS.t476 VSS 0.1331f
C1921 VSS.t132 VSS 0.02844f
C1922 VSS.t142 VSS 0.16116f
C1923 VSS.t577 VSS 0.55031f
C1924 VSS.t572 VSS 0.08298f
C1925 VSS.t559 VSS 0.16992f
C1926 VSS.t185 VSS 0.49856f
C1927 VSS.t557 VSS 0.16992f
C1928 VSS.t46 VSS 0.06836f
C1929 VSS.t69 VSS 0.15176f
C1930 VSS.t549 VSS 0.19553f
C1931 VSS.t546 VSS 0.19553f
C1932 VSS.t523 VSS 0.0786f
C1933 VSS.t528 VSS 0.17641f
C1934 VSS.t586 VSS 0.26159f
C1935 VSS.t591 VSS 0.01537f
C1936 VSS.t689 VSS 0.23997f
C1937 VSS.t596 VSS 0.06149f
C1938 VSS.t600 VSS 0.2047f
C1939 VSS.t708 VSS 0.05525f
C1940 VSS.t707 VSS 0.05525f
C1941 VSS.t729 VSS 0.03522f
C1942 VSS.t187 VSS 0.01111f
C1943 VSS.t937 VSS 0.55521f
C1944 VSS.t936 VSS 0.05683f
C1945 VSS.t942 VSS 0.0847f
C1946 VSS.t947 VSS 0.29123f
C1947 VSS.t952 VSS 0.10792f
C1948 VSS.t956 VSS 0.01234f
C1949 VSS.t957 VSS 0.01234f
C1950 VSS.t962 VSS 0.02952f
C1951 VSS.t977 VSS 0.04047f
C1952 VSS.t987 VSS 1.53519f
C1953 VSS.t1002 VSS 0.51909f
C1954 VSS.t1022 VSS 0.10208f
C1955 VSS.t1021 VSS 0.01587f
C1956 VSS.t1027 VSS 0.08938f
C1957 VSS.t1037 VSS 0.13319f
C1958 VSS.t1042 VSS 0.16508f
C1959 VSS.t1047 VSS 0.07728f
C1960 VSS.t395 VSS 0.33592f
C1961 VSS.t109 VSS 0.05268f
C1962 VSS.t98 VSS 0.29886f
C1963 VSS.t275 VSS 0.54612f
C1964 VSS.t343 VSS 0.33592f
C1965 VSS.t328 VSS 0.58962p
C1966 VSS.t168 VSS 2.41696f
C1967 VSS.t313 VSS 0.11496f
C1968 VSS.t104 VSS 0.06086f
C1969 VSS.t63 VSS 0.36062f
C1970 VSS.t216 VSS 0.56014f
C1971 VSS.t430 VSS 0.20936f
C1972 VSS.t202 VSS 0.36174f
C1973 VSS.t1 VSS 0.42984f
C1974 VSS.t228 VSS 0.8213f
C1975 VSS.t49 VSS 0.39773f
C1976 VSS.t9 VSS 0.27422f
C1977 VSS.t121 VSS 0.15522f
C1978 VSS.t42 VSS 0.20853f
C1979 VSS.t40 VSS 0.71356f
C1980 VSS.t118 VSS 0.31069f
C1981 VSS.t66 VSS 0.12171f
C1982 VSS.t81 VSS 0.17321f
C1983 VSS.t18 VSS 0.39073f
C1984 VSS.t629 VSS 0.17947f
C1985 VSS.t625 VSS 0.27644f
C1986 VSS.t636 VSS 0.57633f
C1987 VSS.t609 VSS 0.15765f
C1988 VSS.t737 VSS 0.57315f
C1989 VSS.t126 VSS 0.14216f
C1990 VSS.t3196 VSS 0.13335f
C1991 VSS.t297 VSS 0.217f
C1992 VSS.t1318 VSS 0.06253f
C1993 VSS.t1436 VSS 0.1064f
C1994 VSS.t1319 VSS 0.06253f
C1995 VSS.t1324 VSS 0.14747p
C1996 VSS.t1304 VSS 0.02074f
C1997 VSS.t1285 VSS 0.04761f
C1998 VSS.t1284 VSS 0.04761f
C1999 VSS.t1280 VSS 0.08343f
C2000 VSS.t1277 VSS 0.14973f
C2001 VSS.t1276 VSS 0.14155f
C2002 VSS.t1274 VSS 0.03174f
C2003 VSS.t1268 VSS 0.2143f
C2004 VSS.t1267 VSS 0.2143f
C2005 VSS.t1262 VSS 0.04186f
C2006 VSS.t1249 VSS 0.02586f
C2007 VSS.t1246 VSS 0.01551f
C2008 VSS.t1244 VSS 0.11879f
C2009 VSS.t1231 VSS 0.19093f
C2010 VSS.t1536 VSS 0.42851f
C2011 VSS.t1546 VSS 0.03005f
C2012 VSS.t1556 VSS 0.03093f
C2013 VSS.t1561 VSS 0.01421f
C2014 VSS.t1565 VSS 0.05839f
C2015 VSS.t1566 VSS 0.3233f
C2016 VSS.t1581 VSS 0.2492f
C2017 VSS.t1591 VSS 0.08223f
C2018 VSS.t1590 VSS 0.01037f
C2019 VSS.t1601 VSS 0.032f
C2020 VSS.t1605 VSS 0.10234f
C2021 VSS.t1606 VSS 0.34753f
C2022 VSS.t1616 VSS 0.55544f
C2023 VSS.t1621 VSS 0.0623f
C2024 VSS.t1626 VSS 0.93348f
C2025 VSS.t1636 VSS 0.16863f
C2026 VSS.t1641 VSS 0.03806f
C2027 VSS.t1646 VSS 0.07666f
C2028 VSS.t1656 VSS 0.32646f
C2029 VSS.t1661 VSS 0.03307f
C2030 VSS.t1665 VSS 0.12004f
C2031 VSS.t1666 VSS 0.27655f
C2032 VSS.t1676 VSS 0.78376f
C2033 VSS.t1681 VSS 0.1388f
C2034 VSS.t1691 VSS 0.11322f
C2035 VSS.t1696 VSS 0.0601f
C2036 VSS.t1701 VSS 0.06879f
C2037 VSS.t1706 VSS 0.04019f
C2038 VSS.t1711 VSS 73.73426f
C2039 VSS.t1721 VSS 0.23373f
C2040 VSS.t1713 VSS 73.73426f
C2041 VSS.t2003 VSS 0.03474f
C2042 VSS.t2008 VSS 0.02013f
C2043 VSS.t2005 VSS 0.03474f
C2044 VSS.t2012 VSS 0.01145f
C2045 VSS.t2013 VSS 0.01145f
C2046 VSS.t2018 VSS 0.01275f
C2047 VSS.t2028 VSS 0.49318f
C2048 VSS.t2038 VSS 0.0173f
C2049 VSS.t2042 VSS 0.31564f
C2050 VSS.t2043 VSS 0.31564f
C2051 VSS.t2053 VSS 0.02624f
C2052 VSS.t2088 VSS 0.12751f
C2053 VSS.t2113 VSS 0.02675f
C2054 VSS.t2115 VSS 0.02675f
C2055 VSS.t3142 VSS 0.01916f
C2056 VSS.t2768 VSS 0.7676f
C2057 VSS.t2893 VSS 0.05347f
C2058 VSS.t2774 VSS 0.04691f
C2059 VSS.t2776 VSS 0.027f
C2060 VSS.t2782 VSS 0.05173f
C2061 VSS.t2763 VSS 0.26342f
C2062 VSS.t2762 VSS 0.26342f
C2063 VSS.t2759 VSS 0.11401f
C2064 VSS.t2754 VSS 0.14143f
C2065 VSS.t2747 VSS 0.17209f
C2066 VSS.t2746 VSS 0.17209f
C2067 VSS.t2735 VSS 0.14003f
C2068 VSS.t2724 VSS 0.01861f
C2069 VSS.t2723 VSS 0.01861f
C2070 VSS.t3039 VSS 0.03074f
C2071 VSS.t3034 VSS 0.04927f
C2072 VSS.t3037 VSS 0.03074f
C2073 VSS.t3032 VSS 0.04927f
C2074 VSS.t3072 VSS 0.0405f
C2075 VSS.t3122 VSS 0.02025f
C2076 VSS.t3157 VSS 0.14412f
C2077 VSS.t2718 VSS 0.57633f
C2078 VSS.t2712 VSS 0.03474f
C2079 VSS.t2711 VSS 0.1208f
C2080 VSS.t2706 VSS 0.46536f
C2081 VSS.t2703 VSS 0.12887f
C2082 VSS.t2697 VSS 0.07373f
C2083 VSS.t2470 VSS 0.09389f
C2084 VSS.t2460 VSS 0.08971f
C2085 VSS.t2455 VSS 0.03604f
C2086 VSS.t2450 VSS 0.09397f
C2087 VSS.t2437 VSS 0.11817f
C2088 VSS.t2439 VSS 0.07235f
C2089 VSS.t2440 VSS 0.07235f
C2090 VSS.t2435 VSS 0.11817f
C2091 VSS.t2430 VSS 0.07208f
C2092 VSS.t2422 VSS 0.03282f
C2093 VSS.t2424 VSS 0.10998f
C2094 VSS.t2425 VSS 0.36559f
C2095 VSS.t2420 VSS 0.1466f
C2096 VSS.t2415 VSS 0.08971f
C2097 VSS.t2390 VSS 0.37555f
C2098 VSS.t2385 VSS 0.07918f
C2099 VSS.t2380 VSS 0.31935f
C2100 VSS.t2365 VSS 0.71324f
C2101 VSS.t2355 VSS 0.27782f
C2102 VSS.t2350 VSS 0.12332f
C2103 VSS.t2345 VSS 0.96607f
C2104 VSS.t2337 VSS 0.09387f
C2105 VSS.t2332 VSS 0.05665f
C2106 VSS.t2335 VSS 0.09387f
C2107 VSS.t2330 VSS 0.08834f
C2108 VSS.t2325 VSS 0.15835f
C2109 VSS.t2314 VSS 0.02579f
C2110 VSS.t2315 VSS 0.02579f
C2111 VSS.t2309 VSS 0.05015f
C2112 VSS.t2310 VSS 0.09274f
C2113 VSS.t2305 VSS 1.04956f
C2114 VSS.t2300 VSS 0.05689f
C2115 VSS.t2290 VSS 0.04025f
C2116 VSS.t2284 VSS 0.10393f
C2117 VSS.t2285 VSS 0.10393f
C2118 VSS.t2277 VSS 0.04159f
C2119 VSS.t2274 VSS 0.41811f
C2120 VSS.t2275 VSS 0.4597f
C2121 VSS.t2270 VSS 0.07687f
C2122 VSS.t2255 VSS 0.28911f
C2123 VSS.t2250 VSS 0.4189f
C2124 VSS.t791 VSS 0.31326f
C2125 VSS.t782 VSS 0.11677f
C2126 VSS.t777 VSS 0.0346f
C2127 VSS.t772 VSS 1.17881f
C2128 VSS.t792 VSS 0.31326f
C2129 VSS.t797 VSS 0.03514f
C2130 VSS.t802 VSS 0.04548f
C2131 VSS.t807 VSS 0.02611f
C2132 VSS.t817 VSS 0.20586f
C2133 VSS.t827 VSS 0.51122f
C2134 VSS.t832 VSS 0.18778f
C2135 VSS.t837 VSS 0.04486f
C2136 VSS.t841 VSS 0.3701f
C2137 VSS.t842 VSS 0.3701f
C2138 VSS.t851 VSS 0.10541f
C2139 VSS.t852 VSS 0.13091f
C2140 VSS.t862 VSS 0.45117f
C2141 VSS.t867 VSS 0.09469f
C2142 VSS.t866 VSS 0.07001f
C2143 VSS.t877 VSS 0.11961f
C2144 VSS.t882 VSS 0.14703f
C2145 VSS.t902 VSS 0.0173f
C2146 VSS.t907 VSS 0.95326f
C2147 VSS.t922 VSS 0.446f
C2148 VSS.t819 VSS 0.20586f
C2149 VSS.t1179 VSS 0.04589f
C2150 VSS.t1178 VSS 0.04589f
C2151 VSS.t1340 VSS 0.06728f
C2152 VSS.t1181 VSS 0.08821f
C2153 VSS.t1183 VSS 0.98637f
C2154 VSS.t1188 VSS 0.01275f
C2155 VSS.t1187 VSS 0.01275f
C2156 VSS.t1198 VSS 0.51665f
C2157 VSS.t1199 VSS 0.47085f
C2158 VSS.t1208 VSS 0.05396f
C2159 VSS.t1207 VSS 0.05396f
C2160 VSS.t1192 VSS 0.07074f
C2161 VSS.t1333 VSS 0.044f
C2162 VSS.t1332 VSS 0.044f
C2163 VSS.t1171 VSS 0.22845f
C2164 VSS.t1170 VSS 0.22845f
C2165 VSS.t1169 VSS 0.01111f
C2166 VSS.t1168 VSS 0.01111f
C2167 VSS.t1461 VSS 0.08189f
C2168 VSS.t1451 VSS 0.03833f
C2169 VSS.t1466 VSS 0.34587f
C2170 VSS.t1471 VSS 0.09731f
C2171 VSS.t1476 VSS 0.0535f
C2172 VSS.t1481 VSS 0.29487p
C2173 VSS.t1486 VSS 0.08615f
C2174 VSS.t1496 VSS 0.26217f
C2175 VSS.t1511 VSS 0.13758f
C2176 VSS.t1521 VSS 0.09756f
C2177 VSS.t1526 VSS 0.06001f
C2178 VSS.t1531 VSS 0.09321f
C2179 VSS.t1528 VSS 0.02862f
C2180 VSS.t1848 VSS 0.06316f
C2181 VSS.t1838 VSS 0.0229f
C2182 VSS.t1867 VSS 0.02603f
C2183 VSS.t1868 VSS 0.02603f
C2184 VSS.t1897 VSS 0.10623f
C2185 VSS.t1898 VSS 0.11105f
C2186 VSS.t1903 VSS 0.03911f
C2187 VSS.t1913 VSS 0.14467f
C2188 VSS.t1912 VSS 0.05011f
C2189 VSS.t1927 VSS 0.36957f
C2190 VSS.t1928 VSS 0.36957f
C2191 VSS.t1937 VSS 0.08448f
C2192 VSS.t1938 VSS 0.11069f
C2193 VSS.t1953 VSS 0.04552f
C2194 VSS.t1952 VSS 0.04552f
C2195 VSS.t1958 VSS 0.0346f
C2196 VSS.t1963 VSS 0.43656f
C2197 VSS.t1977 VSS 0.04471f
C2198 VSS.t1978 VSS 0.04471f
C2199 VSS.t1983 VSS 0.01476f
C2200 VSS.t1998 VSS 0.05254f
C2201 VSS.t1965 VSS 0.05323f
C2202 VSS.t1915 VSS 0.09457f
C2203 VSS.t2244 VSS 0.14353f
C2204 VSS.t2245 VSS 0.14353f
C2205 VSS.t2235 VSS 0.05074f
C2206 VSS.t2230 VSS 0.21083f
C2207 VSS.t2465 VSS 0.04311f
C2208 VSS.t2475 VSS 0.20848f
C2209 VSS.t2472 VSS 0.09389f
C2210 VSS.t2474 VSS 0.1233f
C2211 VSS.t2485 VSS 0.02024f
C2212 VSS.t2484 VSS 0.02024f
C2213 VSS.t2490 VSS 0.71624f
C2214 VSS.t2499 VSS 0.03439f
C2215 VSS.t2500 VSS 0.07283f
C2216 VSS.t2502 VSS 0.03843f
C2217 VSS.t2078 VSS 0.12508f
C2218 VSS.t2077 VSS 0.11544f
C2219 VSS.t2040 VSS 0.0173f
C2220 VSS.t1603 VSS 0.02154f
C2221 VSS.t1593 VSS 0.07186f
C2222 VSS.t1012 VSS 0.1986f
C2223 VSS.t2622 VSS 0.13374f
C2224 VSS.t2627 VSS 0.03812f
C2225 VSS.t2635 VSS 0.17826f
C2226 VSS.t2634 VSS 0.01503f
C2227 VSS.t2643 VSS 0.04081f
C2228 VSS.t2644 VSS 0.04081f
C2229 VSS.t2647 VSS 0.17729f
C2230 VSS.t2656 VSS 0.107f
C2231 VSS.t2661 VSS 0.13246f
C2232 VSS.t2662 VSS 0.13246f
C2233 VSS.t2667 VSS 0.16896f
C2234 VSS.t2670 VSS 0.01928f
.ends
