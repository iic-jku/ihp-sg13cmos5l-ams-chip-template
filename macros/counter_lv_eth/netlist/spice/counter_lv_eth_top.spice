* NGSPICE file created from counter_lv_eth_top.ext - technology: ihp-sg13cmos5l

* Black-box entry subcircuit for DECAP32 abstract view
.subckt DECAP32 VDD VSS
.ends

* Black-box entry subcircuit for DECAP4 abstract view
.subckt DECAP4 VDD VSS
.ends

* Black-box entry subcircuit for DECAP8 abstract view
.subckt DECAP8 VDD VSS
.ends

* Black-box entry subcircuit for WELLTAP abstract view
.subckt WELLTAP VDD VSS
.ends

* Black-box entry subcircuit for FILLER2 abstract view
.subckt FILLER2 VSS VDD
.ends

* Black-box entry subcircuit for AND2X1 abstract view
.subckt AND2X1 A B VDD VSS Y
.ends

* Black-box entry subcircuit for DECAP16 abstract view
.subckt DECAP16 VDD VSS
.ends

* Black-box entry subcircuit for BUFX3 abstract view
.subckt BUFX3 A VDD VSS Y
.ends

* Black-box entry subcircuit for FILLER1 abstract view
.subckt FILLER1 VDD VSS
.ends

* Black-box entry subcircuit for XNOR2X1 abstract view
.subckt XNOR2X1 A B VDD VSS Y
.ends

* Black-box entry subcircuit for NAND2X1 abstract view
.subckt NAND2X1 A B VDD VSS Y
.ends

* Black-box entry subcircuit for AOI21BX2 abstract view
.subckt AOI21BX2 A B CB VDD VSS Y
.ends

* Black-box entry subcircuit for OR3X1 abstract view
.subckt OR3X1 A B C VDD VSS Y
.ends

* Black-box entry subcircuit for DFFQX1 abstract view
.subckt DFFQX1 CK D Q VDD VSS
.ends

* Black-box entry subcircuit for OAI21X1 abstract view
.subckt OAI21X1 A B C VDD VSS Y
.ends

* Black-box entry subcircuit for NAND3X1 abstract view
.subckt NAND3X1 A B VDD VSS Y C
.ends

* Black-box entry subcircuit for AOI21BX1 abstract view
.subckt AOI21BX1 A B CB VDD VSS Y
.ends

* Black-box entry subcircuit for OR3BX1 abstract view
.subckt OR3BX1 AB B C VDD VSS Y
.ends

* Black-box entry subcircuit for BUFX24 abstract view
.subckt BUFX24 A VDD VSS Y
.ends

* Black-box entry subcircuit for INVX1 abstract view
.subckt INVX1 A VDD VSS Y
.ends

* Black-box entry subcircuit for OA21X2 abstract view
.subckt OA21X2 A B C VDD VSS Y
.ends

* Black-box entry subcircuit for NOR3X1 abstract view
.subckt NOR3X1 A B C VDD VSS Y
.ends

* Black-box entry subcircuit for NAND4X2 abstract view
.subckt NAND4X2 A B VDD VSS Y C D
.ends

* Black-box entry subcircuit for XOR2X1 abstract view
.subckt XOR2X1 A B VDD VSS Y
.ends

.subckt counter_lv_eth_top VDD VSS clock_i counter_value_o[0] counter_value_o[1] counter_value_o[2]
+ counter_value_o[3] counter_value_o[4] counter_value_o[5] counter_value_o[6] counter_value_o[7]
+ enable_i reset_n_i
XFILLER_10_328 VDD VSS DECAP32
XFILLER_18_225 VDD VSS DECAP4
XFILLER_6_129 VDD VSS DECAP8
XTAP_TAPCELL_ROW_8_44 VDD VSS WELLTAP
XFILLER_12_32 VDD VSS DECAP8
XFILLER_5_184 VSS VDD FILLER2
XFILLER_9_88 VDD VSS DECAP4
XFILLER_20_220 VDD VSS DECAP4
XTAP_TAPCELL_ROW_18_86 VDD VSS WELLTAP
X_49_ _49_/A _49_/B VDD VSS _49_/Y AND2X1
XFILLER_4_408 VDD VSS DECAP8
XFILLER_11_253 VDD VSS DECAP16
XTAP_TAPCELL_ROW_20_98 VDD VSS WELLTAP
XFILLER_19_375 VDD VSS DECAP32
XFILLER_20_32 VDD VSS DECAP8
Xhold41 _54_/Q VDD VSS _47_/A BUFX3
Xhold30 _32_/Y VDD VSS _33_/B BUFX3
XFILLER_16_323 VSS VDD FILLER2
XFILLER_3_282 VDD VSS DECAP32
XFILLER_15_32 VDD VSS DECAP32
XTAP_TAPCELL_ROW_2_13 VDD VSS WELLTAP
Xoutput7 _58_/Q VDD VSS counter_value_o[4] BUFX3
XFILLER_16_142 VDD VSS DECAP32
XFILLER_12_392 VDD VSS DECAP16
XFILLER_13_189 VDD VSS DECAP32
XFILLER_17_451 VDD VSS FILLER1
XFILLER_10_137 VSS VDD FILLER2
XFILLER_12_44 VSS VDD FILLER2
XFILLER_17_270 VDD VSS DECAP8
XFILLER_14_421 VDD VSS DECAP16
XFILLER_20_424 VDD VSS DECAP4
XFILLER_7_439 VDD VSS DECAP8
X_48_ _50_/B _48_/B VDD VSS _48_/Y XNOR2X1
XTAP_TAPCELL_ROW_18_87 VDD VSS WELLTAP
XFILLER_18_43 VSS VDD FILLER2
XFILLER_11_221 VDD VSS DECAP32
XFILLER_7_269 VDD VSS DECAP8
XTAP_TAPCELL_ROW_20_99 VDD VSS WELLTAP
Xhold20 _55_/Q VDD VSS _50_/B BUFX3
XFILLER_20_44 VDD VSS FILLER1
XFILLER_20_22 VDD VSS FILLER1
Xhold31 _33_/Y VDD VSS _57_/D BUFX3
Xhold42 _48_/Y VDD VSS hold42/Y BUFX3
XFILLER_4_206 VDD VSS DECAP16
Xoutput10 _61_/Q VDD VSS counter_value_o[7] BUFX3
Xoutput8 _59_/Q VDD VSS counter_value_o[5] BUFX3
XFILLER_15_88 VDD VSS DECAP4
XFILLER_12_360 VDD VSS DECAP32
XTAP_TAPCELL_ROW_2_14 VDD VSS WELLTAP
XFILLER_18_408 VDD VSS DECAP8
XFILLER_9_128 VDD VSS DECAP32
XTAP_TAPCELL_ROW_20_100 VDD VSS WELLTAP
XFILLER_2_315 VDD VSS DECAP8
XFILLER_1_370 VSS VDD FILLER2
XFILLER_20_403 VSS VDD FILLER2
XFILLER_17_282 VDD VSS DECAP32
XFILLER_14_230 VSS VDD FILLER2
XFILLER_11_447 VDD VSS DECAP4
XFILLER_0_48 VDD VSS DECAP32
XFILLER_7_407 VDD VSS DECAP32
XTAP_TAPCELL_ROW_18_88 VDD VSS WELLTAP
X_47_ _47_/A _50_/D VDD VSS _48_/B NAND2X1
XFILLER_6_451 VDD VSS FILLER1
XFILLER_20_277 VDD VSS DECAP32
XFILLER_11_277 VSS VDD FILLER2
XFILLER_20_56 VDD VSS DECAP4
Xhold21 hold42/Y VDD VSS _49_/B BUFX3
Xhold32 _61_/Q VDD VSS _36_/A BUFX3
XFILLER_19_163 VDD VSS DECAP4
Xoutput9 _60_/Q VDD VSS counter_value_o[6] BUFX3
XTAP_TAPCELL_ROW_2_15 VDD VSS WELLTAP
XFILLER_5_346 VDD VSS DECAP16
XTAP_TAPCELL_ROW_20_101 VDD VSS WELLTAP
XFILLER_14_445 VDD VSS DECAP4
XFILLER_5_176 VDD VSS DECAP8
XFILLER_2_113 VDD VSS DECAP16
X_46_ _46_/A _46_/B _49_/A VDD VSS _46_/Y AOI21BX2
XTAP_TAPCELL_ROW_1_9 VDD VSS WELLTAP
XFILLER_20_267 VSS VDD FILLER2
XFILLER_20_212 VDD VSS DECAP8
XTAP_TAPCELL_ROW_18_89 VDD VSS WELLTAP
XFILLER_18_45 VDD VSS FILLER1
X_29_ _29_/A _53_/Y _49_/A VDD VSS _29_/Y AOI21BX2
XFILLER_1_92 VDD VSS FILLER1
Xhold33 _36_/Y VDD VSS _37_/B BUFX3
Xhold22 _49_/Y VDD VSS _55_/D BUFX3
Xhold11 hold39/Y VDD VSS _51_/C BUFX3
XFILLER_0_403 VSS VDD FILLER2
XFILLER_15_370 VSS VDD FILLER2
XTAP_TAPCELL_ROW_2_16 VDD VSS WELLTAP
XFILLER_7_80 VDD VSS DECAP8
XFILLER_5_314 VDD VSS DECAP32
XTAP_TAPCELL_ROW_20_102 VDD VSS WELLTAP
XFILLER_8_174 VDD VSS DECAP32
XFILLER_10_129 VDD VSS DECAP8
XTAP_TAPCELL_ROW_12_58 VDD VSS WELLTAP
XFILLER_18_229 VSS VDD FILLER2
XFILLER_2_328 VDD VSS DECAP32
XFILLER_20_449 VSS VDD FILLER2
XFILLER_4_81 VDD VSS DECAP32
XFILLER_20_224 VDD VSS FILLER1
XFILLER_18_35 VDD VSS DECAP8
X_45_ _51_/C _53_/B _45_/C VDD VSS _46_/B OR3X1
XFILLER_19_346 VDD VSS DECAP16
XTAP_TAPCELL_ROW_5_27 VDD VSS WELLTAP
X_28_ _50_/C _28_/B VDD VSS _28_/Y XNOR2X1
Xhold34 _37_/Y VDD VSS _61_/D BUFX3
Xhold23 _56_/Q VDD VSS _50_/C BUFX3
Xhold12 _44_/Y VDD VSS _46_/A BUFX3
XFILLER_0_448 VDD VSS DECAP4
XFILLER_19_198 VSS VDD FILLER2
XFILLER_3_253 VDD VSS DECAP16
XFILLER_6_49 VDD VSS DECAP32
XTAP_TAPCELL_ROW_2_17 VDD VSS WELLTAP
XFILLER_16_113 VDD VSS DECAP16
XFILLER_0_223 VSS VDD FILLER2
XFILLER_8_323 VSS VDD FILLER2
XFILLER_7_92 VDD VSS FILLER1
XFILLER_11_4 VDD VSS DECAP32
XFILLER_4_392 VDD VSS DECAP16
XFILLER_8_142 VDD VSS DECAP32
XTAP_TAPCELL_ROW_12_59 VDD VSS WELLTAP
XFILLER_20_428 VDD VSS FILLER1
X_61_ _61_/CK _61_/D _61_/Q VDD VSS DFFQX1
XFILLER_1_362 VDD VSS DECAP8
XFILLER_5_189 VDD VSS DECAP32
XFILLER_9_451 VDD VSS FILLER1
XFILLER_11_439 VDD VSS DECAP8
XFILLER_14_299 VDD VSS DECAP16
XFILLER_14_222 VDD VSS DECAP8
XFILLER_13_80 VDD VSS DECAP8
XFILLER_2_137 VSS VDD FILLER2
XFILLER_6_421 VDD VSS DECAP16
XFILLER_20_269 VDD VSS FILLER1
XFILLER_20_236 VDD VSS DECAP4
X_44_ _53_/B _45_/C _51_/C VDD VSS _44_/Y OAI21X1
XFILLER_19_314 VDD VSS DECAP32
XFILLER_11_269 VDD VSS DECAP8
XTAP_TAPCELL_ROW_5_28 VDD VSS WELLTAP
X_27_ _47_/A _50_/B VDD VSS _28_/B _50_/D NAND3X1
Xhold35 _57_/Q VDD VSS _38_/A BUFX3
Xhold24 _28_/Y VDD VSS _39_/B BUFX3
XFILLER_20_48 VDD VSS DECAP8
XFILLER_16_328 VDD VSS DECAP32
Xhold13 _46_/Y VDD VSS _59_/D BUFX3
XFILLER_19_155 VDD VSS DECAP8
XFILLER_19_100 VSS VDD FILLER2
XTAP_TAPCELL_ROW_19_90 VDD VSS WELLTAP
XFILLER_3_221 VDD VSS DECAP32
XFILLER_10_81 VDD VSS DECAP32
XFILLER_0_268 VSS VDD FILLER2
XTAP_TAPCELL_ROW_16_80 VDD VSS WELLTAP
XFILLER_13_128 VDD VSS DECAP32
XFILLER_4_360 VDD VSS DECAP32
XFILLER_12_49 VDD VSS DECAP32
X_60_ _61_/CK _60_/D _60_/Q VDD VSS DFFQX1
XFILLER_14_437 VDD VSS DECAP8
XFILLER_11_407 VDD VSS DECAP32
XFILLER_14_267 VDD VSS DECAP32
XFILLER_13_92 VDD VSS FILLER1
XFILLER_10_451 VDD VSS FILLER1
X_43_ _51_/A _51_/B VDD VSS _45_/C NAND2X1
XFILLER_1_160 VDD VSS DECAP16
XFILLER_9_282 VDD VSS DECAP32
XFILLER_1_4 VDD VSS DECAP32
XFILLER_3_447 VDD VSS DECAP4
XTAP_TAPCELL_ROW_5_29 VDD VSS WELLTAP
XFILLER_6_230 VSS VDD FILLER2
XFILLER_20_27 VDD VSS FILLER1
XFILLER_20_16 VDD VSS DECAP4
Xhold25 _39_/Y VDD VSS _56_/D BUFX3
XFILLER_18_392 VDD VSS DECAP16
Xhold14 _58_/Q VDD VSS _51_/B BUFX3
Xhold36 _51_/A VDD VSS _41_/AB BUFX3
XFILLER_1_84 VDD VSS DECAP8
XTAP_TAPCELL_ROW_19_91 VDD VSS WELLTAP
XFILLER_19_189 VSS VDD FILLER2
XFILLER_19_167 VSS VDD FILLER2
XFILLER_19_134 VDD VSS DECAP4
XFILLER_19_91 VSS VDD FILLER2
XFILLER_3_277 VSS VDD FILLER2
XFILLER_15_362 VDD VSS DECAP8
XFILLER_16_137 VSS VDD FILLER2
XFILLER_16_81 VDD VSS DECAP32
XFILLER_14_449 VSS VDD FILLER2
XFILLER_14_416 VSS VDD FILLER2
XFILLER_1_375 VDD VSS DECAP32
XFILLER_20_408 VDD VSS DECAP16
XFILLER_4_40 VDD VSS DECAP4
XFILLER_14_235 VDD VSS DECAP32
X_42_ _42_/A _42_/B _49_/A VDD VSS _42_/Y AOI21BX1
XFILLER_6_445 VDD VSS DECAP4
XFILLER_18_49 VDD VSS DECAP16
XFILLER_18_16 VSS VDD FILLER2
XFILLER_18_360 VDD VSS DECAP32
XFILLER_1_96 VDD VSS DECAP32
XTAP_TAPCELL_ROW_19_92 VDD VSS WELLTAP
Xhold37 _41_/Y VDD VSS _42_/B BUFX3
Xhold15 _40_/Y VDD VSS _42_/A BUFX3
Xhold26 _54_/Q VDD VSS _50_/A BUFX3
XFILLER_16_319 VDD VSS DECAP4
XTAP_TAPCELL_ROW_10_50 VDD VSS WELLTAP
XFILLER_18_0 VDD VSS DECAP16
XFILLER_0_215 VDD VSS DECAP8
XFILLER_15_160 VDD VSS DECAP16
XFILLER_8_315 VDD VSS DECAP8
XFILLER_7_370 VSS VDD FILLER2
XFILLER_17_447 VDD VSS DECAP4
XFILLER_12_174 VDD VSS DECAP32
XFILLER_2_129 VDD VSS DECAP8
X_41_ _41_/AB _51_/B _53_/B VDD VSS _41_/Y OR3BX1
XFILLER_1_184 VSS VDD FILLER2
XFILLER_20_228 VDD VSS DECAP8
XFILLER_20_206 VSS VDD FILLER2
Xhold38 _42_/Y VDD VSS hold38/Y BUFX3
XTAP_TAPCELL_ROW_19_93 VDD VSS WELLTAP
Xhold16 hold38/Y VDD VSS _58_/D BUFX3
Xhold27 _30_/Y VDD VSS _31_/B BUFX3
XFILLER_0_408 VDD VSS DECAP32
XFILLER_10_40 VDD VSS DECAP4
XTAP_TAPCELL_ROW_10_51 VDD VSS WELLTAP
XFILLER_19_169 VDD VSS FILLER1
XFILLER_15_375 VDD VSS DECAP32
XFILLER_12_323 VSS VDD FILLER2
XFILLER_7_96 VDD VSS DECAP32
XFILLER_12_142 VDD VSS DECAP32
XTAP_TAPCELL_ROW_3_20 VDD VSS WELLTAP
XFILLER_8_113 VDD VSS DECAP16
XFILLER_17_278 VDD VSS FILLER1
XFILLER_13_451 VDD VSS FILLER1
X_40_ _40_/A _53_/B _51_/B VDD VSS _40_/Y OAI21X1
XFILLER_8_0 VDD VSS DECAP32
XFILLER_10_421 VDD VSS DECAP16
XFILLER_18_18 VDD VSS FILLER1
XFILLER_3_439 VDD VSS DECAP8
XFILLER_6_222 VDD VSS DECAP8
XFILLER_6_299 VDD VSS DECAP16
Xhold17 hold40/Y VDD VSS _53_/A BUFX3
Xhold28 _31_/Y VDD VSS _54_/D BUFX3
Xhold39 _59_/Q VDD VSS hold39/Y BUFX3
XTAP_TAPCELL_ROW_10_52 VDD VSS WELLTAP
XFILLER_3_269 VDD VSS DECAP8
XTAP_TAPCELL_ROW_6_31 VDD VSS WELLTAP
XFILLER_0_228 VDD VSS DECAP32
XFILLER_16_129 VDD VSS DECAP8
XFILLER_8_328 VDD VSS DECAP32
XFILLER_15_184 VSS VDD FILLER2
XFILLER_7_64 VDD VSS DECAP16
XFILLER_16_40 VDD VSS DECAP4
XTAP_TAPCELL_ROW_3_21 VDD VSS WELLTAP
XFILLER_14_408 VDD VSS DECAP8
XFILLER_17_213 VDD VSS DECAP16
XFILLER_5_128 VDD VSS DECAP32
XFILLER_4_32 VDD VSS DECAP8
XTAP_TAPCELL_ROW_13_63 VDD VSS WELLTAP
XFILLER_13_96 VDD VSS DECAP32
XFILLER_6_437 VDD VSS DECAP8
XFILLER_13_282 VDD VSS DECAP32
XFILLER_9_253 VDD VSS DECAP16
XFILLER_3_407 VDD VSS DECAP32
XFILLER_2_451 VDD VSS FILLER1
XFILLER_6_267 VDD VSS DECAP32
XFILLER_10_230 VSS VDD FILLER2
Xhold18 _52_/Y VDD VSS _29_/A BUFX3
Xhold29 _38_/A VDD VSS _51_/A BUFX3
XTAP_TAPCELL_ROW_10_53 VDD VSS WELLTAP
XFILLER_19_138 VDD VSS FILLER1
XFILLER_19_51 VDD VSS DECAP8
XTAP_TAPCELL_ROW_6_32 VDD VSS WELLTAP
XFILLER_20_391 VDD VSS DECAP8
XFILLER_7_32 VDD VSS DECAP32
XFILLER_7_362 VDD VSS DECAP8
Xclkbuf_1_1__f_clock_i clkbuf_0_clock_i/Y VDD VSS _61_/CK BUFX24
XFILLER_16_0 VDD VSS DECAP32
XFILLER_17_439 VDD VSS DECAP8
XFILLER_8_137 VSS VDD FILLER2
XFILLER_1_346 VDD VSS DECAP16
XFILLER_4_44 VSS VDD FILLER2
XFILLER_14_206 VDD VSS DECAP16
XTAP_TAPCELL_ROW_13_64 VDD VSS WELLTAP
XFILLER_13_64 VDD VSS DECAP16
XFILLER_6_416 VSS VDD FILLER2
XFILLER_6_449 VSS VDD FILLER2
XFILLER_10_445 VDD VSS DECAP4
XFILLER_1_176 VDD VSS DECAP8
XFILLER_9_221 VDD VSS DECAP32
XFILLER_6_235 VDD VSS DECAP32
XFILLER_18_320 VDD VSS DECAP4
Xhold19 _29_/Y VDD VSS _60_/D BUFX3
XFILLER_10_32 VDD VSS DECAP8
XTAP_TAPCELL_ROW_6_33 VDD VSS WELLTAP
XFILLER_12_315 VDD VSS DECAP8
XFILLER_11_370 VSS VDD FILLER2
XFILLER_7_88 VDD VSS DECAP4
XFILLER_17_407 VDD VSS DECAP32
XFILLER_16_451 VDD VSS FILLER1
XFILLER_7_160 VDD VSS DECAP16
XFILLER_17_237 VSS VDD FILLER2
XFILLER_1_314 VDD VSS DECAP32
XFILLER_4_174 VDD VSS DECAP32
XFILLER_9_447 VDD VSS DECAP4
XTAP_TAPCELL_ROW_13_65 VDD VSS WELLTAP
XFILLER_13_32 VDD VSS DECAP32
XFILLER_9_277 VSS VDD FILLER2
XFILLER_6_0 VDD VSS DECAP32
XFILLER_1_68 VDD VSS DECAP16
XFILLER_19_118 VDD VSS DECAP16
Xinput1 enable_i VDD VSS _50_/D BUFX3
XFILLER_10_44 VSS VDD FILLER2
XFILLER_15_346 VDD VSS DECAP16
XTAP_TAPCELL_ROW_6_34 VDD VSS WELLTAP
XFILLER_15_176 VDD VSS DECAP8
XFILLER_7_375 VDD VSS DECAP32
XTAP_TAPCELL_ROW_16_76 VDD VSS WELLTAP
XFILLER_16_32 VDD VSS DECAP8
XFILLER_4_323 VSS VDD FILLER2
XFILLER_12_113 VDD VSS DECAP16
XFILLER_4_142 VDD VSS DECAP32
XTAP_TAPCELL_ROW_13_66 VDD VSS WELLTAP
XFILLER_13_88 VDD VSS DECAP4
XFILLER_1_189 VDD VSS DECAP32
XTAP_TAPCELL_ROW_9_45 VDD VSS WELLTAP
XFILLER_5_451 VDD VSS FILLER1
XFILLER_10_222 VDD VSS DECAP8
XFILLER_1_36 VDD VSS DECAP32
XFILLER_2_421 VDD VSS DECAP16
XFILLER_10_299 VDD VSS DECAP16
Xinput2 reset_n_i VDD VSS _49_/A BUFX3
XFILLER_15_314 VDD VSS DECAP32
XTAP_TAPCELL_ROW_6_35 VDD VSS WELLTAP
XFILLER_18_174 VDD VSS DECAP4
XFILLER_20_350 VDD VSS DECAP8
XFILLER_12_328 VDD VSS DECAP32
XTAP_TAPCELL_ROW_16_77 VDD VSS WELLTAP
XFILLER_16_44 VSS VDD FILLER2
XTAP_TAPCELL_ROW_0_0 VDD VSS WELLTAP
XFILLER_8_129 VDD VSS DECAP8
XFILLER_14_0 VDD VSS DECAP32
XFILLER_7_184 VSS VDD FILLER2
XFILLER_17_239 VDD VSS FILLER1
Xclkbuf_1_0__f_clock_i clkbuf_0_clock_i/Y VDD VSS _57_/CK BUFX24
XFILLER_6_408 VDD VSS DECAP8
XTAP_TAPCELL_ROW_9_46 VDD VSS WELLTAP
XFILLER_10_437 VDD VSS DECAP8
XFILLER_13_253 VDD VSS DECAP16
XFILLER_18_312 VDD VSS DECAP8
XFILLER_10_267 VDD VSS DECAP32
XFILLER_5_282 VDD VSS DECAP32
XFILLER_18_142 VDD VSS DECAP32
XFILLER_14_392 VDD VSS DECAP16
XFILLER_2_230 VSS VDD FILLER2
XFILLER_19_451 VDD VSS FILLER1
XFILLER_15_189 VDD VSS DECAP32
XFILLER_11_362 VDD VSS DECAP8
XTAP_TAPCELL_ROW_16_78 VDD VSS WELLTAP
XTAP_TAPCELL_ROW_0_1 VDD VSS WELLTAP
XFILLER_16_421 VDD VSS DECAP16
XFILLER_12_137 VSS VDD FILLER2
XFILLER_17_229 VDD VSS DECAP8
XFILLER_9_439 VDD VSS DECAP8
XFILLER_16_295 VDD VSS DECAP16
XFILLER_0_350 VDD VSS DECAP8
XFILLER_10_416 VSS VDD FILLER2
XFILLER_10_449 VSS VDD FILLER2
XFILLER_13_221 VDD VSS DECAP32
XFILLER_9_269 VDD VSS DECAP8
XTAP_TAPCELL_ROW_9_47 VDD VSS WELLTAP
XFILLER_5_80 VDD VSS DECAP8
XFILLER_18_324 VDD VSS FILLER1
XFILLER_2_445 VDD VSS DECAP4
XFILLER_6_206 VDD VSS DECAP16
XFILLER_10_235 VDD VSS DECAP32
XFILLER_14_360 VDD VSS DECAP32
XFILLER_4_0 VDD VSS DECAP32
XFILLER_20_363 VDD VSS DECAP8
XFILLER_2_81 VDD VSS DECAP32
XTAP_TAPCELL_ROW_16_79 VDD VSS WELLTAP
XTAP_TAPCELL_ROW_0_2 VDD VSS WELLTAP
XFILLER_4_315 VDD VSS DECAP8
XFILLER_19_282 VDD VSS DECAP32
XFILLER_3_370 VSS VDD FILLER2
XFILLER_11_160 VDD VSS DECAP16
XFILLER_13_447 VDD VSS DECAP4
XFILLER_9_407 VDD VSS DECAP32
XFILLER_16_263 VDD VSS DECAP32
XFILLER_16_230 VSS VDD FILLER2
XFILLER_0_395 VDD VSS DECAP8
XFILLER_4_49 VDD VSS DECAP32
XFILLER_8_451 VDD VSS FILLER1
XFILLER_13_277 VSS VDD FILLER2
XTAP_TAPCELL_ROW_9_48 VDD VSS WELLTAP
XFILLER_0_170 VDD VSS DECAP8
XFILLER_5_92 VDD VSS FILLER1
XFILLER_20_375 VDD VSS DECAP16
X_59_ _61_/CK _59_/D _59_/Q VDD VSS DFFQX1
XFILLER_11_375 VDD VSS DECAP32
XFILLER_7_346 VDD VSS DECAP16
XTAP_TAPCELL_ROW_0_3 VDD VSS WELLTAP
XFILLER_20_183 VDD VSS DECAP8
XFILLER_16_445 VDD VSS DECAP4
XFILLER_7_176 VDD VSS DECAP8
XFILLER_8_81 VDD VSS DECAP32
XFILLER_0_363 VDD VSS DECAP32
XFILLER_4_113 VDD VSS DECAP16
XFILLER_12_0 VDD VSS DECAP32
XFILLER_17_370 VSS VDD FILLER2
XFILLER_10_49 VDD VSS DECAP32
XTAP_TAPCELL_ROW_10_49 VDD VSS WELLTAP
XFILLER_2_299 VDD VSS DECAP16
XFILLER_2_222 VDD VSS DECAP8
X_58_ _61_/CK _58_/D _58_/Q VDD VSS DFFQX1
XFILLER_18_178 VSS VDD FILLER2
XTAP_TAPCELL_ROW_0_4 VDD VSS WELLTAP
XFILLER_7_314 VDD VSS DECAP32
XFILLER_11_92 VDD VSS FILLER1
XTAP_TAPCELL_ROW_3_18 VDD VSS WELLTAP
XFILLER_4_328 VDD VSS DECAP32
XFILLER_12_129 VDD VSS DECAP8
XFILLER_11_184 VSS VDD FILLER2
XFILLER_17_80 VDD VSS DECAP8
XFILLER_16_243 VDD VSS FILLER1
XFILLER_1_128 VDD VSS DECAP32
XFILLER_10_408 VDD VSS DECAP8
XFILLER_0_183 VDD VSS DECAP32
XTAP_TAPCELL_ROW_14_70 VDD VSS WELLTAP
XFILLER_14_81 VDD VSS DECAP32
XFILLER_2_437 VDD VSS DECAP8
XFILLER_5_253 VDD VSS DECAP16
XFILLER_19_59 VSS VDD FILLER2
XFILLER_2_267 VDD VSS DECAP32
XFILLER_2_40 VDD VSS DECAP4
XFILLER_20_399 VDD VSS DECAP4
X_57_ _57_/CK _57_/D _57_/Q VDD VSS DFFQX1
XFILLER_2_0 VDD VSS DECAP32
XFILLER_16_49 VDD VSS DECAP32
XTAP_TAPCELL_ROW_0_5 VDD VSS WELLTAP
XFILLER_6_392 VDD VSS DECAP16
XTAP_TAPCELL_ROW_3_19 VDD VSS WELLTAP
XFILLER_3_362 VDD VSS DECAP8
XFILLER_7_189 VDD VSS DECAP32
XTAP_TAPCELL_ROW_17_81 VDD VSS WELLTAP
XFILLER_13_439 VDD VSS DECAP8
XFILLER_4_137 VSS VDD FILLER2
XFILLER_17_92 VDD VSS FILLER1
XFILLER_16_222 VDD VSS DECAP8
XFILLER_8_421 VDD VSS DECAP16
XFILLER_13_269 VDD VSS DECAP8
XFILLER_18_328 VDD VSS DECAP32
XTAP_TAPCELL_ROW_14_71 VDD VSS WELLTAP
XFILLER_2_416 VSS VDD FILLER2
XFILLER_2_449 VSS VDD FILLER2
XFILLER_10_206 VDD VSS DECAP16
XFILLER_5_221 VDD VSS DECAP32
XFILLER_19_16 VSS VDD FILLER2
XFILLER_18_136 VSS VDD FILLER2
XFILLER_2_235 VDD VSS DECAP32
X_56_ _57_/CK _56_/D _56_/Q VDD VSS DFFQX1
XFILLER_15_128 VDD VSS DECAP32
X_39_ _49_/A _39_/B VDD VSS _39_/Y AND2X1
XTAP_TAPCELL_ROW_0_6 VDD VSS WELLTAP
XFILLER_6_360 VDD VSS DECAP32
XFILLER_20_175 VDD VSS DECAP4
XFILLER_16_437 VDD VSS DECAP8
XFILLER_8_40 VDD VSS DECAP4
XTAP_TAPCELL_ROW_17_82 VDD VSS WELLTAP
XFILLER_13_407 VDD VSS DECAP32
XFILLER_12_451 VDD VSS FILLER1
XFILLER_3_160 VDD VSS DECAP16
XFILLER_5_447 VDD VSS DECAP4
XFILLER_5_96 VDD VSS DECAP32
XFILLER_8_230 VSS VDD FILLER2
XFILLER_10_0 VDD VSS DECAP32
XFILLER_17_362 VDD VSS DECAP8
XFILLER_5_277 VSS VDD FILLER2
XFILLER_19_39 VDD VSS DECAP8
XFILLER_18_104 VDD VSS DECAP32
X_55_ _57_/CK _55_/D _55_/Q VDD VSS DFFQX1
XFILLER_11_346 VDD VSS DECAP16
XFILLER_11_84 VDD VSS DECAP8
XTAP_TAPCELL_ROW_0_7 VDD VSS WELLTAP
X_38_ _38_/A VDD VSS _40_/A INVX1
XFILLER_20_143 VDD VSS DECAP32
XFILLER_20_132 VSS VDD FILLER2
XFILLER_19_276 VSS VDD FILLER2
XFILLER_16_449 VSS VDD FILLER2
XFILLER_16_416 VSS VDD FILLER2
XFILLER_3_375 VDD VSS DECAP32
XFILLER_11_176 VDD VSS DECAP8
XTAP_TAPCELL_ROW_17_83 VDD VSS WELLTAP
XFILLER_16_235 VDD VSS DECAP8
XFILLER_8_445 VDD VSS DECAP4
XFILLER_5_64 VDD VSS DECAP16
XFILLER_14_40 VDD VSS DECAP4
XFILLER_1_451 VDD VSS FILLER1
XTAP_TAPCELL_ROW_1_10 VDD VSS WELLTAP
XFILLER_19_18 VDD VSS FILLER1
XFILLER_18_138 VDD VSS FILLER1
XFILLER_20_358 VSS VDD FILLER2
X_54_ _57_/CK _54_/D _54_/Q VDD VSS DFFQX1
XFILLER_17_160 VDD VSS DECAP16
XFILLER_2_32 VDD VSS DECAP8
XFILLER_9_370 VSS VDD FILLER2
XFILLER_11_314 VDD VSS DECAP32
XFILLER_19_447 VDD VSS DECAP4
XFILLER_14_174 VDD VSS DECAP32
XTAP_TAPCELL_ROW_0_8 VDD VSS WELLTAP
XFILLER_11_96 VDD VSS DECAP32
X_37_ _37_/A _37_/B _49_/A VDD VSS _37_/Y OA21X2
XFILLER_20_100 VDD VSS DECAP32
XFILLER_0_0 VDD VSS DECAP32
XTAP_TAPCELL_ROW_17_84 VDD VSS WELLTAP
XFILLER_0_313 VSS VDD FILLER2
XFILLER_4_129 VDD VSS DECAP8
XFILLER_3_184 VSS VDD FILLER2
XFILLER_2_408 VDD VSS DECAP8
XFILLER_5_32 VDD VSS DECAP32
XTAP_TAPCELL_ROW_1_11 VDD VSS WELLTAP
XFILLER_17_375 VDD VSS DECAP32
X_53_ _53_/A _53_/B _53_/C VDD VSS _53_/Y OR3X1
XFILLER_14_323 VSS VDD FILLER2
XFILLER_2_44 VSS VDD FILLER2
XFILLER_1_282 VDD VSS DECAP32
XFILLER_14_142 VDD VSS DECAP32
XFILLER_20_134 VDD VSS FILLER1
X_36_ _36_/A _53_/B _36_/C VDD VSS _36_/Y NOR3X1
XFILLER_10_392 VDD VSS DECAP16
XFILLER_11_189 VDD VSS DECAP32
XFILLER_19_278 VDD VSS FILLER1
XFILLER_19_234 VSS VDD FILLER2
XFILLER_15_451 VDD VSS FILLER1
XFILLER_8_32 VDD VSS DECAP8
XFILLER_0_358 VSS VDD FILLER2
XFILLER_17_96 VDD VSS DECAP32
XFILLER_12_421 VDD VSS DECAP16
XTAP_TAPCELL_ROW_4_22 VDD VSS WELLTAP
XFILLER_0_133 VSS VDD FILLER2
XFILLER_5_439 VDD VSS DECAP8
XFILLER_5_88 VDD VSS DECAP4
XFILLER_8_222 VDD VSS DECAP8
XFILLER_8_299 VDD VSS DECAP16
XTAP_TAPCELL_ROW_1_12 VDD VSS WELLTAP
XFILLER_5_269 VDD VSS DECAP8
XFILLER_2_206 VDD VSS DECAP16
X_52_ _53_/B _53_/C _53_/A VDD VSS _52_/Y OAI21X1
XFILLER_17_184 VSS VDD FILLER2
XTAP_TAPCELL_ROW_11_54 VDD VSS WELLTAP
X_35_ _53_/B _36_/C _36_/A VDD VSS _37_/A OA21X2
XFILLER_10_360 VDD VSS DECAP32
XFILLER_20_179 VDD VSS FILLER1
XFILLER_16_408 VDD VSS DECAP8
XFILLER_7_128 VDD VSS DECAP32
XFILLER_8_44 VSS VDD FILLER2
XFILLER_19_0 VDD VSS DECAP16
XFILLER_17_64 VDD VSS DECAP16
XTAP_TAPCELL_ROW_4_23 VDD VSS WELLTAP
XFILLER_8_437 VDD VSS DECAP8
XFILLER_15_282 VDD VSS DECAP32
XFILLER_0_178 VSS VDD FILLER2
XFILLER_5_407 VDD VSS DECAP32
XFILLER_12_230 VSS VDD FILLER2
XFILLER_4_451 VDD VSS FILLER1
XFILLER_8_267 VDD VSS DECAP32
XFILLER_14_32 VDD VSS DECAP8
X_51_ _51_/A _51_/B VDD VSS _53_/C _51_/C NAND3X1
XTAP_TAPCELL_ROW_11_55 VDD VSS WELLTAP
XFILLER_9_362 VDD VSS DECAP8
XFILLER_19_439 VDD VSS DECAP8
X_34_ _51_/A _51_/B VDD VSS _36_/C _51_/C _53_/A NAND4X2
XFILLER_3_346 VDD VSS DECAP16
XFILLER_18_280 VDD VSS DECAP32
XFILLER_17_32 VDD VSS DECAP32
XFILLER_16_206 VDD VSS DECAP16
XFILLER_12_445 VDD VSS DECAP4
XFILLER_0_305 VDD VSS DECAP8
XTAP_TAPCELL_ROW_4_24 VDD VSS WELLTAP
XFILLER_8_416 VSS VDD FILLER2
XFILLER_8_449 VSS VDD FILLER2
XFILLER_3_176 VDD VSS DECAP8
XFILLER_8_235 VDD VSS DECAP32
XFILLER_14_44 VSS VDD FILLER2
XFILLER_14_315 VDD VSS DECAP8
XFILLER_20_318 VDD VSS DECAP32
X_50_ _50_/A _50_/B VDD VSS _53_/B _50_/C _50_/D NAND4X2
XFILLER_13_370 VSS VDD FILLER2
XFILLER_9_0 VDD VSS DECAP32
XTAP_TAPCELL_ROW_11_56 VDD VSS WELLTAP
XFILLER_19_407 VDD VSS DECAP32
X_33_ _49_/A _33_/B VDD VSS _33_/Y AND2X1
XFILLER_18_451 VDD VSS FILLER1
XFILLER_9_160 VDD VSS DECAP16
XFILLER_3_314 VDD VSS DECAP32
XFILLER_6_174 VDD VSS DECAP32
XFILLER_17_88 VDD VSS DECAP4
XTAP_TAPCELL_ROW_4_25 VDD VSS WELLTAP
XFILLER_0_80 VDD VSS DECAP8
XFILLER_0_125 VDD VSS DECAP8
XTAP_TAPCELL_ROW_14_67 VDD VSS WELLTAP
XFILLER_17_346 VDD VSS DECAP16
XFILLER_17_176 VDD VSS DECAP8
XFILLER_1_253 VDD VSS DECAP16
XFILLER_9_375 VDD VSS DECAP32
XTAP_TAPCELL_ROW_11_57 VDD VSS WELLTAP
XFILLER_14_113 VDD VSS DECAP16
XFILLER_6_323 VSS VDD FILLER2
XTAP_TAPCELL_ROW_7_36 VDD VSS WELLTAP
XFILLER_11_68 VDD VSS DECAP16
XFILLER_20_138 VDD VSS FILLER1
X_32_ _51_/A _53_/B VDD VSS _32_/Y XNOR2X1
XFILLER_3_80 VDD VSS DECAP8
XFILLER_2_392 VDD VSS DECAP16
XFILLER_6_142 VDD VSS DECAP32
XFILLER_0_318 VDD VSS DECAP32
XFILLER_3_189 VDD VSS DECAP32
XTAP_TAPCELL_ROW_4_26 VDD VSS WELLTAP
XFILLER_17_0 VDD VSS DECAP32
XFILLER_7_451 VDD VSS FILLER1
XFILLER_12_299 VDD VSS DECAP16
XFILLER_12_222 VDD VSS DECAP8
XFILLER_4_421 VDD VSS DECAP16
XTAP_TAPCELL_ROW_14_68 VDD VSS WELLTAP
XFILLER_17_314 VDD VSS DECAP32
XFILLER_17_199 VDD VSS DECAP4
XFILLER_14_328 VDD VSS DECAP32
XFILLER_2_49 VDD VSS DECAP32
XFILLER_1_221 VDD VSS DECAP32
XFILLER_20_309 VSS VDD FILLER2
XTAP_TAPCELL_ROW_7_37 VDD VSS WELLTAP
XFILLER_11_36 VDD VSS DECAP32
X_31_ _49_/A _31_/B VDD VSS _31_/Y AND2X1
XFILLER_9_184 VSS VDD FILLER2
XFILLER_3_92 VDD VSS FILLER1
XFILLER_11_128 VDD VSS DECAP32
XFILLER_2_360 VDD VSS DECAP32
XFILLER_12_437 VDD VSS DECAP8
XFILLER_8_408 VDD VSS DECAP8
XFILLER_15_253 VDD VSS DECAP16
XFILLER_0_93 VDD VSS DECAP32
XFILLER_12_267 VDD VSS DECAP32
XFILLER_0_138 VDD VSS DECAP32
XFILLER_9_80 VDD VSS DECAP8
XTAP_TAPCELL_ROW_14_69 VDD VSS WELLTAP
XFILLER_7_282 VDD VSS DECAP32
XFILLER_1_447 VDD VSS DECAP4
XFILLER_4_230 VSS VDD FILLER2
XFILLER_16_392 VDD VSS DECAP16
XFILLER_6_81 VDD VSS DECAP32
XFILLER_1_277 VSS VDD FILLER2
XFILLER_17_189 VDD VSS FILLER1
XFILLER_13_362 VDD VSS DECAP8
XFILLER_14_137 VSS VDD FILLER2
XTAP_TAPCELL_ROW_7_38 VDD VSS WELLTAP
XFILLER_18_421 VDD VSS DECAP16
X_30_ _50_/A _50_/D VDD VSS _30_/Y XOR2X1
XFILLER_7_0 VDD VSS DECAP32
XFILLER_19_218 VDD VSS DECAP16
XFILLER_8_49 VDD VSS DECAP32
XFILLER_12_449 VSS VDD FILLER2
XFILLER_12_416 VSS VDD FILLER2
XFILLER_15_221 VDD VSS DECAP32
XFILLER_9_92 VDD VSS FILLER1
XFILLER_12_235 VDD VSS DECAP32
XFILLER_4_445 VDD VSS DECAP4
XFILLER_8_206 VDD VSS DECAP16
XFILLER_16_360 VDD VSS DECAP32
XFILLER_15_80 VDD VSS DECAP8
XFILLER_6_315 VDD VSS DECAP8
XTAP_TAPCELL_ROW_7_39 VDD VSS WELLTAP
XFILLER_13_160 VDD VSS DECAP16
XFILLER_5_370 VSS VDD FILLER2
XFILLER_15_447 VDD VSS DECAP4
XFILLER_10_174 VDD VSS DECAP32
XFILLER_12_81 VDD VSS DECAP32
XFILLER_15_277 VSS VDD FILLER2
XFILLER_0_40 VDD VSS DECAP4
XFILLER_15_0 VDD VSS DECAP32
XFILLER_14_49 VDD VSS DECAP32
XFILLER_15_92 VDD VSS FILLER1
XFILLER_13_375 VDD VSS DECAP32
XFILLER_9_346 VDD VSS DECAP16
XFILLER_10_323 VSS VDD FILLER2
XFILLER_18_445 VDD VSS DECAP4
XFILLER_9_176 VDD VSS DECAP8
XTAP_TAPCELL_ROW_12_60 VDD VSS WELLTAP
XFILLER_18_231 VDD VSS FILLER1
XFILLER_6_113 VDD VSS DECAP16
XFILLER_10_142 VDD VSS DECAP32
XFILLER_20_451 VDD VSS FILLER1
XFILLER_11_451 VDD VSS FILLER1
XFILLER_19_370 VSS VDD FILLER2
XFILLER_1_439 VDD VSS DECAP8
XFILLER_20_93 VSS VDD FILLER2
XFILLER_20_60 VSS VDD FILLER2
XFILLER_4_222 VDD VSS DECAP8
XFILLER_4_299 VDD VSS DECAP16
XFILLER_6_40 VDD VSS DECAP4
XFILLER_1_269 VDD VSS DECAP8
XFILLER_9_314 VDD VSS DECAP32
XFILLER_14_129 VDD VSS DECAP8
XFILLER_6_328 VDD VSS DECAP32
XFILLER_13_184 VSS VDD FILLER2
XTAP_TAPCELL_ROW_12_61 VDD VSS WELLTAP
XFILLER_3_96 VDD VSS DECAP32
XFILLER_5_0 VDD VSS DECAP32
XTAP_TAPCELL_ROW_8_40 VDD VSS WELLTAP
XFILLER_12_408 VDD VSS DECAP8
XFILLER_3_128 VDD VSS DECAP32
XFILLER_4_437 VDD VSS DECAP8
XFILLER_11_282 VDD VSS DECAP32
XTAP_TAPCELL_ROW_5_30 VDD VSS WELLTAP
XFILLER_7_253 VDD VSS DECAP16
XFILLER_1_407 VDD VSS DECAP32
XTAP_TAPCELL_ROW_20_94 VDD VSS WELLTAP
XFILLER_0_440 VDD VSS DECAP8
XFILLER_4_267 VDD VSS DECAP32
XFILLER_20_0 VDD VSS DECAP16
XTAP_TAPCELL_ROW_15_72 VDD VSS WELLTAP
Xoutput3 _54_/Q VDD VSS counter_value_o[0] BUFX3
XFILLER_8_392 VDD VSS DECAP16
XFILLER_5_362 VDD VSS DECAP8
XFILLER_9_189 VDD VSS DECAP32
XFILLER_3_64 VDD VSS DECAP16
XFILLER_15_439 VDD VSS DECAP8
XTAP_TAPCELL_ROW_12_62 VDD VSS WELLTAP
XFILLER_6_137 VSS VDD FILLER2
XFILLER_12_40 VDD VSS DECAP4
XTAP_TAPCELL_ROW_8_41 VDD VSS WELLTAP
XFILLER_15_269 VDD VSS DECAP8
XFILLER_0_32 VDD VSS DECAP8
XFILLER_12_206 VDD VSS DECAP16
XFILLER_9_96 VDD VSS DECAP32
XFILLER_4_416 VSS VDD FILLER2
XFILLER_4_449 VSS VDD FILLER2
XFILLER_7_221 VDD VSS DECAP32
XTAP_TAPCELL_ROW_20_95 VDD VSS WELLTAP
XFILLER_20_95 VDD VSS FILLER1
XFILLER_20_62 VDD VSS FILLER1
XFILLER_20_40 VDD VSS DECAP4
XFILLER_4_235 VDD VSS DECAP32
XTAP_TAPCELL_ROW_15_73 VDD VSS WELLTAP
XFILLER_13_0 VDD VSS DECAP32
Xoutput4 _55_/Q VDD VSS counter_value_o[1] BUFX3
XFILLER_17_128 VDD VSS DECAP32
XFILLER_0_260 VDD VSS DECAP8
XFILLER_8_360 VDD VSS DECAP32
XFILLER_18_437 VDD VSS DECAP8
XFILLER_10_315 VDD VSS DECAP8
XFILLER_3_32 VDD VSS DECAP32
XFILLER_15_407 VDD VSS DECAP32
XFILLER_14_451 VDD VSS FILLER1
XFILLER_5_160 VDD VSS DECAP16
XTAP_TAPCELL_ROW_8_42 VDD VSS WELLTAP
XFILLER_2_174 VDD VSS DECAP32
XFILLER_0_44 VDD VSS FILLER1
XFILLER_7_447 VDD VSS DECAP4
XFILLER_0_88 VSS VDD FILLER2
XFILLER_9_64 VDD VSS DECAP16
XFILLER_19_362 VDD VSS DECAP8
XFILLER_7_277 VSS VDD FILLER2
XTAP_TAPCELL_ROW_20_96 VDD VSS WELLTAP
XFILLER_6_32 VDD VSS DECAP8
Xclkbuf_0_clock_i clock_i VDD VSS clkbuf_0_clock_i/Y BUFX24
XTAP_TAPCELL_ROW_15_74 VDD VSS WELLTAP
Xoutput5 _56_/Q VDD VSS counter_value_o[2] BUFX3
XFILLER_15_96 VDD VSS DECAP32
XFILLER_13_346 VDD VSS DECAP16
XFILLER_18_449 VSS VDD FILLER2
XFILLER_18_416 VSS VDD FILLER2
XFILLER_13_176 VDD VSS DECAP8
XFILLER_3_88 VDD VSS DECAP4
XFILLER_5_375 VDD VSS DECAP32
XFILLER_10_113 VDD VSS DECAP16
XFILLER_2_323 VSS VDD FILLER2
XTAP_TAPCELL_ROW_8_43 VDD VSS WELLTAP
XFILLER_20_433 VDD VSS DECAP16
XFILLER_2_142 VDD VSS DECAP32
XFILLER_3_0 VDD VSS DECAP32
XFILLER_9_32 VDD VSS DECAP32
XTAP_TAPCELL_ROW_18_85 VDD VSS WELLTAP
XFILLER_3_451 VDD VSS FILLER1
XTAP_TAPCELL_ROW_20_97 VDD VSS WELLTAP
XFILLER_20_20 VSS VDD FILLER2
Xhold40 _60_/Q VDD VSS hold40/Y BUFX3
XFILLER_16_311 VDD VSS DECAP8
XFILLER_6_44 VSS VDD FILLER2
Xoutput6 _57_/Q VDD VSS counter_value_o[3] BUFX3
XTAP_TAPCELL_ROW_15_75 VDD VSS WELLTAP
XFILLER_15_64 VDD VSS DECAP16
XFILLER_13_314 VDD VSS DECAP32
XFILLER_16_174 VDD VSS DECAP32
XFILLER_0_273 VDD VSS DECAP32
.ends
