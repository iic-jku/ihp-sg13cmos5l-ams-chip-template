* PEX produced on Sat Nov  7 03:38:04 PM CET 2026 using /foss/tools/sak/sak-pex.sh with m=3 and s=1 (extresist threshold=10000 mOhm, minres=1000 mOhm, mindelay=1 ps)
* NGSPICE file created from counter_lv_eth_top_pex.ext - technology: ihp-sg13cmos5l

.subckt counter_lv_eth_top_pex VDD VSS clock_i reset_n_i enable_i
+ counter_value_o[0] counter_value_o[1] counter_value_o[2] counter_value_o[3]
+ counter_value_o[4] counter_value_o[5] counter_value_o[6] counter_value_o[7]
X0 VSS.t107 a_23209_16146# OA21X2_0.B VSS.t614 sg13_lv_nmos ad=0.1567p pd=1.27u as=0.2924p ps=2.4u w=0.86u l=0.13u
X1 VSS.t365 a_11849_11792# VSS.t1491 VSS.t1521 sg13_lv_nmos ad=0.1672p pd=1.26u as=0 ps=0 w=0.88u l=5.575u
X2 VDD.t1094 a_7833_9462# VDD.t1095 VDD.t8 sg13_lv_pmos ad=0.1938p pd=1.4u as=0 ps=0 w=1.02u l=5.575u
X3 VDD.t1202 DFFQX1_0.Q a_6325_16182# VDD.t0 sg13_lv_pmos ad=0.2412p pd=1.73u as=0.1632p ps=1.64u w=0.48u l=0.13u
X4 VSS.t386 a_30497_16146# VSS.t1158 VSS.t385 sg13_lv_nmos ad=0.1738p pd=1.275u as=0 ps=0 w=0.88u l=1.945u
X5 VSS.t914 a_19157_2706# a_19089_2742# VSS.t913 sg13_lv_nmos ad=0.1738p pd=1.275u as=0.2992p ps=2.44u w=0.88u l=0.13u
X6 BUFX24_2.A a_12714_15510# VDD.t1167 VDD.t5 sg13_lv_pmos ad=0.2508p pd=1.7u as=0.2508p ps=1.7u w=1.32u l=0.13u
X7 a_35285_13136# a_35217_13210# VDD.t840 VDD.t93 sg13_lv_pmos ad=0.1938p pd=1.4u as=0.1938p ps=1.4u w=1.02u l=0.13u
X8 VSS.t170 a_11933_8082# a_11865_8118# VSS.t169 sg13_lv_nmos ad=0.1738p pd=1.275u as=0.2992p ps=2.44u w=0.88u l=0.13u
X9 a_13025_13458# a_12957_13494# VDD.t1732 VDD.t100 sg13_lv_pmos ad=0.1938p pd=1.4u as=0.1938p ps=1.4u w=1.02u l=0.13u
X10 VSS.t355 a_20837_9426# VSS.t356 VSS.t1054 sg13_lv_nmos ad=0.1672p pd=1.26u as=0 ps=0 w=0.88u l=5.575u
X11 VDD.t1017 a_31269_10806# a_31337_10770# VDD.t281 sg13_lv_pmos ad=0.1938p pd=1.4u as=0.1938p ps=1.4u w=1.02u l=0.13u
X12 a_31505_15824# a_31437_15898# VDD.t1981 VDD.t5 sg13_lv_pmos ad=0.3468p pd=2.72u as=0.20145p ps=1.415u w=1.02u l=0.13u
X13 VSS.t1467 a_9833_14802# VSS.t1 VSS.t1466 sg13_lv_nmos ad=0.1672p pd=1.26u as=0 ps=0 w=0.88u l=5.575u
X14 VDD.t779 a_9765_14838# VDD.t778 VDD.t5 sg13_lv_pmos ad=0.3468p pd=2.72u as=0 ps=0 w=1.02u l=5.575u
X15 VDD.t1113 a_35217_9178# a_35285_9104# VDD.t29 sg13_lv_pmos ad=0.1938p pd=1.4u as=0.1938p ps=1.4u w=1.02u l=0.13u
X16 a_30161_10448# a_30093_10522# VDD.t188 VDD.t8 sg13_lv_pmos ad=0.3468p pd=2.72u as=0.20145p ps=1.415u w=1.02u l=0.13u
X17 a_23171_15532# a_23033_15572# VDD.t1466 VDD.t5 sg13_lv_pmos ad=0.1632p pd=1.64u as=0.37935p ps=2.32u w=0.48u l=0.13u
X18 VSS.t663 BUFX24_2.A a_15318_15510# VSS.t1255 sg13_lv_nmos ad=0.1634p pd=1.24u as=0.1634p ps=1.24u w=0.86u l=0.13u
X19 VDD.t1604 a_19677_13494# VDD.t1603 VDD.t100 sg13_lv_pmos ad=0.3468p pd=2.72u as=0 ps=0 w=1.02u l=1.945u
X20 VSS.t50 a_37973_6416# VSS.t50 VSS.t49 sg13_lv_nmos ad=0.1738p pd=1.275u as=0 ps=0 w=0.88u l=1.945u
X21 VSS.t922 a_3785_12114# a_3717_12150# VSS.t923 sg13_lv_nmos ad=0.1738p pd=1.275u as=0.2992p ps=2.44u w=0.88u l=0.13u
X22 VDD.t179 a_17497_14130# BUFX3_3.Y VDD.t100 sg13_lv_pmos ad=0.2412p pd=1.73u as=0.4488p ps=3.32u w=1.32u l=0.13u
X23 VSS.t9 a_16973_10448# a_16905_10522# VSS.t1421 sg13_lv_nmos ad=0.1672p pd=1.26u as=0.2992p ps=2.44u w=0.88u l=0.13u
X24 VSS.t444 a_37973_14480# a_37905_14554# VSS.t443 sg13_lv_nmos ad=0.1738p pd=1.275u as=0.2992p ps=2.44u w=0.88u l=0.13u
X25 VDD.t41 a_1029_7834# VDD.t40 VDD.t39 sg13_lv_pmos ad=0.3468p pd=2.72u as=0 ps=0 w=1.02u l=5.575u
X26 VDD.t1367 a_31269_4086# a_31337_4050# VDD.t83 sg13_lv_pmos ad=0.1938p pd=1.4u as=0.1938p ps=1.4u w=1.02u l=0.13u
X27 VSS.t752 a_11849_3728# VSS.t312 VSS.t1536 sg13_lv_nmos ad=0.1672p pd=1.26u as=0 ps=0 w=0.88u l=5.575u
X28 VDD.t1865 a_33873_16182# VDD.t1864 VDD.t0 sg13_lv_pmos ad=0.3468p pd=2.72u as=0 ps=0 w=1.02u l=1.945u
X29 VDD.t416 a_5145_8118# a_5213_8082# VDD.t29 sg13_lv_pmos ad=0.1938p pd=1.4u as=0.1938p ps=1.4u w=1.02u l=0.13u
X30 a_27473_5072# a_27405_5146# VDD.t765 VDD.t83 sg13_lv_pmos ad=0.1938p pd=1.4u as=0.1938p ps=1.4u w=1.02u l=0.13u
X31 VDD.t1297 a_24717_15898# a_24785_15824# VDD.t5 sg13_lv_pmos ad=0.1938p pd=1.4u as=0.1938p ps=1.4u w=1.02u l=0.13u
X32 VSS.t431 a_18401_6738# a_18333_6774# VSS.t684 sg13_lv_nmos ad=0.1738p pd=1.275u as=0.2992p ps=2.44u w=0.88u l=0.13u
X33 a_7833_9462# a_7901_9426# VSS.t91 VSS.t92 sg13_lv_nmos ad=0.2992p pd=2.44u as=0.1672p ps=1.26u w=0.88u l=0.13u
X34 a_6417_15938# a_6153_15938# VSS.t1118 VSS.t1117 sg13_lv_nmos ad=57f pd=0.68u as=61.5f ps=0.71u w=0.3u l=0.13u
X35 a_6911_15770# a_7093_15779# a_7057_15952# VSS.t1107 sg13_lv_nmos ad=57f pd=0.68u as=27f ps=0.48u w=0.3u l=0.13u
X36 a_18757_15474# OR3BX1_0.Y VSS.t14 VSS.t1110 sg13_lv_nmos ad=0.102p pd=1.28u as=0.1567p ps=1.27u w=0.3u l=0.13u
X37 VDD.t540 a_35301_12150# VDD.t539 VDD.t93 sg13_lv_pmos ad=0.3468p pd=2.72u as=0 ps=0 w=1.02u l=1.945u
X38 VSS.t1370 a_12689_2706# a_12621_2742# VSS.t1372 sg13_lv_nmos ad=0.1672p pd=1.26u as=0.2992p ps=2.44u w=0.88u l=0.13u
X39 a_11849_7760# a_11781_7834# VDD.t804 VDD.t39 sg13_lv_pmos ad=0.1938p pd=1.4u as=0.1938p ps=1.4u w=1.02u l=0.13u
X40 VSS.t783 a_7817_7760# VSS.t785 VSS.t784 sg13_lv_nmos ad=0.1738p pd=1.275u as=0 ps=0 w=0.88u l=1.945u
X41 a_1097_15824# a_1029_15898# VDD.t303 VDD.t5 sg13_lv_pmos ad=0.3468p pd=2.72u as=0.20145p ps=1.415u w=1.02u l=0.13u
X42 VDD.t1749 a_32529_13210# a_32597_13136# VDD.t93 sg13_lv_pmos ad=0.1938p pd=1.4u as=0.1938p ps=1.4u w=1.02u l=0.13u
X43 a_19745_4050# a_19677_4086# VDD.t447 VDD.t83 sg13_lv_pmos ad=0.3468p pd=2.72u as=0.20145p ps=1.415u w=1.02u l=0.13u
X44 VDD.t431 a_16905_6490# VDD.t429 VDD.t68 sg13_lv_pmos ad=0.1938p pd=1.4u as=0 ps=0 w=1.02u l=5.575u
X45 a_9257_15244# a_8421_14920# a_9027_15045# VDD.t5 sg13_lv_pmos ad=91.2f pd=0.86u as=91.2f ps=0.86u w=0.48u l=0.13u
X46 a_11781_13210# a_11849_13136# VSS.t238 VSS.t1526 sg13_lv_nmos ad=0.2992p pd=2.44u as=0.1672p ps=1.26u w=0.88u l=0.13u
X47 VSS.t425 a_31337_4050# a_31269_4086# VSS.t1347 sg13_lv_nmos ad=0.1672p pd=1.26u as=0.2992p ps=2.44u w=0.88u l=0.13u
X48 VSS.t89 a_7901_9426# VSS.t87 VSS.t88 sg13_lv_nmos ad=0.1672p pd=1.26u as=0 ps=0 w=0.88u l=5.575u
X49 VSS.t497 a_1097_13458# a_1029_13494# VSS.t835 sg13_lv_nmos ad=0.1672p pd=1.26u as=0.2992p ps=2.44u w=0.88u l=0.13u
X50 a_27473_10448# a_27405_10522# VDD.t891 VDD.t8 sg13_lv_pmos ad=0.1938p pd=1.4u as=0.1938p ps=1.4u w=1.02u l=0.13u
X51 VSS.t101 a_18573_14575# a_18534_14670# VSS.t1451 sg13_lv_nmos ad=57f pd=0.68u as=35.25f ps=0.535u w=0.3u l=0.13u
X52 VSS.t11 a_35285_15824# a_35217_15898# VSS.t10 sg13_lv_nmos ad=0.1672p pd=1.26u as=0.2992p ps=2.44u w=0.88u l=0.13u
X53 VSS.t346 a_9161_11792# VSS.t345 VSS.t344 sg13_lv_nmos ad=0.1672p pd=1.26u as=0 ps=0 w=0.88u l=5.575u
X54 VDD.t1042 a_13041_16182# VDD.t1043 VDD.t0 sg13_lv_pmos ad=0.1938p pd=1.4u as=0 ps=0 w=1.02u l=5.575u
X55 VSS.t1345 a_15377_2706# VSS.t1344 VSS.t1343 sg13_lv_nmos ad=0.1738p pd=1.275u as=0 ps=0 w=0.88u l=1.945u
X56 VSS.t769 a_23693_3728# a_23625_3802# VSS.t768 sg13_lv_nmos ad=0.1738p pd=1.275u as=0.2992p ps=2.44u w=0.88u l=0.13u
X57 a_33941_16146# a_33873_16182# VDD.t1864 VDD.t0 sg13_lv_pmos ad=0.3468p pd=2.72u as=0.20145p ps=1.415u w=1.02u l=0.13u
X58 VSS.t1044 a_22349_5072# a_22281_5146# VSS.t1043 sg13_lv_nmos ad=0.1738p pd=1.275u as=0.2992p ps=2.44u w=0.88u l=0.13u
X59 VSS.t776 a_34025_4050# VSS.t778 VSS.t1459 sg13_lv_nmos ad=0.1738p pd=1.275u as=0 ps=0 w=0.88u l=5.305u
X60 a_24785_6416# a_24717_6490# VDD.t1447 VDD.t68 sg13_lv_pmos ad=0.1938p pd=1.4u as=0.1938p ps=1.4u w=1.02u l=0.13u
X61 VSS.t31 a_15881_9104# a_15813_9178# VSS.t119 sg13_lv_nmos ad=0.1738p pd=1.275u as=0.2992p ps=2.44u w=0.88u l=0.13u
X62 VSS.t383 a_3313_15779# a_3325_15532# VSS.t1756 sg13_lv_nmos ad=0.1193p pd=1.05u as=0.2176p ps=1.96u w=0.64u l=0.13u
X63 VSS.t224 a_3785_4050# a_3717_4086# VSS.t854 sg13_lv_nmos ad=0.1738p pd=1.275u as=0.2992p ps=2.44u w=0.88u l=0.13u
X64 VDD.t1767 a_16401_2742# VDD.t1766 VDD.t354 sg13_lv_pmos ad=0.1938p pd=1.4u as=0 ps=0 w=1.02u l=5.575u
X65 a_35217_10522# a_35285_10448# VSS.t20 VSS.t19 sg13_lv_nmos ad=0.2992p pd=2.44u as=0.1672p ps=1.26u w=0.88u l=0.13u
X66 a_36716_16160# a_36648_16196# VDD.t1 VDD.t0 sg13_lv_pmos ad=0.3332p pd=2.64u as=0.3332p ps=2.64u w=0.98u l=0.76u
X67 a_25877_13458# a_25809_13494# VDD.t1129 VDD.t100 sg13_lv_pmos ad=0.3468p pd=2.72u as=0.20145p ps=1.415u w=1.02u l=0.13u
X68 counter_value_o[1] a_6997_16182# VDD.t1144 VDD.t0 sg13_lv_pmos ad=0.4488p pd=3.32u as=0.2412p ps=1.73u w=1.32u l=0.13u
X69 VSS.t554 DFFQX1_4.Q a_17077_16182# VSS.t568 sg13_lv_nmos ad=0.1567p pd=1.27u as=0.102p ps=1.28u w=0.3u l=0.13u
X70 VSS.t889 a_25877_13458# VSS.t885 VSS.t1835 sg13_lv_nmos ad=0.1738p pd=1.275u as=0 ps=0 w=0.88u l=5.305u
X71 a_3785_6738# a_3717_6774# VDD.t1948 VDD.t39 sg13_lv_pmos ad=0.3468p pd=2.72u as=0.20145p ps=1.415u w=1.02u l=0.13u
X72 a_22611_14608# a_22231_14180# a_22497_14228# VSS.t989 sg13_lv_nmos ad=27f pd=0.48u as=57f ps=0.68u w=0.3u l=0.13u
X73 VSS.t799 a_38480_13472# a_38412_13508# VSS.t798 sg13_lv_nmos ad=0.2176p pd=1.96u as=0.2176p ps=1.96u w=0.64u l=0.76u
X74 VDD.t993 a_9093_5146# VDD.t994 VDD.t83 sg13_lv_pmos ad=0.3468p pd=2.72u as=0 ps=0 w=1.02u l=5.575u
X75 VSS.t143 a_11933_6738# a_11865_6774# VSS.t1829 sg13_lv_nmos ad=0.1738p pd=1.275u as=0.2992p ps=2.44u w=0.88u l=0.13u
X76 VDD.t692 a_31437_13210# VDD.t691 VDD.t93 sg13_lv_pmos ad=0.3468p pd=2.72u as=0 ps=0 w=1.02u l=1.945u
X77 VSS.t725 a_35369_2706# a_35301_2742# VSS.t1046 sg13_lv_nmos ad=0.1672p pd=1.26u as=0.2992p ps=2.44u w=0.88u l=0.13u
X78 a_19745_12114# a_19677_12150# VDD.t1665 VDD.t93 sg13_lv_pmos ad=0.3468p pd=2.72u as=0.20145p ps=1.415u w=1.02u l=0.13u
X79 a_11933_9426# a_11865_9462# VDD.t635 VDD.t8 sg13_lv_pmos ad=0.3468p pd=2.72u as=0.20145p ps=1.415u w=1.02u l=0.13u
X80 a_32597_7760# a_32529_7834# VDD.t1943 VDD.t39 sg13_lv_pmos ad=0.1938p pd=1.4u as=0.1938p ps=1.4u w=1.02u l=0.13u
X81 a_19661_11792# a_19593_11866# VDD.t1493 VDD.t281 sg13_lv_pmos ad=0.1938p pd=1.4u as=0.1938p ps=1.4u w=1.02u l=0.13u
X82 VSS.t370 a_23525_9426# a_23457_9462# VSS.t1005 sg13_lv_nmos ad=0.1672p pd=1.26u as=0.2992p ps=2.44u w=0.88u l=0.13u
X83 a_3049_16146# BUFX3_12.A VDD.t619 VDD.t0 sg13_lv_pmos ad=0.1632p pd=1.64u as=0.2412p ps=1.73u w=0.48u l=0.13u
X84 DFFQX1_5.Q a_23003_14188# VSS.t896 VSS.t895 sg13_lv_nmos ad=0.102p pd=1.28u as=0.1519p ps=1.265u w=0.3u l=0.13u
X85 VDD.t567 a_32529_9178# VDD.t566 VDD.t29 sg13_lv_pmos ad=0.3468p pd=2.72u as=0 ps=0 w=1.02u l=5.575u
X86 VDD.t128 a_37905_10522# VDD.t127 VDD.t8 sg13_lv_pmos ad=0.3468p pd=2.72u as=0 ps=0 w=1.02u l=1.945u
X87 VDD.t1820 a_15645_10806# VDD.t1819 VDD.t281 sg13_lv_pmos ad=0.3468p pd=2.72u as=0 ps=0 w=1.02u l=5.575u
X88 VSS.t9 a_15713_10770# VSS.t7 VSS.t1633 sg13_lv_nmos ad=0.1672p pd=1.26u as=0 ps=0 w=0.88u l=5.575u
X89 VSS.t925 a_5213_12114# VSS.t921 VSS.t1642 sg13_lv_nmos ad=0.1672p pd=1.26u as=0 ps=0 w=0.88u l=5.575u
X90 VSS.t297 a_31505_6416# VSS.t297 VSS.t298 sg13_lv_nmos ad=0.1738p pd=1.275u as=0 ps=0 w=0.88u l=1.945u
X91 VDD.t1504 a_3717_12150# VDD.t1503 VDD.t93 sg13_lv_pmos ad=0.3468p pd=2.72u as=0 ps=0 w=1.02u l=1.945u
X92 a_1097_5072# a_1029_5146# VDD.t332 VDD.t83 sg13_lv_pmos ad=0.1938p pd=1.4u as=0.1938p ps=1.4u w=1.02u l=0.13u
X93 a_1097_6738# a_1029_6774# VDD.t1975 VDD.t39 sg13_lv_pmos ad=0.1938p pd=1.4u as=0.1938p ps=1.4u w=1.02u l=0.13u
X94 a_8492_7782# a_8424_7868# VDD.t1491 VDD.t39 sg13_lv_pmos ad=0.3332p pd=2.64u as=0.3332p ps=2.64u w=0.98u l=0.76u
X95 VSS.t968 BUFX3_29.A a_21865_13494# VSS.t1710 sg13_lv_nmos ad=0.1567p pd=1.27u as=0.102p ps=1.28u w=0.3u l=0.13u
X96 a_38648_11814# a_38580_11900# VDD.t963 VDD.t281 sg13_lv_pmos ad=0.3332p pd=2.64u as=0.3332p ps=2.64u w=0.98u l=0.76u
X97 VSS.t725 a_38057_2706# VSS.t725 VSS.t1046 sg13_lv_nmos ad=0.1738p pd=1.275u as=0 ps=0 w=0.88u l=1.945u
X98 a_23003_14188# a_22865_14228# VDD.t941 VDD.t100 sg13_lv_pmos ad=0.1632p pd=1.64u as=0.37935p ps=2.32u w=0.48u l=0.13u
X99 VSS.t381 BUFX3_12.A a_2629_15510# VSS.t659 sg13_lv_nmos ad=0.1567p pd=1.27u as=0.102p ps=1.28u w=0.3u l=0.13u
X100 a_1029_9178# a_1097_9104# VSS.t520 VSS.t624 sg13_lv_nmos ad=0.2992p pd=2.44u as=0.1672p ps=1.26u w=0.88u l=0.13u
X101 VSS.t345 a_10589_12114# a_10521_12150# VSS.t1612 sg13_lv_nmos ad=0.1738p pd=1.275u as=0.2992p ps=2.44u w=0.88u l=0.13u
X102 a_38480_8096# a_38412_8132# VDD.t38 VDD.t29 sg13_lv_pmos ad=0.3332p pd=2.64u as=0.3332p ps=2.64u w=0.98u l=0.76u
X103 VSS.t386 a_31589_16146# a_31521_16182# VSS.t605 sg13_lv_nmos ad=0.1738p pd=1.275u as=0.2992p ps=2.44u w=0.88u l=0.13u
X104 VDD.t1224 NAND3X1_0.B a_6559_15572# VDD.t5 sg13_lv_pmos ad=0.1632p pd=1.64u as=45.6f ps=0.67u w=0.48u l=0.13u
X105 a_12957_13494# a_13025_13458# VSS.t241 VSS.t242 sg13_lv_nmos ad=0.2992p pd=2.44u as=0.1672p ps=1.26u w=0.88u l=0.13u
X106 VSS.t581 a_6809_10448# a_6741_10522# VSS.t845 sg13_lv_nmos ad=0.1738p pd=1.275u as=0.2992p ps=2.44u w=0.88u l=0.13u
X107 VDD.t70 a_6405_6490# VDD.t69 VDD.t68 sg13_lv_pmos ad=0.3468p pd=2.72u as=0 ps=0 w=1.02u l=5.305u
X108 a_22195_14900# BUFX3_29.Y VSS.t602 VSS.t1185 sg13_lv_nmos ad=27f pd=0.48u as=0.102p ps=1.28u w=0.3u l=0.13u
X109 VDD.t1701 a_9093_14554# a_9161_14480# VDD.t100 sg13_lv_pmos ad=0.1938p pd=1.4u as=0.1938p ps=1.4u w=1.02u l=0.13u
X110 VSS.t882 a_24029_2706# VSS.t880 VSS.t881 sg13_lv_nmos ad=0.1672p pd=1.26u as=0 ps=0 w=0.88u l=5.575u
X111 VSS.t1070 a_10589_8082# a_10521_8118# VSS.t1069 sg13_lv_nmos ad=0.1738p pd=1.275u as=0.2992p ps=2.44u w=0.88u l=0.13u
X112 VSS.t381 a_3049_16146# counter_value_o[0] VSS.t616 sg13_lv_nmos ad=0.1567p pd=1.27u as=0.2924p ps=2.4u w=0.86u l=0.13u
X113 a_6417_15938# NAND3X1_0.B BUFX3_26.A VSS.t1214 sg13_lv_nmos ad=0.102p pd=1.28u as=58.5f ps=0.69u w=0.3u l=0.13u
X114 VSS.t248 a_28649_14802# a_28581_14838# VSS.t1617 sg13_lv_nmos ad=0.1672p pd=1.26u as=0.2992p ps=2.44u w=0.88u l=0.13u
X115 VDD.t538 a_27405_13210# VDD.t536 VDD.t93 sg13_lv_pmos ad=0.1938p pd=1.4u as=0 ps=0 w=1.02u l=5.575u
X116 VDD.t581 a_15645_8118# a_15713_8082# VDD.t29 sg13_lv_pmos ad=0.1938p pd=1.4u as=0.1938p ps=1.4u w=1.02u l=0.13u
X117 VDD.t1073 a_23457_8118# VDD.t1072 VDD.t29 sg13_lv_pmos ad=0.1938p pd=1.4u as=0 ps=0 w=1.02u l=5.575u
X118 VDD.t1791 a_35217_11866# VDD.t1790 VDD.t281 sg13_lv_pmos ad=0.3468p pd=2.72u as=0 ps=0 w=1.02u l=5.575u
X119 a_7817_14480# a_7749_14554# VDD.t1715 VDD.t100 sg13_lv_pmos ad=0.3468p pd=2.72u as=0.20145p ps=1.415u w=1.02u l=0.13u
X120 VSS.t661 a_12714_15510# BUFX24_2.A VSS.t1144 sg13_lv_nmos ad=0.1634p pd=1.24u as=0.1634p ps=1.24u w=0.86u l=0.13u
X121 VSS.t561 a_5213_8082# a_5145_8118# VSS.t1809 sg13_lv_nmos ad=0.1672p pd=1.26u as=0.2992p ps=2.44u w=0.88u l=0.13u
X122 VDD.t1319 a_1029_13494# VDD.t1318 VDD.t100 sg13_lv_pmos ad=0.3468p pd=2.72u as=0 ps=0 w=1.02u l=5.575u
X123 VDD.t1364 a_31269_4086# VDD.t1363 VDD.t83 sg13_lv_pmos ad=0.3468p pd=2.72u as=0 ps=0 w=1.02u l=5.575u
X124 a_18297_15244# DFFQX1_2.D a_18235_15244# VDD.t5 sg13_lv_pmos ad=91.2f pd=0.86u as=43.2f ps=0.66u w=0.48u l=0.13u
X125 VDD.t108 a_16905_13210# VDD.t107 VDD.t93 sg13_lv_pmos ad=0.3468p pd=2.72u as=0 ps=0 w=1.02u l=5.575u
X126 a_3717_9178# a_3785_9104# VSS.t526 VSS.t638 sg13_lv_nmos ad=0.2992p pd=2.44u as=0.1672p ps=1.26u w=0.88u l=0.13u
X127 VDD.t590 a_17497_16146# BUFX3_2.A VDD.t0 sg13_lv_pmos ad=0.2412p pd=1.73u as=0.4488p ps=3.32u w=1.32u l=0.13u
X128 a_36461_9426# a_36393_9462# VDD.t555 VDD.t8 sg13_lv_pmos ad=0.3468p pd=2.72u as=0.20145p ps=1.415u w=1.02u l=0.13u
X129 VSS.t24 a_11849_9104# VSS.t26 VSS.t539 sg13_lv_nmos ad=0.1672p pd=1.26u as=0 ps=0 w=0.88u l=5.575u
X130 VSS.t303 a_35285_5072# VSS.t305 VSS.t304 sg13_lv_nmos ad=0.1672p pd=1.26u as=0 ps=0 w=0.88u l=5.575u
X131 VDD.t1187 a_9674_15474# DFFQX1_3.CK VDD.t5 sg13_lv_pmos ad=0.2508p pd=1.7u as=0.2508p ps=1.7u w=1.32u l=0.13u
X132 a_5213_14802# a_5145_14838# VDD.t176 VDD.t5 sg13_lv_pmos ad=0.3468p pd=2.72u as=0.20145p ps=1.415u w=1.02u l=0.13u
X133 a_22377_13948# OR3X1_1.B a_22291_13948# VDD.t100 sg13_lv_pmos ad=86.39999f pd=0.84u as=71.99999f ps=0.78u w=0.48u l=0.13u
X134 VSS.t497 a_1097_13136# VSS.t497 VSS.t836 sg13_lv_nmos ad=0.1672p pd=1.26u as=0 ps=0 w=0.88u l=5.575u
X135 VSS.t668 a_13025_8082# VSS.t172 VSS.t1074 sg13_lv_nmos ad=0.1672p pd=1.26u as=0 ps=0 w=0.88u l=5.575u
X136 a_8889_15244# a_8421_14920# a_8839_14900# VSS.t401 sg13_lv_nmos ad=57f pd=0.68u as=27f ps=0.48u w=0.3u l=0.13u
X137 VSS.t264 a_23777_14480# VSS.t448 VSS.t1708 sg13_lv_nmos ad=0.1738p pd=1.275u as=0 ps=0 w=0.88u l=1.945u
X138 VSS.t97 a_37805_8082# a_37737_8118# VSS.t96 sg13_lv_nmos ad=0.1738p pd=1.275u as=0.2992p ps=2.44u w=0.88u l=0.13u
X139 OR3X1_1.Y a_22197_13608# VSS.t262 VSS.t518 sg13_lv_nmos ad=0.102p pd=1.28u as=61.5f ps=0.71u w=0.3u l=0.13u
X140 VDD.t231 a_19677_6774# VDD.t230 VDD.t39 sg13_lv_pmos ad=0.3468p pd=2.72u as=0 ps=0 w=1.02u l=1.945u
X141 VDD.t814 a_35217_7834# VDD.t812 VDD.t39 sg13_lv_pmos ad=0.1938p pd=1.4u as=0 ps=0 w=1.02u l=5.575u
X142 OAI21X1_1.Y OR3X1_1.C a_21289_15524# VDD.t5 sg13_lv_pmos ad=91.2f pd=0.86u as=91.2f ps=0.86u w=0.48u l=0.13u
X143 VSS.t886 a_24785_13136# a_24717_13210# VSS.t887 sg13_lv_nmos ad=0.1672p pd=1.26u as=0.2992p ps=2.44u w=0.88u l=0.13u
X144 VDD.t911 a_3717_4086# VDD.t910 VDD.t83 sg13_lv_pmos ad=0.3468p pd=2.72u as=0 ps=0 w=1.02u l=1.945u
X145 a_3785_5394# a_3717_5430# VDD.t435 VDD.t68 sg13_lv_pmos ad=0.3468p pd=2.72u as=0.20145p ps=1.415u w=1.02u l=0.13u
X146 a_9093_9178# a_9161_9104# VSS.t24 VSS.t644 sg13_lv_nmos ad=0.2992p pd=2.44u as=0.1672p ps=1.26u w=0.88u l=0.13u
X147 a_9181_15474# AND2X1_2.Y VDD.t1179 VDD.t5 sg13_lv_pmos ad=0.1632p pd=1.64u as=0.2412p ps=1.73u w=0.48u l=0.13u
X148 VDD.t270 a_3717_5146# VDD.t268 VDD.t83 sg13_lv_pmos ad=0.1938p pd=1.4u as=0 ps=0 w=1.02u l=5.575u
X149 VSS.t952 a_7901_13458# a_7833_13494# VSS.t951 sg13_lv_nmos ad=0.1672p pd=1.26u as=0.2992p ps=2.44u w=0.88u l=0.13u
X150 VDD.t585 a_27489_8118# VDD.t584 VDD.t29 sg13_lv_pmos ad=0.3468p pd=2.72u as=0 ps=0 w=1.02u l=1.945u
X151 VDD.t21 a_23457_9462# VDD.t20 VDD.t8 sg13_lv_pmos ad=0.3468p pd=2.72u as=0 ps=0 w=1.02u l=5.575u
X152 VSS.t1652 a_11597_2706# VSS.t1337 VSS.t1651 sg13_lv_nmos ad=0.1738p pd=1.275u as=0 ps=0 w=0.88u l=1.945u
X153 VSS.t559 a_6473_7760# VSS.t783 VSS.t1828 sg13_lv_nmos ad=0.1738p pd=1.275u as=0 ps=0 w=0.88u l=5.305u
X154 OAI21X1_0.Y OR3X1_1.B a_19273_15292# VDD.t5 sg13_lv_pmos ad=91.2f pd=0.86u as=91.2f ps=0.86u w=0.48u l=0.13u
X155 VDD.t421 a_14469_6490# VDD.t422 VDD.t68 sg13_lv_pmos ad=0.3468p pd=2.72u as=0 ps=0 w=1.02u l=5.305u
X156 a_31269_14838# a_31337_14802# VSS.t869 VSS.t1717 sg13_lv_nmos ad=0.2992p pd=2.44u as=0.1672p ps=1.26u w=0.88u l=0.13u
X157 a_1097_5394# a_1029_5430# VDD.t680 VDD.t68 sg13_lv_pmos ad=0.1938p pd=1.4u as=0.1938p ps=1.4u w=1.02u l=0.13u
X158 VDD.t1694 BUFX3_1.Y.t6 a_18165_15510# VDD.t5 sg13_lv_pmos ad=0.1632p pd=1.64u as=0.1632p ps=1.64u w=0.48u l=0.13u
X159 BUFX3_1.Y a_1033_10134# VSS.t1573 VSS.t1572 sg13_lv_nmos ad=0.2924p pd=2.4u as=0.1567p ps=1.27u w=0.86u l=0.13u
X160 a_27405_14554# a_27473_14480# VSS.t246 VSS.t245 sg13_lv_nmos ad=0.2992p pd=2.44u as=0.1672p ps=1.26u w=0.88u l=0.13u
X161 a_4053_3802# a_4121_3728# VSS.t859 VSS.t1094 sg13_lv_nmos ad=0.2992p pd=2.44u as=0.1672p ps=1.26u w=0.88u l=0.13u
X162 a_37153_16146# BUFX3_41.A VSS.t11 VSS.t10 sg13_lv_nmos ad=0.102p pd=1.28u as=0.1567p ps=1.27u w=0.3u l=0.13u
X163 VSS.t262 NOR3X1_0.A NOR3X1_0.Y VSS.t261 sg13_lv_nmos ad=0.102p pd=1.28u as=57f ps=0.68u w=0.3u l=0.13u
X164 VSS.t821 a_27557_10770# VSS.t813 VSS.t1508 sg13_lv_nmos ad=0.1738p pd=1.275u as=0 ps=0 w=0.88u l=1.945u
X165 VSS.t117 a_27809_16146# VSS.t115 VSS.t900 sg13_lv_nmos ad=0.1672p pd=1.26u as=0 ps=0 w=0.88u l=5.575u
X166 a_21613_13458# BUFX3_27.A VSS.t72 VSS.t1207 sg13_lv_nmos ad=0.102p pd=1.28u as=0.1567p ps=1.27u w=0.3u l=0.13u
X167 VDD.t212 a_22281_7834# VDD.t211 VDD.t39 sg13_lv_pmos ad=0.3468p pd=2.72u as=0 ps=0 w=1.02u l=5.305u
X168 a_14117_15824# a_14049_15898# VDD.t1229 VDD.t5 sg13_lv_pmos ad=0.3468p pd=2.72u as=0.20145p ps=1.415u w=1.02u l=0.13u
X169 VDD.t871 a_10521_12150# VDD.t870 VDD.t93 sg13_lv_pmos ad=0.3468p pd=2.72u as=0 ps=0 w=1.02u l=5.305u
X170 VDD.t1554 a_31521_16182# VDD.t1553 VDD.t0 sg13_lv_pmos ad=0.3468p pd=2.72u as=0 ps=0 w=1.02u l=1.945u
X171 a_3721_14802# XOR2X1_0.Y VDD.t369 VDD.t5 sg13_lv_pmos ad=0.1632p pd=1.64u as=0.2412p ps=1.73u w=0.48u l=0.13u
X172 DFFQX1_5.CK a_15318_15510# VDD.t1164 VDD.t5 sg13_lv_pmos ad=0.4488p pd=3.32u as=0.2508p ps=1.7u w=1.32u l=0.13u
X173 a_15645_10806# a_15713_10770# VSS.t1423 VSS.t1635 sg13_lv_nmos ad=0.2992p pd=2.44u as=0.1672p ps=1.26u w=0.88u l=0.13u
X174 a_1097_13136# a_1029_13210# VDD.t1515 VDD.t93 sg13_lv_pmos ad=0.1938p pd=1.4u as=0.1938p ps=1.4u w=1.02u l=0.13u
X175 VDD.t469 a_1029_6490# VDD.t468 VDD.t68 sg13_lv_pmos ad=0.1938p pd=1.4u as=0 ps=0 w=1.02u l=5.575u
X176 VSS.t1393 a_19661_10448# a_19593_10522# VSS.t1392 sg13_lv_nmos ad=0.1672p pd=1.26u as=0.2992p ps=2.44u w=0.88u l=0.13u
X177 a_24301_14802# BUFX3_41.A VDD.t462 VDD.t5 sg13_lv_pmos ad=0.1632p pd=1.64u as=0.2412p ps=1.73u w=0.48u l=0.13u
X178 VSS.t89 a_9161_9104# a_9093_9178# VSS.t641 sg13_lv_nmos ad=0.1672p pd=1.26u as=0.2992p ps=2.44u w=0.88u l=0.13u
X179 a_28649_6738# a_28581_6774# VDD.t1357 VDD.t39 sg13_lv_pmos ad=0.1938p pd=1.4u as=0.1938p ps=1.4u w=1.02u l=0.13u
X180 VSS.t141 a_10589_6738# a_10521_6774# VSS.t140 sg13_lv_nmos ad=0.1738p pd=1.275u as=0.2992p ps=2.44u w=0.88u l=0.13u
X181 VDD.t1920 a_12621_2742# a_12689_2706# VDD.t354 sg13_lv_pmos ad=0.1938p pd=1.4u as=0.1938p ps=1.4u w=1.02u l=0.13u
X182 BUFX24_2.A a_12714_15510# VSS.t661 VSS.t1147 sg13_lv_nmos ad=0.1634p pd=1.24u as=0.1634p ps=1.24u w=0.86u l=0.13u
X183 VDD.t223 a_7833_6774# VDD.t222 VDD.t39 sg13_lv_pmos ad=0.3468p pd=2.72u as=0 ps=0 w=1.02u l=5.575u
X184 VDD.t647 a_12957_8118# VDD.t646 VDD.t29 sg13_lv_pmos ad=0.3468p pd=2.72u as=0 ps=0 w=1.02u l=5.575u
X185 a_35369_13458# a_35301_13494# VDD.t1351 VDD.t100 sg13_lv_pmos ad=0.3468p pd=2.72u as=0.20145p ps=1.415u w=1.02u l=0.13u
X186 a_32529_13210# a_32597_13136# VSS.t1549 VSS.t1552 sg13_lv_nmos ad=0.2992p pd=2.44u as=0.1672p ps=1.26u w=0.88u l=0.13u
X187 VSS.t474 a_5213_6738# a_5145_6774# VSS.t680 sg13_lv_nmos ad=0.1672p pd=1.26u as=0.2992p ps=2.44u w=0.88u l=0.13u
X188 a_16687_14852# a_16485_14920# VDD.t371 VDD.t5 sg13_lv_pmos ad=0.3332p pd=2.64u as=0.1834p ps=1.39u w=0.98u l=0.13u
X189 VDD.t906 a_11781_5146# VDD.t904 VDD.t83 sg13_lv_pmos ad=0.1938p pd=1.4u as=0 ps=0 w=1.02u l=5.575u
X190 a_24717_15898# a_24785_15824# VSS.t113 VSS.t405 sg13_lv_nmos ad=0.2992p pd=2.44u as=0.1672p ps=1.26u w=0.88u l=0.13u
X191 VSS.t796 a_15881_11792# VSS.t795 VSS.t794 sg13_lv_nmos ad=0.1738p pd=1.275u as=0 ps=0 w=0.88u l=1.945u
X192 VDD.t1623 a_16905_11866# VDD.t1622 VDD.t281 sg13_lv_pmos ad=0.1938p pd=1.4u as=0 ps=0 w=1.02u l=5.575u
X193 VSS.t121 a_16973_9104# VSS.t126 VSS.t125 sg13_lv_nmos ad=0.1672p pd=1.26u as=0 ps=0 w=0.88u l=5.575u
X194 VSS.t485 a_30161_6416# VSS.t297 VSS.t689 sg13_lv_nmos ad=0.1738p pd=1.275u as=0 ps=0 w=0.88u l=5.305u
X195 VSS.t81 a_3785_14480# a_3717_14554# VSS.t907 sg13_lv_nmos ad=0.1672p pd=1.26u as=0.2992p ps=2.44u w=0.88u l=0.13u
X196 VSS.t212 a_28649_5394# VSS.t209 VSS.t211 sg13_lv_nmos ad=0.1672p pd=1.26u as=0 ps=0 w=0.88u l=5.575u
X197 OR3X1_1.B XOR2X1_0.A VDD.t167 VDD.t5 sg13_lv_pmos ad=0.1862p pd=1.36u as=0.3332p ps=2.64u w=0.98u l=0.13u
X198 VSS.t190 a_13025_6738# VSS.t717 VSS.t720 sg13_lv_nmos ad=0.1672p pd=1.26u as=0 ps=0 w=0.88u l=5.575u
X199 a_23803_14838# NOR3X1_0.C a_23709_14838# VSS.t1128 sg13_lv_nmos ad=0.102p pd=1.28u as=0.102p ps=1.28u w=0.3u l=0.13u
X200 VDD.t1475 a_26649_2742# VDD.t1474 VDD.t354 sg13_lv_pmos ad=0.3468p pd=2.72u as=0 ps=0 w=1.02u l=1.945u
X201 VSS.t50 a_37805_6738# a_37737_6774# VSS.t49 sg13_lv_nmos ad=0.1738p pd=1.275u as=0.2992p ps=2.44u w=0.88u l=0.13u
X202 VDD.t290 NOR3X1_0.A a_23709_14838# VDD.t5 sg13_lv_pmos ad=0.1834p pd=1.39u as=0.1212p ps=0.985u w=0.48u l=0.13u
X203 VDD.t686 a_19677_5430# VDD.t685 VDD.t68 sg13_lv_pmos ad=0.3468p pd=2.72u as=0 ps=0 w=1.02u l=1.945u
X204 VSS.t878 a_24029_2706# a_23961_2742# VSS.t877 sg13_lv_nmos ad=0.1672p pd=1.26u as=0.2992p ps=2.44u w=0.88u l=0.13u
X205 a_19661_5072# a_19593_5146# VDD.t1340 VDD.t83 sg13_lv_pmos ad=0.1938p pd=1.4u as=0.1938p ps=1.4u w=1.02u l=0.13u
X206 a_17055_15244# a_16485_14920# a_16953_15244# VDD.t5 sg13_lv_pmos ad=43.2f pd=0.66u as=91.2f ps=0.86u w=0.48u l=0.13u
X207 VSS.t224 a_1097_4050# VSS.t224 VSS.t226 sg13_lv_nmos ad=0.1672p pd=1.26u as=0 ps=0 w=0.88u l=5.575u
X208 VSS.t764 a_23693_10448# a_23625_10522# VSS.t839 sg13_lv_nmos ad=0.1738p pd=1.275u as=0.2992p ps=2.44u w=0.88u l=0.13u
X209 a_22665_15572# DFFQX1_6.D a_22603_15572# VDD.t5 sg13_lv_pmos ad=91.2f pd=0.86u as=43.2f ps=0.66u w=0.48u l=0.13u
X210 a_22613_15244# a_21777_14920# a_22383_15045# VDD.t5 sg13_lv_pmos ad=91.2f pd=0.86u as=91.2f ps=0.86u w=0.48u l=0.13u
X211 a_22245_15244# a_21777_14920# a_22195_14900# VSS.t1660 sg13_lv_nmos ad=57f pd=0.68u as=27f ps=0.48u w=0.3u l=0.13u
X212 VDD.t513 a_35301_2742# a_35369_2706# VDD.t354 sg13_lv_pmos ad=0.1938p pd=1.4u as=0.1938p ps=1.4u w=1.02u l=0.13u
X213 VDD.t771 a_7833_13494# VDD.t770 VDD.t100 sg13_lv_pmos ad=0.3468p pd=2.72u as=0 ps=0 w=1.02u l=5.575u
X214 a_4460_9440# a_4392_9476# VDD.t130 VDD.t8 sg13_lv_pmos ad=0.3332p pd=2.64u as=0.3332p ps=2.64u w=0.98u l=0.76u
X215 a_20769_8118# a_20837_8082# VSS.t374 VSS.t1079 sg13_lv_nmos ad=0.2992p pd=2.44u as=0.1672p ps=1.26u w=0.88u l=0.13u
X216 a_17091_15045# a_16953_15244# VDD.t146 VDD.t5 sg13_lv_pmos ad=91.2f pd=0.86u as=91.2f ps=0.86u w=0.48u l=0.13u
X217 VDD.t1511 a_36393_10806# VDD.t1510 VDD.t281 sg13_lv_pmos ad=0.3468p pd=2.72u as=0 ps=0 w=1.02u l=5.305u
X218 VSS.t11 a_35285_15824# VSS.t11 VSS.t10 sg13_lv_nmos ad=0.1672p pd=1.26u as=0 ps=0 w=0.88u l=5.575u
X219 VDD.t520 a_9093_6490# VDD.t518 VDD.t68 sg13_lv_pmos ad=0.1938p pd=1.4u as=0 ps=0 w=1.02u l=5.575u
X220 VSS.t552 a_27473_7760# VSS.t466 VSS.t714 sg13_lv_nmos ad=0.1672p pd=1.26u as=0 ps=0 w=0.88u l=5.575u
X221 VSS.t370 a_20837_9426# VSS.t355 VSS.t1055 sg13_lv_nmos ad=0.1672p pd=1.26u as=0 ps=0 w=0.88u l=5.575u
X222 VSS.t381 a_1097_15824# a_1029_15898# VSS.t1002 sg13_lv_nmos ad=0.1738p pd=1.275u as=0.2992p ps=2.44u w=0.88u l=0.13u
X223 a_7057_15952# a_6803_15792# VSS.t1121 VSS.t1233 sg13_lv_nmos ad=27f pd=0.48u as=0.1519p ps=1.265u w=0.3u l=0.13u
X224 a_14537_3728# a_14469_3802# VDD.t989 VDD.t354 sg13_lv_pmos ad=0.3468p pd=2.72u as=0.20145p ps=1.415u w=1.02u l=0.13u
X225 a_8841_2742# a_8909_2706# VSS.t1337 VSS.t1338 sg13_lv_nmos ad=0.2992p pd=2.44u as=0.1672p ps=1.26u w=0.88u l=0.13u
X226 VDD.t1300 a_24717_15898# VDD.t1297 VDD.t5 sg13_lv_pmos ad=0.1938p pd=1.4u as=0 ps=0 w=1.02u l=5.575u
X227 VDD.t1773 a_27741_2742# VDD.t1772 VDD.t354 sg13_lv_pmos ad=0.1938p pd=1.4u as=0 ps=0 w=1.02u l=5.575u
X228 VSS.t970 a_4460_10784# a_4392_10820# VSS.t1636 sg13_lv_nmos ad=0.2176p pd=1.96u as=0.2176p ps=1.96u w=0.64u l=0.76u
X229 VDD.t143 a_27741_16182# a_27809_16146# VDD.t0 sg13_lv_pmos ad=0.1938p pd=1.4u as=0.1938p ps=1.4u w=1.02u l=0.13u
X230 VDD.t1431 a_19089_2742# VDD.t1430 VDD.t354 sg13_lv_pmos ad=0.3468p pd=2.72u as=0 ps=0 w=1.02u l=1.945u
X231 VDD.t168 XOR2X1_0.A a_3139_15244# VDD.t5 sg13_lv_pmos ad=98.39999f pd=0.89u as=43.2f ps=0.66u w=0.48u l=0.13u
X232 VSS.t925 a_6473_11792# VSS.t1305 VSS.t1304 sg13_lv_nmos ad=0.1738p pd=1.275u as=0 ps=0 w=0.88u l=5.305u
X233 VSS.t365 a_13025_12114# a_12957_12150# VSS.t1489 sg13_lv_nmos ad=0.1672p pd=1.26u as=0.2992p ps=2.44u w=0.88u l=0.13u
X234 a_22349_5072# a_22281_5146# VDD.t1346 VDD.t83 sg13_lv_pmos ad=0.3468p pd=2.72u as=0.20145p ps=1.415u w=1.02u l=0.13u
X235 VDD.t1296 a_24717_15898# VDD.t1298 VDD.t5 sg13_lv_pmos ad=0.3468p pd=2.72u as=0 ps=0 w=1.02u l=5.575u
X236 VSS.t346 a_7901_12114# VSS.t1305 VSS.t1581 sg13_lv_nmos ad=0.1672p pd=1.26u as=0 ps=0 w=0.88u l=5.575u
X237 VDD.t1434 a_18333_10806# VDD.t1433 VDD.t281 sg13_lv_pmos ad=0.3468p pd=2.72u as=0 ps=0 w=1.02u l=5.305u
X238 VDD.t1234 a_12793_16146# counter_value_o[2] VDD.t0 sg13_lv_pmos ad=0.2412p pd=1.73u as=0.4488p ps=3.32u w=1.32u l=0.13u
X239 VSS.t1335 a_8909_2706# VSS.t1333 VSS.t1334 sg13_lv_nmos ad=0.1672p pd=1.26u as=0 ps=0 w=0.88u l=5.575u
X240 a_23457_8118# a_23525_8082# VSS.t651 VSS.t1028 sg13_lv_nmos ad=0.2992p pd=2.44u as=0.1672p ps=1.26u w=0.88u l=0.13u
X241 a_35369_8082# a_35301_8118# VDD.t366 VDD.t29 sg13_lv_pmos ad=0.3468p pd=2.72u as=0.20145p ps=1.415u w=1.02u l=0.13u
X242 VDD.t122 BUFX3_0.Y NAND2X1_0.Y VDD.t5 sg13_lv_pmos ad=0.1632p pd=1.64u as=91.2f ps=0.86u w=0.48u l=0.13u
X243 a_28649_5394# a_28581_5430# VDD.t1951 VDD.t68 sg13_lv_pmos ad=0.1938p pd=1.4u as=0.1938p ps=1.4u w=1.02u l=0.13u
X244 VSS.t320 a_24785_11792# VSS.t318 VSS.t1405 sg13_lv_nmos ad=0.1672p pd=1.26u as=0 ps=0 w=0.88u l=5.575u
X245 VDD.t439 a_7833_5430# VDD.t438 VDD.t68 sg13_lv_pmos ad=0.3468p pd=2.72u as=0 ps=0 w=1.02u l=5.575u
X246 a_10589_10770# a_10521_10806# VDD.t1640 VDD.t281 sg13_lv_pmos ad=0.3468p pd=2.72u as=0.20145p ps=1.415u w=1.02u l=0.13u
X247 a_16973_3728# a_16905_3802# VDD.t451 VDD.t354 sg13_lv_pmos ad=0.1938p pd=1.4u as=0.1938p ps=1.4u w=1.02u l=0.13u
X248 a_31521_2742# a_31589_2706# VSS.t723 VSS.t1438 sg13_lv_nmos ad=0.2992p pd=2.44u as=0.1672p ps=1.26u w=0.88u l=0.13u
X249 VDD.t104 a_11781_14554# a_11849_14480# VDD.t100 sg13_lv_pmos ad=0.1938p pd=1.4u as=0.1938p ps=1.4u w=1.02u l=0.13u
X250 VSS.t1083 a_9161_7760# VSS.t1070 VSS.t1082 sg13_lv_nmos ad=0.1672p pd=1.26u as=0 ps=0 w=0.88u l=5.575u
X251 AND2X1_1.B a_6661_16182# VSS.t1121 VSS.t1120 sg13_lv_nmos ad=0.2924p pd=2.4u as=0.1567p ps=1.27u w=0.86u l=0.13u
X252 a_21391_15175# a_21189_14906# VDD.t1208 VDD.t5 sg13_lv_pmos ad=0.1862p pd=1.36u as=0.1834p ps=1.39u w=0.98u l=0.13u
X253 VDD.t229 a_18333_6774# VDD.t227 VDD.t39 sg13_lv_pmos ad=0.3468p pd=2.72u as=0 ps=0 w=1.02u l=5.305u
X254 VDD.t1461 a_32529_5146# a_32597_5072# VDD.t83 sg13_lv_pmos ad=0.1938p pd=1.4u as=0.1938p ps=1.4u w=1.02u l=0.13u
X255 a_32529_3802# a_32597_3728# VSS.t776 VSS.t775 sg13_lv_nmos ad=0.2992p pd=2.44u as=0.1672p ps=1.26u w=0.88u l=0.13u
X256 a_3441_15952# a_3325_15532# a_3131_15770# VSS.t1112 sg13_lv_nmos ad=57f pd=0.68u as=57f ps=0.68u w=0.3u l=0.13u
X257 VDD.t272 a_19593_13210# VDD.t271 VDD.t93 sg13_lv_pmos ad=0.3468p pd=2.72u as=0 ps=0 w=1.02u l=5.575u
X258 VDD.t1918 a_12621_2742# VDD.t1917 VDD.t354 sg13_lv_pmos ad=0.3468p pd=2.72u as=0 ps=0 w=1.02u l=5.575u
X259 VSS.t284 a_7817_6416# VSS.t290 VSS.t289 sg13_lv_nmos ad=0.1738p pd=1.275u as=0 ps=0 w=0.88u l=1.945u
X260 VDD.t220 a_5145_6774# VDD.t221 VDD.t39 sg13_lv_pmos ad=0.1938p pd=1.4u as=0 ps=0 w=1.02u l=5.575u
X261 VSS.t936 a_20837_12114# VSS.t935 VSS.t934 sg13_lv_nmos ad=0.1672p pd=1.26u as=0 ps=0 w=0.88u l=5.575u
X262 VDD.t87 a_1029_4086# a_1097_4050# VDD.t83 sg13_lv_pmos ad=0.1938p pd=1.4u as=0.1938p ps=1.4u w=1.02u l=0.13u
X263 VDD.t653 a_26145_8118# VDD.t652 VDD.t29 sg13_lv_pmos ad=0.3468p pd=2.72u as=0 ps=0 w=1.02u l=5.305u
X264 a_8095_16258# NAND3X1_0.Y a_8001_16258# VSS.t15 sg13_lv_nmos ad=27f pd=0.48u as=0.102p ps=1.28u w=0.3u l=0.13u
X265 VSS.t163 a_19409_15824# a_19341_15898# VSS.t1228 sg13_lv_nmos ad=0.1738p pd=1.275u as=0.2992p ps=2.44u w=0.88u l=0.13u
X266 VDD.t1793 a_35217_11866# a_35285_11792# VDD.t281 sg13_lv_pmos ad=0.1938p pd=1.4u as=0.1938p ps=1.4u w=1.02u l=0.13u
X267 VDD.t1870 a_27405_3802# a_27473_3728# VDD.t354 sg13_lv_pmos ad=0.1938p pd=1.4u as=0.1938p ps=1.4u w=1.02u l=0.13u
X268 a_37805_8082# a_37737_8118# VDD.t587 VDD.t29 sg13_lv_pmos ad=0.3468p pd=2.72u as=0.20145p ps=1.415u w=1.02u l=0.13u
X269 BUFX3_0.Y a_1033_3414# VDD.t946 VDD.t354 sg13_lv_pmos ad=0.4488p pd=3.32u as=0.2412p ps=1.73u w=1.32u l=0.13u
X270 VSS.t36 a_35369_9426# a_35301_9462# VSS.t1056 sg13_lv_nmos ad=0.1738p pd=1.275u as=0.2992p ps=2.44u w=0.88u l=0.13u
X271 a_13041_16182# a_13109_16146# VSS.t663 VSS.t662 sg13_lv_nmos ad=0.2992p pd=2.44u as=0.1672p ps=1.26u w=0.88u l=0.13u
X272 OAI21X1_1.Y OR3X1_1.A a_21195_16000# VSS.t670 sg13_lv_nmos ad=0.102p pd=1.28u as=57f ps=0.68u w=0.3u l=0.13u
X273 VDD.t965 a_1029_11866# VDD.t964 VDD.t281 sg13_lv_pmos ad=0.3468p pd=2.72u as=0 ps=0 w=1.02u l=5.575u
X274 a_20769_6774# a_20837_6738# VSS.t787 VSS.t1040 sg13_lv_nmos ad=0.2992p pd=2.44u as=0.1672p ps=1.26u w=0.88u l=0.13u
X275 VDD.t299 a_20769_9462# a_20837_9426# VDD.t8 sg13_lv_pmos ad=0.1938p pd=1.4u as=0.1938p ps=1.4u w=1.02u l=0.13u
X276 VSS.t1137 a_16469_16146# a_16401_16182# VSS.t1182 sg13_lv_nmos ad=0.1738p pd=1.275u as=0.2992p ps=2.44u w=0.88u l=0.13u
X277 VSS.t208 a_28649_5394# a_28581_5430# VSS.t210 sg13_lv_nmos ad=0.1672p pd=1.26u as=0.2992p ps=2.44u w=0.88u l=0.13u
X278 VSS.t674 a_24785_7760# a_24717_7834# VSS.t673 sg13_lv_nmos ad=0.1672p pd=1.26u as=0.2992p ps=2.44u w=0.88u l=0.13u
X279 VSS.t338 a_27473_13136# a_27405_13210# VSS.t337 sg13_lv_nmos ad=0.1672p pd=1.26u as=0.2992p ps=2.44u w=0.88u l=0.13u
X280 a_5145_4086# a_5213_4050# VSS.t861 VSS.t862 sg13_lv_nmos ad=0.2992p pd=2.44u as=0.1672p ps=1.26u w=0.88u l=0.13u
X281 VDD.t672 a_11781_6490# a_11849_6416# VDD.t68 sg13_lv_pmos ad=0.1938p pd=1.4u as=0.1938p ps=1.4u w=1.02u l=0.13u
X282 VDD.t1000 a_35217_5146# a_35285_5072# VDD.t83 sg13_lv_pmos ad=0.1938p pd=1.4u as=0.1938p ps=1.4u w=1.02u l=0.13u
X283 VSS.t352 a_38648_9126# a_38580_9212# VSS.t351 sg13_lv_nmos ad=0.2176p pd=1.96u as=0.2176p ps=1.96u w=0.64u l=0.76u
X284 a_11781_7834# a_11849_7760# VSS.t668 VSS.t1034 sg13_lv_nmos ad=0.2992p pd=2.44u as=0.1672p ps=1.26u w=0.88u l=0.13u
X285 VSS.t419 a_18401_4050# VSS.t441 VSS.t442 sg13_lv_nmos ad=0.1738p pd=1.275u as=0 ps=0 w=0.88u l=5.305u
X286 VSS.t872 a_35369_14802# a_35301_14838# VSS.t1102 sg13_lv_nmos ad=0.1738p pd=1.275u as=0.2992p ps=2.44u w=0.88u l=0.13u
X287 VSS.t362 a_15881_14480# a_15813_14554# VSS.t1204 sg13_lv_nmos ad=0.1738p pd=1.275u as=0.2992p ps=2.44u w=0.88u l=0.13u
X288 a_22231_14180# a_22029_14280# VSS.t602 VSS.t823 sg13_lv_nmos ad=0.2176p pd=1.96u as=0.1193p ps=1.05u w=0.64u l=0.13u
X289 VSS.t67 a_38480_12128# a_38412_12164# VSS.t66 sg13_lv_nmos ad=0.2176p pd=1.96u as=0.2176p ps=1.96u w=0.64u l=0.76u
X290 VSS.t224 a_1097_4050# a_1029_4086# VSS.t223 sg13_lv_nmos ad=0.1672p pd=1.26u as=0.2992p ps=2.44u w=0.88u l=0.13u
X291 a_15881_3728# a_15813_3802# VDD.t1424 VDD.t354 sg13_lv_pmos ad=0.3468p pd=2.72u as=0.20145p ps=1.415u w=1.02u l=0.13u
X292 VDD.t1389 a_12957_12150# VDD.t1388 VDD.t93 sg13_lv_pmos ad=0.3468p pd=2.72u as=0 ps=0 w=1.02u l=5.575u
X293 a_7601_15572# DFFQX1_0.D a_7297_15682# VDD.t5 sg13_lv_pmos ad=43.2f pd=0.66u as=91.2f ps=0.86u w=0.48u l=0.13u
X294 VSS.t246 a_28649_14802# VSS.t248 VSS.t1616 sg13_lv_nmos ad=0.1672p pd=1.26u as=0 ps=0 w=0.88u l=5.575u
X295 VDD.t511 a_35301_2742# VDD.t510 VDD.t354 sg13_lv_pmos ad=0.3468p pd=2.72u as=0 ps=0 w=1.02u l=5.575u
X296 VDD.t508 a_11865_6774# VDD.t507 VDD.t39 sg13_lv_pmos ad=0.3468p pd=2.72u as=0 ps=0 w=1.02u l=1.945u
X297 a_4460_13472# a_4392_13508# VDD.t1587 VDD.t100 sg13_lv_pmos ad=0.3332p pd=2.64u as=0.3332p ps=2.64u w=0.98u l=0.76u
X298 VSS.t1030 a_20249_16146# a_20181_16182# VSS.t1271 sg13_lv_nmos ad=0.1738p pd=1.275u as=0.2992p ps=2.44u w=0.88u l=0.13u
X299 a_23457_6774# a_23525_6738# VSS.t737 VSS.t1296 sg13_lv_nmos ad=0.2992p pd=2.44u as=0.1672p ps=1.26u w=0.88u l=0.13u
X300 VDD.t1416 a_23625_13210# VDD.t1415 VDD.t93 sg13_lv_pmos ad=0.3468p pd=2.72u as=0 ps=0 w=1.02u l=1.945u
X301 VDD.t1055 a_31269_9462# VDD.t1056 VDD.t8 sg13_lv_pmos ad=0.1938p pd=1.4u as=0 ps=0 w=1.02u l=5.575u
X302 a_8839_14900# DFFQX1_3.D VSS.t74 VSS.t1193 sg13_lv_nmos ad=27f pd=0.48u as=0.102p ps=1.28u w=0.3u l=0.13u
X303 VDD.t490 a_5145_12150# VDD.t489 VDD.t93 sg13_lv_pmos ad=0.1938p pd=1.4u as=0 ps=0 w=1.02u l=5.575u
X304 VSS.t861 a_8153_3728# a_8085_3802# VSS.t1378 sg13_lv_nmos ad=0.1738p pd=1.275u as=0.2992p ps=2.44u w=0.88u l=0.13u
X305 VDD.t1743 a_32529_11866# VDD.t1742 VDD.t281 sg13_lv_pmos ad=0.1938p pd=1.4u as=0 ps=0 w=1.02u l=5.575u
X306 DFFQX1_3.Q a_9395_15170# VDD.t170 VDD.t5 sg13_lv_pmos ad=0.1632p pd=1.64u as=0.2529p ps=1.545u w=0.48u l=0.13u
X307 a_31589_2706# a_31521_2742# VDD.t860 VDD.t354 sg13_lv_pmos ad=0.1938p pd=1.4u as=0.1938p ps=1.4u w=1.02u l=0.13u
X308 DFFQX1_3.CK a_9674_15474# VDD.t1187 VDD.t5 sg13_lv_pmos ad=0.2508p pd=1.7u as=0.2508p ps=1.7u w=1.32u l=0.13u
X309 VDD.t243 a_23625_6490# VDD.t242 VDD.t68 sg13_lv_pmos ad=0.3468p pd=2.72u as=0 ps=0 w=1.02u l=1.945u
X310 VDD.t147 a_23209_16146# OA21X2_0.B VDD.t0 sg13_lv_pmos ad=0.2412p pd=1.73u as=0.4488p ps=3.32u w=1.32u l=0.13u
X311 VDD.t526 a_18333_5430# VDD.t524 VDD.t68 sg13_lv_pmos ad=0.3468p pd=2.72u as=0 ps=0 w=1.02u l=5.305u
X312 VSS.t18 a_34025_10770# VSS.t268 VSS.t1704 sg13_lv_nmos ad=0.1738p pd=1.275u as=0 ps=0 w=0.88u l=5.305u
X313 VDD.t819 a_12957_6774# VDD.t818 VDD.t39 sg13_lv_pmos ad=0.1938p pd=1.4u as=0 ps=0 w=1.02u l=5.575u
X314 VDD.t391 a_4305_15898# VDD.t390 VDD.t5 sg13_lv_pmos ad=0.3468p pd=2.72u as=0 ps=0 w=1.02u l=1.945u
X315 OAI21X1_2.Y NAND2X1_1.Y a_20869_15292# VDD.t5 sg13_lv_pmos ad=91.2f pd=0.86u as=91.2f ps=0.86u w=0.48u l=0.13u
X316 a_18401_4050# a_18333_4086# VDD.t444 VDD.t83 sg13_lv_pmos ad=0.3468p pd=2.72u as=0.20145p ps=1.415u w=1.02u l=0.13u
X317 VDD.t879 a_23961_2742# a_24029_2706# VDD.t354 sg13_lv_pmos ad=0.1938p pd=1.4u as=0.1938p ps=1.4u w=1.02u l=0.13u
X318 VSS.t34 a_31337_9426# VSS.t131 VSS.t633 sg13_lv_nmos ad=0.1672p pd=1.26u as=0 ps=0 w=0.88u l=5.575u
X319 a_22635_14192# a_22497_14228# VDD.t1436 VDD.t100 sg13_lv_pmos ad=91.2f pd=0.86u as=91.2f ps=0.86u w=0.48u l=0.13u
X320 VSS.t340 a_28649_13458# a_28581_13494# VSS.t585 sg13_lv_nmos ad=0.1672p pd=1.26u as=0.2992p ps=2.44u w=0.88u l=0.13u
X321 VDD.t75 a_5145_5430# VDD.t76 VDD.t68 sg13_lv_pmos ad=0.1938p pd=1.4u as=0 ps=0 w=1.02u l=5.575u
X322 VDD.t162 OR3BX1_0.B OAI21X1_0.Y VDD.t5 sg13_lv_pmos ad=0.1632p pd=1.64u as=91.2f ps=0.86u w=0.48u l=0.13u
X323 VSS.t76 a_6473_14480# a_6405_14554# VSS.t991 sg13_lv_nmos ad=0.1738p pd=1.275u as=0.2992p ps=2.44u w=0.88u l=0.13u
X324 VSS.t72 a_20837_13458# VSS.t70 VSS.t71 sg13_lv_nmos ad=0.1738p pd=1.275u as=0 ps=0 w=0.88u l=1.945u
X325 VDD.t1273 BUFX24_2.A a_9674_15474# VDD.t5 sg13_lv_pmos ad=0.2508p pd=1.7u as=0.2508p ps=1.7u w=1.32u l=0.13u
X326 VDD.t1120 a_20769_8118# VDD.t1119 VDD.t29 sg13_lv_pmos ad=0.1938p pd=1.4u as=0 ps=0 w=1.02u l=5.575u
X327 a_9161_10448# a_9093_10522# VDD.t10 VDD.t8 sg13_lv_pmos ad=0.1938p pd=1.4u as=0.1938p ps=1.4u w=1.02u l=0.13u
X328 VDD.t695 a_24717_3802# VDD.t694 VDD.t354 sg13_lv_pmos ad=0.3468p pd=2.72u as=0 ps=0 w=1.02u l=5.575u
X329 VDD.t1097 a_35301_9462# VDD.t1096 VDD.t8 sg13_lv_pmos ad=0.3468p pd=2.72u as=0 ps=0 w=1.02u l=1.945u
X330 VDD.t1451 a_24717_6490# VDD.t1449 VDD.t68 sg13_lv_pmos ad=0.1938p pd=1.4u as=0 ps=0 w=1.02u l=5.575u
X331 VDD.t493 a_15813_10522# VDD.t494 VDD.t8 sg13_lv_pmos ad=0.3468p pd=2.72u as=0 ps=0 w=1.02u l=1.945u
X332 VDD.t1124 a_16401_16182# VDD.t1123 VDD.t0 sg13_lv_pmos ad=0.3468p pd=2.72u as=0 ps=0 w=1.02u l=1.945u
X333 VDD.t60 a_15645_6774# VDD.t61 VDD.t39 sg13_lv_pmos ad=0.1938p pd=1.4u as=0 ps=0 w=1.02u l=5.575u
X334 BUFX3_28.A AOI21BX2_0.A a_23323_15175# VDD.t5 sg13_lv_pmos ad=0.1862p pd=1.36u as=0.1862p ps=1.36u w=0.98u l=0.13u
X335 VSS.t936 a_22349_11792# VSS.t316 VSS.t1579 sg13_lv_nmos ad=0.1738p pd=1.275u as=0 ps=0 w=0.88u l=5.305u
X336 VDD.t1459 a_32529_5146# VDD.t1458 VDD.t83 sg13_lv_pmos ad=0.3468p pd=2.72u as=0 ps=0 w=1.02u l=5.575u
X337 VDD.t1140 NAND3X1_0.B a_6153_15938# VDD.t5 sg13_lv_pmos ad=98.39999f pd=0.89u as=91.2f ps=0.86u w=0.48u l=0.13u
X338 VSS.t870 a_32597_14480# VSS.t869 VSS.t868 sg13_lv_nmos ad=0.1672p pd=1.26u as=0 ps=0 w=0.88u l=5.575u
X339 a_7901_6738# a_7833_6774# VDD.t222 VDD.t39 sg13_lv_pmos ad=0.1938p pd=1.4u as=0.1938p ps=1.4u w=1.02u l=0.13u
X340 VDD.t1618 a_20265_14554# VDD.t1617 VDD.t100 sg13_lv_pmos ad=0.3468p pd=2.72u as=0 ps=0 w=1.02u l=1.945u
X341 VDD.t1516 a_1029_13210# a_1097_13136# VDD.t93 sg13_lv_pmos ad=0.1938p pd=1.4u as=0.1938p ps=1.4u w=1.02u l=0.13u
X342 VSS.t808 a_16973_11792# VSS.t1364 VSS.t1566 sg13_lv_nmos ad=0.1672p pd=1.26u as=0 ps=0 w=0.88u l=5.575u
X343 VSS.t209 a_30161_5072# a_30093_5146# VSS.t848 sg13_lv_nmos ad=0.1738p pd=1.275u as=0.2992p ps=2.44u w=0.88u l=0.13u
X344 VSS.t374 a_23693_7760# VSS.t674 VSS.t847 sg13_lv_nmos ad=0.1738p pd=1.275u as=0 ps=0 w=0.88u l=1.945u
X345 VDD.t85 a_1029_4086# VDD.t84 VDD.t83 sg13_lv_pmos ad=0.3468p pd=2.72u as=0 ps=0 w=1.02u l=5.575u
X346 VSS.t38 a_32597_9104# VSS.t36 VSS.t39 sg13_lv_nmos ad=0.1672p pd=1.26u as=0 ps=0 w=0.88u l=5.575u
X347 a_30497_2706# a_30429_2742# VDD.t1394 VDD.t354 sg13_lv_pmos ad=0.3468p pd=2.72u as=0.20145p ps=1.415u w=1.02u l=0.13u
X348 VDD.t246 a_11865_5430# VDD.t245 VDD.t68 sg13_lv_pmos ad=0.3468p pd=2.72u as=0 ps=0 w=1.02u l=1.945u
X349 VDD.t1191 a_9674_15474# DFFQX1_3.CK VDD.t5 sg13_lv_pmos ad=0.2508p pd=1.7u as=0.2508p ps=1.7u w=1.32u l=0.13u
X350 a_15645_4086# a_15713_4050# VSS.t441 VSS.t867 sg13_lv_nmos ad=0.2992p pd=2.44u as=0.1672p ps=1.26u w=0.88u l=0.13u
X351 a_23525_6738# a_23457_6774# VDD.t62 VDD.t39 sg13_lv_pmos ad=0.1938p pd=1.4u as=0.1938p ps=1.4u w=1.02u l=0.13u
X352 VDD.t1294 a_20181_16182# VDD.t1293 VDD.t0 sg13_lv_pmos ad=0.3468p pd=2.72u as=0 ps=0 w=1.02u l=1.945u
X353 VSS.t310 a_4121_3728# VSS.t857 VSS.t1092 sg13_lv_nmos ad=0.1672p pd=1.26u as=0 ps=0 w=0.88u l=5.575u
X354 a_37973_6416# a_37905_6490# VDD.t1896 VDD.t68 sg13_lv_pmos ad=0.3468p pd=2.72u as=0.20145p ps=1.415u w=1.02u l=0.13u
X355 VSS.t478 a_6473_6416# VSS.t284 VSS.t687 sg13_lv_nmos ad=0.1738p pd=1.275u as=0 ps=0 w=0.88u l=5.305u
X356 VSS.t94 NAND4X2_0.C a_8095_16258# VSS.t1427 sg13_lv_nmos ad=61.5f pd=0.71u as=27f ps=0.48u w=0.3u l=0.13u
X357 VSS.t64 a_7901_5394# VSS.t60 VSS.t743 sg13_lv_nmos ad=0.1672p pd=1.26u as=0 ps=0 w=0.88u l=5.575u
X358 VSS.t819 a_30161_10448# a_30093_10522# VSS.t828 sg13_lv_nmos ad=0.1738p pd=1.275u as=0.2992p ps=2.44u w=0.88u l=0.13u
X359 a_31269_13494# a_31337_13458# VSS.t1513 VSS.t1514 sg13_lv_nmos ad=0.2992p pd=2.44u as=0.1672p ps=1.26u w=0.88u l=0.13u
X360 NAND2X1_1.Y BUFX3_2.A VDD.t1313 VDD.t100 sg13_lv_pmos ad=91.2f pd=0.86u as=0.1632p ps=1.64u w=0.48u l=0.13u
X361 VSS.t1284 a_1097_2706# VSS.t1284 VSS.t1791 sg13_lv_nmos ad=0.1672p pd=1.26u as=0 ps=0 w=0.88u l=5.575u
X362 VSS.t97 a_37973_7760# a_37905_7834# VSS.t96 sg13_lv_nmos ad=0.1738p pd=1.275u as=0.2992p ps=2.44u w=0.88u l=0.13u
X363 VSS.t362 AND2X1_0.Y a_16153_14838# VSS.t1181 sg13_lv_nmos ad=0.1567p pd=1.27u as=0.102p ps=1.28u w=0.3u l=0.13u
X364 a_31337_8082# a_31269_8118# VDD.t196 VDD.t29 sg13_lv_pmos ad=0.1938p pd=1.4u as=0.1938p ps=1.4u w=1.02u l=0.13u
X365 a_19409_15824# a_19341_15898# VDD.t1239 VDD.t5 sg13_lv_pmos ad=0.3468p pd=2.72u as=0.20145p ps=1.415u w=1.02u l=0.13u
X366 VSS.t139 OAI21X1_0.A a_19179_14852# VSS.t1179 sg13_lv_nmos ad=57f pd=0.68u as=0.102p ps=1.28u w=0.3u l=0.13u
X367 VDD.t606 a_27405_15898# VDD.t605 VDD.t5 sg13_lv_pmos ad=0.3468p pd=2.72u as=0 ps=0 w=1.02u l=5.575u
X368 VSS.t204 a_23525_5394# VSS.t330 VSS.t331 sg13_lv_nmos ad=0.1672p pd=1.26u as=0 ps=0 w=0.88u l=5.575u
X369 VSS.t181 a_19661_7760# VSS.t179 VSS.t182 sg13_lv_nmos ad=0.1672p pd=1.26u as=0 ps=0 w=0.88u l=5.575u
X370 DFFQX1_7.Q a_22751_15170# VSS.t896 VSS.t928 sg13_lv_nmos ad=0.102p pd=1.28u as=0.1519p ps=1.265u w=0.3u l=0.13u
X371 a_15881_10448# a_15813_10522# VDD.t493 VDD.t8 sg13_lv_pmos ad=0.3468p pd=2.72u as=0.20145p ps=1.415u w=1.02u l=0.13u
X372 VDD.t1162 a_15318_15510# DFFQX1_5.CK VDD.t5 sg13_lv_pmos ad=0.2508p pd=1.7u as=0.2508p ps=1.7u w=1.32u l=0.13u
X373 a_35285_6416# a_35217_6490# VDD.t474 VDD.t68 sg13_lv_pmos ad=0.1938p pd=1.4u as=0.1938p ps=1.4u w=1.02u l=0.13u
X374 VSS.t352 a_35285_9104# VSS.t352 VSS.t351 sg13_lv_nmos ad=0.1672p pd=1.26u as=0 ps=0 w=0.88u l=5.575u
X375 a_8320_15932# NAND3X1_0.B a_8218_15932# VSS.t1215 sg13_lv_nmos ad=0.1216p pd=1.02u as=0.1216p ps=1.02u w=0.64u l=0.13u
X376 a_12714_15510# clock_i VDD.t1786 VDD.t5 sg13_lv_pmos ad=0.2508p pd=1.7u as=0.2508p ps=1.7u w=1.32u l=0.13u
X377 VSS.t796 a_13025_12114# VSS.t1491 VSS.t1492 sg13_lv_nmos ad=0.1672p pd=1.26u as=0 ps=0 w=0.88u l=5.575u
X378 VSS.t998 a_27473_11792# VSS.t1096 VSS.t1287 sg13_lv_nmos ad=0.1672p pd=1.26u as=0 ps=0 w=0.88u l=5.575u
X379 VDD.t251 a_12957_5430# VDD.t252 VDD.t68 sg13_lv_pmos ad=0.1938p pd=1.4u as=0 ps=0 w=1.02u l=5.575u
X380 VSS.t107 a_23965_15474# BUFX3_27.A VSS.t1106 sg13_lv_nmos ad=0.1567p pd=1.27u as=0.2924p ps=2.4u w=0.86u l=0.13u
X381 VSS.t237 a_11933_13458# VSS.t1384 VSS.t1497 sg13_lv_nmos ad=0.1738p pd=1.275u as=0 ps=0 w=0.88u l=1.945u
X382 VDD.t1884 a_9093_13210# VDD.t1882 VDD.t93 sg13_lv_pmos ad=0.1938p pd=1.4u as=0 ps=0 w=1.02u l=5.575u
X383 a_22767_15572# a_22197_15624# a_22665_15572# VDD.t5 sg13_lv_pmos ad=43.2f pd=0.66u as=91.2f ps=0.86u w=0.48u l=0.13u
X384 VSS.t202 a_19661_5072# a_19593_5146# VSS.t1325 sg13_lv_nmos ad=0.1672p pd=1.26u as=0.2992p ps=2.44u w=0.88u l=0.13u
X385 VSS.t293 BUFX3_12.A a_4981_15510# VSS.t658 sg13_lv_nmos ad=0.1567p pd=1.27u as=0.102p ps=1.28u w=0.3u l=0.13u
X386 VDD.t178 a_5145_14838# VDD.t176 VDD.t5 sg13_lv_pmos ad=0.3468p pd=2.72u as=0 ps=0 w=1.02u l=5.305u
X387 VDD.t746 a_10521_6774# VDD.t744 VDD.t39 sg13_lv_pmos ad=0.3468p pd=2.72u as=0 ps=0 w=1.02u l=5.305u
X388 a_20924_16160# a_20856_16196# VDD.t1973 VDD.t0 sg13_lv_pmos ad=0.3332p pd=2.64u as=0.3332p ps=2.64u w=0.98u l=0.76u
X389 VDD.t114 a_28581_13494# VDD.t113 VDD.t100 sg13_lv_pmos ad=0.3468p pd=2.72u as=0 ps=0 w=1.02u l=5.575u
X390 VSS.t38 a_34025_9426# a_33957_9462# VSS.t533 sg13_lv_nmos ad=0.1738p pd=1.275u as=0.2992p ps=2.44u w=0.88u l=0.13u
X391 a_22399_15524# a_22197_15624# VSS.t154 VSS.t1758 sg13_lv_nmos ad=0.2176p pd=1.96u as=0.1193p ps=1.05u w=0.64u l=0.13u
X392 VDD.t218 a_5145_6774# VDD.t217 VDD.t39 sg13_lv_pmos ad=0.3468p pd=2.72u as=0 ps=0 w=1.02u l=5.575u
X393 VSS.t1573 a_1097_10770# VSS.t1573 VSS.t1676 sg13_lv_nmos ad=0.1672p pd=1.26u as=0 ps=0 w=0.88u l=5.575u
X394 a_3139_15244# BUFX3_0.Y a_3045_15244# VDD.t5 sg13_lv_pmos ad=43.2f pd=0.66u as=0.1632p ps=1.64u w=0.48u l=0.13u
X395 a_31505_6416# a_31437_6490# VDD.t677 VDD.t68 sg13_lv_pmos ad=0.3468p pd=2.72u as=0.20145p ps=1.415u w=1.02u l=0.13u
X396 a_22613_16650# OA21X2_0.B a_22350_16146# VDD.t0 sg13_lv_pmos ad=43.2f pd=0.66u as=0.1212p ps=0.985u w=0.48u l=0.13u
X397 OR3BX1_0.Y BUFX3_2.Y VDD.t1506 VDD.t100 sg13_lv_pmos ad=91.2f pd=0.86u as=0.2184p ps=1.87u w=0.48u l=0.13u
X398 a_16905_13210# a_16973_13136# VSS.t700 VSS.t699 sg13_lv_nmos ad=0.2992p pd=2.44u as=0.1672p ps=1.26u w=0.88u l=0.13u
X399 VSS.t314 a_13025_4050# VSS.t312 VSS.t945 sg13_lv_nmos ad=0.1672p pd=1.26u as=0 ps=0 w=0.88u l=5.575u
X400 a_9161_3728# a_9093_3802# VDD.t1689 VDD.t354 sg13_lv_pmos ad=0.1938p pd=1.4u as=0.1938p ps=1.4u w=1.02u l=0.13u
X401 VDD.t756 a_15645_5430# VDD.t757 VDD.t68 sg13_lv_pmos ad=0.1938p pd=1.4u as=0 ps=0 w=1.02u l=5.575u
X402 VSS.t320 a_23525_12114# VSS.t316 VSS.t319 sg13_lv_nmos ad=0.1672p pd=1.26u as=0 ps=0 w=0.88u l=5.575u
X403 VDD.t1127 a_37737_6774# VDD.t1126 VDD.t39 sg13_lv_pmos ad=0.3468p pd=2.72u as=0 ps=0 w=1.02u l=1.945u
X404 a_16687_14852# a_16485_14920# VSS.t105 VSS.t377 sg13_lv_nmos ad=0.2176p pd=1.96u as=0.1193p ps=1.05u w=0.64u l=0.13u
X405 VSS.t57 a_5213_5394# VSS.t55 VSS.t195 sg13_lv_nmos ad=0.1672p pd=1.26u as=0 ps=0 w=0.88u l=5.575u
X406 a_7901_5394# a_7833_5430# VDD.t438 VDD.t68 sg13_lv_pmos ad=0.1938p pd=1.4u as=0.1938p ps=1.4u w=1.02u l=0.13u
X407 VDD.t877 a_23961_2742# VDD.t876 VDD.t354 sg13_lv_pmos ad=0.3468p pd=2.72u as=0 ps=0 w=1.02u l=5.575u
X408 VSS.t647 a_3785_8082# VSS.t165 VSS.t1067 sg13_lv_nmos ad=0.1738p pd=1.275u as=0 ps=0 w=0.88u l=1.945u
X409 a_23525_5394# a_23457_5430# VDD.t828 VDD.t68 sg13_lv_pmos ad=0.1938p pd=1.4u as=0.1938p ps=1.4u w=1.02u l=0.13u
X410 VDD.t619 a_3049_16146# counter_value_o[0] VDD.t0 sg13_lv_pmos ad=0.2412p pd=1.73u as=0.4488p ps=3.32u w=1.32u l=0.13u
X411 a_14537_13136# a_14469_13210# VDD.t1675 VDD.t93 sg13_lv_pmos ad=0.3468p pd=2.72u as=0.20145p ps=1.415u w=1.02u l=0.13u
X412 VDD.t1828 a_5061_2742# VDD.t1827 VDD.t354 sg13_lv_pmos ad=0.1938p pd=1.4u as=0 ps=0 w=1.02u l=5.575u
X413 a_4460_8096# a_4392_8132# VDD.t1069 VDD.t29 sg13_lv_pmos ad=0.3332p pd=2.64u as=0.3332p ps=2.64u w=0.98u l=0.76u
X414 VDD.t849 a_37905_3802# VDD.t848 VDD.t354 sg13_lv_pmos ad=0.3468p pd=2.72u as=0 ps=0 w=1.02u l=1.945u
X415 VSS.t1503 a_11933_10770# a_11865_10806# VSS.t1502 sg13_lv_nmos ad=0.1738p pd=1.275u as=0.2992p ps=2.44u w=0.88u l=0.13u
X416 VDD.t781 a_9765_14838# a_9833_14802# VDD.t5 sg13_lv_pmos ad=0.1938p pd=1.4u as=0.1938p ps=1.4u w=1.02u l=0.13u
X417 a_27405_5146# a_27473_5072# VSS.t209 VSS.t981 sg13_lv_nmos ad=0.2992p pd=2.44u as=0.1672p ps=1.26u w=0.88u l=0.13u
X418 a_9093_14554# a_9161_14480# VSS.t3 VSS.t5 sg13_lv_nmos ad=0.2992p pd=2.44u as=0.1672p ps=1.26u w=0.88u l=0.13u
X419 VSS.t799 a_37973_13136# VSS.t799 VSS.t798 sg13_lv_nmos ad=0.1738p pd=1.275u as=0 ps=0 w=0.88u l=1.945u
X420 VDD.t1754 a_19593_3802# a_19661_3728# VDD.t354 sg13_lv_pmos ad=0.1938p pd=1.4u as=0.1938p ps=1.4u w=1.02u l=0.13u
X421 a_20249_2706# a_20181_2742# VDD.t1520 VDD.t354 sg13_lv_pmos ad=0.1938p pd=1.4u as=0.1938p ps=1.4u w=1.02u l=0.13u
X422 VSS.t483 a_27473_6416# VSS.t485 VSS.t484 sg13_lv_nmos ad=0.1672p pd=1.26u as=0 ps=0 w=0.88u l=5.575u
X423 a_24785_11792# a_24717_11866# VDD.t852 VDD.t281 sg13_lv_pmos ad=0.1938p pd=1.4u as=0.1938p ps=1.4u w=1.02u l=0.13u
X424 VSS.t340 a_27473_13136# VSS.t342 VSS.t341 sg13_lv_nmos ad=0.1672p pd=1.26u as=0 ps=0 w=0.88u l=5.575u
X425 VSS.t651 a_24785_7760# VSS.t550 VSS.t676 sg13_lv_nmos ad=0.1672p pd=1.26u as=0 ps=0 w=0.88u l=5.575u
X426 a_9674_15474# BUFX24_2.A VSS.t612 VSS.t1253 sg13_lv_nmos ad=0.2924p pd=2.4u as=0.1634p ps=1.24u w=0.86u l=0.13u
X427 VSS.t1327 a_20837_5394# a_20769_5430# VSS.t1777 sg13_lv_nmos ad=0.1672p pd=1.26u as=0.2992p ps=2.44u w=0.88u l=0.13u
X428 VSS.t954 a_8492_13158# a_8424_13244# VSS.t1698 sg13_lv_nmos ad=0.2176p pd=1.96u as=0.2176p ps=1.96u w=0.64u l=0.76u
X429 VSS.t608 a_9674_15474# DFFQX1_3.CK VSS.t1168 sg13_lv_nmos ad=0.1634p pd=1.24u as=0.2924p ps=2.4u w=0.86u l=0.13u
X430 VSS.t993 a_7817_14480# VSS.t109 VSS.t1586 sg13_lv_nmos ad=0.1738p pd=1.275u as=0 ps=0 w=0.88u l=1.945u
X431 VSS.t34 a_32597_9104# a_32529_9178# VSS.t33 sg13_lv_nmos ad=0.1672p pd=1.26u as=0.2992p ps=2.44u w=0.88u l=0.13u
X432 VDD.t1391 a_12957_12150# a_13025_12114# VDD.t93 sg13_lv_pmos ad=0.1938p pd=1.4u as=0.1938p ps=1.4u w=1.02u l=0.13u
X433 VSS.t1503 a_11849_10448# a_11781_10522# VSS.t1637 sg13_lv_nmos ad=0.1672p pd=1.26u as=0.2992p ps=2.44u w=0.88u l=0.13u
X434 VDD.t668 a_30093_7834# VDD.t667 VDD.t39 sg13_lv_pmos ad=0.3468p pd=2.72u as=0 ps=0 w=1.02u l=5.305u
X435 VDD.t1854 a_28581_14838# a_28649_14802# VDD.t5 sg13_lv_pmos ad=0.1938p pd=1.4u as=0.1938p ps=1.4u w=1.02u l=0.13u
X436 VDD.t1795 a_35217_11866# VDD.t1793 VDD.t281 sg13_lv_pmos ad=0.1938p pd=1.4u as=0 ps=0 w=1.02u l=5.575u
X437 VSS.t256 a_27557_4050# VSS.t254 VSS.t255 sg13_lv_nmos ad=0.1738p pd=1.275u as=0 ps=0 w=0.88u l=1.945u
X438 a_19593_9178# a_19661_9104# VSS.t355 VSS.t359 sg13_lv_nmos ad=0.2992p pd=2.44u as=0.1672p ps=1.26u w=0.88u l=0.13u
X439 VDD.t395 a_10521_5430# VDD.t394 VDD.t68 sg13_lv_pmos ad=0.3468p pd=2.72u as=0 ps=0 w=1.02u l=5.305u
X440 VSS.t246 a_30161_14480# VSS.t1507 VSS.t1506 sg13_lv_nmos ad=0.1738p pd=1.275u as=0 ps=0 w=0.88u l=5.305u
X441 VDD.t1323 a_1029_13494# VDD.t1321 VDD.t100 sg13_lv_pmos ad=0.1938p pd=1.4u as=0 ps=0 w=1.02u l=5.575u
X442 VSS.t70 a_19745_13458# VSS.t700 VSS.t1584 sg13_lv_nmos ad=0.1738p pd=1.275u as=0 ps=0 w=0.88u l=1.945u
X443 VDD.t28 a_33957_9462# VDD.t26 VDD.t8 sg13_lv_pmos ad=0.3468p pd=2.72u as=0 ps=0 w=1.02u l=5.305u
X444 a_5213_4050# a_5145_4086# VDD.t1003 VDD.t83 sg13_lv_pmos ad=0.1938p pd=1.4u as=0.1938p ps=1.4u w=1.02u l=0.13u
X445 VDD.t1958 a_30093_13210# VDD.t1957 VDD.t93 sg13_lv_pmos ad=0.3468p pd=2.72u as=0 ps=0 w=1.02u l=5.305u
X446 VSS.t67 a_37805_12114# a_37737_12150# VSS.t66 sg13_lv_nmos ad=0.1738p pd=1.275u as=0.2992p ps=2.44u w=0.88u l=0.13u
X447 VDD.t73 a_5145_5430# VDD.t72 VDD.t68 sg13_lv_pmos ad=0.3468p pd=2.72u as=0 ps=0 w=1.02u l=5.575u
X448 VSS.t1590 a_24785_14480# VSS.t244 VSS.t1685 sg13_lv_nmos ad=0.1672p pd=1.26u as=0 ps=0 w=0.88u l=5.575u
X449 VSS.t94 BUFX3_4.A a_7669_16182# VSS.t1843 sg13_lv_nmos ad=0.1567p pd=1.27u as=0.102p ps=1.28u w=0.3u l=0.13u
X450 DFFQX1_3.CK a_9674_15474# VSS.t612 VSS.t1175 sg13_lv_nmos ad=0.1634p pd=1.24u as=0.1634p ps=1.24u w=0.86u l=0.13u
X451 VSS.t53 a_3785_5072# VSS.t55 VSS.t54 sg13_lv_nmos ad=0.1672p pd=1.26u as=0 ps=0 w=0.88u l=5.575u
X452 BUFX3_41.A a_23171_15532# VSS.t1399 VSS.t1398 sg13_lv_nmos ad=0.102p pd=1.28u as=0.1519p ps=1.265u w=0.3u l=0.13u
X453 VSS.t419 a_19661_3728# VSS.t421 VSS.t1691 sg13_lv_nmos ad=0.1672p pd=1.26u as=0 ps=0 w=0.88u l=5.575u
X454 VDD.t979 a_12957_4086# a_13025_4050# VDD.t83 sg13_lv_pmos ad=0.1938p pd=1.4u as=0.1938p ps=1.4u w=1.02u l=0.13u
X455 VSS.t185 a_9161_6416# VSS.t141 VSS.t186 sg13_lv_nmos ad=0.1672p pd=1.26u as=0 ps=0 w=0.88u l=5.575u
X456 VDD.t759 a_37737_5430# VDD.t758 VDD.t68 sg13_lv_pmos ad=0.3468p pd=2.72u as=0 ps=0 w=1.02u l=1.945u
X457 a_14537_9104# a_14469_9178# VDD.t638 VDD.t29 sg13_lv_pmos ad=0.3468p pd=2.72u as=0.20145p ps=1.415u w=1.02u l=0.13u
X458 VSS.t1 a_9161_14480# a_9093_14554# VSS.t4 sg13_lv_nmos ad=0.1672p pd=1.26u as=0.2992p ps=2.44u w=0.88u l=0.13u
X459 VSS.t705 a_32597_11792# VSS.t514 VSS.t708 sg13_lv_nmos ad=0.1672p pd=1.26u as=0 ps=0 w=0.88u l=5.575u
X460 VSS.t206 a_26213_5394# VSS.t204 VSS.t205 sg13_lv_nmos ad=0.1738p pd=1.275u as=0 ps=0 w=0.88u l=5.305u
X461 VSS.t179 a_22349_7760# VSS.t374 VSS.t373 sg13_lv_nmos ad=0.1738p pd=1.275u as=0 ps=0 w=0.88u l=5.305u
X462 a_11849_10448# a_11781_10522# VDD.t182 VDD.t8 sg13_lv_pmos ad=0.1938p pd=1.4u as=0.1938p ps=1.4u w=1.02u l=0.13u
X463 VSS.t530 a_19745_9426# VSS.t124 VSS.t529 sg13_lv_nmos ad=0.1738p pd=1.275u as=0 ps=0 w=0.88u l=1.945u
X464 VDD.t1025 a_28581_10806# VDD.t1024 VDD.t281 sg13_lv_pmos ad=0.1938p pd=1.4u as=0 ps=0 w=1.02u l=5.575u
X465 VSS.t757 a_31505_10448# VSS.t266 VSS.t842 sg13_lv_nmos ad=0.1738p pd=1.275u as=0 ps=0 w=0.88u l=1.945u
X466 VSS.t48 a_3785_6738# VSS.t475 VSS.t1848 sg13_lv_nmos ad=0.1738p pd=1.275u as=0 ps=0 w=0.88u l=1.945u
X467 VSS.t352 a_37973_9104# VSS.t352 VSS.t351 sg13_lv_nmos ad=0.1738p pd=1.275u as=0 ps=0 w=0.88u l=1.945u
X468 VSS.t67 a_35369_12114# VSS.t514 VSS.t827 sg13_lv_nmos ad=0.1738p pd=1.275u as=0 ps=0 w=0.88u l=1.945u
X469 a_16905_3802# a_16973_3728# VSS.t419 VSS.t963 sg13_lv_nmos ad=0.2992p pd=2.44u as=0.1672p ps=1.26u w=0.88u l=0.13u
X470 VDD.t49 a_19593_7834# VDD.t50 VDD.t39 sg13_lv_pmos ad=0.3468p pd=2.72u as=0 ps=0 w=1.02u l=5.575u
X471 DFFQX1_5.CK a_15318_15510# VSS.t1137 VSS.t1138 sg13_lv_nmos ad=0.1634p pd=1.24u as=0.1634p ps=1.24u w=0.86u l=0.13u
X472 VSS.t11 a_38648_15846# a_38580_15932# VSS.t10 sg13_lv_nmos ad=0.2176p pd=1.96u as=0.2176p ps=1.96u w=0.64u l=0.76u
X473 VSS.t896 a_23003_14188# a_22979_14608# VSS.t897 sg13_lv_nmos ad=0.1519p pd=1.265u as=27f ps=0.48u w=0.3u l=0.13u
X474 VDD.t917 a_7833_4086# VDD.t916 VDD.t83 sg13_lv_pmos ad=0.1938p pd=1.4u as=0 ps=0 w=1.02u l=5.575u
X475 VSS.t97 a_38480_8096# a_38412_8132# VSS.t96 sg13_lv_nmos ad=0.2176p pd=1.96u as=0.2176p ps=1.96u w=0.64u l=0.76u
X476 a_34616_16160# a_34548_16196# VDD.t1559 VDD.t0 sg13_lv_pmos ad=0.3332p pd=2.64u as=0.3332p ps=2.64u w=0.98u l=0.76u
X477 VSS.t295 a_5381_15824# VSS.t295 VSS.t1197 sg13_lv_nmos ad=0.1738p pd=1.275u as=0 ps=0 w=0.88u l=1.945u
X478 VSS.t661 clock_i a_12714_15510# VSS.t1666 sg13_lv_nmos ad=0.1634p pd=1.24u as=0.1634p ps=1.24u w=0.86u l=0.13u
X479 VSS.t922 a_1097_12114# VSS.t922 VSS.t1316 sg13_lv_nmos ad=0.1672p pd=1.26u as=0 ps=0 w=0.88u l=5.575u
X480 a_22183_15244# a_21979_14852# VDD.t724 VDD.t5 sg13_lv_pmos ad=43.2f pd=0.66u as=0.1632p ps=1.64u w=0.48u l=0.13u
X481 VDD.t696 a_24717_3802# a_24785_3728# VDD.t354 sg13_lv_pmos ad=0.1938p pd=1.4u as=0.1938p ps=1.4u w=1.02u l=0.13u
X482 VDD.t545 a_32529_3802# VDD.t544 VDD.t354 sg13_lv_pmos ad=0.1938p pd=1.4u as=0 ps=0 w=1.02u l=5.575u
X483 a_6911_15770# a_7105_15532# a_7069_15572# VDD.t5 sg13_lv_pmos ad=91.2f pd=0.86u as=43.2f ps=0.66u w=0.48u l=0.13u
X484 VSS.t872 a_35285_14480# VSS.t444 VSS.t947 sg13_lv_nmos ad=0.1672p pd=1.26u as=0 ps=0 w=0.88u l=5.575u
X485 a_19593_10522# a_19661_10448# VSS.t766 VSS.t1394 sg13_lv_nmos ad=0.2992p pd=2.44u as=0.1672p ps=1.26u w=0.88u l=0.13u
X486 VSS.t1541 a_20837_4050# VSS.t421 VSS.t1739 sg13_lv_nmos ad=0.1672p pd=1.26u as=0 ps=0 w=0.88u l=5.575u
X487 VSS.t735 a_24785_6416# a_24717_6490# VSS.t734 sg13_lv_nmos ad=0.1672p pd=1.26u as=0.2992p ps=2.44u w=0.88u l=0.13u
X488 AND2X1_3.Y a_2625_14852# VDD.t603 VDD.t5 sg13_lv_pmos ad=0.192p pd=1.76u as=91.2f ps=0.86u w=0.48u l=0.13u
X489 a_31505_10448# a_31437_10522# VDD.t125 VDD.t8 sg13_lv_pmos ad=0.3468p pd=2.72u as=0.20145p ps=1.415u w=1.02u l=0.13u
X490 VDD.t1729 a_1029_2742# VDD.t1728 VDD.t354 sg13_lv_pmos ad=0.1938p pd=1.4u as=0 ps=0 w=1.02u l=5.575u
X491 a_16973_9104# a_16905_9178# VDD.t155 VDD.t29 sg13_lv_pmos ad=0.1938p pd=1.4u as=0.1938p ps=1.4u w=1.02u l=0.13u
X492 VDD.t665 OR3X1_1.A NOR3X1_0.C VDD.t5 sg13_lv_pmos ad=0.3332p pd=2.64u as=0.1862p ps=1.36u w=0.98u l=0.13u
X493 VSS.t1100 a_31505_11792# a_31437_11866# VSS.t1560 sg13_lv_nmos ad=0.1738p pd=1.275u as=0.2992p ps=2.44u w=0.88u l=0.13u
X494 a_11781_6490# a_11849_6416# VSS.t190 VSS.t1766 sg13_lv_nmos ad=0.2992p pd=2.44u as=0.1672p ps=1.26u w=0.88u l=0.13u
X495 a_15713_13458# a_15645_13494# VDD.t1437 VDD.t100 sg13_lv_pmos ad=0.1938p pd=1.4u as=0.1938p ps=1.4u w=1.02u l=0.13u
X496 VSS.t1549 a_35369_13458# a_35301_13494# VSS.t1720 sg13_lv_nmos ad=0.1738p pd=1.275u as=0.2992p ps=2.44u w=0.88u l=0.13u
X497 a_7817_9104# a_7749_9178# VDD.t31 VDD.t29 sg13_lv_pmos ad=0.3468p pd=2.72u as=0.20145p ps=1.415u w=1.02u l=0.13u
X498 DFFQX1_2.D a_17833_15510# VDD.t1178 VDD.t5 sg13_lv_pmos ad=0.4488p pd=3.32u as=0.2412p ps=1.73u w=1.32u l=0.13u
X499 VSS.t224 enable_i a_1033_3414# VSS.t1457 sg13_lv_nmos ad=0.1567p pd=1.27u as=0.102p ps=1.28u w=0.3u l=0.13u
X500 a_11597_2706# a_11529_2742# VDD.t1960 VDD.t354 sg13_lv_pmos ad=0.3468p pd=2.72u as=0.20145p ps=1.415u w=1.02u l=0.13u
X501 VSS.t342 a_28649_13458# VSS.t340 VSS.t586 sg13_lv_nmos ad=0.1672p pd=1.26u as=0 ps=0 w=0.88u l=5.575u
X502 a_8889_15244# DFFQX1_3.D a_8827_15244# VDD.t5 sg13_lv_pmos ad=91.2f pd=0.86u as=43.2f ps=0.66u w=0.48u l=0.13u
X503 VDD.t626 a_19593_10522# a_19661_10448# VDD.t8 sg13_lv_pmos ad=0.1938p pd=1.4u as=0.1938p ps=1.4u w=1.02u l=0.13u
X504 a_34025_10770# a_33957_10806# VDD.t1717 VDD.t281 sg13_lv_pmos ad=0.3468p pd=2.72u as=0.20145p ps=1.415u w=1.02u l=0.13u
X505 a_5145_12150# a_5213_12114# VSS.t1305 VSS.t1644 sg13_lv_nmos ad=0.2992p pd=2.44u as=0.1672p ps=1.26u w=0.88u l=0.13u
X506 a_7093_15779# DFFQX1_3.CK VDD.t481 VDD.t5 sg13_lv_pmos ad=0.1632p pd=1.64u as=0.1834p ps=1.39u w=0.48u l=0.13u
X507 a_22751_15170# a_22613_15244# VDD.t957 VDD.t5 sg13_lv_pmos ad=0.1632p pd=1.64u as=0.37935p ps=2.32u w=0.48u l=0.13u
X508 VDD.t886 a_24717_10522# a_24785_10448# VDD.t8 sg13_lv_pmos ad=0.1938p pd=1.4u as=0.1938p ps=1.4u w=1.02u l=0.13u
X509 a_7833_4086# a_7901_4050# VSS.t229 VSS.t1442 sg13_lv_nmos ad=0.2992p pd=2.44u as=0.1672p ps=1.26u w=0.88u l=0.13u
X510 VDD.t795 a_28581_9462# VDD.t794 VDD.t8 sg13_lv_pmos ad=0.1938p pd=1.4u as=0 ps=0 w=1.02u l=5.575u
X511 VSS.t876 a_3785_12114# VSS.t922 VSS.t1533 sg13_lv_nmos ad=0.1738p pd=1.275u as=0 ps=0 w=0.88u l=1.945u
X512 VDD.t701 a_7749_11866# VDD.t700 VDD.t281 sg13_lv_pmos ad=0.3468p pd=2.72u as=0 ps=0 w=1.02u l=1.945u
X513 VDD.t927 a_37737_12150# VDD.t926 VDD.t93 sg13_lv_pmos ad=0.3468p pd=2.72u as=0 ps=0 w=1.02u l=1.945u
X514 VDD.t388 a_19593_6490# VDD.t383 VDD.t68 sg13_lv_pmos ad=0.1938p pd=1.4u as=0 ps=0 w=1.02u l=5.575u
X515 VSS.t41 a_32597_7760# VSS.t43 VSS.t42 sg13_lv_nmos ad=0.1672p pd=1.26u as=0 ps=0 w=0.88u l=5.575u
X516 VDD.t562 a_27405_9178# a_27473_9104# VDD.t29 sg13_lv_pmos ad=0.1938p pd=1.4u as=0.1938p ps=1.4u w=1.02u l=0.13u
X517 VSS.t20 a_36461_10770# VSS.t20 VSS.t19 sg13_lv_nmos ad=0.1738p pd=1.275u as=0 ps=0 w=0.88u l=5.305u
X518 VSS.t808 a_15713_12114# VSS.t795 VSS.t807 sg13_lv_nmos ad=0.1672p pd=1.26u as=0 ps=0 w=0.88u l=5.575u
X519 VDD.t608 a_27405_15898# a_27473_15824# VDD.t5 sg13_lv_pmos ad=0.1938p pd=1.4u as=0.1938p ps=1.4u w=1.02u l=0.13u
X520 a_31337_12114# a_31269_12150# VDD.t94 VDD.t93 sg13_lv_pmos ad=0.1938p pd=1.4u as=0.1938p ps=1.4u w=1.02u l=0.13u
X521 VDD.t10 a_9093_10522# VDD.t9 VDD.t8 sg13_lv_pmos ad=0.3468p pd=2.72u as=0 ps=0 w=1.02u l=5.575u
X522 VSS.t107 a_23629_15474# BUFX3_38.Y VSS.t1209 sg13_lv_nmos ad=0.1567p pd=1.27u as=0.2924p ps=2.4u w=0.86u l=0.13u
X523 VSS.t1605 a_13025_14802# a_12957_14838# VSS.t1795 sg13_lv_nmos ad=0.1672p pd=1.26u as=0.2992p ps=2.44u w=0.88u l=0.13u
X524 VDD.t1723 a_11781_13210# VDD.t1722 VDD.t93 sg13_lv_pmos ad=0.1938p pd=1.4u as=0 ps=0 w=1.02u l=5.575u
X525 a_16401_2742# a_16469_2706# VSS.t914 VSS.t1649 sg13_lv_nmos ad=0.2992p pd=2.44u as=0.1672p ps=1.26u w=0.88u l=0.13u
X526 VSS.t57 a_6473_5072# a_6405_5146# VSS.t1781 sg13_lv_nmos ad=0.1738p pd=1.275u as=0.2992p ps=2.44u w=0.88u l=0.13u
X527 VSS.t1377 a_7901_4050# VSS.t861 VSS.t1440 sg13_lv_nmos ad=0.1672p pd=1.26u as=0 ps=0 w=0.88u l=5.575u
X528 VDD.t1904 a_6741_3802# VDD.t1903 VDD.t354 sg13_lv_pmos ad=0.3468p pd=2.72u as=0 ps=0 w=1.02u l=5.305u
X529 VDD.t1089 a_1029_9462# VDD.t1090 VDD.t8 sg13_lv_pmos ad=0.1938p pd=1.4u as=0 ps=0 w=1.02u l=5.575u
X530 VDD.t398 a_18921_14554# VDD.t397 VDD.t100 sg13_lv_pmos ad=0.3468p pd=2.72u as=0 ps=0 w=1.02u l=5.305u
X531 a_32597_14480# a_32529_14554# VDD.t1611 VDD.t100 sg13_lv_pmos ad=0.1938p pd=1.4u as=0.1938p ps=1.4u w=1.02u l=0.13u
X532 VDD.t1721 a_11781_13210# VDD.t1720 VDD.t93 sg13_lv_pmos ad=0.3468p pd=2.72u as=0 ps=0 w=1.02u l=5.575u
X533 a_18757_15474# OR3BX1_0.Y VDD.t6 VDD.t5 sg13_lv_pmos ad=0.1632p pd=1.64u as=0.2412p ps=1.73u w=0.48u l=0.13u
X534 BUFX3_29.A a_21189_14906# VSS.t137 VSS.t1615 sg13_lv_nmos ad=0.1216p pd=1.02u as=0.1193p ps=1.05u w=0.64u l=0.13u
X535 a_30161_11792# a_30093_11866# VDD.t1402 VDD.t281 sg13_lv_pmos ad=0.3468p pd=2.72u as=0.20145p ps=1.415u w=1.02u l=0.13u
X536 VSS.t131 a_31505_9104# VSS.t34 VSS.t1060 sg13_lv_nmos ad=0.1738p pd=1.275u as=0 ps=0 w=0.88u l=1.945u
X537 VSS.t1393 a_18401_10770# VSS.t1423 VSS.t1762 sg13_lv_nmos ad=0.1738p pd=1.275u as=0 ps=0 w=0.88u l=5.305u
X538 VSS.t497 a_3785_13458# a_3717_13494# VSS.t496 sg13_lv_nmos ad=0.1738p pd=1.275u as=0.2992p ps=2.44u w=0.88u l=0.13u
X539 VSS.t395 OR3X1_1.B a_20775_14852# VSS.t394 sg13_lv_nmos ad=57f pd=0.68u as=0.102p ps=1.28u w=0.3u l=0.13u
X540 a_27221_13458# a_27153_13494# VDD.t1019 VDD.t100 sg13_lv_pmos ad=0.3468p pd=2.72u as=0.20145p ps=1.415u w=1.02u l=0.13u
X541 VSS.t795 a_16973_11792# a_16905_11866# VSS.t1565 sg13_lv_nmos ad=0.1672p pd=1.26u as=0.2992p ps=2.44u w=0.88u l=0.13u
X542 a_15881_9104# a_15813_9178# VDD.t559 VDD.t29 sg13_lv_pmos ad=0.3468p pd=2.72u as=0.20145p ps=1.415u w=1.02u l=0.13u
X543 VSS.t11 a_37973_15824# a_37905_15898# VSS.t10 sg13_lv_nmos ad=0.1738p pd=1.275u as=0.2992p ps=2.44u w=0.88u l=0.13u
X544 a_8909_2706# a_8841_2742# VDD.t1409 VDD.t354 sg13_lv_pmos ad=0.1938p pd=1.4u as=0.1938p ps=1.4u w=1.02u l=0.13u
X545 a_24049_16146# BUFX3_23.A VDD.t925 VDD.t0 sg13_lv_pmos ad=0.1632p pd=1.64u as=0.2412p ps=1.73u w=0.48u l=0.13u
X546 BUFX3_29.Y a_21865_13494# VSS.t968 VSS.t967 sg13_lv_nmos ad=0.2924p pd=2.4u as=0.1567p ps=1.27u w=0.86u l=0.13u
X547 a_11933_4050# a_11865_4086# VDD.t1009 VDD.t83 sg13_lv_pmos ad=0.3468p pd=2.72u as=0.20145p ps=1.415u w=1.02u l=0.13u
X548 VSS.t81 XOR2X1_0.A a_3451_14838# VSS.t146 sg13_lv_nmos ad=0.102p pd=1.28u as=28.5f ps=0.49u w=0.3u l=0.13u
X549 VSS.t769 a_23525_4050# a_23457_4086# VSS.t830 sg13_lv_nmos ad=0.1672p pd=1.26u as=0.2992p ps=2.44u w=0.88u l=0.13u
X550 a_37973_13136# a_37905_13210# VDD.t1428 VDD.t93 sg13_lv_pmos ad=0.3468p pd=2.72u as=0.20145p ps=1.415u w=1.02u l=0.13u
X551 VSS.t520 a_1097_9426# VSS.t520 VSS.t622 sg13_lv_nmos ad=0.1672p pd=1.26u as=0 ps=0 w=0.88u l=5.575u
X552 AND2X1_1.B a_6661_16182# VDD.t1143 VDD.t0 sg13_lv_pmos ad=0.4488p pd=3.32u as=0.2412p ps=1.73u w=1.32u l=0.13u
X553 VSS.t305 a_36461_5394# a_36393_5430# VSS.t306 sg13_lv_nmos ad=0.1738p pd=1.275u as=0.2992p ps=2.44u w=0.88u l=0.13u
X554 VSS.t133 OAI21X1_1.Y a_21529_16182# VSS.t1068 sg13_lv_nmos ad=0.1567p pd=1.27u as=0.102p ps=1.28u w=0.3u l=0.13u
X555 VDD.t1352 a_35301_13494# VDD.t1351 VDD.t100 sg13_lv_pmos ad=0.3468p pd=2.72u as=0 ps=0 w=1.02u l=1.945u
X556 VDD.t1860 a_3717_11866# a_3785_11792# VDD.t281 sg13_lv_pmos ad=0.1938p pd=1.4u as=0.1938p ps=1.4u w=1.02u l=0.13u
X557 VSS.t787 a_23693_6416# VSS.t789 VSS.t788 sg13_lv_nmos ad=0.1738p pd=1.275u as=0 ps=0 w=0.88u l=1.945u
X558 a_7901_12114# a_7833_12150# VDD.t325 VDD.t93 sg13_lv_pmos ad=0.1938p pd=1.4u as=0.1938p ps=1.4u w=1.02u l=0.13u
X559 a_27557_12114# a_27489_12150# VDD.t484 VDD.t93 sg13_lv_pmos ad=0.3468p pd=2.72u as=0.20145p ps=1.415u w=1.02u l=0.13u
X560 VSS.t314 a_15881_3728# a_15813_3802# VSS.t334 sg13_lv_nmos ad=0.1738p pd=1.275u as=0.2992p ps=2.44u w=0.88u l=0.13u
X561 VDD.t353 a_16905_7834# VDD.t351 VDD.t39 sg13_lv_pmos ad=0.1938p pd=1.4u as=0 ps=0 w=1.02u l=5.575u
X562 VSS.t266 a_32597_10448# a_32529_10522# VSS.t265 sg13_lv_nmos ad=0.1672p pd=1.26u as=0.2992p ps=2.44u w=0.88u l=0.13u
X563 VSS.t218 a_14537_5072# a_14469_5146# VSS.t220 sg13_lv_nmos ad=0.1738p pd=1.275u as=0.2992p ps=2.44u w=0.88u l=0.13u
X564 a_11781_14554# a_11849_14480# VSS.t1603 VSS.t1602 sg13_lv_nmos ad=0.2992p pd=2.44u as=0.1672p ps=1.26u w=0.88u l=0.13u
X565 a_27473_11792# a_27405_11866# VDD.t1527 VDD.t281 sg13_lv_pmos ad=0.1938p pd=1.4u as=0.1938p ps=1.4u w=1.02u l=0.13u
X566 a_23693_3728# a_23625_3802# VDD.t955 VDD.t354 sg13_lv_pmos ad=0.3468p pd=2.72u as=0.20145p ps=1.415u w=1.02u l=0.13u
X567 VSS.t107 a_24049_16146# counter_value_o[4] VSS.t863 sg13_lv_nmos ad=0.1567p pd=1.27u as=0.2924p ps=2.4u w=0.86u l=0.13u
X568 a_20837_6738# a_20769_6774# VDD.t822 VDD.t39 sg13_lv_pmos ad=0.1938p pd=1.4u as=0.1938p ps=1.4u w=1.02u l=0.13u
X569 a_18779_14900# a_17829_14920# a_18665_15244# VSS.t260 sg13_lv_nmos ad=27f pd=0.48u as=57f ps=0.68u w=0.3u l=0.13u
X570 VSS.t1030 a_19580_16160# a_19512_16196# VSS.t1029 sg13_lv_nmos ad=0.2176p pd=1.96u as=0.2176p ps=1.96u w=0.64u l=0.76u
X571 VSS.t50 a_37973_6416# a_37905_6490# VSS.t49 sg13_lv_nmos ad=0.1738p pd=1.275u as=0.2992p ps=2.44u w=0.88u l=0.13u
X572 VDD.t375 a_18573_14575# OR3BX1_0.Y VDD.t100 sg13_lv_pmos ad=0.1044p pd=0.915u as=91.2f ps=0.86u w=0.48u l=0.13u
X573 a_24785_7760# a_24717_7834# VDD.t738 VDD.t39 sg13_lv_pmos ad=0.1938p pd=1.4u as=0.1938p ps=1.4u w=1.02u l=0.13u
X574 VSS.t31 a_15713_9426# a_15645_9462# VSS.t1799 sg13_lv_nmos ad=0.1672p pd=1.26u as=0.2992p ps=2.44u w=0.88u l=0.13u
X575 a_32281_16146# DFFQX1_5.Q VSS.t156 VSS.t1469 sg13_lv_nmos ad=0.102p pd=1.28u as=0.1567p ps=1.27u w=0.3u l=0.13u
X576 a_19093_15474# OAI21X1_0.Y VSS.t14 VSS.t1391 sg13_lv_nmos ad=0.102p pd=1.28u as=0.1567p ps=1.27u w=0.3u l=0.13u
X577 VDD.t1651 a_15645_12150# a_15713_12114# VDD.t93 sg13_lv_pmos ad=0.1938p pd=1.4u as=0.1938p ps=1.4u w=1.02u l=0.13u
X578 a_35217_11866# a_35285_11792# VSS.t67 VSS.t66 sg13_lv_nmos ad=0.2992p pd=2.44u as=0.1672p ps=1.26u w=0.88u l=0.13u
X579 VSS.t45 a_35285_7760# a_35217_7834# VSS.t95 sg13_lv_nmos ad=0.1672p pd=1.26u as=0.2992p ps=2.44u w=0.88u l=0.13u
X580 VDD.t641 a_24717_9178# VDD.t640 VDD.t29 sg13_lv_pmos ad=0.3468p pd=2.72u as=0 ps=0 w=1.02u l=5.575u
X581 VSS.t509 a_14537_10448# a_14469_10522# VSS.t1702 sg13_lv_nmos ad=0.1738p pd=1.275u as=0.2992p ps=2.44u w=0.88u l=0.13u
X582 VSS.t414 a_19661_6416# VSS.t412 VSS.t415 sg13_lv_nmos ad=0.1672p pd=1.26u as=0 ps=0 w=0.88u l=5.575u
X583 a_3785_8082# a_3717_8118# VDD.t409 VDD.t29 sg13_lv_pmos ad=0.3468p pd=2.72u as=0.20145p ps=1.415u w=1.02u l=0.13u
X584 VDD.t660 BUFX3_12.A a_2629_15510# VDD.t5 sg13_lv_pmos ad=0.2412p pd=1.73u as=0.1632p ps=1.64u w=0.48u l=0.13u
X585 VSS.t349 a_10589_12114# VSS.t345 VSS.t1613 sg13_lv_nmos ad=0.1738p pd=1.275u as=0 ps=0 w=0.88u l=5.305u
X586 VSS.t156 a_31589_16146# VSS.t386 VSS.t604 sg13_lv_nmos ad=0.1738p pd=1.275u as=0 ps=0 w=0.88u l=1.945u
X587 a_30161_6416# a_30093_6490# VDD.t522 VDD.t68 sg13_lv_pmos ad=0.3468p pd=2.72u as=0.20145p ps=1.415u w=1.02u l=0.13u
X588 a_19745_13458# a_19677_13494# VDD.t1603 VDD.t100 sg13_lv_pmos ad=0.3468p pd=2.72u as=0.20145p ps=1.415u w=1.02u l=0.13u
X589 VSS.t581 a_6809_10448# VSS.t844 VSS.t843 sg13_lv_nmos ad=0.1738p pd=1.275u as=0 ps=0 w=0.88u l=5.305u
X590 a_36461_4050# a_36393_4086# VDD.t1963 VDD.t83 sg13_lv_pmos ad=0.3468p pd=2.72u as=0.20145p ps=1.415u w=1.02u l=0.13u
X591 VDD.t1080 a_1365_3802# VDD.t1079 VDD.t354 sg13_lv_pmos ad=0.1938p pd=1.4u as=0 ps=0 w=1.02u l=5.575u
X592 a_22751_15170# a_22613_15244# VSS.t896 VSS.t1593 sg13_lv_nmos ad=0.102p pd=1.28u as=0.22785p ps=1.9u w=0.3u l=0.13u
X593 VDD.t323 a_37905_11866# VDD.t324 VDD.t281 sg13_lv_pmos ad=0.3468p pd=2.72u as=0 ps=0 w=1.02u l=1.945u
X594 a_20837_10770# a_20769_10806# VDD.t725 VDD.t281 sg13_lv_pmos ad=0.1938p pd=1.4u as=0.1938p ps=1.4u w=1.02u l=0.13u
X595 BUFX3_23.A a_18803_15170# VSS.t139 VSS.t1154 sg13_lv_nmos ad=0.102p pd=1.28u as=0.1519p ps=1.265u w=0.3u l=0.13u
X596 VSS.t501 a_5213_13458# VSS.t499 VSS.t1735 sg13_lv_nmos ad=0.1672p pd=1.26u as=0 ps=0 w=0.88u l=5.575u
X597 AOI21BX1_0.Y a_18165_15510# VSS.t160 VSS.t159 sg13_lv_nmos ad=57f pd=0.68u as=57f ps=0.68u w=0.3u l=0.13u
X598 VDD.t969 a_1029_11866# VDD.t967 VDD.t281 sg13_lv_pmos ad=0.1938p pd=1.4u as=0 ps=0 w=1.02u l=5.575u
X599 VSS.t251 a_38648_3750# a_38580_3836# VSS.t250 sg13_lv_nmos ad=0.2176p pd=1.96u as=0.2176p ps=1.96u w=0.64u l=0.76u
X600 a_1097_8082# a_1029_8118# VDD.t573 VDD.t29 sg13_lv_pmos ad=0.1938p pd=1.4u as=0.1938p ps=1.4u w=1.02u l=0.13u
X601 VDD.t874 a_3717_13494# VDD.t873 VDD.t100 sg13_lv_pmos ad=0.3468p pd=2.72u as=0 ps=0 w=1.02u l=1.945u
X602 VDD.t1635 a_27489_10806# VDD.t1634 VDD.t281 sg13_lv_pmos ad=0.3468p pd=2.72u as=0 ps=0 w=1.02u l=1.945u
X603 VSS.t579 a_5213_10770# a_5145_10806# VSS.t578 sg13_lv_nmos ad=0.1672p pd=1.26u as=0.2992p ps=2.44u w=0.88u l=0.13u
X604 VSS.t956 a_10589_13458# a_10521_13494# VSS.t1385 sg13_lv_nmos ad=0.1738p pd=1.275u as=0.2992p ps=2.44u w=0.88u l=0.13u
X605 VSS.t497 a_3785_13136# VSS.t499 VSS.t498 sg13_lv_nmos ad=0.1672p pd=1.26u as=0 ps=0 w=0.88u l=5.575u
X606 a_20769_12150# a_20837_12114# VSS.t316 VSS.t939 sg13_lv_nmos ad=0.2992p pd=2.44u as=0.1672p ps=1.26u w=0.88u l=0.13u
X607 VDD.t1194 a_3517_15682# a_3441_15952# VDD.t5 sg13_lv_pmos ad=91.2f pd=0.86u as=91.2f ps=0.86u w=0.48u l=0.13u
X608 a_22497_14228# DFFQX1_5.D a_22435_14228# VDD.t100 sg13_lv_pmos ad=91.2f pd=0.86u as=43.2f ps=0.66u w=0.48u l=0.13u
X609 a_9371_14900# a_8421_14920# a_9257_15244# VSS.t402 sg13_lv_nmos ad=27f pd=0.48u as=57f ps=0.68u w=0.3u l=0.13u
X610 VDD.t457 a_23457_4086# VDD.t456 VDD.t83 sg13_lv_pmos ad=0.3468p pd=2.72u as=0 ps=0 w=1.02u l=5.575u
X611 VDD.t662 a_6405_7834# VDD.t661 VDD.t39 sg13_lv_pmos ad=0.3468p pd=2.72u as=0 ps=0 w=1.02u l=5.305u
X612 VDD.t1391 a_12957_12150# VDD.t1390 VDD.t93 sg13_lv_pmos ad=0.1938p pd=1.4u as=0 ps=0 w=1.02u l=5.575u
X613 VSS.t231 a_11849_3728# VSS.t752 VSS.t1538 sg13_lv_nmos ad=0.1672p pd=1.26u as=0 ps=0 w=0.88u l=5.575u
X614 VSS.t1503 a_11849_10448# VSS.t508 VSS.t1639 sg13_lv_nmos ad=0.1672p pd=1.26u as=0 ps=0 w=0.88u l=5.575u
X615 VSS.t844 a_8153_10448# a_8085_10522# VSS.t1104 sg13_lv_nmos ad=0.1738p pd=1.275u as=0.2992p ps=2.44u w=0.88u l=0.13u
X616 VSS.t266 a_31337_10770# VSS.t757 VSS.t759 sg13_lv_nmos ad=0.1672p pd=1.26u as=0 ps=0 w=0.88u l=5.575u
X617 VDD.t1014 a_31269_10806# VDD.t1013 VDD.t281 sg13_lv_pmos ad=0.3468p pd=2.72u as=0 ps=0 w=1.02u l=5.575u
X618 a_3517_15682# a_3313_15779# a_3657_15572# VDD.t5 sg13_lv_pmos ad=91.2f pd=0.86u as=43.2f ps=0.66u w=0.48u l=0.13u
X619 a_23425_14838# AOI21BX2_0.A BUFX3_28.A VSS.t1211 sg13_lv_nmos ad=0.1216p pd=1.02u as=0.1216p ps=1.02u w=0.64u l=0.13u
X620 VSS.t206 a_27473_5072# VSS.t208 VSS.t979 sg13_lv_nmos ad=0.1672p pd=1.26u as=0 ps=0 w=0.88u l=5.575u
X621 VSS.t9 a_16973_10448# VSS.t1423 VSS.t1422 sg13_lv_nmos ad=0.1672p pd=1.26u as=0 ps=0 w=0.88u l=5.575u
X622 VSS.t305 a_35369_5394# VSS.t303 VSS.t693 sg13_lv_nmos ad=0.1738p pd=1.275u as=0 ps=0 w=0.88u l=1.945u
X623 a_11933_10770# a_11865_10806# VDD.t775 VDD.t281 sg13_lv_pmos ad=0.3468p pd=2.72u as=0.20145p ps=1.415u w=1.02u l=0.13u
X624 a_20837_5394# a_20769_5430# VDD.t253 VDD.t68 sg13_lv_pmos ad=0.1938p pd=1.4u as=0.1938p ps=1.4u w=1.02u l=0.13u
X625 VSS.t129 a_30161_9104# VSS.t131 VSS.t130 sg13_lv_nmos ad=0.1738p pd=1.275u as=0 ps=0 w=0.88u l=5.305u
X626 a_9093_3802# a_9161_3728# VSS.t231 VSS.t1501 sg13_lv_nmos ad=0.2992p pd=2.44u as=0.1672p ps=1.26u w=0.88u l=0.13u
X627 VDD.t897 a_1365_10522# VDD.t896 VDD.t8 sg13_lv_pmos ad=0.3468p pd=2.72u as=0 ps=0 w=1.02u l=5.575u
X628 VDD.t1536 a_35217_3802# VDD.t1535 VDD.t354 sg13_lv_pmos ad=0.3468p pd=2.72u as=0 ps=0 w=1.02u l=5.575u
X629 VSS.t468 a_28649_8082# VSS.t466 VSS.t1819 sg13_lv_nmos ad=0.1672p pd=1.26u as=0 ps=0 w=0.88u l=5.575u
X630 VSS.t612 a_9674_15474# DFFQX1_3.CK VSS.t1176 sg13_lv_nmos ad=0.1634p pd=1.24u as=0.1634p ps=1.24u w=0.86u l=0.13u
X631 a_23189_13458# a_23121_13494# VDD.t1797 VDD.t100 sg13_lv_pmos ad=0.1938p pd=1.4u as=0.1938p ps=1.4u w=1.02u l=0.13u
X632 VSS.t705 a_31337_12114# VSS.t706 VSS.t1450 sg13_lv_nmos ad=0.1672p pd=1.26u as=0 ps=0 w=0.88u l=5.575u
X633 a_24717_5146# a_24785_5072# VSS.t206 VSS.t1382 sg13_lv_nmos ad=0.2992p pd=2.44u as=0.1672p ps=1.26u w=0.88u l=0.13u
X634 VSS.t129 a_28649_9426# VSS.t281 VSS.t1011 sg13_lv_nmos ad=0.1672p pd=1.26u as=0 ps=0 w=0.88u l=5.575u
X635 DFFQX1_4.Q a_17459_15170# VDD.t948 VDD.t5 sg13_lv_pmos ad=0.1632p pd=1.64u as=0.2529p ps=1.545u w=0.48u l=0.13u
X636 VSS.t81 a_1097_14480# VSS.t81 VSS.t1713 sg13_lv_nmos ad=0.1672p pd=1.26u as=0 ps=0 w=0.88u l=5.575u
X637 VSS.t737 a_24785_6416# VSS.t481 VSS.t738 sg13_lv_nmos ad=0.1672p pd=1.26u as=0 ps=0 w=0.88u l=5.575u
X638 VDD.t801 a_19677_8118# VDD.t800 VDD.t29 sg13_lv_pmos ad=0.3468p pd=2.72u as=0 ps=0 w=1.02u l=1.945u
X639 VDD.t132 a_15645_9462# VDD.t131 VDD.t8 sg13_lv_pmos ad=0.3468p pd=2.72u as=0 ps=0 w=1.02u l=5.575u
X640 VSS.t448 a_24785_14480# a_24717_14554# VSS.t1682 sg13_lv_nmos ad=0.1672p pd=1.26u as=0.2992p ps=2.44u w=0.88u l=0.13u
X641 a_3785_13136# a_3717_13210# VDD.t1404 VDD.t93 sg13_lv_pmos ad=0.1938p pd=1.4u as=0.1938p ps=1.4u w=1.02u l=0.13u
X642 DFFQX1_5.CK a_15318_15510# VDD.t1158 VDD.t5 sg13_lv_pmos ad=0.2508p pd=1.7u as=0.2508p ps=1.7u w=1.32u l=0.13u
X643 VSS.t490 a_31337_5394# VSS.t301 VSS.t748 sg13_lv_nmos ad=0.1672p pd=1.26u as=0 ps=0 w=0.88u l=5.575u
X644 a_9161_9104# a_9093_9178# VDD.t1102 VDD.t29 sg13_lv_pmos ad=0.1938p pd=1.4u as=0.1938p ps=1.4u w=1.02u l=0.13u
X645 a_18401_12114# a_18333_12150# VDD.t1594 VDD.t93 sg13_lv_pmos ad=0.3468p pd=2.72u as=0.20145p ps=1.415u w=1.02u l=0.13u
X646 BUFX3_3.A OR3X1_1.B a_17337_15938# VSS.t388 sg13_lv_nmos ad=58.5f pd=0.69u as=57f ps=0.68u w=0.3u l=0.13u
X647 VDD.t1747 a_32529_13210# VDD.t1746 VDD.t93 sg13_lv_pmos ad=0.3468p pd=2.72u as=0 ps=0 w=1.02u l=5.575u
X648 VSS.t87 a_5213_9426# VSS.t526 VSS.t527 sg13_lv_nmos ad=0.1672p pd=1.26u as=0 ps=0 w=0.88u l=5.575u
X649 VDD.t47 a_14469_7834# VDD.t46 VDD.t39 sg13_lv_pmos ad=0.3468p pd=2.72u as=0 ps=0 w=1.02u l=5.305u
X650 VDD.t1544 a_4053_3802# a_4121_3728# VDD.t354 sg13_lv_pmos ad=0.1938p pd=1.4u as=0.1938p ps=1.4u w=1.02u l=0.13u
X651 VSS.t608 a_9674_15474# DFFQX1_3.CK VSS.t1172 sg13_lv_nmos ad=0.1634p pd=1.24u as=0.1634p ps=1.24u w=0.86u l=0.13u
X652 NAND3X1_0.Y BUFX3_0.Y VDD.t121 VDD.t5 sg13_lv_pmos ad=0.192p pd=1.76u as=91.2f ps=0.86u w=0.48u l=0.13u
X653 VSS.t757 a_28649_10770# VSS.t819 VSS.t1454 sg13_lv_nmos ad=0.1672p pd=1.26u as=0 ps=0 w=0.88u l=5.575u
X654 a_27405_15898# a_27473_15824# VSS.t117 VSS.t118 sg13_lv_nmos ad=0.2992p pd=2.44u as=0.1672p ps=1.26u w=0.88u l=0.13u
X655 a_28649_10770# a_28581_10806# VDD.t1022 VDD.t281 sg13_lv_pmos ad=0.1938p pd=1.4u as=0.1938p ps=1.4u w=1.02u l=0.13u
X656 VSS.t1377 a_9161_3728# a_9093_3802# VSS.t1498 sg13_lv_nmos ad=0.1672p pd=1.26u as=0.2992p ps=2.44u w=0.88u l=0.13u
X657 VSS.t468 a_31505_7760# a_31437_7834# VSS.t678 sg13_lv_nmos ad=0.1738p pd=1.275u as=0.2992p ps=2.44u w=0.88u l=0.13u
X658 VSS.t931 a_4460_13472# a_4392_13508# VSS.t1474 sg13_lv_nmos ad=0.2176p pd=1.96u as=0.2176p ps=1.96u w=0.64u l=0.76u
X659 a_34025_6738# a_33957_6774# VDD.t1374 VDD.t39 sg13_lv_pmos ad=0.3468p pd=2.72u as=0.20145p ps=1.415u w=1.02u l=0.13u
X660 VDD.t1205 BUFX3_1.Y.t1 a_17069_14144# VDD.t100 sg13_lv_pmos ad=0.1632p pd=1.64u as=91.2f ps=0.86u w=0.48u l=0.13u
X661 VDD.t1067 a_37905_9178# VDD.t1066 VDD.t29 sg13_lv_pmos ad=0.3468p pd=2.72u as=0 ps=0 w=1.02u l=1.945u
X662 VDD.t1533 a_10521_13494# VDD.t1532 VDD.t100 sg13_lv_pmos ad=0.3468p pd=2.72u as=0 ps=0 w=1.02u l=5.305u
X663 a_8827_15244# a_8623_14852# VDD.t149 VDD.t5 sg13_lv_pmos ad=43.2f pd=0.66u as=0.1632p ps=1.64u w=0.48u l=0.13u
X664 a_35285_14480# a_35217_14554# VDD.t1678 VDD.t100 sg13_lv_pmos ad=0.1938p pd=1.4u as=0.1938p ps=1.4u w=1.02u l=0.13u
X665 VDD.t1675 a_14469_13210# VDD.t1674 VDD.t93 sg13_lv_pmos ad=0.3468p pd=2.72u as=0 ps=0 w=1.02u l=5.305u
X666 VSS.t362 a_13025_14802# VSS.t1603 VSS.t1797 sg13_lv_nmos ad=0.1672p pd=1.26u as=0 ps=0 w=0.88u l=5.575u
X667 VSS.t53 a_1097_5072# VSS.t53 VSS.t434 sg13_lv_nmos ad=0.1672p pd=1.26u as=0 ps=0 w=0.88u l=5.575u
X668 VDD.t1928 a_19593_9178# a_19661_9104# VDD.t29 sg13_lv_pmos ad=0.1938p pd=1.4u as=0.1938p ps=1.4u w=1.02u l=0.13u
X669 a_15318_15510# BUFX24_2.A VDD.t1275 VDD.t5 sg13_lv_pmos ad=0.2508p pd=1.7u as=0.2508p ps=1.7u w=1.32u l=0.13u
X670 a_13025_14802# a_12957_14838# VDD.t1213 VDD.t5 sg13_lv_pmos ad=0.1938p pd=1.4u as=0.1938p ps=1.4u w=1.02u l=0.13u
X671 VSS.t336 a_16973_3728# VSS.t441 VSS.t961 sg13_lv_nmos ad=0.1672p pd=1.26u as=0 ps=0 w=0.88u l=5.575u
X672 VSS.t381 AND2X1_3.Y a_3385_16182# VSS.t1189 sg13_lv_nmos ad=0.1567p pd=1.27u as=0.102p ps=1.28u w=0.3u l=0.13u
X673 VSS.t1364 a_19661_11792# a_19593_11866# VSS.t1363 sg13_lv_nmos ad=0.1672p pd=1.26u as=0.2992p ps=2.44u w=0.88u l=0.13u
X674 VDD.t45 a_1029_7834# VDD.t43 VDD.t39 sg13_lv_pmos ad=0.1938p pd=1.4u as=0 ps=0 w=1.02u l=5.575u
X675 VSS.t412 a_22349_6416# VSS.t787 VSS.t1832 sg13_lv_nmos ad=0.1738p pd=1.275u as=0 ps=0 w=0.88u l=5.305u
X676 a_18411_14900# a_18031_14852# a_18297_15244# VSS.t1594 sg13_lv_nmos ad=27f pd=0.48u as=57f ps=0.68u w=0.3u l=0.13u
X677 VSS.t769 a_20837_4050# VSS.t1541 VSS.t1741 sg13_lv_nmos ad=0.1672p pd=1.26u as=0 ps=0 w=0.88u l=5.575u
X678 a_28649_8082# a_28581_8118# VDD.t33 VDD.t29 sg13_lv_pmos ad=0.1938p pd=1.4u as=0.1938p ps=1.4u w=1.02u l=0.13u
X679 VDD.t341 a_7833_8118# VDD.t340 VDD.t29 sg13_lv_pmos ad=0.3468p pd=2.72u as=0 ps=0 w=1.02u l=5.575u
X680 VDD.t1696 BUFX3_1.Y.t5 a_7241_14816# VDD.t5 sg13_lv_pmos ad=0.1632p pd=1.64u as=91.2f ps=0.86u w=0.48u l=0.13u
X681 VSS.t262 a_22349_13136# a_22281_13210# VSS.t1443 sg13_lv_nmos ad=0.1738p pd=1.275u as=0.2992p ps=2.44u w=0.88u l=0.13u
X682 a_23135_15572# a_22399_15524# a_23033_15572# VDD.t5 sg13_lv_pmos ad=43.2f pd=0.66u as=91.2f ps=0.86u w=0.48u l=0.13u
X683 VDD.t959 BUFX3_1.Y.t2 a_23121_14906# VDD.t5 sg13_lv_pmos ad=0.1834p pd=1.39u as=0.1632p ps=1.64u w=0.48u l=0.13u
X684 a_32529_14554# a_32597_14480# VSS.t872 VSS.t874 sg13_lv_nmos ad=0.2992p pd=2.44u as=0.1672p ps=1.26u w=0.88u l=0.13u
X685 VDD.t887 a_24717_10522# VDD.t886 VDD.t8 sg13_lv_pmos ad=0.1938p pd=1.4u as=0 ps=0 w=1.02u l=5.575u
X686 a_7093_15779# DFFQX1_3.CK VSS.t94 VSS.t461 sg13_lv_nmos ad=0.102p pd=1.28u as=0.1193p ps=1.05u w=0.3u l=0.13u
X687 VSS.t76 a_5213_14802# VSS.t595 VSS.t596 sg13_lv_nmos ad=0.1738p pd=1.275u as=0 ps=0 w=0.88u l=5.305u
X688 a_22803_15536# a_22665_15572# VSS.t154 VSS.t999 sg13_lv_nmos ad=57f pd=0.68u as=57f ps=0.68u w=0.3u l=0.13u
X689 VSS.t216 a_11849_5072# VSS.t218 VSS.t217 sg13_lv_nmos ad=0.1672p pd=1.26u as=0 ps=0 w=0.88u l=5.575u
X690 VDD.t1243 a_6911_15770# a_6803_15792# VDD.t5 sg13_lv_pmos ad=0.37935p pd=2.32u as=0.1632p ps=1.64u w=0.48u l=0.13u
X691 VSS.t1311 a_28649_6738# VSS.t485 VSS.t1313 sg13_lv_nmos ad=0.1672p pd=1.26u as=0 ps=0 w=0.88u l=5.575u
X692 VSS.t956 a_9161_13136# VSS.t1384 VSS.t1527 sg13_lv_nmos ad=0.1672p pd=1.26u as=0 ps=0 w=0.88u l=5.575u
X693 VDD.t885 a_24717_10522# VDD.t884 VDD.t8 sg13_lv_pmos ad=0.3468p pd=2.72u as=0 ps=0 w=1.02u l=5.575u
X694 VSS.t612 a_9497_16146# VSS.t608 VSS.t611 sg13_lv_nmos ad=0.1672p pd=1.26u as=0 ps=0 w=0.88u l=5.575u
X695 VSS.t1264 a_19681_14802# OR3BX1_0.B VSS.t1598 sg13_lv_nmos ad=0.1567p pd=1.27u as=0.2924p ps=2.4u w=0.86u l=0.13u
X696 VDD.t98 a_31269_12150# a_31337_12114# VDD.t93 sg13_lv_pmos ad=0.1938p pd=1.4u as=0.1938p ps=1.4u w=1.02u l=0.13u
X697 VSS.t1165 a_9181_16146# NAND4X2_0.C VSS.t1164 sg13_lv_nmos ad=0.1567p pd=1.27u as=0.2924p ps=2.4u w=0.86u l=0.13u
X698 OR3X1_1.C BUFX3_27.Y a_22057_16196# VSS.t598 sg13_lv_nmos ad=0.12p pd=1.4u as=57f ps=0.68u w=0.3u l=0.13u
X699 a_7675_14852# NAND3X1_0.B VSS.t993 VSS.t1216 sg13_lv_nmos ad=57f pd=0.68u as=0.102p ps=1.28u w=0.3u l=0.13u
X700 VSS.t1333 a_8909_2706# a_8841_2742# VSS.t1332 sg13_lv_nmos ad=0.1672p pd=1.26u as=0.2992p ps=2.44u w=0.88u l=0.13u
X701 VSS.t18 a_35285_10448# a_35217_10522# VSS.t17 sg13_lv_nmos ad=0.1672p pd=1.26u as=0.2992p ps=2.44u w=0.88u l=0.13u
X702 a_3785_6416# a_3717_6490# VDD.t1890 VDD.t68 sg13_lv_pmos ad=0.1938p pd=1.4u as=0.1938p ps=1.4u w=1.02u l=0.13u
X703 VSS.t796 a_15713_12114# a_15645_12150# VSS.t806 sg13_lv_nmos ad=0.1672p pd=1.26u as=0.2992p ps=2.44u w=0.88u l=0.13u
X704 VSS.t81 AND2X1_3.B a_2719_14852# VSS.t1210 sg13_lv_nmos ad=57f pd=0.68u as=57f ps=0.68u w=0.3u l=0.13u
X705 VSS.t87 a_7817_9104# VSS.t1806 VSS.t1805 sg13_lv_nmos ad=0.1738p pd=1.275u as=0 ps=0 w=0.88u l=1.945u
X706 VDD.t1612 a_32529_14554# a_32597_14480# VDD.t100 sg13_lv_pmos ad=0.1938p pd=1.4u as=0.1938p ps=1.4u w=1.02u l=0.13u
X707 VSS.t316 a_23693_11792# a_23625_11866# VSS.t891 sg13_lv_nmos ad=0.1738p pd=1.275u as=0.2992p ps=2.44u w=0.88u l=0.13u
X708 a_17816_14502# a_17748_14588# VDD.t1704 VDD.t100 sg13_lv_pmos ad=0.3332p pd=2.64u as=0.3332p ps=2.64u w=0.98u l=0.76u
X709 a_11009_15824# a_10941_15898# VDD.t1182 VDD.t5 sg13_lv_pmos ad=0.3468p pd=2.72u as=0.20145p ps=1.415u w=1.02u l=0.13u
X710 VDD.t18 a_5145_9462# a_5213_9426# VDD.t8 sg13_lv_pmos ad=0.1938p pd=1.4u as=0.1938p ps=1.4u w=1.02u l=0.13u
X711 VDD.t1626 a_31437_3802# VDD.t1627 VDD.t354 sg13_lv_pmos ad=0.3468p pd=2.72u as=0 ps=0 w=1.02u l=1.945u
X712 VSS.t105 a_17069_14144# AND2X1_0.Y VSS.t1432 sg13_lv_nmos ad=57f pd=0.68u as=0.12p ps=1.4u w=0.3u l=0.13u
X713 VDD.t1078 a_1365_3802# VDD.t1077 VDD.t354 sg13_lv_pmos ad=0.3468p pd=2.72u as=0 ps=0 w=1.02u l=5.575u
X714 VDD.t1940 a_9093_7834# VDD.t1939 VDD.t39 sg13_lv_pmos ad=0.1938p pd=1.4u as=0 ps=0 w=1.02u l=5.575u
X715 VSS.t552 a_28649_8082# a_28581_8118# VSS.t1817 sg13_lv_nmos ad=0.1672p pd=1.26u as=0.2992p ps=2.44u w=0.88u l=0.13u
X716 a_23121_13494# a_23189_13458# VSS.t885 VSS.t1413 sg13_lv_nmos ad=0.2992p pd=2.44u as=0.1672p ps=1.26u w=0.88u l=0.13u
X717 a_14537_5072# a_14469_5146# VDD.t1383 VDD.t83 sg13_lv_pmos ad=0.3468p pd=2.72u as=0.20145p ps=1.415u w=1.02u l=0.13u
X718 VSS.t24 a_10589_9426# VSS.t91 VSS.t272 sg13_lv_nmos ad=0.1738p pd=1.275u as=0 ps=0 w=0.88u l=5.305u
X719 VSS.t1647 a_16469_2706# VSS.t1345 VSS.t1646 sg13_lv_nmos ad=0.1672p pd=1.26u as=0 ps=0 w=0.88u l=5.575u
X720 VSS.t328 a_23693_5072# a_23625_5146# VSS.t941 sg13_lv_nmos ad=0.1738p pd=1.275u as=0.2992p ps=2.44u w=0.88u l=0.13u
X721 VSS.t453 a_32597_6416# VSS.t455 VSS.t454 sg13_lv_nmos ad=0.1672p pd=1.26u as=0 ps=0 w=0.88u l=5.575u
X722 VSS.t381 a_2444_16160# a_2376_16196# VSS.t1032 sg13_lv_nmos ad=0.2176p pd=1.96u as=0.2176p ps=1.96u w=0.64u l=0.76u
X723 a_34025_5394# a_33957_5430# VDD.t80 VDD.t68 sg13_lv_pmos ad=0.3468p pd=2.72u as=0.20145p ps=1.415u w=1.02u l=0.13u
X724 a_17479_15572# OR3X1_1.B BUFX3_3.A VDD.t5 sg13_lv_pmos ad=45.6f pd=0.67u as=91.2f ps=0.86u w=0.48u l=0.13u
X725 VSS.t126 a_15713_9426# VSS.t121 VSS.t1801 sg13_lv_nmos ad=0.1672p pd=1.26u as=0 ps=0 w=0.88u l=5.575u
X726 VDD.t571 a_32529_9178# VDD.t569 VDD.t29 sg13_lv_pmos ad=0.1938p pd=1.4u as=0 ps=0 w=1.02u l=5.575u
X727 VDD.t643 a_24717_9178# a_24785_9104# VDD.t29 sg13_lv_pmos ad=0.1938p pd=1.4u as=0.1938p ps=1.4u w=1.02u l=0.13u
X728 VDD.t596 DFFQX1_4.Q a_17749_16182# VDD.t0 sg13_lv_pmos ad=0.2412p pd=1.73u as=0.1632p ps=1.64u w=0.48u l=0.13u
X729 VSS.t237 a_13025_13458# a_12957_13494# VSS.t239 sg13_lv_nmos ad=0.1672p pd=1.26u as=0.2992p ps=2.44u w=0.88u l=0.13u
X730 VDD.t1874 a_31437_14554# VDD.t1873 VDD.t100 sg13_lv_pmos ad=0.3468p pd=2.72u as=0 ps=0 w=1.02u l=1.945u
X731 VSS.t954 a_7901_13458# VSS.t952 VSS.t953 sg13_lv_nmos ad=0.1672p pd=1.26u as=0 ps=0 w=0.88u l=5.575u
X732 VSS.t776 a_35369_4050# a_35301_4086# VSS.t994 sg13_lv_nmos ad=0.1738p pd=1.275u as=0.2992p ps=2.44u w=0.88u l=0.13u
X733 VSS.t212 a_31337_5394# a_31269_5430# VSS.t746 sg13_lv_nmos ad=0.1672p pd=1.26u as=0.2992p ps=2.44u w=0.88u l=0.13u
X734 VDD.t1862 a_3717_11866# VDD.t1860 VDD.t281 sg13_lv_pmos ad=0.1938p pd=1.4u as=0 ps=0 w=1.02u l=5.575u
X735 VSS.t14 a_18905_16146# a_18837_16182# VSS.t161 sg13_lv_nmos ad=0.1738p pd=1.275u as=0.2992p ps=2.44u w=0.88u l=0.13u
X736 VSS.t352 a_37805_9426# VSS.t352 VSS.t351 sg13_lv_nmos ad=0.1738p pd=1.275u as=0 ps=0 w=0.88u l=1.945u
X737 VDD.t1631 a_20769_4086# a_20837_4050# VDD.t83 sg13_lv_pmos ad=0.1938p pd=1.4u as=0.1938p ps=1.4u w=1.02u l=0.13u
X738 VDD.t1037 a_9429_16182# VDD.t1038 VDD.t0 sg13_lv_pmos ad=0.1938p pd=1.4u as=0 ps=0 w=1.02u l=5.575u
X739 VDD.t611 BUFX3_2.A OR3X1_1.C VDD.t0 sg13_lv_pmos ad=91.2f pd=0.86u as=91.2f ps=0.86u w=0.48u l=0.13u
X740 VDD.t1858 a_3717_11866# VDD.t1857 VDD.t281 sg13_lv_pmos ad=0.3468p pd=2.72u as=0 ps=0 w=1.02u l=5.575u
X741 VSS.t444 a_37805_14802# a_37737_14838# VSS.t443 sg13_lv_nmos ad=0.1738p pd=1.275u as=0.2992p ps=2.44u w=0.88u l=0.13u
X742 a_16973_5072# a_16905_5146# VDD.t1331 VDD.t83 sg13_lv_pmos ad=0.1938p pd=1.4u as=0.1938p ps=1.4u w=1.02u l=0.13u
X743 VSS.t303 a_34025_5394# VSS.t490 VSS.t491 sg13_lv_nmos ad=0.1738p pd=1.275u as=0 ps=0 w=0.88u l=5.305u
X744 VSS.t163 a_19409_15824# VSS.t1030 VSS.t1229 sg13_lv_nmos ad=0.1738p pd=1.275u as=0 ps=0 w=0.88u l=5.305u
X745 VSS.t53 a_3785_5394# a_3717_5430# VSS.t52 sg13_lv_nmos ad=0.1738p pd=1.275u as=0.2992p ps=2.44u w=0.88u l=0.13u
X746 VSS.t663 a_15318_15510# DFFQX1_5.CK VSS.t1134 sg13_lv_nmos ad=0.1634p pd=1.24u as=0.1634p ps=1.24u w=0.86u l=0.13u
X747 a_5213_10770# a_5145_10806# VDD.t282 VDD.t281 sg13_lv_pmos ad=0.1938p pd=1.4u as=0.1938p ps=1.4u w=1.02u l=0.13u
X748 a_7817_5072# a_7749_5146# VDD.t528 VDD.t83 sg13_lv_pmos ad=0.3468p pd=2.72u as=0.20145p ps=1.415u w=1.02u l=0.13u
X749 VSS.t583 a_5213_10770# VSS.t581 VSS.t582 sg13_lv_nmos ad=0.1672p pd=1.26u as=0 ps=0 w=0.88u l=5.575u
X750 VSS.t244 a_24617_14802# VSS.t1590 VSS.t1591 sg13_lv_nmos ad=0.1672p pd=1.26u as=0 ps=0 w=0.88u l=5.575u
X751 VDD.t1935 a_18333_8118# VDD.t1934 VDD.t29 sg13_lv_pmos ad=0.3468p pd=2.72u as=0 ps=0 w=1.02u l=5.305u
X752 VSS.t1137 a_16469_16146# VSS.t1137 VSS.t1183 sg13_lv_nmos ad=0.1738p pd=1.275u as=0 ps=0 w=0.88u l=1.945u
X753 a_6473_6416# a_6405_6490# VDD.t70 VDD.t68 sg13_lv_pmos ad=0.3468p pd=2.72u as=0.20145p ps=1.415u w=1.02u l=0.13u
X754 VDD.t1718 a_33957_10806# VDD.t1717 VDD.t281 sg13_lv_pmos ad=0.3468p pd=2.72u as=0 ps=0 w=1.02u l=5.305u
X755 a_19661_13136# a_19593_13210# VDD.t272 VDD.t93 sg13_lv_pmos ad=0.1938p pd=1.4u as=0.1938p ps=1.4u w=1.02u l=0.13u
X756 VSS.t922 a_1097_11792# VSS.t922 VSS.t1317 sg13_lv_nmos ad=0.1672p pd=1.26u as=0 ps=0 w=0.88u l=5.575u
X757 VSS.t278 a_27557_9426# a_27489_9462# VSS.t531 sg13_lv_nmos ad=0.1738p pd=1.275u as=0.2992p ps=2.44u w=0.88u l=0.13u
X758 VSS.t1165 a_9181_15474# DFFQX1_3.D VSS.t1164 sg13_lv_nmos ad=0.1567p pd=1.27u as=0.2924p ps=2.4u w=0.86u l=0.13u
X759 a_18665_15244# a_17829_14920# a_18435_15045# VDD.t5 sg13_lv_pmos ad=91.2f pd=0.86u as=91.2f ps=0.86u w=0.48u l=0.13u
X760 VDD.t1367 a_31269_4086# VDD.t1366 VDD.t83 sg13_lv_pmos ad=0.1938p pd=1.4u as=0 ps=0 w=1.02u l=5.575u
X761 VDD.t933 a_27405_14554# VDD.t930 VDD.t100 sg13_lv_pmos ad=0.1938p pd=1.4u as=0 ps=0 w=1.02u l=5.575u
X762 VDD.t1649 a_15645_12150# VDD.t1648 VDD.t93 sg13_lv_pmos ad=0.3468p pd=2.72u as=0 ps=0 w=1.02u l=5.575u
X763 VSS.t444 a_35369_14802# VSS.t872 VSS.t1103 sg13_lv_nmos ad=0.1738p pd=1.275u as=0 ps=0 w=0.88u l=1.945u
X764 AND2X1_2.Y a_8001_14852# VDD.t148 VDD.t5 sg13_lv_pmos ad=0.192p pd=1.76u as=91.2f ps=0.86u w=0.48u l=0.13u
X765 VSS.t566 a_16973_7760# a_16905_7834# VSS.t571 sg13_lv_nmos ad=0.1672p pd=1.26u as=0.2992p ps=2.44u w=0.88u l=0.13u
X766 VDD.t416 a_5145_8118# VDD.t415 VDD.t29 sg13_lv_pmos ad=0.1938p pd=1.4u as=0 ps=0 w=1.02u l=5.575u
X767 VDD.t728 a_20769_10806# a_20837_10770# VDD.t281 sg13_lv_pmos ad=0.1938p pd=1.4u as=0.1938p ps=1.4u w=1.02u l=0.13u
X768 VDD.t971 a_4053_10522# VDD.t970 VDD.t8 sg13_lv_pmos ad=0.3468p pd=2.72u as=0 ps=0 w=1.02u l=5.575u
X769 VDD.t766 a_27405_5146# a_27473_5072# VDD.t83 sg13_lv_pmos ad=0.1938p pd=1.4u as=0.1938p ps=1.4u w=1.02u l=0.13u
X770 VDD.t1200 a_1029_14838# VDD.t1199 VDD.t5 sg13_lv_pmos ad=0.3468p pd=2.72u as=0 ps=0 w=1.02u l=5.305u
X771 VSS.t1030 a_20249_16146# VSS.t1030 VSS.t1272 sg13_lv_nmos ad=0.1738p pd=1.275u as=0 ps=0 w=0.88u l=1.945u
X772 VSS.t762 a_20837_10770# a_20769_10806# VSS.t761 sg13_lv_nmos ad=0.1672p pd=1.26u as=0.2992p ps=2.44u w=0.88u l=0.13u
X773 VSS.t483 a_28649_6738# a_28581_6774# VSS.t1309 sg13_lv_nmos ad=0.1672p pd=1.26u as=0.2992p ps=2.44u w=0.88u l=0.13u
X774 VDD.t899 a_1365_10522# a_1433_10448# VDD.t8 sg13_lv_pmos ad=0.1938p pd=1.4u as=0.1938p ps=1.4u w=1.02u l=0.13u
X775 VSS.t244 a_27473_14480# a_27405_14554# VSS.t243 sg13_lv_nmos ad=0.1672p pd=1.26u as=0.2992p ps=2.44u w=0.88u l=0.13u
X776 VDD.t805 a_11781_7834# a_11849_7760# VDD.t39 sg13_lv_pmos ad=0.1938p pd=1.4u as=0.1938p ps=1.4u w=1.02u l=0.13u
X777 VSS.t81 XOR2X1_0.A a_3045_15244# VSS.t144 sg13_lv_nmos ad=61.5f pd=0.71u as=57f ps=0.68u w=0.3u l=0.13u
X778 a_3657_15572# a_3441_15952# VDD.t1194 VDD.t5 sg13_lv_pmos ad=43.2f pd=0.66u as=91.2f ps=0.86u w=0.48u l=0.13u
X779 a_6949_14852# NAND2X1_0.A NAND2X1_0.Y VSS.t1257 sg13_lv_nmos ad=57f pd=0.68u as=0.102p ps=1.28u w=0.3u l=0.13u
X780 VSS.t774 a_31337_4050# VSS.t425 VSS.t1348 sg13_lv_nmos ad=0.1672p pd=1.26u as=0 ps=0 w=0.88u l=5.575u
X781 VSS.t457 a_35285_6416# a_35217_6490# VSS.t1767 sg13_lv_nmos ad=0.1672p pd=1.26u as=0.2992p ps=2.44u w=0.88u l=0.13u
X782 VDD.t134 a_15645_9462# a_15713_9426# VDD.t8 sg13_lv_pmos ad=0.1938p pd=1.4u as=0.1938p ps=1.4u w=1.02u l=0.13u
X783 VSS.t647 a_4460_8096# a_4392_8132# VSS.t646 sg13_lv_nmos ad=0.2176p pd=1.96u as=0.2176p ps=1.96u w=0.64u l=0.76u
X784 VSS.t26 a_13025_9426# a_12957_9462# VSS.t27 sg13_lv_nmos ad=0.1672p pd=1.26u as=0.2992p ps=2.44u w=0.88u l=0.13u
X785 VDD.t24 a_23457_9462# VDD.t23 VDD.t8 sg13_lv_pmos ad=0.1938p pd=1.4u as=0 ps=0 w=1.02u l=5.575u
X786 VDD.t840 a_35217_13210# VDD.t839 VDD.t93 sg13_lv_pmos ad=0.3468p pd=2.72u as=0 ps=0 w=1.02u l=5.575u
X787 a_15881_5072# a_15813_5146# VDD.t1386 VDD.t83 sg13_lv_pmos ad=0.3468p pd=2.72u as=0.20145p ps=1.415u w=1.02u l=0.13u
X788 OR3X1_0.Y a_21525_14180# VSS.t602 VSS.t1302 sg13_lv_nmos ad=0.102p pd=1.28u as=61.5f ps=0.71u w=0.3u l=0.13u
X789 VDD.t1734 a_12957_13494# VDD.t1732 VDD.t100 sg13_lv_pmos ad=0.3468p pd=2.72u as=0 ps=0 w=1.02u l=5.575u
X790 VDD.t419 a_11865_8118# VDD.t418 VDD.t29 sg13_lv_pmos ad=0.3468p pd=2.72u as=0 ps=0 w=1.02u l=1.945u
X791 VDD.t1084 a_35301_4086# VDD.t1083 VDD.t83 sg13_lv_pmos ad=0.3468p pd=2.72u as=0 ps=0 w=1.02u l=1.945u
X792 a_23209_16146# NOR3X1_0.Y VSS.t107 VSS.t106 sg13_lv_nmos ad=0.102p pd=1.28u as=0.1567p ps=1.27u w=0.3u l=0.13u
X793 VDD.t1246 a_18837_16182# VDD.t1245 VDD.t0 sg13_lv_pmos ad=0.3468p pd=2.72u as=0 ps=0 w=1.02u l=1.945u
X794 VSS.t526 a_6473_9104# VSS.t87 VSS.t536 sg13_lv_nmos ad=0.1738p pd=1.275u as=0 ps=0 w=0.88u l=5.305u
X795 a_17497_16146# BUFX3_16.A VDD.t590 VDD.t0 sg13_lv_pmos ad=0.1632p pd=1.64u as=0.2412p ps=1.73u w=0.48u l=0.13u
X796 VDD.t424 a_15813_6490# VDD.t423 VDD.t68 sg13_lv_pmos ad=0.3468p pd=2.72u as=0 ps=0 w=1.02u l=1.945u
X797 a_19157_2706# a_19089_2742# VDD.t1430 VDD.t354 sg13_lv_pmos ad=0.3468p pd=2.72u as=0.20145p ps=1.415u w=1.02u l=0.13u
X798 VSS.t1070 a_7901_8082# VSS.t1083 VSS.t1815 sg13_lv_nmos ad=0.1672p pd=1.26u as=0 ps=0 w=0.88u l=5.575u
X799 VDD.t1600 a_5145_13494# VDD.t1599 VDD.t100 sg13_lv_pmos ad=0.1938p pd=1.4u as=0 ps=0 w=1.02u l=5.575u
X800 a_8001_16258# NAND3X1_0.Y VDD.t7 VDD.t0 sg13_lv_pmos ad=91.2f pd=0.86u as=0.1632p ps=1.64u w=0.48u l=0.13u
X801 VDD.t404 a_7833_10806# a_7901_10770# VDD.t281 sg13_lv_pmos ad=0.1938p pd=1.4u as=0.1938p ps=1.4u w=1.02u l=0.13u
X802 a_16973_10448# a_16905_10522# VDD.t496 VDD.t8 sg13_lv_pmos ad=0.1938p pd=1.4u as=0.1938p ps=1.4u w=1.02u l=0.13u
X803 a_8095_14852# BUFX3_1.Y.t4 a_8001_14852# VSS.t1001 sg13_lv_nmos ad=57f pd=0.68u as=0.102p ps=1.28u w=0.3u l=0.13u
X804 a_1029_13210# a_1097_13136# VSS.t497 VSS.t838 sg13_lv_nmos ad=0.2992p pd=2.44u as=0.1672p ps=1.26u w=0.88u l=0.13u
X805 VDD.t482 a_3313_15779# a_3325_15532# VDD.t5 sg13_lv_pmos ad=0.1834p pd=1.39u as=0.3332p ps=2.64u w=0.98u l=0.13u
X806 VSS.t651 a_23525_8082# VSS.t674 VSS.t1027 sg13_lv_nmos ad=0.1672p pd=1.26u as=0 ps=0 w=0.88u l=5.575u
X807 VSS.t911 a_22937_2706# a_22869_2742# VSS.t910 sg13_lv_nmos ad=0.1738p pd=1.275u as=0.2992p ps=2.44u w=0.88u l=0.13u
X808 VDD.t735 a_23625_7834# VDD.t734 VDD.t39 sg13_lv_pmos ad=0.3468p pd=2.72u as=0 ps=0 w=1.02u l=1.945u
X809 VDD.t170 a_9395_15170# a_9359_15244# VDD.t5 sg13_lv_pmos ad=0.2529p pd=1.545u as=43.2f ps=0.66u w=0.48u l=0.13u
X810 a_23693_9104# a_23625_9178# VDD.t1064 VDD.t29 sg13_lv_pmos ad=0.3468p pd=2.72u as=0.20145p ps=1.415u w=1.02u l=0.13u
X811 VSS.t542 a_23525_9426# VSS.t370 VSS.t1006 sg13_lv_nmos ad=0.1672p pd=1.26u as=0 ps=0 w=0.88u l=5.575u
X812 a_28581_10806# a_28649_10770# VSS.t757 VSS.t1455 sg13_lv_nmos ad=0.2992p pd=2.44u as=0.1672p ps=1.26u w=0.88u l=0.13u
X813 VDD.t649 a_12957_8118# VDD.t648 VDD.t29 sg13_lv_pmos ad=0.1938p pd=1.4u as=0 ps=0 w=1.02u l=5.575u
X814 VDD.t379 a_27489_9462# VDD.t378 VDD.t8 sg13_lv_pmos ad=0.3468p pd=2.72u as=0 ps=0 w=1.02u l=1.945u
X815 a_23777_14480# a_23709_14554# VDD.t1833 VDD.t100 sg13_lv_pmos ad=0.3468p pd=2.72u as=0.20145p ps=1.415u w=1.02u l=0.13u
X816 VDD.t451 a_16905_3802# VDD.t450 VDD.t354 sg13_lv_pmos ad=0.3468p pd=2.72u as=0 ps=0 w=1.02u l=5.575u
X817 a_24717_10522# a_24785_10448# VSS.t813 VSS.t812 sg13_lv_nmos ad=0.2992p pd=2.44u as=0.1672p ps=1.26u w=0.88u l=0.13u
X818 a_1097_14480# a_1029_14554# VDD.t1151 VDD.t100 sg13_lv_pmos ad=0.1938p pd=1.4u as=0.1938p ps=1.4u w=1.02u l=0.13u
X819 VSS.t67 a_36461_12114# a_36393_12150# VSS.t66 sg13_lv_nmos ad=0.1738p pd=1.275u as=0.2992p ps=2.44u w=0.88u l=0.13u
X820 VSS.t723 a_31589_2706# VSS.t1436 VSS.t1437 sg13_lv_nmos ad=0.1672p pd=1.26u as=0 ps=0 w=0.88u l=5.575u
X821 VDD.t1822 a_15645_10806# VDD.t1821 VDD.t281 sg13_lv_pmos ad=0.1938p pd=1.4u as=0 ps=0 w=1.02u l=5.575u
X822 VSS.t1118 DFFQX1_0.Q a_6325_16182# VSS.t1260 sg13_lv_nmos ad=0.1567p pd=1.27u as=0.102p ps=1.28u w=0.3u l=0.13u
X823 a_3721_14802# XOR2X1_0.Y VSS.t81 VSS.t371 sg13_lv_nmos ad=0.102p pd=1.28u as=0.1567p ps=1.27u w=0.3u l=0.13u
X824 a_35369_14802# a_35301_14838# VDD.t960 VDD.t5 sg13_lv_pmos ad=0.3468p pd=2.72u as=0.20145p ps=1.415u w=1.02u l=0.13u
X825 NAND2X1_0.A a_4981_15510# VSS.t293 VSS.t1119 sg13_lv_nmos ad=0.2924p pd=2.4u as=0.1567p ps=1.27u w=0.86u l=0.13u
X826 a_9161_11792# a_9093_11866# VDD.t1589 VDD.t281 sg13_lv_pmos ad=0.1938p pd=1.4u as=0.1938p ps=1.4u w=1.02u l=0.13u
X827 VSS.t859 a_6809_3728# VSS.t861 VSS.t1408 sg13_lv_nmos ad=0.1738p pd=1.275u as=0 ps=0 w=0.88u l=5.305u
X828 VSS.t393 OAI21X1_2.Y a_20857_15510# VSS.t1757 sg13_lv_nmos ad=0.1567p pd=1.27u as=0.102p ps=1.28u w=0.3u l=0.13u
X829 VSS.t237 a_11849_13136# VSS.t238 VSS.t1525 sg13_lv_nmos ad=0.1672p pd=1.26u as=0 ps=0 w=0.88u l=5.575u
X830 VDD.t1453 a_24717_5146# VDD.t1452 VDD.t83 sg13_lv_pmos ad=0.3468p pd=2.72u as=0 ps=0 w=1.02u l=5.575u
X831 VSS.t352 a_36461_9426# VSS.t352 VSS.t351 sg13_lv_nmos ad=0.1738p pd=1.275u as=0 ps=0 w=0.88u l=5.305u
X832 VSS.t783 a_7817_7760# a_7749_7834# VSS.t782 sg13_lv_nmos ad=0.1738p pd=1.275u as=0.2992p ps=2.44u w=0.88u l=0.13u
X833 VDD.t891 a_27405_10522# VDD.t890 VDD.t8 sg13_lv_pmos ad=0.3468p pd=2.72u as=0 ps=0 w=1.02u l=5.575u
X834 a_24301_14802# BUFX3_41.A VSS.t448 VSS.t447 sg13_lv_nmos ad=0.102p pd=1.28u as=0.1567p ps=1.27u w=0.3u l=0.13u
X835 VSS.t778 a_32597_3728# VSS.t776 VSS.t779 sg13_lv_nmos ad=0.1672p pd=1.26u as=0 ps=0 w=0.88u l=5.575u
X836 VDD.t742 a_24717_7834# VDD.t740 VDD.t39 sg13_lv_pmos ad=0.1938p pd=1.4u as=0 ps=0 w=1.02u l=5.575u
X837 VSS.t564 a_15881_7760# VSS.t566 VSS.t565 sg13_lv_nmos ad=0.1738p pd=1.275u as=0 ps=0 w=0.88u l=1.945u
X838 VSS.t808 a_18401_12114# a_18333_12150# VSS.t1463 sg13_lv_nmos ad=0.1738p pd=1.275u as=0.2992p ps=2.44u w=0.88u l=0.13u
X839 VDD.t1738 a_15813_11866# VDD.t1737 VDD.t281 sg13_lv_pmos ad=0.3468p pd=2.72u as=0 ps=0 w=1.02u l=1.945u
X840 VDD.t581 a_15645_8118# VDD.t580 VDD.t29 sg13_lv_pmos ad=0.1938p pd=1.4u as=0 ps=0 w=1.02u l=5.575u
X841 VSS.t1344 a_15377_2706# a_15309_2742# VSS.t1346 sg13_lv_nmos ad=0.1738p pd=1.275u as=0.2992p ps=2.44u w=0.88u l=0.13u
X842 a_15713_6738# a_15645_6774# VDD.t57 VDD.t39 sg13_lv_pmos ad=0.1938p pd=1.4u as=0.1938p ps=1.4u w=1.02u l=0.13u
X843 VSS.t103 a_3131_15770# a_3023_15792# VSS.t102 sg13_lv_nmos ad=0.22785p pd=1.9u as=0.102p ps=1.28u w=0.3u l=0.13u
X844 VSS.t156 a_32597_15824# VSS.t158 VSS.t1749 sg13_lv_nmos ad=0.1672p pd=1.26u as=0 ps=0 w=0.88u l=5.575u
X845 BUFX3_29.Y a_21865_13494# VDD.t992 VDD.t100 sg13_lv_pmos ad=0.4488p pd=3.32u as=0.2412p ps=1.73u w=1.32u l=0.13u
X846 a_17091_15045# a_16953_15244# VSS.t105 VSS.t104 sg13_lv_nmos ad=57f pd=0.68u as=57f ps=0.68u w=0.3u l=0.13u
X847 VSS.t998 a_26213_12114# VSS.t318 VSS.t997 sg13_lv_nmos ad=0.1738p pd=1.275u as=0 ps=0 w=0.88u l=5.305u
X848 VSS.t20 a_35285_10448# VSS.t20 VSS.t19 sg13_lv_nmos ad=0.1672p pd=1.26u as=0 ps=0 w=0.88u l=5.575u
X849 VSS.t559 a_5213_8082# VSS.t561 VSS.t1811 sg13_lv_nmos ad=0.1672p pd=1.26u as=0 ps=0 w=0.88u l=5.575u
X850 a_7901_8082# a_7833_8118# VDD.t340 VDD.t29 sg13_lv_pmos ad=0.1938p pd=1.4u as=0.1938p ps=1.4u w=1.02u l=0.13u
X851 VDD.t1157 BUFX24_2.A a_15318_15510# VDD.t5 sg13_lv_pmos ad=0.2508p pd=1.7u as=0.2508p ps=1.7u w=1.32u l=0.13u
X852 VSS.t896 a_22751_15170# a_22727_14900# VSS.t927 sg13_lv_nmos ad=0.1519p pd=1.265u as=27f ps=0.48u w=0.3u l=0.13u
X853 VSS.t778 a_34025_4050# a_33957_4086# VSS.t1458 sg13_lv_nmos ad=0.1738p pd=1.275u as=0.2992p ps=2.44u w=0.88u l=0.13u
X854 VDD.t359 a_12957_9462# VDD.t358 VDD.t8 sg13_lv_pmos ad=0.3468p pd=2.72u as=0 ps=0 w=1.02u l=5.575u
X855 a_23525_8082# a_23457_8118# VDD.t1070 VDD.t29 sg13_lv_pmos ad=0.1938p pd=1.4u as=0.1938p ps=1.4u w=1.02u l=0.13u
X856 VDD.t110 a_16905_13210# VDD.t109 VDD.t93 sg13_lv_pmos ad=0.1938p pd=1.4u as=0 ps=0 w=1.02u l=5.575u
X857 VSS.t251 a_35285_3728# VSS.t251 VSS.t250 sg13_lv_nmos ad=0.1672p pd=1.26u as=0 ps=0 w=0.88u l=5.575u
X858 a_37973_7760# a_37905_7834# VDD.t215 VDD.t39 sg13_lv_pmos ad=0.3468p pd=2.72u as=0.20145p ps=1.415u w=1.02u l=0.13u
X859 VSS.t26 a_11933_9426# VSS.t24 VSS.t25 sg13_lv_nmos ad=0.1738p pd=1.275u as=0 ps=0 w=0.88u l=1.945u
X860 counter_value_o[3] a_17077_16182# VSS.t554 VSS.t1246 sg13_lv_nmos ad=0.2924p pd=2.4u as=0.1567p ps=1.27u w=0.86u l=0.13u
X861 a_7589_15952# a_7093_15779# a_7297_15682# VSS.t1108 sg13_lv_nmos ad=27f pd=0.48u as=57f ps=0.68u w=0.3u l=0.13u
X862 VSS.t1098 a_30161_11792# a_30093_11866# VSS.t1662 sg13_lv_nmos ad=0.1738p pd=1.275u as=0.2992p ps=2.44u w=0.88u l=0.13u
X863 a_5061_2742# a_5129_2706# VSS.t504 VSS.t1547 sg13_lv_nmos ad=0.2992p pd=2.44u as=0.1672p ps=1.26u w=0.88u l=0.13u
X864 VSS.t141 a_7901_6738# VSS.t185 VSS.t286 sg13_lv_nmos ad=0.1672p pd=1.26u as=0 ps=0 w=0.88u l=5.575u
X865 VDD.t659 BUFX3_12.A a_4981_15510# VDD.t5 sg13_lv_pmos ad=0.2412p pd=1.73u as=0.1632p ps=1.64u w=0.48u l=0.13u
X866 a_27473_6416# a_27405_6490# VDD.t748 VDD.t68 sg13_lv_pmos ad=0.1938p pd=1.4u as=0.1938p ps=1.4u w=1.02u l=0.13u
X867 VSS.t281 a_27473_9104# VSS.t129 VSS.t282 sg13_lv_nmos ad=0.1672p pd=1.26u as=0 ps=0 w=0.88u l=5.575u
X868 a_38648_9126# a_38580_9212# VDD.t572 VDD.t29 sg13_lv_pmos ad=0.3332p pd=2.64u as=0.3332p ps=2.64u w=0.98u l=0.76u
X869 VSS.t626 a_33941_16146# VSS.t158 VSS.t625 sg13_lv_nmos ad=0.1738p pd=1.275u as=0 ps=0 w=0.88u l=1.945u
X870 VDD.t925 a_24049_16146# counter_value_o[4] VDD.t0 sg13_lv_pmos ad=0.2412p pd=1.73u as=0.4488p ps=3.32u w=1.32u l=0.13u
X871 a_3717_11866# a_3785_11792# VSS.t925 VSS.t926 sg13_lv_nmos ad=0.2992p pd=2.44u as=0.1672p ps=1.26u w=0.88u l=0.13u
X872 VSS.t297 a_31505_6416# a_31437_6490# VSS.t296 sg13_lv_nmos ad=0.1738p pd=1.275u as=0.2992p ps=2.44u w=0.88u l=0.13u
X873 VSS.t737 a_23525_6738# VSS.t735 VSS.t1295 sg13_lv_nmos ad=0.1672p pd=1.26u as=0 ps=0 w=0.88u l=5.575u
X874 a_7777_14852# NAND2X1_0.A a_7675_14852# VSS.t1258 sg13_lv_nmos ad=57f pd=0.68u as=57f ps=0.68u w=0.3u l=0.13u
X875 VSS.t876 a_4460_12128# a_4392_12164# VSS.t875 sg13_lv_nmos ad=0.2176p pd=1.96u as=0.2176p ps=1.96u w=0.64u l=0.76u
X876 a_15881_11792# a_15813_11866# VDD.t1738 VDD.t281 sg13_lv_pmos ad=0.3468p pd=2.72u as=0.20145p ps=1.415u w=1.02u l=0.13u
X877 VSS.t725 a_38057_2706# a_37989_2742# VSS.t1046 sg13_lv_nmos ad=0.1738p pd=1.275u as=0.2992p ps=2.44u w=0.88u l=0.13u
X878 VSS.t181 a_20837_8082# a_20769_8118# VSS.t1076 sg13_lv_nmos ad=0.1672p pd=1.26u as=0.2992p ps=2.44u w=0.88u l=0.13u
X879 VSS.t53 a_1097_5394# VSS.t53 VSS.t435 sg13_lv_nmos ad=0.1672p pd=1.26u as=0 ps=0 w=0.88u l=5.575u
X880 a_35285_7760# a_35217_7834# VDD.t810 VDD.t39 sg13_lv_pmos ad=0.1938p pd=1.4u as=0.1938p ps=1.4u w=1.02u l=0.13u
X881 VSS.t544 a_26213_9426# a_26145_9462# VSS.t630 sg13_lv_nmos ad=0.1738p pd=1.275u as=0.2992p ps=2.44u w=0.88u l=0.13u
X882 VSS.t241 a_13025_13458# VSS.t238 VSS.t240 sg13_lv_nmos ad=0.1672p pd=1.26u as=0 ps=0 w=0.88u l=5.575u
X883 VDD.t1111 a_35217_9178# VDD.t1110 VDD.t29 sg13_lv_pmos ad=0.3468p pd=2.72u as=0 ps=0 w=1.02u l=5.575u
X884 a_22615_15952# DFFQX1_6.D VSS.t154 VSS.t153 sg13_lv_nmos ad=27f pd=0.48u as=0.102p ps=1.28u w=0.3u l=0.13u
X885 a_4460_2720# a_4392_2756# VDD.t1885 VDD.t354 sg13_lv_pmos ad=0.3332p pd=2.64u as=0.3332p ps=2.64u w=0.98u l=0.76u
X886 VSS.t163 a_18905_16146# VSS.t14 VSS.t162 sg13_lv_nmos ad=0.1738p pd=1.275u as=0 ps=0 w=0.88u l=1.945u
X887 VDD.t1655 a_6405_11866# VDD.t1654 VDD.t281 sg13_lv_pmos ad=0.3468p pd=2.72u as=0 ps=0 w=1.02u l=5.305u
X888 VSS.t954 a_9161_13136# VSS.t956 VSS.t1529 sg13_lv_nmos ad=0.1672p pd=1.26u as=0 ps=0 w=0.88u l=5.575u
X889 VDD.t847 a_36393_12150# VDD.t845 VDD.t93 sg13_lv_pmos ad=0.3468p pd=2.72u as=0 ps=0 w=1.02u l=5.305u
X890 VDD.t364 a_10521_8118# VDD.t363 VDD.t29 sg13_lv_pmos ad=0.3468p pd=2.72u as=0 ps=0 w=1.02u l=5.305u
X891 a_31269_9462# a_31337_9426# VSS.t38 VSS.t635 sg13_lv_nmos ad=0.2992p pd=2.44u as=0.1672p ps=1.26u w=0.88u l=0.13u
X892 a_17197_14656# BUFX3_3.Y VSS.t105 VSS.t1426 sg13_lv_nmos ad=57f pd=0.68u as=57f ps=0.68u w=0.3u l=0.13u
X893 a_3289_15572# a_3023_15792# VDD.t139 VDD.t5 sg13_lv_pmos ad=43.2f pd=0.66u as=0.2529p ps=1.545u w=0.48u l=0.13u
X894 VDD.t413 a_5145_8118# VDD.t412 VDD.t29 sg13_lv_pmos ad=0.3468p pd=2.72u as=0 ps=0 w=1.02u l=5.575u
X895 VSS.t1393 a_19745_10770# a_19677_10806# VSS.t1518 sg13_lv_nmos ad=0.1738p pd=1.275u as=0.2992p ps=2.44u w=0.88u l=0.13u
X896 a_31505_7760# a_31437_7834# VDD.t137 VDD.t39 sg13_lv_pmos ad=0.3468p pd=2.72u as=0.20145p ps=1.415u w=1.02u l=0.13u
X897 a_3049_16146# BUFX3_12.A VSS.t381 VSS.t657 sg13_lv_nmos ad=0.102p pd=1.28u as=0.1567p ps=1.27u w=0.3u l=0.13u
X898 OR3X1_1.C OR3BX1_0.B VDD.t160 VDD.t0 sg13_lv_pmos ad=91.2f pd=0.86u as=0.1632p ps=1.64u w=0.48u l=0.13u
X899 a_7369_14852# AND2X1_1.B VSS.t78 VSS.t1276 sg13_lv_nmos ad=57f pd=0.68u as=57f ps=0.68u w=0.3u l=0.13u
X900 VDD.t516 a_9093_6490# VDD.t515 VDD.t68 sg13_lv_pmos ad=0.3468p pd=2.72u as=0 ps=0 w=1.02u l=5.575u
X901 a_9161_5072# a_9093_5146# VDD.t993 VDD.t83 sg13_lv_pmos ad=0.1938p pd=1.4u as=0.1938p ps=1.4u w=1.02u l=0.13u
X902 VSS.t89 a_9161_9104# VSS.t91 VSS.t642 sg13_lv_nmos ad=0.1672p pd=1.26u as=0 ps=0 w=0.88u l=5.575u
X903 VDD.t1595 a_18333_12150# VDD.t1594 VDD.t93 sg13_lv_pmos ad=0.3468p pd=2.72u as=0 ps=0 w=1.02u l=5.305u
X904 VDD.t1360 a_28581_6774# a_28649_6738# VDD.t39 sg13_lv_pmos ad=0.1938p pd=1.4u as=0.1938p ps=1.4u w=1.02u l=0.13u
X905 VDD.t614 BUFX3_27.Y OAI21X1_2.Y VDD.t5 sg13_lv_pmos ad=0.1632p pd=1.64u as=91.2f ps=0.86u w=0.48u l=0.13u
X906 VSS.t165 a_3785_7760# a_3717_7834# VSS.t557 sg13_lv_nmos ad=0.1672p pd=1.26u as=0.2992p ps=2.44u w=0.88u l=0.13u
X907 a_15713_5394# a_15645_5430# VDD.t753 VDD.t68 sg13_lv_pmos ad=0.1938p pd=1.4u as=0.1938p ps=1.4u w=1.02u l=0.13u
X908 VDD.t588 a_37737_8118# VDD.t587 VDD.t29 sg13_lv_pmos ad=0.3468p pd=2.72u as=0 ps=0 w=1.02u l=1.945u
X909 a_35369_9426# a_35301_9462# VDD.t1096 VDD.t8 sg13_lv_pmos ad=0.3468p pd=2.72u as=0.20145p ps=1.415u w=1.02u l=0.13u
X910 a_12793_16146# DFFQX1_3.Q VDD.t1234 VDD.t0 sg13_lv_pmos ad=0.1632p pd=1.64u as=0.2412p ps=1.73u w=0.48u l=0.13u
X911 VDD.t1410 a_8841_2742# VDD.t1409 VDD.t354 sg13_lv_pmos ad=0.3468p pd=2.72u as=0 ps=0 w=1.02u l=5.575u
X912 VSS.t550 a_26213_8082# VSS.t651 VSS.t652 sg13_lv_nmos ad=0.1738p pd=1.275u as=0 ps=0 w=0.88u l=5.305u
X913 VSS.t478 a_5213_6738# VSS.t474 VSS.t682 sg13_lv_nmos ad=0.1672p pd=1.26u as=0 ps=0 w=0.88u l=5.575u
X914 VSS.t1434 a_31589_2706# a_31521_2742# VSS.t1433 sg13_lv_nmos ad=0.1672p pd=1.26u as=0.2992p ps=2.44u w=0.88u l=0.13u
X915 a_32529_5146# a_32597_5072# VSS.t303 VSS.t851 sg13_lv_nmos ad=0.2992p pd=2.44u as=0.1672p ps=1.26u w=0.88u l=0.13u
X916 VDD.t91 a_33957_4086# VDD.t90 VDD.t83 sg13_lv_pmos ad=0.3468p pd=2.72u as=0 ps=0 w=1.02u l=5.305u
X917 a_1097_6416# a_1029_6490# VDD.t467 VDD.t68 sg13_lv_pmos ad=0.1938p pd=1.4u as=0.1938p ps=1.4u w=1.02u l=0.13u
X918 a_22903_13948# OR3X1_1.B a_22801_13948# VDD.t100 sg13_lv_pmos ad=91.2f pd=0.86u as=91.2f ps=0.86u w=0.48u l=0.13u
X919 VSS.t764 a_23525_10770# a_23457_10806# VSS.t1624 sg13_lv_nmos ad=0.1672p pd=1.26u as=0.2992p ps=2.44u w=0.88u l=0.13u
X920 VSS.t896 a_22635_14192# a_22611_14608# VSS.t1375 sg13_lv_nmos ad=57f pd=0.68u as=27f ps=0.48u w=0.3u l=0.13u
X921 a_10589_12114# a_10521_12150# VDD.t870 VDD.t93 sg13_lv_pmos ad=0.3468p pd=2.72u as=0.20145p ps=1.415u w=1.02u l=0.13u
X922 VSS.t573 a_16973_7760# VSS.t177 VSS.t574 sg13_lv_nmos ad=0.1672p pd=1.26u as=0 ps=0 w=0.88u l=5.575u
X923 VDD.t972 a_4053_10522# a_4121_10448# VDD.t8 sg13_lv_pmos ad=0.1938p pd=1.4u as=0.1938p ps=1.4u w=1.02u l=0.13u
X924 VDD.t908 a_37905_5146# VDD.t907 VDD.t83 sg13_lv_pmos ad=0.3468p pd=2.72u as=0 ps=0 w=1.02u l=1.945u
X925 VSS.t725 a_34277_2706# VSS.t723 VSS.t724 sg13_lv_nmos ad=0.1738p pd=1.275u as=0 ps=0 w=0.88u l=1.945u
X926 VSS.t774 a_32597_3728# a_32529_3802# VSS.t773 sg13_lv_nmos ad=0.1672p pd=1.26u as=0.2992p ps=2.44u w=0.88u l=0.13u
X927 VSS.t444 a_37973_14480# VSS.t444 VSS.t443 sg13_lv_nmos ad=0.1738p pd=1.275u as=0 ps=0 w=0.88u l=1.945u
X928 VDD.t1342 a_19593_5146# a_19661_5072# VDD.t83 sg13_lv_pmos ad=0.1938p pd=1.4u as=0.1938p ps=1.4u w=1.02u l=0.13u
X929 VSS.t869 a_31337_14802# VSS.t870 VSS.t1719 sg13_lv_nmos ad=0.1672p pd=1.26u as=0 ps=0 w=0.88u l=5.575u
X930 VSS.t248 a_27473_14480# VSS.t246 VSS.t249 sg13_lv_nmos ad=0.1672p pd=1.26u as=0 ps=0 w=0.88u l=5.575u
X931 VSS.t542 a_24785_9104# a_24717_9178# VSS.t541 sg13_lv_nmos ad=0.1672p pd=1.26u as=0.2992p ps=2.44u w=0.88u l=0.13u
X932 a_19593_3802# a_19661_3728# VSS.t1541 VSS.t1694 sg13_lv_nmos ad=0.2992p pd=2.44u as=0.1672p ps=1.26u w=0.88u l=0.13u
X933 VSS.t67 a_37805_12114# VSS.t67 VSS.t66 sg13_lv_nmos ad=0.1738p pd=1.275u as=0 ps=0 w=0.88u l=1.945u
X934 VDD.t513 a_35301_2742# VDD.t514 VDD.t354 sg13_lv_pmos ad=0.1938p pd=1.4u as=0 ps=0 w=1.02u l=5.575u
X935 VSS.t421 a_19745_4050# VSS.t419 VSS.t420 sg13_lv_nmos ad=0.1738p pd=1.275u as=0 ps=0 w=0.88u l=1.945u
X936 a_11781_9178# a_11849_9104# VSS.t29 VSS.t538 sg13_lv_nmos ad=0.2992p pd=2.44u as=0.1672p ps=1.26u w=0.88u l=0.13u
X937 a_1029_2742# a_1097_2706# VSS.t1284 VSS.t1793 sg13_lv_nmos ad=0.2992p pd=2.44u as=0.1672p ps=1.26u w=0.88u l=0.13u
X938 VSS.t414 a_20837_6738# a_20769_6774# VSS.t1037 sg13_lv_nmos ad=0.1672p pd=1.26u as=0.2992p ps=2.44u w=0.88u l=0.13u
X939 VSS.t185 a_8492_6438# a_8424_6524# VSS.t291 sg13_lv_nmos ad=0.2176p pd=1.96u as=0.2176p ps=1.96u w=0.64u l=0.76u
X940 VDD.t1169 a_12714_15510# BUFX24_2.A VDD.t5 sg13_lv_pmos ad=0.2508p pd=1.7u as=0.2508p ps=1.7u w=1.32u l=0.13u
X941 a_18767_15244# a_18031_14852# a_18665_15244# VDD.t5 sg13_lv_pmos ad=43.2f pd=0.66u as=91.2f ps=0.86u w=0.48u l=0.13u
X942 VSS.t74 a_8492_14502# a_8424_14588# VSS.t73 sg13_lv_nmos ad=0.2176p pd=1.96u as=0.2176p ps=1.96u w=0.64u l=0.76u
X943 BUFX3_41.A a_23171_15532# VDD.t1466 VDD.t5 sg13_lv_pmos ad=0.1632p pd=1.64u as=0.2529p ps=1.545u w=0.48u l=0.13u
X944 VDD.t841 a_35217_13210# a_35285_13136# VDD.t93 sg13_lv_pmos ad=0.1938p pd=1.4u as=0.1938p ps=1.4u w=1.02u l=0.13u
X945 VSS.t911 a_20249_2706# VSS.t1483 VSS.t1485 sg13_lv_nmos ad=0.1672p pd=1.26u as=0 ps=0 w=0.88u l=5.575u
X946 VDD.t191 a_26145_9462# VDD.t190 VDD.t8 sg13_lv_pmos ad=0.3468p pd=2.72u as=0 ps=0 w=1.02u l=5.305u
X947 VSS.t20 a_38648_10470# a_38580_10556# VSS.t19 sg13_lv_nmos ad=0.2176p pd=1.96u as=0.2176p ps=1.96u w=0.64u l=0.76u
X948 VDD.t1735 a_12957_13494# a_13025_13458# VDD.t100 sg13_lv_pmos ad=0.1938p pd=1.4u as=0.1938p ps=1.4u w=1.02u l=0.13u
X949 VSS.t349 a_11849_11792# a_11781_11866# VSS.t1520 sg13_lv_nmos ad=0.1672p pd=1.26u as=0.2992p ps=2.44u w=0.88u l=0.13u
X950 a_37805_9426# a_37737_9462# VDD.t193 VDD.t8 sg13_lv_pmos ad=0.3468p pd=2.72u as=0.20145p ps=1.415u w=1.02u l=0.13u
X951 VDD.t1017 a_31269_10806# VDD.t1016 VDD.t281 sg13_lv_pmos ad=0.1938p pd=1.4u as=0 ps=0 w=1.02u l=5.575u
X952 a_27896_13472# a_27828_13508# VDD.t280 VDD.t100 sg13_lv_pmos ad=0.3332p pd=2.64u as=0.3332p ps=2.64u w=0.98u l=0.76u
X953 VDD.t1515 a_1029_13210# VDD.t1514 VDD.t93 sg13_lv_pmos ad=0.3468p pd=2.72u as=0 ps=0 w=1.02u l=5.575u
X954 AOI21BX2_1.A a_20857_15510# VSS.t393 VSS.t1116 sg13_lv_nmos ad=0.2924p pd=2.4u as=0.1567p ps=1.27u w=0.86u l=0.13u
X955 VSS.t170 a_11849_7760# a_11781_7834# VSS.t1033 sg13_lv_nmos ad=0.1672p pd=1.26u as=0.2992p ps=2.44u w=0.88u l=0.13u
X956 VSS.t224 a_1433_3728# VSS.t224 VSS.t1841 sg13_lv_nmos ad=0.1672p pd=1.26u as=0 ps=0 w=0.88u l=5.575u
X957 VSS.t117 a_30161_15824# VSS.t386 VSS.t385 sg13_lv_nmos ad=0.1738p pd=1.275u as=0 ps=0 w=0.88u l=5.305u
X958 DFFQX1_5.CK a_15318_15510# VSS.t663 VSS.t1131 sg13_lv_nmos ad=0.1634p pd=1.24u as=0.1634p ps=1.24u w=0.86u l=0.13u
X959 a_5145_5430# a_5213_5394# VSS.t197 VSS.t198 sg13_lv_nmos ad=0.2992p pd=2.44u as=0.1672p ps=1.26u w=0.88u l=0.13u
X960 VSS.t799 a_37805_13458# a_37737_13494# VSS.t798 sg13_lv_nmos ad=0.1738p pd=1.275u as=0.2992p ps=2.44u w=0.88u l=0.13u
X961 VSS.t407 a_24785_15824# VSS.t113 VSS.t408 sg13_lv_nmos ad=0.1672p pd=1.26u as=0 ps=0 w=0.88u l=5.575u
X962 VSS.t202 a_18401_5394# VSS.t200 VSS.t201 sg13_lv_nmos ad=0.1738p pd=1.275u as=0 ps=0 w=0.88u l=5.305u
X963 VSS.t251 a_37973_3728# VSS.t251 VSS.t250 sg13_lv_nmos ad=0.1738p pd=1.275u as=0 ps=0 w=0.88u l=1.945u
X964 VSS.t668 a_14537_7760# VSS.t564 VSS.t669 sg13_lv_nmos ad=0.1738p pd=1.275u as=0 ps=0 w=0.88u l=5.305u
X965 VSS.t602 a_22383_15045# a_22359_14900# VSS.t1670 sg13_lv_nmos ad=57f pd=0.68u as=27f ps=0.48u w=0.3u l=0.13u
X966 VSS.t53 a_1097_5394# a_1029_5430# VSS.t433 sg13_lv_nmos ad=0.1672p pd=1.26u as=0.2992p ps=2.44u w=0.88u l=0.13u
X967 VDD.t1932 a_31437_9178# VDD.t1931 VDD.t29 sg13_lv_pmos ad=0.3468p pd=2.72u as=0 ps=0 w=1.02u l=1.945u
X968 VDD.t1182 a_10941_15898# VDD.t1181 VDD.t5 sg13_lv_pmos ad=0.3468p pd=2.72u as=0 ps=0 w=1.02u l=5.305u
X969 VDD.t1954 a_28581_5430# a_28649_5394# VDD.t68 sg13_lv_pmos ad=0.1938p pd=1.4u as=0.1938p ps=1.4u w=1.02u l=0.13u
X970 VDD.t1894 a_3717_6490# VDD.t1892 VDD.t68 sg13_lv_pmos ad=0.1938p pd=1.4u as=0 ps=0 w=1.02u l=5.575u
X971 a_36461_10770# a_36393_10806# VDD.t1510 VDD.t281 sg13_lv_pmos ad=0.3468p pd=2.72u as=0.20145p ps=1.415u w=1.02u l=0.13u
X972 BUFX3_26.A NAND2X1_0.Y a_6417_15938# VSS.t733 sg13_lv_nmos ad=58.5f pd=0.69u as=57f ps=0.68u w=0.3u l=0.13u
X973 DFFQX1_3.Q a_9395_15170# VSS.t1 VSS.t148 sg13_lv_nmos ad=0.102p pd=1.28u as=0.1519p ps=1.265u w=0.3u l=0.13u
X974 a_11849_11792# a_11781_11866# VDD.t1582 VDD.t281 sg13_lv_pmos ad=0.1938p pd=1.4u as=0.1938p ps=1.4u w=1.02u l=0.13u
X975 VDD.t452 a_16905_3802# a_16973_3728# VDD.t354 sg13_lv_pmos ad=0.1938p pd=1.4u as=0.1938p ps=1.4u w=1.02u l=0.13u
X976 VSS.t481 a_26213_6738# VSS.t737 VSS.t1298 sg13_lv_nmos ad=0.1738p pd=1.275u as=0 ps=0 w=0.88u l=5.305u
X977 a_7221_15952# a_7105_15532# a_6911_15770# VSS.t416 sg13_lv_nmos ad=57f pd=0.68u as=57f ps=0.68u w=0.3u l=0.13u
X978 VSS.t1100 a_31505_11792# VSS.t706 VSS.t1561 sg13_lv_nmos ad=0.1738p pd=1.275u as=0 ps=0 w=0.88u l=1.945u
X979 BUFX3_1.Y.t0 a_1033_10134# VDD.t1664 VDD.t8 sg13_lv_pmos ad=0.4488p pd=3.32u as=0.2412p ps=1.73u w=1.32u l=0.13u
X980 a_22665_15572# a_22197_15624# a_22615_15952# VSS.t1759 sg13_lv_nmos ad=57f pd=0.68u as=27f ps=0.48u w=0.3u l=0.13u
X981 VSS.t799 a_35369_13458# VSS.t1549 VSS.t1721 sg13_lv_nmos ad=0.1738p pd=1.275u as=0 ps=0 w=0.88u l=1.945u
X982 VDD.t1577 a_28581_4086# VDD.t1576 VDD.t83 sg13_lv_pmos ad=0.1938p pd=1.4u as=0 ps=0 w=1.02u l=5.575u
X983 VSS.t428 a_16973_6416# a_16905_6490# VSS.t427 sg13_lv_nmos ad=0.1672p pd=1.26u as=0.2992p ps=2.44u w=0.88u l=0.13u
X984 VDD.t1751 a_32529_13210# VDD.t1749 VDD.t93 sg13_lv_pmos ad=0.1938p pd=1.4u as=0 ps=0 w=1.02u l=5.575u
X985 VSS.t352 a_38480_9440# a_38412_9476# VSS.t351 sg13_lv_nmos ad=0.2176p pd=1.96u as=0.2176p ps=1.96u w=0.64u l=0.76u
X986 a_9359_15244# a_8623_14852# a_9257_15244# VDD.t5 sg13_lv_pmos ad=43.2f pd=0.66u as=91.2f ps=0.86u w=0.48u l=0.13u
X987 VDD.t136 NAND4X2_0.C a_8001_16258# VDD.t0 sg13_lv_pmos ad=98.39999f pd=0.89u as=91.2f ps=0.86u w=0.48u l=0.13u
X988 VSS.t497 a_1097_13458# VSS.t497 VSS.t836 sg13_lv_nmos ad=0.1672p pd=1.26u as=0 ps=0 w=0.88u l=5.575u
X989 VDD.t893 a_27405_10522# a_27473_10448# VDD.t8 sg13_lv_pmos ad=0.1938p pd=1.4u as=0.1938p ps=1.4u w=1.02u l=0.13u
X990 VDD.t1463 a_32529_5146# VDD.t1461 VDD.t83 sg13_lv_pmos ad=0.1938p pd=1.4u as=0 ps=0 w=1.02u l=5.575u
X991 VDD.t1454 a_24717_5146# a_24785_5072# VDD.t83 sg13_lv_pmos ad=0.1938p pd=1.4u as=0.1938p ps=1.4u w=1.02u l=0.13u
X992 VSS.t1473 a_14792_15846# a_14724_15932# VSS.t1472 sg13_lv_nmos ad=0.2176p pd=1.96u as=0.2176p ps=1.96u w=0.64u l=0.76u
X993 VSS.t11 a_35285_15824# VSS.t11 VSS.t10 sg13_lv_nmos ad=0.1672p pd=1.26u as=0 ps=0 w=0.88u l=5.575u
X994 VSS.t109 AND2X1_2.B a_8095_14852# VSS.t108 sg13_lv_nmos ad=57f pd=0.68u as=57f ps=0.68u w=0.3u l=0.13u
X995 a_18573_14575# OR3X1_1.B VSS.t101 VSS.t398 sg13_lv_nmos ad=57f pd=0.68u as=57f ps=0.68u w=0.3u l=0.13u
X996 a_19593_11866# a_19661_11792# VSS.t936 VSS.t1367 sg13_lv_nmos ad=0.2992p pd=2.44u as=0.1672p ps=1.26u w=0.88u l=0.13u
X997 a_22349_10448# a_22281_10522# VDD.t858 VDD.t8 sg13_lv_pmos ad=0.3468p pd=2.72u as=0.20145p ps=1.415u w=1.02u l=0.13u
X998 VDD.t288 DFFQX1_5.CK a_17829_14920# VDD.t5 sg13_lv_pmos ad=0.1834p pd=1.39u as=0.1632p ps=1.64u w=0.48u l=0.13u
X999 VSS.t1573 a_1097_10770# a_1029_10806# VSS.t1675 sg13_lv_nmos ad=0.1672p pd=1.26u as=0.2992p ps=2.44u w=0.88u l=0.13u
X1000 VDD.t1358 a_28581_6774# VDD.t1357 VDD.t39 sg13_lv_pmos ad=0.3468p pd=2.72u as=0 ps=0 w=1.02u l=5.575u
X1001 a_31505_11792# a_31437_11866# VDD.t952 VDD.t281 sg13_lv_pmos ad=0.3468p pd=2.72u as=0.20145p ps=1.415u w=1.02u l=0.13u
X1002 a_23003_14188# a_22865_14228# VSS.t896 VSS.t1341 sg13_lv_nmos ad=0.102p pd=1.28u as=0.22785p ps=1.9u w=0.3u l=0.13u
X1003 VDD.t89 a_1029_4086# VDD.t87 VDD.t83 sg13_lv_pmos ad=0.1938p pd=1.4u as=0 ps=0 w=1.02u l=5.575u
X1004 VDD.t1872 a_27405_3802# VDD.t1870 VDD.t354 sg13_lv_pmos ad=0.1938p pd=1.4u as=0 ps=0 w=1.02u l=5.575u
X1005 VSS.t97 a_36461_8082# a_36393_8118# VSS.t96 sg13_lv_nmos ad=0.1738p pd=1.275u as=0.2992p ps=2.44u w=0.88u l=0.13u
X1006 BUFX24_2.A a_12714_15510# VDD.t1171 VDD.t5 sg13_lv_pmos ad=0.2508p pd=1.7u as=0.2508p ps=1.7u w=1.32u l=0.13u
X1007 VDD.t1292 a_9181_16146# NAND4X2_0.C VDD.t0 sg13_lv_pmos ad=0.2412p pd=1.73u as=0.4488p ps=3.32u w=1.32u l=0.13u
X1008 VDD.t1153 a_1029_14554# a_1097_14480# VDD.t100 sg13_lv_pmos ad=0.1938p pd=1.4u as=0.1938p ps=1.4u w=1.02u l=0.13u
X1009 VDD.t1659 a_11781_3802# VDD.t1658 VDD.t354 sg13_lv_pmos ad=0.3468p pd=2.72u as=0 ps=0 w=1.02u l=5.575u
X1010 VSS.t370 a_23693_9104# VSS.t542 VSS.t1808 sg13_lv_nmos ad=0.1738p pd=1.275u as=0 ps=0 w=0.88u l=1.945u
X1011 a_22350_16146# OA21X2_0.B a_22484_16182# VSS.t1188 sg13_lv_nmos ad=0.102p pd=1.28u as=0.102p ps=1.28u w=0.3u l=0.13u
X1012 VDD.t299 a_20769_9462# VDD.t298 VDD.t8 sg13_lv_pmos ad=0.1938p pd=1.4u as=0 ps=0 w=1.02u l=5.575u
X1013 VSS.t674 a_24785_7760# VSS.t651 VSS.t675 sg13_lv_nmos ad=0.1672p pd=1.26u as=0 ps=0 w=0.88u l=5.575u
X1014 VDD.t673 a_11781_6490# VDD.t672 VDD.t68 sg13_lv_pmos ad=0.1938p pd=1.4u as=0 ps=0 w=1.02u l=5.575u
X1015 VSS.t241 a_15881_13136# VSS.t698 VSS.t1324 sg13_lv_nmos ad=0.1738p pd=1.275u as=0 ps=0 w=0.88u l=1.945u
X1016 VDD.t1495 a_19593_11866# a_19661_11792# VDD.t281 sg13_lv_pmos ad=0.1938p pd=1.4u as=0.1938p ps=1.4u w=1.02u l=0.13u
X1017 VSS.t235 a_30497_2706# VSS.t233 VSS.t234 sg13_lv_nmos ad=0.1738p pd=1.275u as=0 ps=0 w=0.88u l=1.945u
X1018 a_5145_13494# a_5213_13458# VSS.t952 VSS.t1738 sg13_lv_nmos ad=0.2992p pd=2.44u as=0.1672p ps=1.26u w=0.88u l=0.13u
X1019 VSS.t1268 a_4037_14802# a_3969_14838# VSS.t1267 sg13_lv_nmos ad=0.1738p pd=1.275u as=0.2992p ps=2.44u w=0.88u l=0.13u
X1020 VDD.t853 a_24717_11866# a_24785_11792# VDD.t281 sg13_lv_pmos ad=0.1938p pd=1.4u as=0.1938p ps=1.4u w=1.02u l=0.13u
X1021 a_3309_15244# a_3045_15244# VDD.t168 VDD.t5 sg13_lv_pmos ad=91.2f pd=0.86u as=98.39999f ps=0.89u w=0.48u l=0.13u
X1022 VSS.t101 DFFQX1_5.CK a_17829_14920# VSS.t617 sg13_lv_nmos ad=0.1193p pd=1.05u as=0.102p ps=1.28u w=0.3u l=0.13u
X1023 VSS.t931 a_3785_13458# VSS.t497 VSS.t930 sg13_lv_nmos ad=0.1738p pd=1.275u as=0 ps=0 w=0.88u l=1.945u
X1024 VSS.t352 a_37973_9104# a_37905_9178# VSS.t351 sg13_lv_nmos ad=0.1738p pd=1.275u as=0.2992p ps=2.44u w=0.88u l=0.13u
X1025 VDD.t1508 a_37737_13494# VDD.t1507 VDD.t100 sg13_lv_pmos ad=0.3468p pd=2.72u as=0 ps=0 w=1.02u l=1.945u
X1026 VSS.t224 a_1097_4050# VSS.t224 VSS.t225 sg13_lv_nmos ad=0.1672p pd=1.26u as=0 ps=0 w=0.88u l=5.575u
X1027 a_22727_14900# a_21777_14920# a_22613_15244# VSS.t1661 sg13_lv_nmos ad=27f pd=0.48u as=57f ps=0.68u w=0.3u l=0.13u
X1028 VDD.t53 a_19593_7834# VDD.t51 VDD.t39 sg13_lv_pmos ad=0.1938p pd=1.4u as=0 ps=0 w=1.02u l=5.575u
X1029 a_23461_14130# BUFX3_28.A VDD.t1708 VDD.t100 sg13_lv_pmos ad=0.1632p pd=1.64u as=0.2412p ps=1.73u w=0.48u l=0.13u
X1030 VSS.t702 a_15713_13458# VSS.t698 VSS.t803 sg13_lv_nmos ad=0.1672p pd=1.26u as=0 ps=0 w=0.88u l=5.575u
X1031 a_19661_6416# a_19593_6490# VDD.t385 VDD.t68 sg13_lv_pmos ad=0.1938p pd=1.4u as=0.1938p ps=1.4u w=1.02u l=0.13u
X1032 a_31337_13458# a_31269_13494# VDD.t1547 VDD.t100 sg13_lv_pmos ad=0.1938p pd=1.4u as=0.1938p ps=1.4u w=1.02u l=0.13u
X1033 VSS.t425 a_31505_3728# VSS.t425 VSS.t494 sg13_lv_nmos ad=0.1738p pd=1.275u as=0 ps=0 w=0.88u l=1.945u
X1034 VSS.t356 a_19661_9104# VSS.t355 VSS.t354 sg13_lv_nmos ad=0.1672p pd=1.26u as=0 ps=0 w=0.88u l=5.575u
X1035 a_8492_13158# a_8424_13244# VDD.t1031 VDD.t93 sg13_lv_pmos ad=0.3332p pd=2.64u as=0.3332p ps=2.64u w=0.98u l=0.76u
X1036 VDD.t1589 a_9093_11866# VDD.t1588 VDD.t281 sg13_lv_pmos ad=0.3468p pd=2.72u as=0 ps=0 w=1.02u l=5.575u
X1037 VDD.t1485 a_22869_2742# VDD.t1484 VDD.t354 sg13_lv_pmos ad=0.3468p pd=2.72u as=0 ps=0 w=1.02u l=1.945u
X1038 VSS.t916 a_20249_2706# a_20181_2742# VSS.t1484 sg13_lv_nmos ad=0.1672p pd=1.26u as=0.2992p ps=2.44u w=0.88u l=0.13u
X1039 a_15645_5430# a_15713_5394# VSS.t200 VSS.t323 sg13_lv_nmos ad=0.2992p pd=2.44u as=0.1672p ps=1.26u w=0.88u l=0.13u
X1040 VDD.t381 DFFQX1_3.CK a_8421_14920# VDD.t5 sg13_lv_pmos ad=0.1834p pd=1.39u as=0.1632p ps=1.64u w=0.48u l=0.13u
X1041 a_27305_14802# a_27237_14838# VDD.t1876 VDD.t5 sg13_lv_pmos ad=0.3468p pd=2.72u as=0.20145p ps=1.415u w=1.02u l=0.13u
X1042 VDD.t1703 a_9093_14554# VDD.t1701 VDD.t100 sg13_lv_pmos ad=0.1938p pd=1.4u as=0 ps=0 w=1.02u l=5.575u
X1043 a_10589_6738# a_10521_6774# VDD.t744 VDD.t39 sg13_lv_pmos ad=0.3468p pd=2.72u as=0.20145p ps=1.415u w=1.02u l=0.13u
X1044 VSS.t165 a_1097_7760# VSS.t165 VSS.t167 sg13_lv_nmos ad=0.1672p pd=1.26u as=0 ps=0 w=0.88u l=5.575u
X1045 VDD.t864 a_31521_2742# a_31589_2706# VDD.t354 sg13_lv_pmos ad=0.1938p pd=1.4u as=0.1938p ps=1.4u w=1.02u l=0.13u
X1046 a_12957_10806# a_13025_10770# VSS.t7 VSS.t512 sg13_lv_nmos ad=0.2992p pd=2.44u as=0.1672p ps=1.26u w=0.88u l=0.13u
X1047 a_18235_15244# a_18031_14852# VDD.t1684 VDD.t5 sg13_lv_pmos ad=43.2f pd=0.66u as=0.1632p ps=1.64u w=0.48u l=0.13u
X1048 VDD.t1851 a_28581_14838# VDD.t1850 VDD.t5 sg13_lv_pmos ad=0.3468p pd=2.72u as=0 ps=0 w=1.02u l=5.575u
X1049 a_21742_15932# BUFX3_2.A VSS.t133 VSS.t1281 sg13_lv_nmos ad=0.1216p pd=1.02u as=0.2176p ps=1.96u w=0.64u l=0.13u
X1050 VSS.t878 a_22937_2706# VSS.t911 VSS.t912 sg13_lv_nmos ad=0.1738p pd=1.275u as=0 ps=0 w=0.88u l=1.945u
X1051 a_31337_9426# a_31269_9462# VDD.t1052 VDD.t8 sg13_lv_pmos ad=0.1938p pd=1.4u as=0.1938p ps=1.4u w=1.02u l=0.13u
X1052 VSS.t1121 a_6803_15792# DFFQX1_0.Q VSS.t1234 sg13_lv_nmos ad=0.1519p pd=1.265u as=0.102p ps=1.28u w=0.3u l=0.13u
X1053 BUFX24_2.A a_12714_15510# VSS.t661 VSS.t1145 sg13_lv_nmos ad=0.1634p pd=1.24u as=0.1634p ps=1.24u w=0.86u l=0.13u
X1054 VSS.t314 a_15713_4050# a_15645_4086# VSS.t864 sg13_lv_nmos ad=0.1672p pd=1.26u as=0.2992p ps=2.44u w=0.88u l=0.13u
X1055 VDD.t1254 DFFQX1_7.Q a_27157_16182# VDD.t0 sg13_lv_pmos ad=0.2412p pd=1.73u as=0.1632p ps=1.64u w=0.48u l=0.13u
X1056 VSS.t284 a_7817_6416# a_7749_6490# VSS.t288 sg13_lv_nmos ad=0.1738p pd=1.275u as=0.2992p ps=2.44u w=0.88u l=0.13u
X1057 a_18399_15244# a_17829_14920# a_18297_15244# VDD.t5 sg13_lv_pmos ad=43.2f pd=0.66u as=91.2f ps=0.86u w=0.48u l=0.13u
X1058 VSS.t192 a_15881_6416# VSS.t192 VSS.t731 sg13_lv_nmos ad=0.1738p pd=1.275u as=0 ps=0 w=0.88u l=1.945u
X1059 VSS.t501 a_6473_13136# VSS.t952 VSS.t1696 sg13_lv_nmos ad=0.1738p pd=1.275u as=0 ps=0 w=0.88u l=5.305u
X1060 VDD.t879 a_23961_2742# VDD.t880 VDD.t354 sg13_lv_pmos ad=0.1938p pd=1.4u as=0 ps=0 w=1.02u l=5.575u
X1061 VDD.t1952 a_28581_5430# VDD.t1951 VDD.t68 sg13_lv_pmos ad=0.3468p pd=2.72u as=0 ps=0 w=1.02u l=5.575u
X1062 a_22349_6416# a_22281_6490# VDD.t240 VDD.t68 sg13_lv_pmos ad=0.3468p pd=2.72u as=0.20145p ps=1.415u w=1.02u l=0.13u
X1063 VSS.t74 DFFQX1_3.CK a_8421_14920# VSS.t460 sg13_lv_nmos ad=0.1193p pd=1.05u as=0.102p ps=1.28u w=0.3u l=0.13u
X1064 a_9003_14900# a_8623_14852# a_8889_15244# VSS.t110 sg13_lv_nmos ad=27f pd=0.48u as=57f ps=0.68u w=0.3u l=0.13u
X1065 VDD.t1907 a_15309_2742# VDD.t1906 VDD.t354 sg13_lv_pmos ad=0.3468p pd=2.72u as=0 ps=0 w=1.02u l=1.945u
X1066 VSS.t815 a_26213_10770# a_26145_10806# VSS.t1488 sg13_lv_nmos ad=0.1738p pd=1.275u as=0.2992p ps=2.44u w=0.88u l=0.13u
X1067 VSS.t561 a_3785_7760# VSS.t559 VSS.t562 sg13_lv_nmos ad=0.1672p pd=1.26u as=0 ps=0 w=0.88u l=5.575u
X1068 VDD.t664 OR3X1_1.A OAI21X1_1.Y VDD.t5 sg13_lv_pmos ad=0.1632p pd=1.64u as=91.2f ps=0.86u w=0.48u l=0.13u
X1069 VSS.t1337 a_8909_2706# VSS.t1335 VSS.t1336 sg13_lv_nmos ad=0.1672p pd=1.26u as=0 ps=0 w=0.88u l=5.575u
X1070 VSS.t50 a_36461_6738# a_36393_6774# VSS.t49 sg13_lv_nmos ad=0.1738p pd=1.275u as=0.2992p ps=2.44u w=0.88u l=0.13u
X1071 a_13025_6738# a_12957_6774# VDD.t816 VDD.t39 sg13_lv_pmos ad=0.1938p pd=1.4u as=0.1938p ps=1.4u w=1.02u l=0.13u
X1072 VSS.t509 a_14537_10448# VSS.t7 VSS.t1703 sg13_lv_nmos ad=0.1738p pd=1.275u as=0 ps=0 w=0.88u l=5.305u
X1073 a_19093_15474# OAI21X1_0.Y VDD.t1265 VDD.t5 sg13_lv_pmos ad=0.1632p pd=1.64u as=0.2412p ps=1.73u w=0.48u l=0.13u
X1074 VSS.t886 a_24785_13136# VSS.t885 VSS.t884 sg13_lv_nmos ad=0.1672p pd=1.26u as=0 ps=0 w=0.88u l=5.575u
X1075 a_7901_13458# a_7833_13494# VDD.t770 VDD.t100 sg13_lv_pmos ad=0.1938p pd=1.4u as=0.1938p ps=1.4u w=1.02u l=0.13u
X1076 VSS.t706 a_32597_11792# a_32529_11866# VSS.t707 sg13_lv_nmos ad=0.1672p pd=1.26u as=0.2992p ps=2.44u w=0.88u l=0.13u
X1077 VSS.t1544 a_5129_2706# VSS.t894 VSS.t1546 sg13_lv_nmos ad=0.1672p pd=1.26u as=0 ps=0 w=0.88u l=5.575u
X1078 VSS.t815 a_23525_10770# VSS.t811 VSS.t1627 sg13_lv_nmos ad=0.1672p pd=1.26u as=0 ps=0 w=0.88u l=5.575u
X1079 a_18803_15170# a_18665_15244# VDD.t1176 VDD.t5 sg13_lv_pmos ad=0.1632p pd=1.64u as=0.37935p ps=2.32u w=0.48u l=0.13u
X1080 a_23525_10770# a_23457_10806# VDD.t598 VDD.t281 sg13_lv_pmos ad=0.1938p pd=1.4u as=0.1938p ps=1.4u w=1.02u l=0.13u
X1081 BUFX24_2.A a_12714_15510# VSS.t661 VSS.t1141 sg13_lv_nmos ad=0.1634p pd=1.24u as=0.1634p ps=1.24u w=0.86u l=0.13u
X1082 a_17073_15938# OR3X1_1.B VDD.t373 VDD.t5 sg13_lv_pmos ad=91.2f pd=0.86u as=0.1632p ps=1.64u w=0.48u l=0.13u
X1083 a_14537_14480# a_14469_14554# VDD.t173 VDD.t100 sg13_lv_pmos ad=0.3468p pd=2.72u as=0.20145p ps=1.415u w=1.02u l=0.13u
X1084 VSS.t97 a_35369_8082# VSS.t45 VSS.t174 sg13_lv_nmos ad=0.1738p pd=1.275u as=0 ps=0 w=0.88u l=1.945u
X1085 a_23693_5072# a_23625_5146# VDD.t1349 VDD.t83 sg13_lv_pmos ad=0.3468p pd=2.72u as=0.20145p ps=1.415u w=1.02u l=0.13u
X1086 VSS.t550 a_27473_7760# a_27405_7834# VSS.t712 sg13_lv_nmos ad=0.1672p pd=1.26u as=0.2992p ps=2.44u w=0.88u l=0.13u
X1087 VDD.t155 a_16905_9178# VDD.t156 VDD.t29 sg13_lv_pmos ad=0.3468p pd=2.72u as=0 ps=0 w=1.02u l=5.575u
X1088 a_20837_8082# a_20769_8118# VDD.t1117 VDD.t29 sg13_lv_pmos ad=0.1938p pd=1.4u as=0.1938p ps=1.4u w=1.02u l=0.13u
X1089 a_17167_15938# OR3X1_1.B a_17073_15938# VSS.t387 sg13_lv_nmos ad=27f pd=0.48u as=0.102p ps=1.28u w=0.3u l=0.13u
X1090 VSS.t222 a_13025_5394# VSS.t218 VSS.t1774 sg13_lv_nmos ad=0.1672p pd=1.26u as=0 ps=0 w=0.88u l=5.575u
X1091 VDD.t225 a_7833_6774# a_7901_6738# VDD.t39 sg13_lv_pmos ad=0.1938p pd=1.4u as=0.1938p ps=1.4u w=1.02u l=0.13u
X1092 VSS.t1070 a_9161_7760# VSS.t170 VSS.t1085 sg13_lv_nmos ad=0.1672p pd=1.26u as=0 ps=0 w=0.88u l=5.575u
X1093 a_38648_7782# a_38580_7868# VDD.t743 VDD.t39 sg13_lv_pmos ad=0.3332p pd=2.64u as=0.3332p ps=2.64u w=0.98u l=0.76u
X1094 VSS.t844 a_7901_10770# a_7833_10806# VSS.t1724 sg13_lv_nmos ad=0.1672p pd=1.26u as=0.2992p ps=2.44u w=0.88u l=0.13u
X1095 a_27741_2742# a_27809_2706# VSS.t233 VSS.t1481 sg13_lv_nmos ad=0.2992p pd=2.44u as=0.1672p ps=1.26u w=0.88u l=0.13u
X1096 VDD.t320 a_32529_6490# a_32597_6416# VDD.t68 sg13_lv_pmos ad=0.1938p pd=1.4u as=0.1938p ps=1.4u w=1.02u l=0.13u
X1097 VSS.t544 a_24785_9104# VSS.t278 VSS.t545 sg13_lv_nmos ad=0.1672p pd=1.26u as=0 ps=0 w=0.88u l=5.575u
X1098 a_3309_15244# XOR2X1_0.A XOR2X1_0.Y VDD.t5 sg13_lv_pmos ad=0.1632p pd=1.64u as=93.59999f ps=0.87u w=0.48u l=0.13u
X1099 VDD.t1441 a_15645_13494# a_15713_13458# VDD.t100 sg13_lv_pmos ad=0.1938p pd=1.4u as=0.1938p ps=1.4u w=1.02u l=0.13u
X1100 VSS.t1491 a_14537_11792# a_14469_11866# VSS.t1515 sg13_lv_nmos ad=0.1738p pd=1.275u as=0.2992p ps=2.44u w=0.88u l=0.13u
X1101 VDD.t65 a_23457_6774# a_23525_6738# VDD.t39 sg13_lv_pmos ad=0.1938p pd=1.4u as=0.1938p ps=1.4u w=1.02u l=0.13u
X1102 VDD.t1286 a_37989_2742# VDD.t1285 VDD.t354 sg13_lv_pmos ad=0.3468p pd=2.72u as=0 ps=0 w=1.02u l=1.945u
X1103 VSS.t1384 a_10589_13458# VSS.t956 VSS.t1383 sg13_lv_nmos ad=0.1738p pd=1.275u as=0 ps=0 w=0.88u l=5.305u
X1104 a_30161_7760# a_30093_7834# VDD.t668 VDD.t39 sg13_lv_pmos ad=0.3468p pd=2.72u as=0.20145p ps=1.415u w=1.02u l=0.13u
X1105 VSS.t43 a_31337_8082# VSS.t41 VSS.t1823 sg13_lv_nmos ad=0.1672p pd=1.26u as=0 ps=0 w=0.88u l=5.575u
X1106 a_37805_10770# a_37737_10806# VDD.t1028 VDD.t281 sg13_lv_pmos ad=0.3468p pd=2.72u as=0.20145p ps=1.415u w=1.02u l=0.13u
X1107 VDD.t627 a_19593_10522# VDD.t626 VDD.t8 sg13_lv_pmos ad=0.1938p pd=1.4u as=0 ps=0 w=1.02u l=5.575u
X1108 a_1365_10522# a_1433_10448# VSS.t1573 VSS.t1577 sg13_lv_nmos ad=0.2992p pd=2.44u as=0.1672p ps=1.26u w=0.88u l=0.13u
X1109 VSS.t113 a_27809_16146# a_27741_16182# VSS.t898 sg13_lv_nmos ad=0.1672p pd=1.26u as=0.2992p ps=2.44u w=0.88u l=0.13u
X1110 VSS.t156 a_32597_16146# a_32529_16182# VSS.t155 sg13_lv_nmos ad=0.1738p pd=1.275u as=0.2992p ps=2.44u w=0.88u l=0.13u
X1111 a_10589_5394# a_10521_5430# VDD.t394 VDD.t68 sg13_lv_pmos ad=0.3468p pd=2.72u as=0.20145p ps=1.415u w=1.02u l=0.13u
X1112 VSS.t1393 a_19661_10448# VSS.t762 VSS.t1395 sg13_lv_nmos ad=0.1672p pd=1.26u as=0 ps=0 w=0.88u l=5.575u
X1113 a_24785_13136# a_24717_13210# VDD.t1759 VDD.t93 sg13_lv_pmos ad=0.1938p pd=1.4u as=0.1938p ps=1.4u w=1.02u l=0.13u
X1114 VSS.t423 a_28649_4050# VSS.t983 VSS.t1357 sg13_lv_nmos ad=0.1672p pd=1.26u as=0 ps=0 w=0.88u l=5.575u
X1115 VSS.t661 a_12714_15510# BUFX24_2.A VSS.t1148 sg13_lv_nmos ad=0.1634p pd=1.24u as=0.1634p ps=1.24u w=0.86u l=0.13u
X1116 VDD.t475 a_35217_6490# a_35285_6416# VDD.t68 sg13_lv_pmos ad=0.1938p pd=1.4u as=0.1938p ps=1.4u w=1.02u l=0.13u
X1117 VDD.t920 a_15645_4086# VDD.t919 VDD.t83 sg13_lv_pmos ad=0.3468p pd=2.72u as=0 ps=0 w=1.02u l=5.575u
X1118 VDD.t983 a_30093_14554# VDD.t982 VDD.t100 sg13_lv_pmos ad=0.3468p pd=2.72u as=0 ps=0 w=1.02u l=5.305u
X1119 a_9395_15170# a_9257_15244# VDD.t170 VDD.t5 sg13_lv_pmos ad=0.1632p pd=1.64u as=0.37935p ps=2.32u w=0.48u l=0.13u
X1120 VSS.t894 a_4460_2720# a_4392_2756# VSS.t893 sg13_lv_nmos ad=0.2176p pd=1.96u as=0.2176p ps=1.96u w=0.64u l=0.76u
X1121 a_35217_7834# a_35285_7760# VSS.t97 VSS.t96 sg13_lv_nmos ad=0.2992p pd=2.44u as=0.1672p ps=1.26u w=0.88u l=0.13u
X1122 a_28581_9462# a_28649_9426# VSS.t131 VSS.t1013 sg13_lv_nmos ad=0.2992p pd=2.44u as=0.1672p ps=1.26u w=0.88u l=0.13u
X1123 VSS.t81 a_3785_14480# VSS.t595 VSS.t906 sg13_lv_nmos ad=0.1672p pd=1.26u as=0 ps=0 w=0.88u l=5.575u
X1124 VSS.t202 a_19661_5072# VSS.t1327 VSS.t1326 sg13_lv_nmos ad=0.1672p pd=1.26u as=0 ps=0 w=0.88u l=5.575u
X1125 VDD.t1222 NAND3X1_0.B OR3X1_1.B VDD.t5 sg13_lv_pmos ad=0.1862p pd=1.36u as=0.1862p ps=1.36u w=0.98u l=0.13u
X1126 VSS.t889 a_27221_13458# a_27153_13494# VSS.t1788 sg13_lv_nmos ad=0.1738p pd=1.275u as=0.2992p ps=2.44u w=0.88u l=0.13u
X1127 VSS.t423 a_30161_3728# VSS.t425 VSS.t424 sg13_lv_nmos ad=0.1738p pd=1.275u as=0 ps=0 w=0.88u l=5.305u
X1128 VSS.t475 a_3785_6416# a_3717_6490# VSS.t476 sg13_lv_nmos ad=0.1672p pd=1.26u as=0.2992p ps=2.44u w=0.88u l=0.13u
X1129 VSS.t444 a_36461_14802# a_36393_14838# VSS.t443 sg13_lv_nmos ad=0.1738p pd=1.275u as=0.2992p ps=2.44u w=0.88u l=0.13u
X1130 VDD.t842 a_35217_13210# VDD.t841 VDD.t93 sg13_lv_pmos ad=0.1938p pd=1.4u as=0 ps=0 w=1.02u l=5.575u
X1131 VSS.t861 a_5213_4050# VSS.t859 VSS.t860 sg13_lv_nmos ad=0.1672p pd=1.26u as=0 ps=0 w=0.88u l=5.575u
X1132 VSS.t208 a_27557_5394# VSS.t206 VSS.t745 sg13_lv_nmos ad=0.1738p pd=1.275u as=0 ps=0 w=0.88u l=1.945u
X1133 VDD.t1735 a_12957_13494# VDD.t1736 VDD.t100 sg13_lv_pmos ad=0.1938p pd=1.4u as=0 ps=0 w=1.02u l=5.575u
X1134 VSS.t349 a_11849_11792# VSS.t365 VSS.t1519 sg13_lv_nmos ad=0.1672p pd=1.26u as=0 ps=0 w=0.88u l=5.575u
X1135 VSS.t355 a_22349_9104# VSS.t370 VSS.t369 sg13_lv_nmos ad=0.1738p pd=1.275u as=0 ps=0 w=0.88u l=5.305u
X1136 a_13025_5394# a_12957_5430# VDD.t248 VDD.t68 sg13_lv_pmos ad=0.1938p pd=1.4u as=0.1938p ps=1.4u w=1.02u l=0.13u
X1137 VSS.t165 a_1097_7760# a_1029_7834# VSS.t164 sg13_lv_nmos ad=0.1672p pd=1.26u as=0.2992p ps=2.44u w=0.88u l=0.13u
X1138 VDD.t861 a_31521_2742# VDD.t860 VDD.t354 sg13_lv_pmos ad=0.3468p pd=2.72u as=0 ps=0 w=1.02u l=5.575u
X1139 a_1029_9462# a_1097_9426# VSS.t520 VSS.t624 sg13_lv_nmos ad=0.2992p pd=2.44u as=0.1672p ps=1.26u w=0.88u l=0.13u
X1140 VSS.t795 a_16973_11792# VSS.t808 VSS.t1564 sg13_lv_nmos ad=0.1672p pd=1.26u as=0 ps=0 w=0.88u l=5.575u
X1141 VDD.t1868 a_27405_3802# VDD.t1867 VDD.t354 sg13_lv_pmos ad=0.3468p pd=2.72u as=0 ps=0 w=1.02u l=5.575u
X1142 a_22399_15524# a_22197_15624# VDD.t623 VDD.t5 sg13_lv_pmos ad=0.3332p pd=2.64u as=0.1834p ps=1.39u w=0.98u l=0.13u
X1143 a_16905_5146# a_16973_5072# VSS.t202 VSS.t1322 sg13_lv_nmos ad=0.2992p pd=2.44u as=0.1672p ps=1.26u w=0.88u l=0.13u
X1144 BUFX3_26.A a_6153_15938# VDD.t1140 VDD.t5 sg13_lv_pmos ad=91.2f pd=0.86u as=98.39999f ps=0.89u w=0.48u l=0.13u
X1145 a_22715_15244# a_21979_14852# a_22613_15244# VDD.t5 sg13_lv_pmos ad=43.2f pd=0.66u as=91.2f ps=0.86u w=0.48u l=0.13u
X1146 a_22359_14900# a_21979_14852# a_22245_15244# VSS.t710 sg13_lv_nmos ad=27f pd=0.48u as=57f ps=0.68u w=0.3u l=0.13u
X1147 VDD.t1690 a_9093_3802# a_9161_3728# VDD.t354 sg13_lv_pmos ad=0.1938p pd=1.4u as=0.1938p ps=1.4u w=1.02u l=0.13u
X1148 VSS.t431 a_16973_6416# VSS.t410 VSS.t432 sg13_lv_nmos ad=0.1672p pd=1.26u as=0 ps=0 w=0.88u l=5.575u
X1149 VDD.t389 a_7105_15532# a_7601_15572# VDD.t5 sg13_lv_pmos ad=0.1632p pd=1.64u as=43.2f ps=0.66u w=0.48u l=0.13u
X1150 VDD.t946 enable_i a_1033_3414# VDD.t354 sg13_lv_pmos ad=0.2412p pd=1.73u as=0.1632p ps=1.64u w=0.48u l=0.13u
X1151 VSS.t50 a_35369_6738# VSS.t457 VSS.t1340 sg13_lv_nmos ad=0.1738p pd=1.275u as=0 ps=0 w=0.88u l=1.945u
X1152 a_17321_15244# a_16485_14920# a_17091_15045# VDD.t5 sg13_lv_pmos ad=91.2f pd=0.86u as=91.2f ps=0.86u w=0.48u l=0.13u
X1153 VDD.t998 a_35217_5146# VDD.t999 VDD.t83 sg13_lv_pmos ad=0.3468p pd=2.72u as=0 ps=0 w=1.02u l=5.575u
X1154 VDD.t441 a_7833_5430# a_7901_5394# VDD.t68 sg13_lv_pmos ad=0.1938p pd=1.4u as=0.1938p ps=1.4u w=1.02u l=0.13u
X1155 VDD.t31 a_7749_9178# VDD.t30 VDD.t29 sg13_lv_pmos ad=0.3468p pd=2.72u as=0 ps=0 w=1.02u l=1.945u
X1156 VSS.t1513 a_31337_13458# VSS.t755 VSS.t1512 sg13_lv_nmos ad=0.1672p pd=1.26u as=0 ps=0 w=0.88u l=5.575u
X1157 a_1097_10770# a_1029_10806# VDD.t1803 VDD.t281 sg13_lv_pmos ad=0.1938p pd=1.4u as=0.1938p ps=1.4u w=1.02u l=0.13u
X1158 VDD.t1914 a_28581_12150# VDD.t1913 VDD.t93 sg13_lv_pmos ad=0.1938p pd=1.4u as=0 ps=0 w=1.02u l=5.575u
X1159 VDD.t831 a_23457_5430# a_23525_5394# VDD.t68 sg13_lv_pmos ad=0.1938p pd=1.4u as=0.1938p ps=1.4u w=1.02u l=0.13u
X1160 VSS.t404 a_24785_15824# a_24717_15898# VSS.t403 sg13_lv_nmos ad=0.1672p pd=1.26u as=0.2992p ps=2.44u w=0.88u l=0.13u
X1161 VDD.t1144 DFFQX1_0.Q a_6997_16182# VDD.t0 sg13_lv_pmos ad=0.2412p pd=1.73u as=0.1632p ps=1.64u w=0.48u l=0.13u
X1162 VDD.t143 a_27741_16182# VDD.t142 VDD.t0 sg13_lv_pmos ad=0.1938p pd=1.4u as=0 ps=0 w=1.02u l=5.575u
X1163 VDD.t1289 a_19681_14802# OR3BX1_0.B VDD.t5 sg13_lv_pmos ad=0.2412p pd=1.73u as=0.4488p ps=3.32u w=1.32u l=0.13u
X1164 VDD.t823 a_20769_6774# VDD.t822 VDD.t39 sg13_lv_pmos ad=0.3468p pd=2.72u as=0 ps=0 w=1.02u l=5.575u
X1165 a_18803_15170# a_18665_15244# VSS.t139 VSS.t1730 sg13_lv_nmos ad=0.102p pd=1.28u as=0.22785p ps=1.9u w=0.3u l=0.13u
X1166 VSS.t60 a_8492_5094# a_8424_5180# VSS.t696 sg13_lv_nmos ad=0.2176p pd=1.96u as=0.2176p ps=1.96u w=0.64u l=0.76u
X1167 VSS.t1491 a_13025_12114# VSS.t365 VSS.t1490 sg13_lv_nmos ad=0.1672p pd=1.26u as=0 ps=0 w=0.88u l=5.575u
X1168 VDD.t1523 a_20181_2742# a_20249_2706# VDD.t354 sg13_lv_pmos ad=0.1938p pd=1.4u as=0.1938p ps=1.4u w=1.02u l=0.13u
X1169 VSS.t455 a_31337_6738# VSS.t453 VSS.t1089 sg13_lv_nmos ad=0.1672p pd=1.26u as=0 ps=0 w=0.88u l=5.575u
X1170 VSS.t293 a_5129_16146# a_5061_16182# VSS.t292 sg13_lv_nmos ad=0.1738p pd=1.275u as=0.2992p ps=2.44u w=0.88u l=0.13u
X1171 a_18401_13458# a_18333_13494# VDD.t1671 VDD.t100 sg13_lv_pmos ad=0.3468p pd=2.72u as=0.20145p ps=1.415u w=1.02u l=0.13u
X1172 VDD.t141 a_27741_16182# VDD.t140 VDD.t0 sg13_lv_pmos ad=0.3468p pd=2.72u as=0 ps=0 w=1.02u l=5.575u
X1173 VDD.t1563 a_32529_16182# VDD.t1562 VDD.t0 sg13_lv_pmos ad=0.3468p pd=2.72u as=0 ps=0 w=1.02u l=5.305u
X1174 a_1029_12150# a_1097_12114# VSS.t922 VSS.t1315 sg13_lv_nmos ad=0.2992p pd=2.44u as=0.1672p ps=1.26u w=0.88u l=0.13u
X1175 a_26213_6738# a_26145_6774# VDD.t233 VDD.t39 sg13_lv_pmos ad=0.3468p pd=2.72u as=0.20145p ps=1.415u w=1.02u l=0.13u
X1176 a_24365_16146# a_24297_16182# VDD.t1248 VDD.t0 sg13_lv_pmos ad=0.1938p pd=1.4u as=0.1938p ps=1.4u w=1.02u l=0.13u
X1177 VSS.t143 a_11849_6416# a_11781_6490# VSS.t1763 sg13_lv_nmos ad=0.1672p pd=1.26u as=0.2992p ps=2.44u w=0.88u l=0.13u
X1178 VSS.t11 a_36716_16160# a_36648_16196# VSS.t10 sg13_lv_nmos ad=0.2176p pd=1.96u as=0.2176p ps=1.96u w=0.64u l=0.76u
X1179 VSS.t1044 a_20837_5394# VSS.t1327 VSS.t1778 sg13_lv_nmos ad=0.1672p pd=1.26u as=0 ps=0 w=0.88u l=5.575u
X1180 VSS.t262 a_22349_13136# VSS.t1411 VSS.t1444 sg13_lv_nmos ad=0.1738p pd=1.275u as=0 ps=0 w=0.88u l=5.305u
X1181 VDD.t318 a_32529_6490# VDD.t317 VDD.t68 sg13_lv_pmos ad=0.3468p pd=2.72u as=0 ps=0 w=1.02u l=5.575u
X1182 VSS.t34 a_32597_9104# VSS.t38 VSS.t37 sg13_lv_nmos ad=0.1672p pd=1.26u as=0 ps=0 w=0.88u l=5.575u
X1183 counter_value_o[3] a_17077_16182# VDD.t597 VDD.t0 sg13_lv_pmos ad=0.4488p pd=3.32u as=0.2412p ps=1.73u w=1.32u l=0.13u
X1184 a_23965_15474# DFFQX1_7.Q VSS.t107 VSS.t1401 sg13_lv_nmos ad=0.102p pd=1.28u as=0.1567p ps=1.27u w=0.3u l=0.13u
X1185 VSS.t190 a_14537_6416# VSS.t192 VSS.t191 sg13_lv_nmos ad=0.1738p pd=1.275u as=0 ps=0 w=0.88u l=5.305u
X1186 a_34025_8082# a_33957_8118# VDD.t346 VDD.t29 sg13_lv_pmos ad=0.3468p pd=2.72u as=0.20145p ps=1.415u w=1.02u l=0.13u
X1187 VDD.t106 a_11781_14554# VDD.t104 VDD.t100 sg13_lv_pmos ad=0.1938p pd=1.4u as=0 ps=0 w=1.02u l=5.575u
X1188 VSS.t702 a_16973_13136# VSS.t700 VSS.t703 sg13_lv_nmos ad=0.1672p pd=1.26u as=0 ps=0 w=0.88u l=5.575u
X1189 VSS.t20 a_37973_10448# a_37905_10522# VSS.t19 sg13_lv_nmos ad=0.1738p pd=1.275u as=0.2992p ps=2.44u w=0.88u l=0.13u
X1190 BUFX3_29.A AOI21BX2_1.A a_21391_15175# VDD.t5 sg13_lv_pmos ad=0.1862p pd=1.36u as=0.1862p ps=1.36u w=0.98u l=0.13u
X1191 VDD.t1020 a_27153_13494# VDD.t1019 VDD.t100 sg13_lv_pmos ad=0.3468p pd=2.72u as=0 ps=0 w=1.02u l=1.945u
X1192 VSS.t468 a_31337_8082# a_31269_8118# VSS.t1821 sg13_lv_nmos ad=0.1672p pd=1.26u as=0.2992p ps=2.44u w=0.88u l=0.13u
X1193 a_34025_12114# a_33957_12150# VDD.t1421 VDD.t93 sg13_lv_pmos ad=0.3468p pd=2.72u as=0.20145p ps=1.415u w=1.02u l=0.13u
X1194 VDD.t1006 a_5145_4086# a_5213_4050# VDD.t83 sg13_lv_pmos ad=0.1938p pd=1.4u as=0.1938p ps=1.4u w=1.02u l=0.13u
X1195 a_30497_16146# a_30429_16182# VDD.t985 VDD.t0 sg13_lv_pmos ad=0.3468p pd=2.72u as=0.20145p ps=1.415u w=1.02u l=0.13u
X1196 VDD.t102 a_11781_14554# VDD.t101 VDD.t100 sg13_lv_pmos ad=0.3468p pd=2.72u as=0 ps=0 w=1.02u l=5.575u
X1197 VSS.t381 a_3517_15682# a_3441_15952# VSS.t1248 sg13_lv_nmos ad=57f pd=0.68u as=57f ps=0.68u w=0.3u l=0.13u
X1198 a_7833_5430# a_7901_5394# VSS.t64 VSS.t741 sg13_lv_nmos ad=0.2992p pd=2.44u as=0.1672p ps=1.26u w=0.88u l=0.13u
X1199 VSS.t231 a_10589_4050# VSS.t229 VSS.t230 sg13_lv_nmos ad=0.1738p pd=1.275u as=0 ps=0 w=0.88u l=5.305u
X1200 VDD.t1838 a_7749_13210# VDD.t1837 VDD.t93 sg13_lv_pmos ad=0.3468p pd=2.72u as=0 ps=0 w=1.02u l=1.945u
X1201 a_32529_15898# a_32597_15824# VSS.t11 VSS.t1748 sg13_lv_nmos ad=0.2992p pd=2.44u as=0.1672p ps=1.26u w=0.88u l=0.13u
X1202 VDD.t854 a_24717_11866# VDD.t853 VDD.t281 sg13_lv_pmos ad=0.1938p pd=1.4u as=0 ps=0 w=1.02u l=5.575u
X1203 VSS.t45 a_34025_8082# VSS.t43 VSS.t1081 sg13_lv_nmos ad=0.1738p pd=1.275u as=0 ps=0 w=0.88u l=5.305u
X1204 a_13109_16146# a_13041_16182# VDD.t1039 VDD.t0 sg13_lv_pmos ad=0.1938p pd=1.4u as=0.1938p ps=1.4u w=1.02u l=0.13u
X1205 a_9395_15170# a_9257_15244# VSS.t1 VSS.t1794 sg13_lv_nmos ad=0.102p pd=1.28u as=0.22785p ps=1.9u w=0.3u l=0.13u
X1206 VSS.t165 a_3785_8082# a_3717_8118# VSS.t557 sg13_lv_nmos ad=0.1738p pd=1.275u as=0.2992p ps=2.44u w=0.88u l=0.13u
X1207 VSS.t441 a_15713_4050# VSS.t336 VSS.t866 sg13_lv_nmos ad=0.1672p pd=1.26u as=0 ps=0 w=0.88u l=5.575u
X1208 a_11849_3728# a_11781_3802# VDD.t1659 VDD.t354 sg13_lv_pmos ad=0.1938p pd=1.4u as=0.1938p ps=1.4u w=1.02u l=0.13u
X1209 a_3517_15682# a_3325_15532# a_3645_15952# VSS.t1113 sg13_lv_nmos ad=57f pd=0.68u as=27f ps=0.48u w=0.3u l=0.13u
X1210 VSS.t1 a_9161_14480# VSS.t3 VSS.t2 sg13_lv_nmos ad=0.1672p pd=1.26u as=0 ps=0 w=0.88u l=5.575u
X1211 VDD.t1132 a_23965_15474# BUFX3_27.A VDD.t5 sg13_lv_pmos ad=0.2412p pd=1.73u as=0.4488p ps=3.32u w=1.32u l=0.13u
X1212 a_21705_14180# OR3X1_1.B a_21619_14180# VDD.t100 sg13_lv_pmos ad=86.39999f pd=0.84u as=71.99999f ps=0.78u w=0.48u l=0.13u
X1213 VDD.t1550 a_31269_13494# a_31337_13458# VDD.t100 sg13_lv_pmos ad=0.1938p pd=1.4u as=0.1938p ps=1.4u w=1.02u l=0.13u
X1214 VDD.t852 a_24717_11866# VDD.t851 VDD.t281 sg13_lv_pmos ad=0.3468p pd=2.72u as=0 ps=0 w=1.02u l=5.575u
X1215 VSS.t60 a_7901_5394# VSS.t197 VSS.t742 sg13_lv_nmos ad=0.1672p pd=1.26u as=0 ps=0 w=0.88u l=5.575u
X1216 VSS.t338 a_27473_13136# VSS.t340 VSS.t339 sg13_lv_nmos ad=0.1672p pd=1.26u as=0 ps=0 w=0.88u l=5.575u
X1217 VSS.t514 a_35285_11792# a_35217_11866# VSS.t516 sg13_lv_nmos ad=0.1672p pd=1.26u as=0.2992p ps=2.44u w=0.88u l=0.13u
X1218 a_32597_15824# a_32529_15898# VDD.t312 VDD.t5 sg13_lv_pmos ad=0.1938p pd=1.4u as=0.1938p ps=1.4u w=1.02u l=0.13u
X1219 a_37973_14480# a_37905_14554# VDD.t1638 VDD.t100 sg13_lv_pmos ad=0.3468p pd=2.72u as=0.20145p ps=1.415u w=1.02u l=0.13u
X1220 VSS.t251 a_37805_4050# VSS.t251 VSS.t250 sg13_lv_nmos ad=0.1738p pd=1.275u as=0 ps=0 w=0.88u l=1.945u
X1221 a_3785_7760# a_3717_7834# VDD.t203 VDD.t39 sg13_lv_pmos ad=0.1938p pd=1.4u as=0.1938p ps=1.4u w=1.02u l=0.13u
X1222 VSS.t241 a_15713_13458# a_15645_13494# VSS.t801 sg13_lv_nmos ad=0.1672p pd=1.26u as=0.2992p ps=2.44u w=0.88u l=0.13u
X1223 a_30161_13136# a_30093_13210# VDD.t1958 VDD.t93 sg13_lv_pmos ad=0.3468p pd=2.72u as=0.20145p ps=1.415u w=1.02u l=0.13u
X1224 VDD.t254 a_20769_5430# VDD.t253 VDD.t68 sg13_lv_pmos ad=0.3468p pd=2.72u as=0 ps=0 w=1.02u l=5.575u
X1225 VDD.t150 a_3717_9178# VDD.t151 VDD.t29 sg13_lv_pmos ad=0.3468p pd=2.72u as=0 ps=0 w=1.02u l=5.575u
X1226 a_3785_16146# a_3717_16182# VDD.t1260 VDD.t0 sg13_lv_pmos ad=0.3468p pd=2.72u as=0.20145p ps=1.415u w=1.02u l=0.13u
X1227 VDD.t961 a_35301_14838# VDD.t960 VDD.t5 sg13_lv_pmos ad=0.3468p pd=2.72u as=0 ps=0 w=1.02u l=1.945u
X1228 a_18343_15660# a_18165_15510# VDD.t180 VDD.t5 sg13_lv_pmos ad=91.2f pd=0.86u as=0.1632p ps=1.64u w=0.48u l=0.13u
X1229 a_38648_15846# a_38580_15932# VDD.t1468 VDD.t5 sg13_lv_pmos ad=0.3332p pd=2.64u as=0.3332p ps=2.64u w=0.98u l=0.76u
X1230 a_8265_16258# NAND4X2_0.C BUFX3_4.A VSS.t1428 sg13_lv_nmos ad=0.102p pd=1.28u as=58.5f ps=0.69u w=0.3u l=0.13u
X1231 VSS.t998 a_27557_12114# a_27489_12150# VSS.t1700 sg13_lv_nmos ad=0.1738p pd=1.275u as=0.2992p ps=2.44u w=0.88u l=0.13u
X1232 VSS.t222 a_15881_5072# a_15813_5146# VSS.t1041 sg13_lv_nmos ad=0.1738p pd=1.275u as=0.2992p ps=2.44u w=0.88u l=0.13u
X1233 a_23171_15532# a_23033_15572# VSS.t1399 VSS.t1471 sg13_lv_nmos ad=0.102p pd=1.28u as=0.22785p ps=1.9u w=0.3u l=0.13u
X1234 VSS.t735 a_24785_6416# VSS.t737 VSS.t736 sg13_lv_nmos ad=0.1672p pd=1.26u as=0 ps=0 w=0.88u l=5.575u
X1235 VDD.t1149 a_5061_16182# VDD.t1147 VDD.t0 sg13_lv_pmos ad=0.3468p pd=2.72u as=0 ps=0 w=1.02u l=1.945u
X1236 a_3785_2706# a_3717_2742# VDD.t935 VDD.t354 sg13_lv_pmos ad=0.3468p pd=2.72u as=0.20145p ps=1.415u w=1.02u l=0.13u
X1237 a_26213_5394# a_26145_5430# VDD.t77 VDD.t68 sg13_lv_pmos ad=0.3468p pd=2.72u as=0.20145p ps=1.415u w=1.02u l=0.13u
X1238 VDD.t157 a_16905_9178# a_16973_9104# VDD.t29 sg13_lv_pmos ad=0.1938p pd=1.4u as=0.1938p ps=1.4u w=1.02u l=0.13u
X1239 VDD.t957 a_22751_15170# a_22715_15244# VDD.t5 sg13_lv_pmos ad=0.2529p pd=1.545u as=43.2f ps=0.66u w=0.48u l=0.13u
X1240 VDD.t689 a_31437_5146# VDD.t688 VDD.t83 sg13_lv_pmos ad=0.3468p pd=2.72u as=0 ps=0 w=1.02u l=1.945u
X1241 VDD.t1032 a_22803_15536# a_22767_15572# VDD.t5 sg13_lv_pmos ad=91.2f pd=0.86u as=43.2f ps=0.66u w=0.48u l=0.13u
X1242 a_32597_3728# a_32529_3802# VDD.t543 VDD.t354 sg13_lv_pmos ad=0.1938p pd=1.4u as=0.1938p ps=1.4u w=1.02u l=0.13u
X1243 VSS.t254 a_27557_4050# a_27489_4086# VSS.t253 sg13_lv_nmos ad=0.1738p pd=1.275u as=0.2992p ps=2.44u w=0.88u l=0.13u
X1244 VSS.t328 a_23525_5394# a_23457_5430# VSS.t327 sg13_lv_nmos ad=0.1672p pd=1.26u as=0.2992p ps=2.44u w=0.88u l=0.13u
X1245 VSS.t154 a_22350_16146# BUFX3_31.A VSS.t399 sg13_lv_nmos ad=0.1193p pd=1.05u as=0.2176p ps=1.96u w=0.64u l=0.13u
X1246 a_27557_6738# a_27489_6774# VDD.t236 VDD.t39 sg13_lv_pmos ad=0.3468p pd=2.72u as=0.20145p ps=1.415u w=1.02u l=0.13u
X1247 VSS.t444 a_37805_14802# VSS.t444 VSS.t443 sg13_lv_nmos ad=0.1738p pd=1.275u as=0 ps=0 w=0.88u l=1.945u
X1248 a_7833_12150# a_7901_12114# VSS.t345 VSS.t1583 sg13_lv_nmos ad=0.2992p pd=2.44u as=0.1672p ps=1.26u w=0.88u l=0.13u
X1249 VSS.t1100 a_31337_12114# a_31269_12150# VSS.t1447 sg13_lv_nmos ad=0.1672p pd=1.26u as=0.2992p ps=2.44u w=0.88u l=0.13u
X1250 VSS.t36 a_35285_9104# a_35217_9178# VSS.t1062 sg13_lv_nmos ad=0.1672p pd=1.26u as=0.2992p ps=2.44u w=0.88u l=0.13u
X1251 a_4053_10522# a_4121_10448# VSS.t581 VSS.t973 sg13_lv_nmos ad=0.2992p pd=2.44u as=0.1672p ps=1.26u w=0.88u l=0.13u
X1252 a_1097_2706# a_1029_2742# VDD.t1726 VDD.t354 sg13_lv_pmos ad=0.1938p pd=1.4u as=0.1938p ps=1.4u w=1.02u l=0.13u
X1253 VSS.t383 a_4373_15824# a_4305_15898# VSS.t1235 sg13_lv_nmos ad=0.1738p pd=1.275u as=0.2992p ps=2.44u w=0.88u l=0.13u
X1254 VDD.t1405 a_3717_13210# a_3785_13136# VDD.t93 sg13_lv_pmos ad=0.1938p pd=1.4u as=0.1938p ps=1.4u w=1.02u l=0.13u
X1255 a_8492_11814# a_8424_11900# VDD.t1580 VDD.t281 sg13_lv_pmos ad=0.3332p pd=2.64u as=0.3332p ps=2.64u w=0.98u l=0.76u
X1256 VDD.t1062 OA21X2_1.Y a_22613_16650# VDD.t0 sg13_lv_pmos ad=0.1632p pd=1.64u as=43.2f ps=0.66u w=0.48u l=0.13u
X1257 a_27473_13136# a_27405_13210# VDD.t534 VDD.t93 sg13_lv_pmos ad=0.1938p pd=1.4u as=0.1938p ps=1.4u w=1.02u l=0.13u
X1258 VDD.t1521 a_20181_2742# VDD.t1520 VDD.t354 sg13_lv_pmos ad=0.3468p pd=2.72u as=0 ps=0 w=1.02u l=5.575u
X1259 VSS.t297 a_31337_6738# a_31269_6774# VSS.t1087 sg13_lv_nmos ad=0.1672p pd=1.26u as=0.2992p ps=2.44u w=0.88u l=0.13u
X1260 AND2X1_2.B a_7669_16182# VSS.t94 VSS.t1227 sg13_lv_nmos ad=0.2924p pd=2.4u as=0.1567p ps=1.27u w=0.86u l=0.13u
X1261 a_1029_5146# a_1097_5072# VSS.t53 VSS.t436 sg13_lv_nmos ad=0.2992p pd=2.44u as=0.1672p ps=1.26u w=0.88u l=0.13u
X1262 VDD.t858 a_22281_10522# VDD.t857 VDD.t8 sg13_lv_pmos ad=0.3468p pd=2.72u as=0 ps=0 w=1.02u l=5.305u
X1263 BUFX3_2.Y a_18085_14166# VSS.t101 VSS.t1124 sg13_lv_nmos ad=0.2924p pd=2.4u as=0.1567p ps=1.27u w=0.86u l=0.13u
X1264 a_24297_16182# a_24365_16146# VSS.t1240 VSS.t1239 sg13_lv_nmos ad=0.2992p pd=2.44u as=0.1672p ps=1.26u w=0.88u l=0.13u
X1265 VSS.t661 a_12714_15510# BUFX24_2.A VSS.t1142 sg13_lv_nmos ad=0.1634p pd=1.24u as=0.1634p ps=1.24u w=0.86u l=0.13u
X1266 a_38480_14816# a_38412_14852# VDD.t1687 VDD.t5 sg13_lv_pmos ad=0.3332p pd=2.64u as=0.3332p ps=2.64u w=0.98u l=0.76u
X1267 a_38480_4064# a_38412_4100# VDD.t1570 VDD.t83 sg13_lv_pmos ad=0.3332p pd=2.64u as=0.3332p ps=2.64u w=0.98u l=0.76u
X1268 VSS.t475 a_1097_6416# VSS.t475 VSS.t729 sg13_lv_nmos ad=0.1672p pd=1.26u as=0 ps=0 w=0.88u l=5.575u
X1269 VDD.t565 a_27405_9178# VDD.t562 VDD.t29 sg13_lv_pmos ad=0.1938p pd=1.4u as=0 ps=0 w=1.02u l=5.575u
X1270 a_5804_16160# a_5736_16196# VDD.t1204 VDD.t0 sg13_lv_pmos ad=0.3332p pd=2.64u as=0.3332p ps=2.64u w=0.98u l=0.76u
X1271 a_22865_14228# a_22029_14280# a_22635_14192# VDD.t100 sg13_lv_pmos ad=91.2f pd=0.86u as=91.2f ps=0.86u w=0.48u l=0.13u
X1272 VSS.t179 a_22349_7760# a_22281_7834# VSS.t372 sg13_lv_nmos ad=0.1738p pd=1.275u as=0.2992p ps=2.44u w=0.88u l=0.13u
X1273 VDD.t1057 a_11781_9178# VDD.t1058 VDD.t29 sg13_lv_pmos ad=0.3468p pd=2.72u as=0 ps=0 w=1.02u l=5.575u
X1274 VSS.t457 a_34025_6738# VSS.t455 VSS.t1331 sg13_lv_nmos ad=0.1738p pd=1.275u as=0 ps=0 w=0.88u l=5.305u
X1275 VSS.t124 a_19745_9426# a_19677_9462# VSS.t528 sg13_lv_nmos ad=0.1738p pd=1.275u as=0.2992p ps=2.44u w=0.88u l=0.13u
X1276 a_9674_15474# BUFX24_2.A VDD.t1273 VDD.t5 sg13_lv_pmos ad=0.4488p pd=3.32u as=0.2508p ps=1.7u w=1.32u l=0.13u
X1277 VDD.t11 a_9093_10522# a_9161_10448# VDD.t8 sg13_lv_pmos ad=0.1938p pd=1.4u as=0.1938p ps=1.4u w=1.02u l=0.13u
X1278 VSS.t475 a_3785_6738# a_3717_6774# VSS.t476 sg13_lv_nmos ad=0.1738p pd=1.275u as=0.2992p ps=2.44u w=0.88u l=0.13u
X1279 BUFX3_26.Y a_6493_14838# VSS.t76 VSS.t75 sg13_lv_nmos ad=0.2924p pd=2.4u as=0.1567p ps=1.27u w=0.86u l=0.13u
X1280 VDD.t922 a_15645_4086# a_15713_4050# VDD.t83 sg13_lv_pmos ad=0.1938p pd=1.4u as=0.1938p ps=1.4u w=1.02u l=0.13u
X1281 VSS.t821 a_28649_10770# a_28581_10806# VSS.t1452 sg13_lv_nmos ad=0.1672p pd=1.26u as=0.2992p ps=2.44u w=0.88u l=0.13u
X1282 OR3X1_1.Y a_22197_13608# VDD.t548 VDD.t100 sg13_lv_pmos ad=0.1632p pd=1.64u as=0.108p ps=0.93u w=0.48u l=0.13u
X1283 VDD.t459 a_23457_4086# VDD.t460 VDD.t83 sg13_lv_pmos ad=0.1938p pd=1.4u as=0 ps=0 w=1.02u l=5.575u
X1284 VSS.t752 a_13025_4050# a_12957_4086# VSS.t943 sg13_lv_nmos ad=0.1672p pd=1.26u as=0.2992p ps=2.44u w=0.88u l=0.13u
X1285 a_3785_9426# a_3717_9462# VDD.t1045 VDD.t8 sg13_lv_pmos ad=0.3468p pd=2.72u as=0.20145p ps=1.415u w=1.02u l=0.13u
X1286 VDD.t1185 a_9674_15474# DFFQX1_3.CK VDD.t5 sg13_lv_pmos ad=0.2508p pd=1.7u as=0.4488p ps=3.32u w=1.32u l=0.13u
X1287 a_6473_7760# a_6405_7834# VDD.t662 VDD.t39 sg13_lv_pmos ad=0.3468p pd=2.72u as=0.20145p ps=1.415u w=1.02u l=0.13u
X1288 a_3717_5146# a_3785_5072# VSS.t57 VSS.t58 sg13_lv_nmos ad=0.2992p pd=2.44u as=0.1672p ps=1.26u w=0.88u l=0.13u
X1289 VDD.t1428 a_37905_13210# VDD.t1427 VDD.t93 sg13_lv_pmos ad=0.3468p pd=2.72u as=0 ps=0 w=1.02u l=1.945u
X1290 a_20837_12114# a_20769_12150# VDD.t1966 VDD.t93 sg13_lv_pmos ad=0.1938p pd=1.4u as=0.1938p ps=1.4u w=1.02u l=0.13u
X1291 VSS.t62 a_11849_5072# VSS.t216 VSS.t215 sg13_lv_nmos ad=0.1672p pd=1.26u as=0 ps=0 w=0.88u l=5.575u
X1292 VSS.t474 a_3785_6416# VSS.t478 VSS.t477 sg13_lv_nmos ad=0.1672p pd=1.26u as=0 ps=0 w=0.88u l=5.575u
X1293 VDD.t1438 a_15645_13494# VDD.t1437 VDD.t100 sg13_lv_pmos ad=0.3468p pd=2.72u as=0 ps=0 w=1.02u l=5.575u
X1294 VDD.t1413 a_8841_2742# a_8909_2706# VDD.t354 sg13_lv_pmos ad=0.1938p pd=1.4u as=0.1938p ps=1.4u w=1.02u l=0.13u
X1295 VDD.t1399 a_36393_6774# VDD.t1398 VDD.t39 sg13_lv_pmos ad=0.3468p pd=2.72u as=0 ps=0 w=1.02u l=5.305u
X1296 VDD.t1517 a_1029_13210# VDD.t1516 VDD.t93 sg13_lv_pmos ad=0.1938p pd=1.4u as=0 ps=0 w=1.02u l=5.575u
X1297 a_1097_9426# a_1029_9462# VDD.t1086 VDD.t8 sg13_lv_pmos ad=0.1938p pd=1.4u as=0.1938p ps=1.4u w=1.02u l=0.13u
X1298 VSS.t115 a_27809_16146# VSS.t113 VSS.t899 sg13_lv_nmos ad=0.1672p pd=1.26u as=0 ps=0 w=0.88u l=5.575u
X1299 a_23461_14130# BUFX3_28.A VSS.t264 VSS.t1614 sg13_lv_nmos ad=0.102p pd=1.28u as=0.1567p ps=1.27u w=0.3u l=0.13u
X1300 VDD.t485 a_27489_12150# VDD.t484 VDD.t93 sg13_lv_pmos ad=0.3468p pd=2.72u as=0 ps=0 w=1.02u l=1.945u
X1301 VDD.t1539 a_35217_3802# VDD.t1538 VDD.t354 sg13_lv_pmos ad=0.1938p pd=1.4u as=0 ps=0 w=1.02u l=5.575u
X1302 DFFQX1_3.CK a_9674_15474# VDD.t1191 VDD.t5 sg13_lv_pmos ad=0.2508p pd=1.7u as=0.2508p ps=1.7u w=1.32u l=0.13u
X1303 VDD.t1146 BUFX3_2.A a_18085_14166# VDD.t100 sg13_lv_pmos ad=0.2412p pd=1.73u as=0.1632p ps=1.64u w=0.48u l=0.13u
X1304 a_23033_15572# a_22399_15524# a_22803_15536# VSS.t1231 sg13_lv_nmos ad=57f pd=0.68u as=57f ps=0.68u w=0.3u l=0.13u
X1305 VSS.t771 a_23525_4050# VSS.t769 VSS.t833 sg13_lv_nmos ad=0.1672p pd=1.26u as=0 ps=0 w=0.88u l=5.575u
X1306 VSS.t481 a_27473_6416# a_27405_6490# VSS.t480 sg13_lv_nmos ad=0.1672p pd=1.26u as=0.2992p ps=2.44u w=0.88u l=0.13u
X1307 a_9093_5146# a_9161_5072# VSS.t62 VSS.t61 sg13_lv_nmos ad=0.2992p pd=2.44u as=0.1672p ps=1.26u w=0.88u l=0.13u
X1308 VSS.t262 NOR3X1_0.C NOR3X1_0.Y VSS.t1129 sg13_lv_nmos ad=57f pd=0.68u as=0.102p ps=1.28u w=0.3u l=0.13u
X1309 VSS.t113 a_27473_15824# a_27405_15898# VSS.t112 sg13_lv_nmos ad=0.1672p pd=1.26u as=0.2992p ps=2.44u w=0.88u l=0.13u
X1310 VSS.t141 a_9161_6416# VSS.t143 VSS.t187 sg13_lv_nmos ad=0.1672p pd=1.26u as=0 ps=0 w=0.88u l=5.575u
X1311 VDD.t705 a_27489_4086# VDD.t703 VDD.t83 sg13_lv_pmos ad=0.3468p pd=2.72u as=0 ps=0 w=1.02u l=1.945u
X1312 VSS.t1399 a_23171_15532# a_23147_15952# VSS.t1400 sg13_lv_nmos ad=0.1519p pd=1.265u as=27f ps=0.48u w=0.3u l=0.13u
X1313 VDD.t163 OR3BX1_0.B NAND2X1_1.Y VDD.t100 sg13_lv_pmos ad=0.1632p pd=1.64u as=91.2f ps=0.86u w=0.48u l=0.13u
X1314 a_27557_5394# a_27489_5430# VDD.t1899 VDD.t68 sg13_lv_pmos ad=0.3468p pd=2.72u as=0.20145p ps=1.415u w=1.02u l=0.13u
X1315 a_19179_14852# OR3X1_1.B VSS.t139 VSS.t390 sg13_lv_nmos ad=57f pd=0.68u as=57f ps=0.68u w=0.3u l=0.13u
X1316 VSS.t1513 a_32597_13136# VSS.t1549 VSS.t1548 sg13_lv_nmos ad=0.1672p pd=1.26u as=0 ps=0 w=0.88u l=5.575u
X1317 VDD.t95 a_31269_12150# VDD.t94 VDD.t93 sg13_lv_pmos ad=0.3468p pd=2.72u as=0 ps=0 w=1.02u l=5.575u
X1318 VSS.t451 a_4460_9440# a_4392_9476# VSS.t450 sg13_lv_nmos ad=0.2176p pd=1.96u as=0.2176p ps=1.96u w=0.64u l=0.76u
X1319 DFFQX1_5.CK a_15318_15510# VDD.t1162 VDD.t5 sg13_lv_pmos ad=0.2508p pd=1.7u as=0.2508p ps=1.7u w=1.32u l=0.13u
X1320 VSS.t87 a_7901_9426# a_7833_9462# VSS.t86 sg13_lv_nmos ad=0.1672p pd=1.26u as=0.2992p ps=2.44u w=0.88u l=0.13u
X1321 a_31269_10806# a_31337_10770# VSS.t268 VSS.t758 sg13_lv_nmos ad=0.2992p pd=2.44u as=0.1672p ps=1.26u w=0.88u l=0.13u
X1322 a_27405_10522# a_27473_10448# VSS.t819 VSS.t818 sg13_lv_nmos ad=0.2992p pd=2.44u as=0.1672p ps=1.26u w=0.88u l=0.13u
X1323 a_3785_14480# a_3717_14554# VDD.t1777 VDD.t100 sg13_lv_pmos ad=0.1938p pd=1.4u as=0.1938p ps=1.4u w=1.02u l=0.13u
X1324 a_8422_15932# NAND4X2_0.C a_8320_15932# VSS.t1429 sg13_lv_nmos ad=0.1216p pd=1.02u as=0.1216p ps=1.02u w=0.64u l=0.13u
X1325 VDD.t1166 clock_i a_12714_15510# VDD.t5 sg13_lv_pmos ad=0.2508p pd=1.7u as=0.2508p ps=1.7u w=1.32u l=0.13u
X1326 VSS.t251 a_36461_4050# VSS.t251 VSS.t250 sg13_lv_nmos ad=0.1738p pd=1.275u as=0 ps=0 w=0.88u l=5.305u
X1327 DFFQX1_4.Q a_17459_15170# VSS.t904 VSS.t903 sg13_lv_nmos ad=0.102p pd=1.28u as=0.1519p ps=1.265u w=0.3u l=0.13u
X1328 VDD.t1568 a_22281_3802# VDD.t1567 VDD.t354 sg13_lv_pmos ad=0.3468p pd=2.72u as=0 ps=0 w=1.02u l=5.305u
X1329 VDD.t1611 a_32529_14554# VDD.t1610 VDD.t100 sg13_lv_pmos ad=0.3468p pd=2.72u as=0 ps=0 w=1.02u l=5.575u
X1330 a_11933_12114# a_11865_12150# VDD.t1477 VDD.t93 sg13_lv_pmos ad=0.3468p pd=2.72u as=0.20145p ps=1.415u w=1.02u l=0.13u
X1331 VDD.t209 a_15813_7834# VDD.t208 VDD.t39 sg13_lv_pmos ad=0.3468p pd=2.72u as=0 ps=0 w=1.02u l=1.945u
X1332 VSS.t121 a_15713_9426# VSS.t31 VSS.t1800 sg13_lv_nmos ad=0.1672p pd=1.26u as=0 ps=0 w=0.88u l=5.575u
X1333 VSS.t45 a_35285_7760# VSS.t97 VSS.t98 sg13_lv_nmos ad=0.1672p pd=1.26u as=0 ps=0 w=0.88u l=5.575u
X1334 VDD.t433 a_5313_15898# VDD.t432 VDD.t5 sg13_lv_pmos ad=0.3468p pd=2.72u as=0 ps=0 w=1.02u l=1.945u
X1335 a_16973_11792# a_16905_11866# VDD.t1621 VDD.t281 sg13_lv_pmos ad=0.1938p pd=1.4u as=0.1938p ps=1.4u w=1.02u l=0.13u
X1336 VSS.t508 a_11933_10770# VSS.t1503 VSS.t1504 sg13_lv_nmos ad=0.1738p pd=1.275u as=0 ps=0 w=0.88u l=1.945u
X1337 a_1029_14554# a_1097_14480# VSS.t81 VSS.t1712 sg13_lv_nmos ad=0.2992p pd=2.44u as=0.1672p ps=1.26u w=0.88u l=0.13u
X1338 VDD.t295 a_19677_9462# VDD.t293 VDD.t8 sg13_lv_pmos ad=0.3468p pd=2.72u as=0 ps=0 w=1.02u l=1.945u
X1339 VSS.t60 a_9161_5072# a_9093_5146# VSS.t59 sg13_lv_nmos ad=0.1672p pd=1.26u as=0.2992p ps=2.44u w=0.88u l=0.13u
X1340 VSS.t131 a_31505_9104# a_31437_9178# VSS.t1061 sg13_lv_nmos ad=0.1738p pd=1.275u as=0.2992p ps=2.44u w=0.88u l=0.13u
X1341 VDD.t1139 OAI21X1_2.Y a_20857_15510# VDD.t5 sg13_lv_pmos ad=0.2412p pd=1.73u as=0.1632p ps=1.64u w=0.48u l=0.13u
X1342 VSS.t588 a_31505_13136# a_31437_13210# VSS.t753 sg13_lv_nmos ad=0.1738p pd=1.275u as=0.2992p ps=2.44u w=0.88u l=0.13u
X1343 VDD.t1805 a_1029_10806# a_1097_10770# VDD.t281 sg13_lv_pmos ad=0.1938p pd=1.4u as=0.1938p ps=1.4u w=1.02u l=0.13u
X1344 a_35217_6490# a_35285_6416# VSS.t50 VSS.t49 sg13_lv_nmos ad=0.2992p pd=2.44u as=0.1672p ps=1.26u w=0.88u l=0.13u
X1345 VSS.t338 a_27896_13472# a_27828_13508# VSS.t940 sg13_lv_nmos ad=0.2176p pd=1.96u as=0.2176p ps=1.96u w=0.64u l=0.76u
X1346 VDD.t977 a_12957_4086# VDD.t976 VDD.t83 sg13_lv_pmos ad=0.3468p pd=2.72u as=0 ps=0 w=1.02u l=5.575u
X1347 a_22245_15244# BUFX3_29.Y a_22183_15244# VDD.t5 sg13_lv_pmos ad=91.2f pd=0.86u as=43.2f ps=0.66u w=0.48u l=0.13u
X1348 VSS.t165 a_1097_8082# VSS.t165 VSS.t167 sg13_lv_nmos ad=0.1672p pd=1.26u as=0 ps=0 w=0.88u l=5.575u
X1349 a_12957_9462# a_13025_9426# VSS.t31 VSS.t32 sg13_lv_nmos ad=0.2992p pd=2.44u as=0.1672p ps=1.26u w=0.88u l=0.13u
X1350 VDD.t173 a_14469_14554# VDD.t172 VDD.t100 sg13_lv_pmos ad=0.3468p pd=2.72u as=0 ps=0 w=1.02u l=5.305u
X1351 a_24717_11866# a_24785_11792# VSS.t998 VSS.t1404 sg13_lv_nmos ad=0.2992p pd=2.44u as=0.1672p ps=1.26u w=0.88u l=0.13u
X1352 VDD.t1331 a_16905_5146# VDD.t1330 VDD.t83 sg13_lv_pmos ad=0.3468p pd=2.72u as=0 ps=0 w=1.02u l=5.575u
X1353 VSS.t325 a_16973_5072# VSS.t200 VSS.t1320 sg13_lv_nmos ad=0.1672p pd=1.26u as=0 ps=0 w=0.88u l=5.575u
X1354 VSS.t799 a_36461_13458# a_36393_13494# VSS.t798 sg13_lv_nmos ad=0.1738p pd=1.275u as=0.2992p ps=2.44u w=0.88u l=0.13u
X1355 VSS.t752 a_11933_4050# VSS.t231 VSS.t751 sg13_lv_nmos ad=0.1738p pd=1.275u as=0 ps=0 w=0.88u l=1.945u
X1356 a_38732_2720# a_38664_2756# VDD.t1686 VDD.t354 sg13_lv_pmos ad=0.3332p pd=2.64u as=0.3332p ps=2.64u w=0.98u l=0.76u
X1357 VDD.t991 a_22383_15045# a_22347_15244# VDD.t5 sg13_lv_pmos ad=91.2f pd=0.86u as=43.2f ps=0.66u w=0.48u l=0.13u
X1358 VDD.t263 a_36393_5430# VDD.t262 VDD.t68 sg13_lv_pmos ad=0.3468p pd=2.72u as=0 ps=0 w=1.02u l=5.305u
X1359 VSS.t475 a_1097_6416# a_1029_6490# VSS.t726 sg13_lv_nmos ad=0.1672p pd=1.26u as=0.2992p ps=2.44u w=0.88u l=0.13u
X1360 VSS.t1308 a_27809_2706# a_27741_2742# VSS.t1479 sg13_lv_nmos ad=0.1672p pd=1.26u as=0.2992p ps=2.44u w=0.88u l=0.13u
X1361 a_38648_3750# a_38580_3836# VDD.t1609 VDD.t354 sg13_lv_pmos ad=0.3332p pd=2.64u as=0.3332p ps=2.64u w=0.98u l=0.76u
X1362 a_28649_12114# a_28581_12150# VDD.t1911 VDD.t93 sg13_lv_pmos ad=0.1938p pd=1.4u as=0.1938p ps=1.4u w=1.02u l=0.13u
X1363 VDD.t308 a_1029_9178# a_1097_9104# VDD.t29 sg13_lv_pmos ad=0.1938p pd=1.4u as=0.1938p ps=1.4u w=1.02u l=0.13u
X1364 VSS.t1605 a_11849_14480# VSS.t1603 VSS.t1606 sg13_lv_nmos ad=0.1672p pd=1.26u as=0 ps=0 w=0.88u l=5.575u
X1365 VSS.t81 a_1097_14802# VSS.t81 VSS.t1151 sg13_lv_nmos ad=0.1738p pd=1.275u as=0 ps=0 w=0.88u l=5.305u
X1366 VDD.t1527 a_27405_11866# VDD.t1526 VDD.t281 sg13_lv_pmos ad=0.3468p pd=2.72u as=0 ps=0 w=1.02u l=5.575u
X1367 VDD.t1212 a_23629_15474# BUFX3_38.Y VDD.t5 sg13_lv_pmos ad=0.2412p pd=1.73u as=0.4488p ps=3.32u w=1.32u l=0.13u
X1368 VDD.t781 a_9765_14838# VDD.t780 VDD.t5 sg13_lv_pmos ad=0.1938p pd=1.4u as=0 ps=0 w=1.02u l=5.575u
X1369 VDD.t776 a_11865_10806# VDD.t775 VDD.t281 sg13_lv_pmos ad=0.3468p pd=2.72u as=0 ps=0 w=1.02u l=1.945u
X1370 a_35285_15824# a_35217_15898# VDD.t1267 VDD.t5 sg13_lv_pmos ad=0.1938p pd=1.4u as=0.1938p ps=1.4u w=1.02u l=0.13u
X1371 VSS.t832 a_26213_4050# a_26145_4086# VSS.t1291 sg13_lv_nmos ad=0.1738p pd=1.275u as=0.2992p ps=2.44u w=0.88u l=0.13u
X1372 VSS.t702 a_18401_13458# a_18333_13494# VSS.t1494 sg13_lv_nmos ad=0.1738p pd=1.275u as=0.2992p ps=2.44u w=0.88u l=0.13u
X1373 a_15713_8082# a_15645_8118# VDD.t578 VDD.t29 sg13_lv_pmos ad=0.1938p pd=1.4u as=0.1938p ps=1.4u w=1.02u l=0.13u
X1374 VSS.t448 a_24617_14802# a_24549_14838# VSS.t1588 sg13_lv_nmos ad=0.1672p pd=1.26u as=0.2992p ps=2.44u w=0.88u l=0.13u
X1375 VSS.t67 a_35285_11792# VSS.t67 VSS.t66 sg13_lv_nmos ad=0.1672p pd=1.26u as=0 ps=0 w=0.88u l=5.575u
X1376 VSS.t983 a_27473_3728# VSS.t423 VSS.t985 sg13_lv_nmos ad=0.1672p pd=1.26u as=0 ps=0 w=0.88u l=5.575u
X1377 VSS.t328 a_20837_5394# VSS.t1044 VSS.t1779 sg13_lv_nmos ad=0.1672p pd=1.26u as=0 ps=0 w=0.88u l=5.575u
X1378 a_28649_9426# a_28581_9462# VDD.t791 VDD.t8 sg13_lv_pmos ad=0.1938p pd=1.4u as=0.1938p ps=1.4u w=1.02u l=0.13u
X1379 a_24049_16146# BUFX3_23.A VSS.t107 VSS.t1262 sg13_lv_nmos ad=0.102p pd=1.28u as=0.1567p ps=1.27u w=0.3u l=0.13u
X1380 VDD.t1092 a_7833_9462# VDD.t1091 VDD.t8 sg13_lv_pmos ad=0.3468p pd=2.72u as=0 ps=0 w=1.02u l=5.575u
X1381 VSS.t922 a_1097_11792# a_1029_11866# VSS.t1314 sg13_lv_nmos ad=0.1672p pd=1.26u as=0.2992p ps=2.44u w=0.88u l=0.13u
X1382 VSS.t698 a_16973_13136# a_16905_13210# VSS.t697 sg13_lv_nmos ad=0.1672p pd=1.26u as=0.2992p ps=2.44u w=0.88u l=0.13u
X1383 a_31269_4086# a_31337_4050# VSS.t778 VSS.t1350 sg13_lv_nmos ad=0.2992p pd=2.44u as=0.1672p ps=1.26u w=0.88u l=0.13u
X1384 VDD.t152 a_3717_9178# a_3785_9104# VDD.t29 sg13_lv_pmos ad=0.1938p pd=1.4u as=0.1938p ps=1.4u w=1.02u l=0.13u
X1385 DFFQX1_3.CK a_9674_15474# VSS.t608 VSS.t1169 sg13_lv_nmos ad=0.1634p pd=1.24u as=0.1634p ps=1.24u w=0.86u l=0.13u
X1386 VSS.t14 AOI21BX1_0.B a_18463_16014# VSS.t597 sg13_lv_nmos ad=0.117p pd=1.38u as=43.5f ps=0.59u w=0.3u l=0.13u
X1387 VDD.t1372 a_31269_6774# a_31337_6738# VDD.t39 sg13_lv_pmos ad=0.1938p pd=1.4u as=0.1938p ps=1.4u w=1.02u l=0.13u
X1388 a_27473_7760# a_27405_7834# VDD.t502 VDD.t39 sg13_lv_pmos ad=0.1938p pd=1.4u as=0.1938p ps=1.4u w=1.02u l=0.13u
X1389 VSS.t705 a_34025_12114# a_33957_12150# VSS.t1728 sg13_lv_nmos ad=0.1738p pd=1.275u as=0.2992p ps=2.44u w=0.88u l=0.13u
X1390 VSS.t126 a_18401_9426# a_18333_9462# VSS.t628 sg13_lv_nmos ad=0.1738p pd=1.275u as=0.2992p ps=2.44u w=0.88u l=0.13u
X1391 VDD.t561 a_27405_9178# VDD.t563 VDD.t29 sg13_lv_pmos ad=0.3468p pd=2.72u as=0 ps=0 w=1.02u l=5.575u
X1392 a_18589_16146# AOI21BX1_0.Y VDD.t1211 VDD.t0 sg13_lv_pmos ad=0.1632p pd=1.64u as=0.2412p ps=1.73u w=0.48u l=0.13u
X1393 a_35369_4050# a_35301_4086# VDD.t1083 VDD.t83 sg13_lv_pmos ad=0.3468p pd=2.72u as=0.20145p ps=1.415u w=1.02u l=0.13u
X1394 a_23693_10448# a_23625_10522# VDD.t867 VDD.t8 sg13_lv_pmos ad=0.3468p pd=2.72u as=0.20145p ps=1.415u w=1.02u l=0.13u
X1395 VSS.t78 BUFX3_0.Y a_6949_14852# VSS.t83 sg13_lv_nmos ad=0.102p pd=1.28u as=57f ps=0.68u w=0.3u l=0.13u
X1396 a_16903_14900# BUFX3_25.Y VSS.t105 VSS.t360 sg13_lv_nmos ad=27f pd=0.48u as=0.102p ps=1.28u w=0.3u l=0.13u
X1397 VDD.t1104 a_9093_9178# a_9161_9104# VDD.t29 sg13_lv_pmos ad=0.1938p pd=1.4u as=0.1938p ps=1.4u w=1.02u l=0.13u
X1398 VSS.t762 a_19745_10770# VSS.t1393 VSS.t1517 sg13_lv_nmos ad=0.1738p pd=1.275u as=0 ps=0 w=0.88u l=1.945u
X1399 VSS.t316 a_20837_12114# VSS.t936 VSS.t938 sg13_lv_nmos ad=0.1672p pd=1.26u as=0 ps=0 w=0.88u l=5.575u
X1400 a_35301_2742# a_35369_2706# VSS.t725 VSS.t1046 sg13_lv_nmos ad=0.2992p pd=2.44u as=0.1672p ps=1.26u w=0.88u l=0.13u
X1401 VSS.t475 a_1097_6738# VSS.t475 VSS.t729 sg13_lv_nmos ad=0.1672p pd=1.26u as=0 ps=0 w=0.88u l=5.575u
X1402 VDD.t313 a_32529_15898# a_32597_15824# VDD.t5 sg13_lv_pmos ad=0.1938p pd=1.4u as=0.1938p ps=1.4u w=1.02u l=0.13u
X1403 VDD.t1546 a_4053_3802# VDD.t1544 VDD.t354 sg13_lv_pmos ad=0.1938p pd=1.4u as=0 ps=0 w=1.02u l=5.575u
X1404 a_19745_6738# a_19677_6774# VDD.t230 VDD.t39 sg13_lv_pmos ad=0.3468p pd=2.72u as=0.20145p ps=1.415u w=1.02u l=0.13u
X1405 DFFQX1_0.D a_7333_16182# VSS.t1121 VSS.t1218 sg13_lv_nmos ad=0.2924p pd=2.4u as=0.1567p ps=1.27u w=0.86u l=0.13u
X1406 VSS.t381 a_1097_16146# a_1029_16182# VSS.t1002 sg13_lv_nmos ad=0.1738p pd=1.275u as=0.2992p ps=2.44u w=0.88u l=0.13u
X1407 VSS.t1 a_9161_14480# VSS.t1 VSS.t0 sg13_lv_nmos ad=0.1672p pd=1.26u as=0 ps=0 w=0.88u l=5.575u
X1408 VDD.t1811 a_36393_13494# VDD.t1810 VDD.t100 sg13_lv_pmos ad=0.3468p pd=2.72u as=0 ps=0 w=1.02u l=5.305u
X1409 VSS.t1377 a_9161_3728# VSS.t229 VSS.t1499 sg13_lv_nmos ad=0.1672p pd=1.26u as=0 ps=0 w=0.88u l=5.575u
X1410 VDD.t184 a_11781_10522# a_11849_10448# VDD.t8 sg13_lv_pmos ad=0.1938p pd=1.4u as=0.1938p ps=1.4u w=1.02u l=0.13u
X1411 VDD.t528 a_7749_5146# VDD.t527 VDD.t83 sg13_lv_pmos ad=0.3468p pd=2.72u as=0 ps=0 w=1.02u l=1.945u
X1412 a_5145_8118# a_5213_8082# VSS.t783 VSS.t1810 sg13_lv_nmos ad=0.2992p pd=2.44u as=0.1672p ps=1.26u w=0.88u l=0.13u
X1413 VSS.t393 OR3X1_1.B a_21195_16000# VSS.t392 sg13_lv_nmos ad=57f pd=0.68u as=0.102p ps=1.28u w=0.3u l=0.13u
X1414 VSS.t1137 a_15318_15510# DFFQX1_5.CK VSS.t1139 sg13_lv_nmos ad=0.1634p pd=1.24u as=0.1634p ps=1.24u w=0.86u l=0.13u
X1415 a_22197_13608# OR3X1_1.B VSS.t262 VSS.t391 sg13_lv_nmos ad=57f pd=0.68u as=0.102p ps=1.28u w=0.3u l=0.13u
X1416 VSS.t14 a_18589_16146# BUFX3_17.A VSS.t1223 sg13_lv_nmos ad=0.1567p pd=1.27u as=0.2924p ps=2.4u w=0.86u l=0.13u
X1417 VSS.t177 a_18401_8082# VSS.t573 VSS.t648 sg13_lv_nmos ad=0.1738p pd=1.275u as=0 ps=0 w=0.88u l=5.305u
X1418 a_35217_13210# a_35285_13136# VSS.t799 VSS.t798 sg13_lv_nmos ad=0.2992p pd=2.44u as=0.1672p ps=1.26u w=0.88u l=0.13u
X1419 a_7221_15952# a_7093_15779# a_6911_15770# VDD.t5 sg13_lv_pmos ad=91.2f pd=0.86u as=91.2f ps=0.86u w=0.48u l=0.13u
X1420 VDD.t1784 a_26145_4086# VDD.t1783 VDD.t83 sg13_lv_pmos ad=0.3468p pd=2.72u as=0 ps=0 w=1.02u l=5.305u
X1421 a_37805_4050# a_37737_4086# VDD.t1606 VDD.t83 sg13_lv_pmos ad=0.3468p pd=2.72u as=0.20145p ps=1.415u w=1.02u l=0.13u
X1422 VDD.t1938 a_9093_7834# VDD.t1937 VDD.t39 sg13_lv_pmos ad=0.3468p pd=2.72u as=0 ps=0 w=1.02u l=5.575u
X1423 VSS.t165 a_1097_8082# a_1029_8118# VSS.t164 sg13_lv_nmos ad=0.1672p pd=1.26u as=0.2992p ps=2.44u w=0.88u l=0.13u
X1424 VSS.t24 a_11933_9426# a_11865_9462# VSS.t23 sg13_lv_nmos ad=0.1738p pd=1.275u as=0.2992p ps=2.44u w=0.88u l=0.13u
X1425 VDD.t1981 a_31437_15898# VDD.t1980 VDD.t5 sg13_lv_pmos ad=0.3468p pd=2.72u as=0 ps=0 w=1.02u l=1.945u
X1426 VDD.t1672 a_18333_13494# VDD.t1671 VDD.t100 sg13_lv_pmos ad=0.3468p pd=2.72u as=0 ps=0 w=1.02u l=5.305u
X1427 VSS.t303 a_35369_5394# a_35301_5430# VSS.t692 sg13_lv_nmos ad=0.1738p pd=1.275u as=0.2992p ps=2.44u w=0.88u l=0.13u
X1428 VDD.t36 a_28581_8118# a_28649_8082# VDD.t29 sg13_lv_pmos ad=0.1938p pd=1.4u as=0.1938p ps=1.4u w=1.02u l=0.13u
X1429 VSS.t139 a_18803_15170# a_18779_14900# VSS.t1153 sg13_lv_nmos ad=0.1519p pd=1.265u as=27f ps=0.48u w=0.3u l=0.13u
X1430 VDD.t1408 a_3717_13210# VDD.t1405 VDD.t93 sg13_lv_pmos ad=0.1938p pd=1.4u as=0 ps=0 w=1.02u l=5.575u
X1431 a_9181_16146# DFFQX1_3.Q VDD.t1292 VDD.t0 sg13_lv_pmos ad=0.1632p pd=1.64u as=0.2412p ps=1.73u w=0.48u l=0.13u
X1432 VSS.t771 a_24785_3728# a_24717_3802# VSS.t1678 sg13_lv_nmos ad=0.1672p pd=1.26u as=0.2992p ps=2.44u w=0.88u l=0.13u
X1433 VSS.t11 a_37469_16146# a_37401_16182# VSS.t10 sg13_lv_nmos ad=0.1738p pd=1.275u as=0.2992p ps=2.44u w=0.88u l=0.13u
X1434 VSS.t14 a_19093_15474# AOI21BX1_0.A VSS.t1249 sg13_lv_nmos ad=0.1567p pd=1.27u as=0.2924p ps=2.4u w=0.86u l=0.13u
X1435 VDD.t1404 a_3717_13210# VDD.t1406 VDD.t93 sg13_lv_pmos ad=0.3468p pd=2.72u as=0 ps=0 w=1.02u l=5.575u
X1436 VSS.t345 a_7901_12114# VSS.t346 VSS.t1582 sg13_lv_nmos ad=0.1672p pd=1.26u as=0 ps=0 w=0.88u l=5.575u
X1437 a_1097_7760# a_1029_7834# VDD.t41 VDD.t39 sg13_lv_pmos ad=0.1938p pd=1.4u as=0.1938p ps=1.4u w=1.02u l=0.13u
X1438 VSS.t121 a_16973_9104# a_16905_9178# VSS.t122 sg13_lv_nmos ad=0.1672p pd=1.26u as=0.2992p ps=2.44u w=0.88u l=0.13u
X1439 a_38648_14502# a_38580_14588# VDD.t950 VDD.t100 sg13_lv_pmos ad=0.3332p pd=2.64u as=0.3332p ps=2.64u w=0.98u l=0.76u
X1440 a_10589_13458# a_10521_13494# VDD.t1532 VDD.t100 sg13_lv_pmos ad=0.3468p pd=2.72u as=0.20145p ps=1.415u w=1.02u l=0.13u
X1441 a_11781_3802# a_11849_3728# VSS.t312 VSS.t1539 sg13_lv_nmos ad=0.2992p pd=2.44u as=0.1672p ps=1.26u w=0.88u l=0.13u
X1442 VDD.t306 a_1029_9178# VDD.t305 VDD.t29 sg13_lv_pmos ad=0.3468p pd=2.72u as=0 ps=0 w=1.02u l=5.575u
X1443 VDD.t836 a_31269_5430# a_31337_5394# VDD.t68 sg13_lv_pmos ad=0.1938p pd=1.4u as=0.1938p ps=1.4u w=1.02u l=0.13u
X1444 a_3313_15779# DFFQX1_3.CK VDD.t482 VDD.t5 sg13_lv_pmos ad=0.1632p pd=1.64u as=0.1834p ps=1.39u w=0.48u l=0.13u
X1445 a_8991_15244# a_8421_14920# a_8889_15244# VDD.t5 sg13_lv_pmos ad=43.2f pd=0.66u as=91.2f ps=0.86u w=0.48u l=0.13u
X1446 a_22967_14228# a_22231_14180# a_22865_14228# VDD.t100 sg13_lv_pmos ad=43.2f pd=0.66u as=91.2f ps=0.86u w=0.48u l=0.13u
X1447 a_5213_12114# a_5145_12150# VDD.t487 VDD.t93 sg13_lv_pmos ad=0.1938p pd=1.4u as=0.1938p ps=1.4u w=1.02u l=0.13u
X1448 VSS.t7 a_15881_10448# a_15813_10522# VSS.t6 sg13_lv_nmos ad=0.1738p pd=1.275u as=0.2992p ps=2.44u w=0.88u l=0.13u
X1449 VSS.t18 a_35369_10770# a_35301_10806# VSS.t1534 sg13_lv_nmos ad=0.1738p pd=1.275u as=0.2992p ps=2.44u w=0.88u l=0.13u
X1450 VSS.t11 a_37973_15824# VSS.t11 VSS.t10 sg13_lv_nmos ad=0.1738p pd=1.275u as=0 ps=0 w=0.88u l=1.945u
X1451 VDD.t465 a_18333_9462# VDD.t463 VDD.t8 sg13_lv_pmos ad=0.3468p pd=2.72u as=0 ps=0 w=1.02u l=5.305u
X1452 VSS.t764 a_23693_10448# VSS.t811 VSS.t840 sg13_lv_nmos ad=0.1738p pd=1.275u as=0 ps=0 w=0.88u l=1.945u
X1453 VSS.t819 a_28649_10770# VSS.t821 VSS.t1453 sg13_lv_nmos ad=0.1672p pd=1.26u as=0 ps=0 w=0.88u l=5.575u
X1454 VDD.t1422 a_33957_12150# VDD.t1421 VDD.t93 sg13_lv_pmos ad=0.3468p pd=2.72u as=0 ps=0 w=1.02u l=5.305u
X1455 VSS.t115 a_27473_15824# VSS.t117 VSS.t116 sg13_lv_nmos ad=0.1672p pd=1.26u as=0 ps=0 w=0.88u l=5.575u
X1456 VSS.t395 a_20333_14480# a_20265_14554# VSS.t1430 sg13_lv_nmos ad=0.1738p pd=1.275u as=0.2992p ps=2.44u w=0.88u l=0.13u
X1457 VDD.t622 DFFQX1_5.CK a_21777_14920# VDD.t5 sg13_lv_pmos ad=0.1834p pd=1.39u as=0.1632p ps=1.64u w=0.48u l=0.13u
X1458 VSS.t799 a_37805_13458# VSS.t799 VSS.t798 sg13_lv_nmos ad=0.1738p pd=1.275u as=0 ps=0 w=0.88u l=1.945u
X1459 VDD.t610 a_27405_15898# VDD.t608 VDD.t5 sg13_lv_pmos ad=0.1938p pd=1.4u as=0 ps=0 w=1.02u l=5.575u
X1460 VSS.t1083 a_8492_7782# a_8424_7868# VSS.t1397 sg13_lv_nmos ad=0.2176p pd=1.96u as=0.2176p ps=1.96u w=0.64u l=0.76u
X1461 a_11849_9104# a_11781_9178# VDD.t1057 VDD.t29 sg13_lv_pmos ad=0.1938p pd=1.4u as=0.1938p ps=1.4u w=1.02u l=0.13u
X1462 VDD.t1969 a_20769_12150# a_20837_12114# VDD.t93 sg13_lv_pmos ad=0.1938p pd=1.4u as=0.1938p ps=1.4u w=1.02u l=0.13u
X1463 VDD.t18 a_5145_9462# VDD.t19 VDD.t8 sg13_lv_pmos ad=0.1938p pd=1.4u as=0 ps=0 w=1.02u l=5.575u
X1464 VSS.t1603 a_13025_14802# VSS.t1605 VSS.t1796 sg13_lv_nmos ad=0.1672p pd=1.26u as=0 ps=0 w=0.88u l=5.575u
X1465 VDD.t1678 a_35217_14554# VDD.t1677 VDD.t100 sg13_lv_pmos ad=0.3468p pd=2.72u as=0 ps=0 w=1.02u l=5.575u
X1466 a_19745_5394# a_19677_5430# VDD.t685 VDD.t68 sg13_lv_pmos ad=0.3468p pd=2.72u as=0.20145p ps=1.415u w=1.02u l=0.13u
X1467 VDD.t1214 a_12957_14838# VDD.t1213 VDD.t5 sg13_lv_pmos ad=0.3468p pd=2.72u as=0 ps=0 w=1.02u l=5.575u
X1468 VDD.t1135 a_1029_16182# VDD.t1134 VDD.t0 sg13_lv_pmos ad=0.3468p pd=2.72u as=0 ps=0 w=1.02u l=5.305u
X1469 VDD.t1370 a_31269_6774# VDD.t1369 VDD.t39 sg13_lv_pmos ad=0.3468p pd=2.72u as=0 ps=0 w=1.02u l=5.575u
X1470 VDD.t1193 a_9674_15474# DFFQX1_3.CK VDD.t5 sg13_lv_pmos ad=0.2508p pd=1.7u as=0.2508p ps=1.7u w=1.32u l=0.13u
X1471 VSS.t1 a_9395_15170# a_9371_14900# VSS.t149 sg13_lv_nmos ad=0.1519p pd=1.265u as=27f ps=0.48u w=0.3u l=0.13u
X1472 a_23147_15952# a_22197_15624# a_23033_15572# VSS.t1760 sg13_lv_nmos ad=27f pd=0.48u as=57f ps=0.68u w=0.3u l=0.13u
X1473 a_21493_14838# AOI21BX2_1.A BUFX3_29.A VSS.t1111 sg13_lv_nmos ad=0.1216p pd=1.02u as=0.1216p ps=1.02u w=0.64u l=0.13u
X1474 a_5145_6774# a_5213_6738# VSS.t284 VSS.t681 sg13_lv_nmos ad=0.2992p pd=2.44u as=0.1672p ps=1.26u w=0.88u l=0.13u
X1475 a_20775_14852# NAND2X1_1.Y VSS.t395 VSS.t1596 sg13_lv_nmos ad=57f pd=0.68u as=57f ps=0.68u w=0.3u l=0.13u
X1476 VSS.t412 a_22349_6416# a_22281_6490# VSS.t1831 sg13_lv_nmos ad=0.1738p pd=1.275u as=0.2992p ps=2.44u w=0.88u l=0.13u
X1477 DFFQX1_1.D a_3385_16182# VSS.t381 VSS.t1265 sg13_lv_nmos ad=0.2924p pd=2.4u as=0.1567p ps=1.27u w=0.86u l=0.13u
X1478 VSS.t410 a_18401_6738# VSS.t431 VSS.t685 sg13_lv_nmos ad=0.1738p pd=1.275u as=0 ps=0 w=0.88u l=5.305u
X1479 VSS.t602 DFFQX1_5.CK a_21777_14920# VSS.t620 sg13_lv_nmos ad=0.1193p pd=1.05u as=0.102p ps=1.28u w=0.3u l=0.13u
X1480 VDD.t266 a_3717_5146# VDD.t265 VDD.t83 sg13_lv_pmos ad=0.3468p pd=2.72u as=0 ps=0 w=1.02u l=5.575u
X1481 VSS.t301 a_31337_5394# VSS.t212 VSS.t747 sg13_lv_nmos ad=0.1672p pd=1.26u as=0 ps=0 w=0.88u l=5.575u
X1482 VSS.t1573 a_3785_10770# a_3717_10806# VSS.t1707 sg13_lv_nmos ad=0.1738p pd=1.275u as=0.2992p ps=2.44u w=0.88u l=0.13u
X1483 VDD.t1949 a_3717_6774# VDD.t1948 VDD.t39 sg13_lv_pmos ad=0.3468p pd=2.72u as=0 ps=0 w=1.02u l=1.945u
X1484 VSS.t444 a_38480_14816# a_38412_14852# VSS.t443 sg13_lv_nmos ad=0.2176p pd=1.96u as=0.2176p ps=1.96u w=0.64u l=0.76u
X1485 VSS.t602 DFFQX1_5.CK a_22029_14280# VSS.t619 sg13_lv_nmos ad=0.1193p pd=1.05u as=0.102p ps=1.28u w=0.3u l=0.13u
X1486 VSS.t475 a_1097_6738# a_1029_6774# VSS.t726 sg13_lv_nmos ad=0.1672p pd=1.26u as=0.2992p ps=2.44u w=0.88u l=0.13u
X1487 OAI21X1_0.Y OR3BX1_0.B a_19179_14852# VSS.t135 sg13_lv_nmos ad=0.102p pd=1.28u as=57f ps=0.68u w=0.3u l=0.13u
X1488 VDD.t1631 a_20769_4086# VDD.t1630 VDD.t83 sg13_lv_pmos ad=0.1938p pd=1.4u as=0 ps=0 w=1.02u l=5.575u
X1489 VDD.t207 a_3717_7834# VDD.t205 VDD.t39 sg13_lv_pmos ad=0.1938p pd=1.4u as=0 ps=0 w=1.02u l=5.575u
X1490 VDD.t637 a_11865_9462# VDD.t635 VDD.t8 sg13_lv_pmos ad=0.3468p pd=2.72u as=0 ps=0 w=1.02u l=1.945u
X1491 a_3277_15952# a_3023_15792# VSS.t103 VSS.t1226 sg13_lv_nmos ad=27f pd=0.48u as=0.1519p ps=1.265u w=0.3u l=0.13u
X1492 a_15645_8118# a_15713_8082# VSS.t573 VSS.t1024 sg13_lv_nmos ad=0.2992p pd=2.44u as=0.1672p ps=1.26u w=0.88u l=0.13u
X1493 VSS.t393 a_20924_16160# a_20856_16196# VSS.t426 sg13_lv_nmos ad=0.2176p pd=1.96u as=0.2176p ps=1.96u w=0.64u l=0.76u
X1494 a_32597_9104# a_32529_9178# VDD.t567 VDD.t29 sg13_lv_pmos ad=0.1938p pd=1.4u as=0.1938p ps=1.4u w=1.02u l=0.13u
X1495 VDD.t1332 a_16905_5146# a_16973_5072# VDD.t83 sg13_lv_pmos ad=0.1938p pd=1.4u as=0.1938p ps=1.4u w=1.02u l=0.13u
X1496 VDD.t1189 a_9674_15474# DFFQX1_3.CK VDD.t5 sg13_lv_pmos ad=0.2508p pd=1.7u as=0.2508p ps=1.7u w=1.32u l=0.13u
X1497 VDD.t3 a_37401_16182# VDD.t2 VDD.t0 sg13_lv_pmos ad=0.3468p pd=2.72u as=0 ps=0 w=1.02u l=5.305u
X1498 VDD.t328 a_7833_12150# a_7901_12114# VDD.t93 sg13_lv_pmos ad=0.1938p pd=1.4u as=0.1938p ps=1.4u w=1.02u l=0.13u
X1499 VSS.t266 a_32597_10448# VSS.t268 VSS.t267 sg13_lv_nmos ad=0.1672p pd=1.26u as=0 ps=0 w=0.88u l=5.575u
X1500 DFFQX1_6.D a_21193_16182# VSS.t393 VSS.t1212 sg13_lv_nmos ad=0.2924p pd=2.4u as=0.1567p ps=1.27u w=0.86u l=0.13u
X1501 VSS.t137 NAND2X1_1.Y a_21525_14180# VSS.t1597 sg13_lv_nmos ad=0.102p pd=1.28u as=0.102p ps=1.28u w=0.3u l=0.13u
X1502 VSS.t87 a_7817_9104# a_7749_9178# VSS.t1804 sg13_lv_nmos ad=0.1738p pd=1.275u as=0.2992p ps=2.44u w=0.88u l=0.13u
X1503 VDD.t1528 a_27405_11866# a_27473_11792# VDD.t281 sg13_lv_pmos ad=0.1938p pd=1.4u as=0.1938p ps=1.4u w=1.02u l=0.13u
X1504 VSS.t769 a_23693_3728# VSS.t771 VSS.t770 sg13_lv_nmos ad=0.1738p pd=1.275u as=0 ps=0 w=0.88u l=1.945u
X1505 a_22349_11792# a_22281_11866# VDD.t939 VDD.t281 sg13_lv_pmos ad=0.3468p pd=2.72u as=0.20145p ps=1.415u w=1.02u l=0.13u
X1506 VSS.t490 a_32597_5072# VSS.t303 VSS.t853 sg13_lv_nmos ad=0.1672p pd=1.26u as=0 ps=0 w=0.88u l=5.575u
X1507 VSS.t1268 a_4037_14802# VSS.t1268 VSS.t1269 sg13_lv_nmos ad=0.1738p pd=1.275u as=0 ps=0 w=0.88u l=1.945u
X1508 a_23457_12150# a_23525_12114# VSS.t318 VSS.t317 sg13_lv_nmos ad=0.2992p pd=2.44u as=0.1672p ps=1.26u w=0.88u l=0.13u
X1509 VSS.t31 a_15881_9104# VSS.t121 VSS.t120 sg13_lv_nmos ad=0.1738p pd=1.275u as=0 ps=0 w=0.88u l=1.945u
X1510 VSS.t244 a_27305_14802# a_27237_14838# VSS.t919 sg13_lv_nmos ad=0.1738p pd=1.275u as=0.2992p ps=2.44u w=0.88u l=0.13u
X1511 VDD.t34 a_28581_8118# VDD.t33 VDD.t29 sg13_lv_pmos ad=0.3468p pd=2.72u as=0 ps=0 w=1.02u l=5.575u
X1512 VSS.t885 a_23189_13458# VSS.t886 VSS.t1409 sg13_lv_nmos ad=0.1672p pd=1.26u as=0 ps=0 w=0.88u l=5.575u
X1513 VDD.t361 a_12957_9462# VDD.t362 VDD.t8 sg13_lv_pmos ad=0.1938p pd=1.4u as=0 ps=0 w=1.02u l=5.575u
X1514 a_23961_2742# a_24029_2706# VSS.t882 VSS.t883 sg13_lv_nmos ad=0.2992p pd=2.44u as=0.1672p ps=1.26u w=0.88u l=0.13u
X1515 VSS.t1158 a_30497_16146# a_30429_16182# VSS.t1157 sg13_lv_nmos ad=0.1738p pd=1.275u as=0.2992p ps=2.44u w=0.88u l=0.13u
X1516 a_22347_15244# a_21777_14920# a_22245_15244# VDD.t5 sg13_lv_pmos ad=43.2f pd=0.66u as=91.2f ps=0.86u w=0.48u l=0.13u
X1517 VSS.t700 a_19661_13136# a_19593_13210# VSS.t974 sg13_lv_nmos ad=0.1672p pd=1.26u as=0.2992p ps=2.44u w=0.88u l=0.13u
X1518 VDD.t767 a_27405_5146# VDD.t766 VDD.t83 sg13_lv_pmos ad=0.1938p pd=1.4u as=0 ps=0 w=1.02u l=5.575u
X1519 VDD.t1651 a_15645_12150# VDD.t1650 VDD.t93 sg13_lv_pmos ad=0.1938p pd=1.4u as=0 ps=0 w=1.02u l=5.575u
X1520 VSS.t91 a_10589_9426# a_10521_9462# VSS.t271 sg13_lv_nmos ad=0.1738p pd=1.275u as=0.2992p ps=2.44u w=0.88u l=0.13u
X1521 a_24617_14802# a_24549_14838# VDD.t1840 VDD.t5 sg13_lv_pmos ad=0.1938p pd=1.4u as=0.1938p ps=1.4u w=1.02u l=0.13u
X1522 VDD.t902 a_11781_5146# VDD.t903 VDD.t83 sg13_lv_pmos ad=0.3468p pd=2.72u as=0 ps=0 w=1.02u l=5.575u
X1523 VSS.t251 a_37973_3728# a_37905_3802# VSS.t250 sg13_lv_nmos ad=0.1738p pd=1.275u as=0.2992p ps=2.44u w=0.88u l=0.13u
X1524 a_9161_13136# a_9093_13210# VDD.t1880 VDD.t93 sg13_lv_pmos ad=0.1938p pd=1.4u as=0.1938p ps=1.4u w=1.02u l=0.13u
X1525 a_31337_4050# a_31269_4086# VDD.t1363 VDD.t83 sg13_lv_pmos ad=0.1938p pd=1.4u as=0.1938p ps=1.4u w=1.02u l=0.13u
X1526 VSS.t523 a_5213_9426# a_5145_9462# VSS.t522 sg13_lv_nmos ad=0.1672p pd=1.26u as=0.2992p ps=2.44u w=0.88u l=0.13u
X1527 VSS.t421 a_19661_3728# VSS.t1541 VSS.t1693 sg13_lv_nmos ad=0.1672p pd=1.26u as=0 ps=0 w=0.88u l=5.575u
X1528 VDD.t834 a_31269_5430# VDD.t833 VDD.t68 sg13_lv_pmos ad=0.3468p pd=2.72u as=0 ps=0 w=1.02u l=5.575u
X1529 VDD.t806 a_11781_7834# VDD.t805 VDD.t39 sg13_lv_pmos ad=0.1938p pd=1.4u as=0 ps=0 w=1.02u l=5.575u
X1530 VDD.t1542 a_4053_3802# VDD.t1541 VDD.t354 sg13_lv_pmos ad=0.3468p pd=2.72u as=0 ps=0 w=1.02u l=5.575u
X1531 VSS.t362 a_15881_14480# VSS.t362 VSS.t1205 sg13_lv_nmos ad=0.1738p pd=1.275u as=0 ps=0 w=0.88u l=1.945u
X1532 VSS.t305 a_35285_5072# VSS.t305 VSS.t306 sg13_lv_nmos ad=0.1672p pd=1.26u as=0 ps=0 w=0.88u l=5.575u
X1533 a_21313_14656# BUFX3_2.A NAND2X1_1.Y VSS.t1282 sg13_lv_nmos ad=57f pd=0.68u as=0.102p ps=1.28u w=0.3u l=0.13u
X1534 VDD.t1316 a_15813_13210# VDD.t1315 VDD.t93 sg13_lv_pmos ad=0.3468p pd=2.72u as=0 ps=0 w=1.02u l=1.945u
X1535 VSS.t457 a_35285_6416# VSS.t50 VSS.t1769 sg13_lv_nmos ad=0.1672p pd=1.26u as=0 ps=0 w=0.88u l=5.575u
X1536 VSS.t564 a_13025_8082# VSS.t668 VSS.t1075 sg13_lv_nmos ad=0.1672p pd=1.26u as=0 ps=0 w=0.88u l=5.575u
X1537 a_18463_16014# AOI21BX1_0.A AOI21BX1_0.Y VSS.t1009 sg13_lv_nmos ad=43.5f pd=0.59u as=57f ps=0.68u w=0.3u l=0.13u
X1538 VSS.t101 a_18435_15045# a_18411_14900# VSS.t1731 sg13_lv_nmos ad=57f pd=0.68u as=27f ps=0.48u w=0.3u l=0.13u
X1539 VDD.t134 a_15645_9462# VDD.t135 VDD.t8 sg13_lv_pmos ad=0.1938p pd=1.4u as=0 ps=0 w=1.02u l=5.575u
X1540 a_17459_15170# a_17321_15244# VSS.t904 VSS.t1123 sg13_lv_nmos ad=0.102p pd=1.28u as=0.22785p ps=1.9u w=0.3u l=0.13u
X1541 VSS.t29 a_13025_9426# VSS.t26 VSS.t28 sg13_lv_nmos ad=0.1672p pd=1.26u as=0 ps=0 w=0.88u l=5.575u
X1542 VDD.t1208 BUFX3_1.Y.t3 a_21189_14906# VDD.t5 sg13_lv_pmos ad=0.1834p pd=1.39u as=0.1632p ps=1.64u w=0.48u l=0.13u
X1543 VSS.t352 a_37805_9426# a_37737_9462# VSS.t351 sg13_lv_nmos ad=0.1738p pd=1.275u as=0.2992p ps=2.44u w=0.88u l=0.13u
X1544 VDD.t1115 a_35217_9178# VDD.t1113 VDD.t29 sg13_lv_pmos ad=0.1938p pd=1.4u as=0 ps=0 w=1.02u l=5.575u
X1545 a_23323_15175# OR3X1_1.Y BUFX3_28.A VDD.t5 sg13_lv_pmos ad=0.3332p pd=2.64u as=0.1862p ps=1.36u w=0.98u l=0.13u
X1546 a_22435_14228# a_22231_14180# VDD.t1012 VDD.t100 sg13_lv_pmos ad=43.2f pd=0.66u as=0.1632p ps=1.64u w=0.48u l=0.13u
X1547 a_7901_9426# a_7833_9462# VDD.t1091 VDD.t8 sg13_lv_pmos ad=0.1938p pd=1.4u as=0.1938p ps=1.4u w=1.02u l=0.13u
X1548 VSS.t581 a_5213_10770# VSS.t579 VSS.t580 sg13_lv_nmos ad=0.1672p pd=1.26u as=0 ps=0 w=0.88u l=5.575u
X1549 VDD.t1243 a_6803_15792# DFFQX1_0.Q VDD.t5 sg13_lv_pmos ad=0.2529p pd=1.545u as=0.1632p ps=1.64u w=0.48u l=0.13u
X1550 VSS.t1507 a_31337_14802# a_31269_14838# VSS.t1716 sg13_lv_nmos ad=0.1672p pd=1.26u as=0.2992p ps=2.44u w=0.88u l=0.13u
X1551 VDD.t284 a_5145_10806# VDD.t282 VDD.t281 sg13_lv_pmos ad=0.3468p pd=2.72u as=0 ps=0 w=1.02u l=5.575u
X1552 VDD.t436 a_3717_5430# VDD.t435 VDD.t68 sg13_lv_pmos ad=0.3468p pd=2.72u as=0 ps=0 w=1.02u l=1.945u
X1553 a_19661_7760# a_19593_7834# VDD.t49 VDD.t39 sg13_lv_pmos ad=0.1938p pd=1.4u as=0.1938p ps=1.4u w=1.02u l=0.13u
X1554 a_1097_14802# a_1029_14838# VDD.t1200 VDD.t5 sg13_lv_pmos ad=0.3468p pd=2.72u as=0.20145p ps=1.415u w=1.02u l=0.13u
X1555 VSS.t490 a_34025_5394# a_33957_5430# VSS.t489 sg13_lv_nmos ad=0.1738p pd=1.275u as=0.2992p ps=2.44u w=0.88u l=0.13u
X1556 VSS.t466 a_30161_7760# a_30093_7834# VSS.t465 sg13_lv_nmos ad=0.1738p pd=1.275u as=0.2992p ps=2.44u w=0.88u l=0.13u
X1557 VSS.t1411 a_23693_13136# a_23625_13210# VSS.t1460 sg13_lv_nmos ad=0.1738p pd=1.275u as=0.2992p ps=2.44u w=0.88u l=0.13u
X1558 VSS.t610 a_12356_15846# a_12288_15932# VSS.t1178 sg13_lv_nmos ad=0.2176p pd=1.96u as=0.2176p ps=1.96u w=0.64u l=0.76u
X1559 VSS.t101 BUFX3_2.A a_18085_14166# VSS.t1280 sg13_lv_nmos ad=0.1567p pd=1.27u as=0.102p ps=1.28u w=0.3u l=0.13u
X1560 a_15645_6774# a_15713_6738# VSS.t431 VSS.t472 sg13_lv_nmos ad=0.2992p pd=2.44u as=0.1672p ps=1.26u w=0.88u l=0.13u
X1561 a_22599_14228# a_22029_14280# a_22497_14228# VDD.t100 sg13_lv_pmos ad=43.2f pd=0.66u as=91.2f ps=0.86u w=0.48u l=0.13u
X1562 a_23525_9426# a_23457_9462# VDD.t20 VDD.t8 sg13_lv_pmos ad=0.1938p pd=1.4u as=0.1938p ps=1.4u w=1.02u l=0.13u
X1563 VDD.t1833 a_23709_14554# VDD.t1832 VDD.t100 sg13_lv_pmos ad=0.3468p pd=2.72u as=0 ps=0 w=1.02u l=1.945u
X1564 a_10589_8082# a_10521_8118# VDD.t363 VDD.t29 sg13_lv_pmos ad=0.3468p pd=2.72u as=0.20145p ps=1.415u w=1.02u l=0.13u
X1565 VSS.t1688 a_10589_10770# a_10521_10806# VSS.t1837 sg13_lv_nmos ad=0.1738p pd=1.275u as=0.2992p ps=2.44u w=0.88u l=0.13u
X1566 VSS.t506 a_7817_2706# VSS.t504 VSS.t505 sg13_lv_nmos ad=0.1738p pd=1.275u as=0 ps=0 w=0.88u l=1.945u
X1567 VDD.t1771 a_27741_2742# VDD.t1770 VDD.t354 sg13_lv_pmos ad=0.3468p pd=2.72u as=0 ps=0 w=1.02u l=5.575u
X1568 a_3821_15572# DFFQX1_1.D a_3517_15682# VDD.t5 sg13_lv_pmos ad=43.2f pd=0.66u as=91.2f ps=0.86u w=0.48u l=0.13u
X1569 AND2X1_2.B a_7669_16182# VDD.t1237 VDD.t0 sg13_lv_pmos ad=0.4488p pd=3.32u as=0.2412p ps=1.73u w=1.32u l=0.13u
X1570 a_14537_6416# a_14469_6490# VDD.t421 VDD.t68 sg13_lv_pmos ad=0.3468p pd=2.72u as=0.20145p ps=1.415u w=1.02u l=0.13u
X1571 VSS.t160 DFFQX1_4.Q a_17749_16182# VSS.t567 sg13_lv_nmos ad=0.1567p pd=1.27u as=0.102p ps=1.28u w=0.3u l=0.13u
X1572 a_15881_13136# a_15813_13210# VDD.t1316 VDD.t93 sg13_lv_pmos ad=0.3468p pd=2.72u as=0.20145p ps=1.415u w=1.02u l=0.13u
X1573 VDD.t1108 a_22281_9178# VDD.t1107 VDD.t29 sg13_lv_pmos ad=0.3468p pd=2.72u as=0 ps=0 w=1.02u l=5.305u
X1574 VDD.t1229 a_14049_15898# VDD.t1228 VDD.t5 sg13_lv_pmos ad=0.3468p pd=2.72u as=0 ps=0 w=1.02u l=1.945u
X1575 VSS.t725 a_38732_2720# a_38664_2756# VSS.t1046 sg13_lv_nmos ad=0.2176p pd=1.96u as=0.2176p ps=1.96u w=0.64u l=0.76u
X1576 VSS.t1371 a_12689_2706# VSS.t1370 VSS.t1369 sg13_lv_nmos ad=0.1672p pd=1.26u as=0 ps=0 w=0.88u l=5.575u
X1577 VSS.t76 a_6473_14480# VSS.t993 VSS.t992 sg13_lv_nmos ad=0.1738p pd=1.275u as=0 ps=0 w=0.88u l=5.305u
X1578 XOR2X1_0.A a_2629_15510# VSS.t381 VSS.t1167 sg13_lv_nmos ad=0.2924p pd=2.4u as=0.1567p ps=1.27u w=0.86u l=0.13u
X1579 a_9674_15474# BUFX24_2.A VSS.t612 VSS.t1251 sg13_lv_nmos ad=0.1634p pd=1.24u as=0.1634p ps=1.24u w=0.86u l=0.13u
X1580 a_4037_14802# a_3969_14838# VDD.t1305 VDD.t5 sg13_lv_pmos ad=0.3468p pd=2.72u as=0.20145p ps=1.415u w=1.02u l=0.13u
X1581 a_22349_7760# a_22281_7834# VDD.t212 VDD.t39 sg13_lv_pmos ad=0.3468p pd=2.72u as=0.20145p ps=1.415u w=1.02u l=0.13u
X1582 VDD.t1800 a_23121_13494# a_23189_13458# VDD.t100 sg13_lv_pmos ad=0.1938p pd=1.4u as=0.1938p ps=1.4u w=1.02u l=0.13u
X1583 VDD.t986 a_30429_16182# VDD.t985 VDD.t0 sg13_lv_pmos ad=0.3468p pd=2.72u as=0 ps=0 w=1.02u l=1.945u
X1584 VDD.t278 a_6405_13210# VDD.t277 VDD.t93 sg13_lv_pmos ad=0.3468p pd=2.72u as=0 ps=0 w=1.02u l=5.305u
X1585 a_4460_4064# a_4392_4100# VDD.t1464 VDD.t83 sg13_lv_pmos ad=0.3332p pd=2.64u as=0.3332p ps=2.64u w=0.98u l=0.76u
X1586 VSS.t520 a_3785_9104# a_3717_9178# VSS.t519 sg13_lv_nmos ad=0.1672p pd=1.26u as=0.2992p ps=2.44u w=0.88u l=0.13u
X1587 VSS.t1 a_9027_15045# a_9003_14900# VSS.t85 sg13_lv_nmos ad=57f pd=0.68u as=27f ps=0.48u w=0.3u l=0.13u
X1588 VSS.t552 a_27557_8082# VSS.t550 VSS.t551 sg13_lv_nmos ad=0.1738p pd=1.275u as=0 ps=0 w=0.88u l=1.945u
X1589 OA21X2_1.Y a_23709_14838# VDD.t290 VDD.t5 sg13_lv_pmos ad=0.3479p pd=2.67u as=0.1834p ps=1.39u w=0.98u l=0.13u
X1590 VSS.t177 a_19661_7760# a_19593_7834# VSS.t176 sg13_lv_nmos ad=0.1672p pd=1.26u as=0.2992p ps=2.44u w=0.88u l=0.13u
X1591 a_19681_14802# BUFX3_23.A VDD.t1289 VDD.t5 sg13_lv_pmos ad=0.1632p pd=1.64u as=0.2412p ps=1.73u w=0.48u l=0.13u
X1592 VSS.t1491 a_14537_11792# VSS.t796 VSS.t1516 sg13_lv_nmos ad=0.1738p pd=1.275u as=0 ps=0 w=0.88u l=5.305u
X1593 a_13025_8082# a_12957_8118# VDD.t646 VDD.t29 sg13_lv_pmos ad=0.1938p pd=1.4u as=0.1938p ps=1.4u w=1.02u l=0.13u
X1594 VDD.t1050 a_10521_9462# VDD.t1048 VDD.t8 sg13_lv_pmos ad=0.3468p pd=2.72u as=0 ps=0 w=1.02u l=5.305u
X1595 a_9093_10522# a_9161_10448# VSS.t1503 VSS.t1690 sg13_lv_nmos ad=0.2992p pd=2.44u as=0.1672p ps=1.26u w=0.88u l=0.13u
X1596 VSS.t626 a_34616_16160# a_34548_16196# VSS.t1221 sg13_lv_nmos ad=0.2176p pd=1.96u as=0.2176p ps=1.96u w=0.64u l=0.76u
X1597 VSS.t448 a_24785_14480# VSS.t1590 VSS.t1684 sg13_lv_nmos ad=0.1672p pd=1.26u as=0 ps=0 w=0.88u l=5.575u
X1598 VSS.t832 a_24785_3728# VSS.t254 VSS.t1681 sg13_lv_nmos ad=0.1672p pd=1.26u as=0 ps=0 w=0.88u l=5.575u
X1599 VDD.t1160 a_15318_15510# DFFQX1_5.CK VDD.t5 sg13_lv_pmos ad=0.2508p pd=1.7u as=0.2508p ps=1.7u w=1.32u l=0.13u
X1600 a_16973_6416# a_16905_6490# VDD.t427 VDD.t68 sg13_lv_pmos ad=0.1938p pd=1.4u as=0.1938p ps=1.4u w=1.02u l=0.13u
X1601 VSS.t126 a_16973_9104# VSS.t124 VSS.t127 sg13_lv_nmos ad=0.1672p pd=1.26u as=0 ps=0 w=0.88u l=5.575u
X1602 VDD.t16 a_5145_9462# VDD.t15 VDD.t8 sg13_lv_pmos ad=0.3468p pd=2.72u as=0 ps=0 w=1.02u l=5.575u
X1603 a_28581_4086# a_28649_4050# VSS.t1360 VSS.t1361 sg13_lv_nmos ad=0.2992p pd=2.44u as=0.1672p ps=1.26u w=0.88u l=0.13u
X1604 XOR2X1_0.Y a_3045_15244# VSS.t81 VSS.t606 sg13_lv_nmos ad=57f pd=0.68u as=61.5f ps=0.71u w=0.3u l=0.13u
X1605 a_7817_6416# a_7749_6490# VDD.t1444 VDD.t68 sg13_lv_pmos ad=0.3468p pd=2.72u as=0.20145p ps=1.415u w=1.02u l=0.13u
X1606 OR3X1_0.Y a_21525_14180# VDD.t613 VDD.t100 sg13_lv_pmos ad=0.1632p pd=1.64u as=0.108p ps=0.93u w=0.48u l=0.13u
X1607 VSS.t301 a_32597_5072# a_32529_5146# VSS.t850 sg13_lv_nmos ad=0.1672p pd=1.26u as=0.2992p ps=2.44u w=0.88u l=0.13u
X1608 VSS.t719 a_13025_6738# VSS.t190 VSS.t721 sg13_lv_nmos ad=0.1672p pd=1.26u as=0 ps=0 w=0.88u l=5.575u
X1609 VDD.t343 a_7833_8118# a_7901_8082# VDD.t29 sg13_lv_pmos ad=0.1938p pd=1.4u as=0.1938p ps=1.4u w=1.02u l=0.13u
X1610 VDD.t355 a_30093_3802# VDD.t356 VDD.t354 sg13_lv_pmos ad=0.3468p pd=2.72u as=0 ps=0 w=1.02u l=5.305u
X1611 VSS.t725 a_35369_2706# VSS.t725 VSS.t1046 sg13_lv_nmos ad=0.1672p pd=1.26u as=0 ps=0 w=0.88u l=5.575u
X1612 DFFQX1_3.CK a_9674_15474# VSS.t608 VSS.t1173 sg13_lv_nmos ad=0.1634p pd=1.24u as=0.1634p ps=1.24u w=0.86u l=0.13u
X1613 VDD.t1179 a_9181_15474# DFFQX1_3.D VDD.t5 sg13_lv_pmos ad=0.2412p pd=1.73u as=0.4488p ps=3.32u w=1.32u l=0.13u
X1614 VDD.t194 a_37737_9462# VDD.t193 VDD.t8 sg13_lv_pmos ad=0.3468p pd=2.72u as=0 ps=0 w=1.02u l=1.945u
X1615 VDD.t1025 a_28581_10806# a_28649_10770# VDD.t281 sg13_lv_pmos ad=0.1938p pd=1.4u as=0.1938p ps=1.4u w=1.02u l=0.13u
X1616 VSS.t497 a_1097_13136# VSS.t497 VSS.t837 sg13_lv_nmos ad=0.1672p pd=1.26u as=0 ps=0 w=0.88u l=5.575u
X1617 a_19593_5146# a_19661_5072# VSS.t1044 VSS.t1329 sg13_lv_nmos ad=0.2992p pd=2.44u as=0.1672p ps=1.26u w=0.88u l=0.13u
X1618 VDD.t1944 a_32529_7834# a_32597_7760# VDD.t39 sg13_lv_pmos ad=0.1938p pd=1.4u as=0.1938p ps=1.4u w=1.02u l=0.13u
X1619 VDD.t1073 a_23457_8118# a_23525_8082# VDD.t29 sg13_lv_pmos ad=0.1938p pd=1.4u as=0.1938p ps=1.4u w=1.02u l=0.13u
X1620 a_1029_4086# a_1097_4050# VSS.t224 VSS.t227 sg13_lv_nmos ad=0.2992p pd=2.44u as=0.1672p ps=1.26u w=0.88u l=0.13u
X1621 a_16469_2706# a_16401_2742# VDD.t1764 VDD.t354 sg13_lv_pmos ad=0.1938p pd=1.4u as=0.1938p ps=1.4u w=1.02u l=0.13u
X1622 VSS.t819 a_30161_10448# VSS.t757 VSS.t829 sg13_lv_nmos ad=0.1738p pd=1.275u as=0 ps=0 w=0.88u l=5.305u
X1623 VDD.t333 a_1029_5146# a_1097_5072# VDD.t83 sg13_lv_pmos ad=0.1938p pd=1.4u as=0.1938p ps=1.4u w=1.02u l=0.13u
X1624 VDD.t1976 a_1029_6774# a_1097_6738# VDD.t39 sg13_lv_pmos ad=0.1938p pd=1.4u as=0.1938p ps=1.4u w=1.02u l=0.13u
X1625 VSS.t762 a_19661_10448# VSS.t766 VSS.t1396 sg13_lv_nmos ad=0.1672p pd=1.26u as=0 ps=0 w=0.88u l=5.575u
X1626 VDD.t1679 a_35217_14554# a_35285_14480# VDD.t100 sg13_lv_pmos ad=0.1938p pd=1.4u as=0.1938p ps=1.4u w=1.02u l=0.13u
X1627 VDD.t750 a_27405_6490# a_27473_6416# VDD.t68 sg13_lv_pmos ad=0.1938p pd=1.4u as=0.1938p ps=1.4u w=1.02u l=0.13u
X1628 VDD.t1216 a_12957_14838# a_13025_14802# VDD.t5 sg13_lv_pmos ad=0.1938p pd=1.4u as=0.1938p ps=1.4u w=1.02u l=0.13u
X1629 VSS.t815 a_24785_10448# VSS.t813 VSS.t816 sg13_lv_nmos ad=0.1672p pd=1.26u as=0 ps=0 w=0.88u l=5.575u
X1630 VDD.t1151 a_1029_14554# VDD.t1150 VDD.t100 sg13_lv_pmos ad=0.3468p pd=2.72u as=0 ps=0 w=1.02u l=5.575u
X1631 VDD.t1496 a_19593_11866# VDD.t1495 VDD.t281 sg13_lv_pmos ad=0.1938p pd=1.4u as=0 ps=0 w=1.02u l=5.575u
X1632 VSS.t1364 a_19661_11792# VSS.t935 VSS.t1365 sg13_lv_nmos ad=0.1672p pd=1.26u as=0 ps=0 w=0.88u l=5.575u
X1633 a_20769_9462# a_20837_9426# VSS.t370 VSS.t1053 sg13_lv_nmos ad=0.2992p pd=2.44u as=0.1672p ps=1.26u w=0.88u l=0.13u
X1634 DFFQX1_5.CK a_15318_15510# VSS.t663 VSS.t1135 sg13_lv_nmos ad=0.1634p pd=1.24u as=0.1634p ps=1.24u w=0.86u l=0.13u
X1635 VSS.t1305 a_7817_11792# a_7749_11866# VSS.t1386 sg13_lv_nmos ad=0.1738p pd=1.275u as=0.2992p ps=2.44u w=0.88u l=0.13u
X1636 a_27405_7834# a_27473_7760# VSS.t466 VSS.t715 sg13_lv_nmos ad=0.2992p pd=2.44u as=0.1672p ps=1.26u w=0.88u l=0.13u
X1637 VSS.t24 a_11849_9104# a_11781_9178# VSS.t537 sg13_lv_nmos ad=0.1672p pd=1.26u as=0.2992p ps=2.44u w=0.88u l=0.13u
X1638 VSS.t179 a_20837_8082# VSS.t181 VSS.t1077 sg13_lv_nmos ad=0.1672p pd=1.26u as=0 ps=0 w=0.88u l=5.575u
X1639 a_3313_15779# DFFQX1_3.CK VSS.t383 VSS.t462 sg13_lv_nmos ad=0.102p pd=1.28u as=0.1193p ps=1.05u w=0.3u l=0.13u
X1640 VSS.t661 clock_i a_12714_15510# VSS.t1664 sg13_lv_nmos ad=0.1634p pd=1.24u as=0.2924p ps=2.4u w=0.86u l=0.13u
X1641 VDD.t812 a_35217_7834# a_35285_7760# VDD.t39 sg13_lv_pmos ad=0.1938p pd=1.4u as=0.1938p ps=1.4u w=1.02u l=0.13u
X1642 VSS.t844 a_9161_10448# a_9093_10522# VSS.t1686 sg13_lv_nmos ad=0.1672p pd=1.26u as=0.2992p ps=2.44u w=0.88u l=0.13u
X1643 VSS.t1541 a_22349_3728# VSS.t769 VSS.t1540 sg13_lv_nmos ad=0.1738p pd=1.275u as=0 ps=0 w=0.88u l=5.305u
X1644 VDD.t139 a_3131_15770# a_3023_15792# VDD.t5 sg13_lv_pmos ad=0.37935p pd=2.32u as=0.1632p ps=1.64u w=0.48u l=0.13u
X1645 VSS.t1327 a_19745_5394# VSS.t202 VSS.t1776 sg13_lv_nmos ad=0.1738p pd=1.275u as=0 ps=0 w=0.88u l=1.945u
X1646 VSS.t29 a_14537_9104# VSS.t31 VSS.t276 sg13_lv_nmos ad=0.1738p pd=1.275u as=0 ps=0 w=0.88u l=5.305u
X1647 VSS.t1286 a_3785_2706# VSS.t1284 VSS.t1285 sg13_lv_nmos ad=0.1738p pd=1.275u as=0 ps=0 w=0.88u l=1.945u
X1648 VSS.t305 a_37973_5072# VSS.t305 VSS.t306 sg13_lv_nmos ad=0.1738p pd=1.275u as=0 ps=0 w=0.88u l=1.945u
X1649 a_17497_16146# BUFX3_16.A VSS.t554 VSS.t555 sg13_lv_nmos ad=0.102p pd=1.28u as=0.1567p ps=1.27u w=0.3u l=0.13u
X1650 a_2625_14852# BUFX3_1.Y VDD.t1695 VDD.t5 sg13_lv_pmos ad=91.2f pd=0.86u as=0.1632p ps=1.64u w=0.48u l=0.13u
X1651 VSS.t859 a_6809_3728# a_6741_3802# VSS.t1407 sg13_lv_nmos ad=0.1738p pd=1.275u as=0.2992p ps=2.44u w=0.88u l=0.13u
X1652 VDD.t1753 a_19593_3802# VDD.t1752 VDD.t354 sg13_lv_pmos ad=0.3468p pd=2.72u as=0 ps=0 w=1.02u l=5.575u
X1653 VDD.t268 a_3717_5146# a_3785_5072# VDD.t83 sg13_lv_pmos ad=0.1938p pd=1.4u as=0.1938p ps=1.4u w=1.02u l=0.13u
X1654 VSS.t139 a_18989_14480# a_18921_14554# VSS.t1243 sg13_lv_nmos ad=0.1738p pd=1.275u as=0.2992p ps=2.44u w=0.88u l=0.13u
X1655 VSS.t67 a_38648_11814# a_38580_11900# VSS.t66 sg13_lv_nmos ad=0.2176p pd=1.96u as=0.2176p ps=1.96u w=0.64u l=0.76u
X1656 a_15881_6416# a_15813_6490# VDD.t424 VDD.t68 sg13_lv_pmos ad=0.3468p pd=2.72u as=0.20145p ps=1.415u w=1.02u l=0.13u
X1657 VSS.t251 a_38480_4064# a_38412_4100# VSS.t250 sg13_lv_nmos ad=0.2176p pd=1.96u as=0.2176p ps=1.96u w=0.64u l=0.76u
X1658 a_4460_16160# a_4392_16196# VDD.t1231 VDD.t0 sg13_lv_pmos ad=0.3332p pd=2.64u as=0.3332p ps=2.64u w=0.98u l=0.76u
X1659 VDD.t98 a_31269_12150# VDD.t97 VDD.t93 sg13_lv_pmos ad=0.1938p pd=1.4u as=0 ps=0 w=1.02u l=5.575u
X1660 VSS.t1301 a_27557_6738# VSS.t481 VSS.t1300 sg13_lv_nmos ad=0.1738p pd=1.275u as=0 ps=0 w=0.88u l=1.945u
X1661 a_23457_9462# a_23525_9426# VSS.t544 VSS.t1008 sg13_lv_nmos ad=0.2992p pd=2.44u as=0.1672p ps=1.26u w=0.88u l=0.13u
X1662 VSS.t18 a_35285_10448# VSS.t20 VSS.t21 sg13_lv_nmos ad=0.1672p pd=1.26u as=0 ps=0 w=0.88u l=5.575u
X1663 VDD.t1143 BUFX3_26.Y a_6661_16182# VDD.t0 sg13_lv_pmos ad=0.2412p pd=1.73u as=0.1632p ps=1.64u w=0.48u l=0.13u
X1664 VSS.t795 a_15713_12114# VSS.t796 VSS.t805 sg13_lv_nmos ad=0.1672p pd=1.26u as=0 ps=0 w=0.88u l=5.575u
X1665 VDD.t765 a_27405_5146# VDD.t764 VDD.t83 sg13_lv_pmos ad=0.3468p pd=2.72u as=0 ps=0 w=1.02u l=5.575u
X1666 a_7833_8118# a_7901_8082# VSS.t1070 VSS.t1816 sg13_lv_nmos ad=0.2992p pd=2.44u as=0.1672p ps=1.26u w=0.88u l=0.13u
X1667 AND2X1_3.Y a_2625_14852# VSS.t81 VSS.t590 sg13_lv_nmos ad=0.12p pd=1.4u as=57f ps=0.68u w=0.3u l=0.13u
X1668 VDD.t1613 a_32529_14554# VDD.t1612 VDD.t100 sg13_lv_pmos ad=0.1938p pd=1.4u as=0 ps=0 w=1.02u l=5.575u
X1669 VDD.t995 a_9093_5146# a_9161_5072# VDD.t83 sg13_lv_pmos ad=0.1938p pd=1.4u as=0.1938p ps=1.4u w=1.02u l=0.13u
X1670 a_15377_2706# a_15309_2742# VDD.t1906 VDD.t354 sg13_lv_pmos ad=0.3468p pd=2.72u as=0.20145p ps=1.415u w=1.02u l=0.13u
X1671 VSS.t295 a_5129_16146# VSS.t293 VSS.t294 sg13_lv_nmos ad=0.1738p pd=1.275u as=0 ps=0 w=0.88u l=1.945u
X1672 VSS.t165 a_3785_7760# VSS.t561 VSS.t560 sg13_lv_nmos ad=0.1672p pd=1.26u as=0 ps=0 w=0.88u l=5.575u
X1673 a_6473_11792# a_6405_11866# VDD.t1655 VDD.t281 sg13_lv_pmos ad=0.3468p pd=2.72u as=0.20145p ps=1.415u w=1.02u l=0.13u
X1674 VSS.t264 a_23461_14130# DFFQX1_5.D VSS.t1697 sg13_lv_nmos ad=0.1567p pd=1.27u as=0.2924p ps=2.4u w=0.86u l=0.13u
X1675 a_36461_12114# a_36393_12150# VDD.t845 VDD.t93 sg13_lv_pmos ad=0.3468p pd=2.72u as=0.20145p ps=1.415u w=1.02u l=0.13u
X1676 VSS.t1083 a_7901_8082# VSS.t783 VSS.t1814 sg13_lv_nmos ad=0.1672p pd=1.26u as=0 ps=0 w=0.88u l=5.575u
X1677 a_23629_15474# DFFQX1_5.Q VSS.t107 VSS.t1470 sg13_lv_nmos ad=0.102p pd=1.28u as=0.1567p ps=1.27u w=0.3u l=0.13u
X1678 a_11849_13136# a_11781_13210# VDD.t1721 VDD.t93 sg13_lv_pmos ad=0.1938p pd=1.4u as=0.1938p ps=1.4u w=1.02u l=0.13u
X1679 VSS.t921 a_3785_11792# VSS.t925 VSS.t924 sg13_lv_nmos ad=0.1672p pd=1.26u as=0 ps=0 w=0.88u l=5.575u
X1680 VDD.t116 a_28581_13494# VDD.t117 VDD.t100 sg13_lv_pmos ad=0.1938p pd=1.4u as=0 ps=0 w=1.02u l=5.575u
X1681 a_18401_6738# a_18333_6774# VDD.t227 VDD.t39 sg13_lv_pmos ad=0.3468p pd=2.72u as=0.20145p ps=1.415u w=1.02u l=0.13u
X1682 a_23965_15474# DFFQX1_7.Q VDD.t1132 VDD.t5 sg13_lv_pmos ad=0.1632p pd=1.64u as=0.2412p ps=1.73u w=0.48u l=0.13u
X1683 VDD.t1118 a_20769_8118# VDD.t1117 VDD.t29 sg13_lv_pmos ad=0.3468p pd=2.72u as=0 ps=0 w=1.02u l=5.575u
X1684 NAND2X1_0.A a_4981_15510# VDD.t659 VDD.t5 sg13_lv_pmos ad=0.4488p pd=3.32u as=0.2412p ps=1.73u w=1.32u l=0.13u
X1685 VDD.t682 a_1029_5430# a_1097_5394# VDD.t68 sg13_lv_pmos ad=0.1938p pd=1.4u as=0.1938p ps=1.4u w=1.02u l=0.13u
X1686 VSS.t238 a_13025_13458# VSS.t237 VSS.t236 sg13_lv_nmos ad=0.1672p pd=1.26u as=0 ps=0 w=0.88u l=5.575u
X1687 VSS.t774 a_32597_3728# VSS.t778 VSS.t777 sg13_lv_nmos ad=0.1672p pd=1.26u as=0 ps=0 w=0.88u l=5.575u
X1688 VDD.t1447 a_24717_6490# VDD.t1446 VDD.t68 sg13_lv_pmos ad=0.3468p pd=2.72u as=0 ps=0 w=1.02u l=5.575u
X1689 VSS.t542 a_24785_9104# VSS.t544 VSS.t543 sg13_lv_nmos ad=0.1672p pd=1.26u as=0 ps=0 w=0.88u l=5.575u
X1690 a_1029_13494# a_1097_13458# VSS.t497 VSS.t838 sg13_lv_nmos ad=0.2992p pd=2.44u as=0.1672p ps=1.26u w=0.88u l=0.13u
X1691 a_26213_8082# a_26145_8118# VDD.t652 VDD.t29 sg13_lv_pmos ad=0.3468p pd=2.72u as=0.20145p ps=1.415u w=1.02u l=0.13u
X1692 a_38057_2706# a_37989_2742# VDD.t1285 VDD.t354 sg13_lv_pmos ad=0.3468p pd=2.72u as=0.20145p ps=1.415u w=1.02u l=0.13u
X1693 VSS.t508 a_13025_10770# a_12957_10806# VSS.t510 sg13_lv_nmos ad=0.1672p pd=1.26u as=0.2992p ps=2.44u w=0.88u l=0.13u
X1694 VSS.t844 a_7901_10770# VSS.t844 VSS.t1726 sg13_lv_nmos ad=0.1672p pd=1.26u as=0 ps=0 w=0.88u l=5.575u
X1695 VSS.t869 a_34025_14802# a_33957_14838# VSS.t1126 sg13_lv_nmos ad=0.1738p pd=1.275u as=0.2992p ps=2.44u w=0.88u l=0.13u
X1696 VSS.t412 a_20837_6738# VSS.t414 VSS.t1038 sg13_lv_nmos ad=0.1672p pd=1.26u as=0 ps=0 w=0.88u l=5.575u
X1697 OR3X1_1.C BUFX3_27.Y VDD.t611 VDD.t0 sg13_lv_pmos ad=0.192p pd=1.76u as=91.2f ps=0.86u w=0.48u l=0.13u
X1698 a_31505_13136# a_31437_13210# VDD.t692 VDD.t93 sg13_lv_pmos ad=0.3468p pd=2.72u as=0.20145p ps=1.415u w=1.02u l=0.13u
X1699 VSS.t374 a_23525_8082# a_23457_8118# VSS.t1025 sg13_lv_nmos ad=0.1672p pd=1.26u as=0.2992p ps=2.44u w=0.88u l=0.13u
X1700 VDD.t1943 a_32529_7834# VDD.t1945 VDD.t39 sg13_lv_pmos ad=0.3468p pd=2.72u as=0 ps=0 w=1.02u l=5.575u
X1701 VDD.t707 a_37737_14838# VDD.t706 VDD.t5 sg13_lv_pmos ad=0.3468p pd=2.72u as=0 ps=0 w=1.02u l=1.945u
X1702 a_32597_10448# a_32529_10522# VDD.t630 VDD.t8 sg13_lv_pmos ad=0.1938p pd=1.4u as=0.1938p ps=1.4u w=1.02u l=0.13u
X1703 VSS.t212 a_31505_5072# VSS.t301 VSS.t300 sg13_lv_nmos ad=0.1738p pd=1.275u as=0 ps=0 w=0.88u l=1.945u
X1704 a_5381_15824# a_5313_15898# VDD.t433 VDD.t5 sg13_lv_pmos ad=0.3468p pd=2.72u as=0.20145p ps=1.415u w=1.02u l=0.13u
X1705 a_31337_14802# a_31269_14838# VDD.t784 VDD.t5 sg13_lv_pmos ad=0.1938p pd=1.4u as=0.1938p ps=1.4u w=1.02u l=0.13u
X1706 a_3785_10770# a_3717_10806# VDD.t1571 VDD.t281 sg13_lv_pmos ad=0.3468p pd=2.72u as=0.20145p ps=1.415u w=1.02u l=0.13u
X1707 VDD.t285 a_5145_10806# a_5213_10770# VDD.t281 sg13_lv_pmos ad=0.1938p pd=1.4u as=0.1938p ps=1.4u w=1.02u l=0.13u
X1708 a_8492_6438# a_8424_6524# VDD.t472 VDD.t68 sg13_lv_pmos ad=0.3332p pd=2.64u as=0.3332p ps=2.64u w=0.98u l=0.76u
X1709 VSS.t1337 a_11597_2706# a_11529_2742# VSS.t1650 sg13_lv_nmos ad=0.1738p pd=1.275u as=0.2992p ps=2.44u w=0.88u l=0.13u
X1710 a_38648_10470# a_38580_10556# VDD.t291 VDD.t8 sg13_lv_pmos ad=0.3332p pd=2.64u as=0.3332p ps=2.64u w=0.98u l=0.76u
X1711 VSS.t67 a_37973_11792# a_37905_11866# VSS.t66 sg13_lv_nmos ad=0.1738p pd=1.275u as=0.2992p ps=2.44u w=0.88u l=0.13u
X1712 VDD.t332 a_1029_5146# VDD.t331 VDD.t83 sg13_lv_pmos ad=0.3468p pd=2.72u as=0 ps=0 w=1.02u l=5.575u
X1713 VDD.t1975 a_1029_6774# VDD.t1974 VDD.t39 sg13_lv_pmos ad=0.3468p pd=2.72u as=0 ps=0 w=1.02u l=5.575u
X1714 a_22873_16146# BUFX3_38.Y VDD.t287 VDD.t0 sg13_lv_pmos ad=0.1632p pd=1.64u as=0.2412p ps=1.73u w=0.48u l=0.13u
X1715 VDD.t1843 a_24549_14838# a_24617_14802# VDD.t5 sg13_lv_pmos ad=0.1938p pd=1.4u as=0.1938p ps=1.4u w=1.02u l=0.13u
X1716 VSS.t896 BUFX3_1.Y.t2 a_23121_14906# VSS.t1200 sg13_lv_nmos ad=0.1193p pd=1.05u as=0.102p ps=1.28u w=0.3u l=0.13u
X1717 a_34025_13458# a_33957_13494# VDD.t881 VDD.t100 sg13_lv_pmos ad=0.3468p pd=2.72u as=0.20145p ps=1.415u w=1.02u l=0.13u
X1718 VDD.t274 a_19593_13210# a_19661_13136# VDD.t93 sg13_lv_pmos ad=0.1938p pd=1.4u as=0.1938p ps=1.4u w=1.02u l=0.13u
X1719 VDD.t1760 a_24717_13210# a_24785_13136# VDD.t93 sg13_lv_pmos ad=0.1938p pd=1.4u as=0.1938p ps=1.4u w=1.02u l=0.13u
X1720 a_38480_6752# a_38412_6788# VDD.t1426 VDD.t39 sg13_lv_pmos ad=0.3332p pd=2.64u as=0.3332p ps=2.64u w=0.98u l=0.76u
X1721 VSS.t520 a_1097_9104# VSS.t520 VSS.t623 sg13_lv_nmos ad=0.1672p pd=1.26u as=0 ps=0 w=0.88u l=5.575u
X1722 DFFQX1_0.D a_7333_16182# VDD.t1203 VDD.t0 sg13_lv_pmos ad=0.4488p pd=3.32u as=0.2412p ps=1.73u w=1.32u l=0.13u
X1723 VSS.t342 a_30161_13136# a_30093_13210# VSS.t987 sg13_lv_nmos ad=0.1738p pd=1.275u as=0.2992p ps=2.44u w=0.88u l=0.13u
X1724 a_7833_6774# a_7901_6738# VSS.t141 VSS.t287 sg13_lv_nmos ad=0.2992p pd=2.44u as=0.1672p ps=1.26u w=0.88u l=0.13u
X1725 VDD.t728 a_20769_10806# VDD.t727 VDD.t281 sg13_lv_pmos ad=0.1938p pd=1.4u as=0 ps=0 w=1.02u l=5.575u
X1726 a_9765_14838# a_9833_14802# VSS.t3 VSS.t1465 sg13_lv_nmos ad=0.2992p pd=2.44u as=0.1672p ps=1.26u w=0.88u l=0.13u
X1727 VSS.t53 a_1097_5394# VSS.t53 VSS.t434 sg13_lv_nmos ad=0.1672p pd=1.26u as=0 ps=0 w=0.88u l=5.575u
X1728 a_3717_13210# a_3785_13136# VSS.t501 VSS.t502 sg13_lv_nmos ad=0.2992p pd=2.44u as=0.1672p ps=1.26u w=0.88u l=0.13u
X1729 VSS.t1096 a_27557_12114# VSS.t998 VSS.t1701 sg13_lv_nmos ad=0.1738p pd=1.275u as=0 ps=0 w=0.88u l=1.945u
X1730 VSS.t880 a_24029_2706# VSS.t878 VSS.t879 sg13_lv_nmos ad=0.1672p pd=1.26u as=0 ps=0 w=0.88u l=5.575u
X1731 a_11849_5072# a_11781_5146# VDD.t902 VDD.t83 sg13_lv_pmos ad=0.1938p pd=1.4u as=0.1938p ps=1.4u w=1.02u l=0.13u
X1732 VSS.t766 a_20837_10770# VSS.t762 VSS.t765 sg13_lv_nmos ad=0.1672p pd=1.26u as=0 ps=0 w=0.88u l=5.575u
X1733 VDD.t1880 a_9093_13210# VDD.t1879 VDD.t93 sg13_lv_pmos ad=0.3468p pd=2.72u as=0 ps=0 w=1.02u l=5.575u
X1734 VSS.t559 a_6473_7760# a_6405_7834# VSS.t1827 sg13_lv_nmos ad=0.1738p pd=1.275u as=0.2992p ps=2.44u w=0.88u l=0.13u
X1735 VDD.t726 a_20769_10806# VDD.t725 VDD.t281 sg13_lv_pmos ad=0.3468p pd=2.72u as=0 ps=0 w=1.02u l=5.575u
X1736 VDD.t453 a_16905_3802# VDD.t452 VDD.t354 sg13_lv_pmos ad=0.1938p pd=1.4u as=0 ps=0 w=1.02u l=5.575u
X1737 VDD.t901 a_1365_10522# VDD.t899 VDD.t8 sg13_lv_pmos ad=0.1938p pd=1.4u as=0 ps=0 w=1.02u l=5.575u
X1738 VDD.t1211 a_18589_16146# BUFX3_17.A VDD.t0 sg13_lv_pmos ad=0.2412p pd=1.73u as=0.4488p ps=3.32u w=1.32u l=0.13u
X1739 VSS.t94 DFFQX1_0.D a_7589_15952# VSS.t615 sg13_lv_nmos ad=0.102p pd=1.28u as=27f ps=0.48u w=0.3u l=0.13u
X1740 VSS.t244 a_27473_14480# VSS.t248 VSS.t247 sg13_lv_nmos ad=0.1672p pd=1.26u as=0 ps=0 w=0.88u l=5.575u
X1741 VSS.t723 a_34277_2706# a_34209_2742# VSS.t722 sg13_lv_nmos ad=0.1738p pd=1.275u as=0.2992p ps=2.44u w=0.88u l=0.13u
X1742 VSS.t185 a_7901_6738# VSS.t284 VSS.t285 sg13_lv_nmos ad=0.1672p pd=1.26u as=0 ps=0 w=0.88u l=5.575u
X1743 a_11781_10522# a_11849_10448# VSS.t509 VSS.t1638 sg13_lv_nmos ad=0.2992p pd=2.44u as=0.1672p ps=1.26u w=0.88u l=0.13u
X1744 VSS.t381 a_1097_15824# VSS.t381 VSS.t1003 sg13_lv_nmos ad=0.1738p pd=1.275u as=0 ps=0 w=0.88u l=5.305u
X1745 BUFX3_26.Y a_6493_14838# VDD.t118 VDD.t5 sg13_lv_pmos ad=0.4488p pd=3.32u as=0.2412p ps=1.73u w=1.32u l=0.13u
X1746 VSS.t154 a_22873_16146# OR3X1_1.A VSS.t1000 sg13_lv_nmos ad=0.1567p pd=1.27u as=0.2924p ps=2.4u w=0.86u l=0.13u
X1747 a_15645_12150# a_15713_12114# VSS.t808 VSS.t809 sg13_lv_nmos ad=0.2992p pd=2.44u as=0.1672p ps=1.26u w=0.88u l=0.13u
X1748 a_18401_5394# a_18333_5430# VDD.t524 VDD.t68 sg13_lv_pmos ad=0.3468p pd=2.72u as=0.20145p ps=1.415u w=1.02u l=0.13u
X1749 VSS.t523 a_3785_9104# VSS.t526 VSS.t640 sg13_lv_nmos ad=0.1672p pd=1.26u as=0 ps=0 w=0.88u l=5.575u
X1750 VSS.t419 a_19745_4050# a_19677_4086# VSS.t418 sg13_lv_nmos ad=0.1738p pd=1.275u as=0.2992p ps=2.44u w=0.88u l=0.13u
X1751 a_24785_3728# a_24717_3802# VDD.t695 VDD.t354 sg13_lv_pmos ad=0.1938p pd=1.4u as=0.1938p ps=1.4u w=1.02u l=0.13u
X1752 VSS.t222 a_15713_5394# a_15645_5430# VSS.t322 sg13_lv_nmos ad=0.1672p pd=1.26u as=0.2992p ps=2.44u w=0.88u l=0.13u
X1753 VSS.t1573 a_1433_10448# a_1365_10522# VSS.t1574 sg13_lv_nmos ad=0.1672p pd=1.26u as=0.2992p ps=2.44u w=0.88u l=0.13u
X1754 VSS.t776 a_35285_3728# a_35217_3802# VSS.t1417 sg13_lv_nmos ad=0.1672p pd=1.26u as=0.2992p ps=2.44u w=0.88u l=0.13u
X1755 VSS.t861 a_8153_3728# VSS.t1377 VSS.t1376 sg13_lv_nmos ad=0.1738p pd=1.275u as=0 ps=0 w=0.88u l=1.945u
X1756 a_12793_16146# DFFQX1_3.Q VSS.t661 VSS.t1274 sg13_lv_nmos ad=0.102p pd=1.28u as=0.1567p ps=1.27u w=0.3u l=0.13u
X1757 a_3785_4050# a_3717_4086# VDD.t910 VDD.t83 sg13_lv_pmos ad=0.3468p pd=2.72u as=0.20145p ps=1.415u w=1.02u l=0.13u
X1758 VSS.t278 a_27473_9104# a_27405_9178# VSS.t277 sg13_lv_nmos ad=0.1672p pd=1.26u as=0.2992p ps=2.44u w=0.88u l=0.13u
X1759 a_14792_15846# a_14724_15932# VDD.t1566 VDD.t5 sg13_lv_pmos ad=0.3332p pd=2.64u as=0.3332p ps=2.64u w=0.98u l=0.76u
X1760 a_26213_10770# a_26145_10806# VDD.t1923 VDD.t281 sg13_lv_pmos ad=0.3468p pd=2.72u as=0.20145p ps=1.415u w=1.02u l=0.13u
X1761 a_9161_6416# a_9093_6490# VDD.t516 VDD.t68 sg13_lv_pmos ad=0.1938p pd=1.4u as=0.1938p ps=1.4u w=1.02u l=0.13u
X1762 VSS.t91 a_9161_9104# VSS.t24 VSS.t643 sg13_lv_nmos ad=0.1672p pd=1.26u as=0 ps=0 w=0.88u l=5.575u
X1763 a_32597_5072# a_32529_5146# VDD.t1459 VDD.t83 sg13_lv_pmos ad=0.1938p pd=1.4u as=0.1938p ps=1.4u w=1.02u l=0.13u
X1764 VSS.t787 a_23525_6738# a_23457_6774# VSS.t1293 sg13_lv_nmos ad=0.1672p pd=1.26u as=0.2992p ps=2.44u w=0.88u l=0.13u
X1765 VDD.t404 a_7833_10806# VDD.t403 VDD.t281 sg13_lv_pmos ad=0.1938p pd=1.4u as=0 ps=0 w=1.02u l=5.575u
X1766 VDD.t497 a_16905_10522# a_16973_10448# VDD.t8 sg13_lv_pmos ad=0.1938p pd=1.4u as=0.1938p ps=1.4u w=1.02u l=0.13u
X1767 a_7833_13494# a_7901_13458# VSS.t956 VSS.t957 sg13_lv_nmos ad=0.2992p pd=2.44u as=0.1672p ps=1.26u w=0.88u l=0.13u
X1768 a_27557_8082# a_27489_8118# VDD.t584 VDD.t29 sg13_lv_pmos ad=0.3468p pd=2.72u as=0.20145p ps=1.415u w=1.02u l=0.13u
X1769 a_27809_2706# a_27741_2742# VDD.t1770 VDD.t354 sg13_lv_pmos ad=0.1938p pd=1.4u as=0.1938p ps=1.4u w=1.02u l=0.13u
X1770 VSS.t588 a_31337_13458# a_31269_13494# VSS.t1510 sg13_lv_nmos ad=0.1672p pd=1.26u as=0.2992p ps=2.44u w=0.88u l=0.13u
X1771 a_3131_15770# a_3325_15532# a_3289_15572# VDD.t5 sg13_lv_pmos ad=91.2f pd=0.86u as=43.2f ps=0.66u w=0.48u l=0.13u
X1772 a_1097_4050# a_1029_4086# VDD.t85 VDD.t83 sg13_lv_pmos ad=0.1938p pd=1.4u as=0.1938p ps=1.4u w=1.02u l=0.13u
X1773 a_8492_5094# a_8424_5180# VDD.t1956 VDD.t83 sg13_lv_pmos ad=0.3332p pd=2.64u as=0.3332p ps=2.64u w=0.98u l=0.76u
X1774 a_9027_15045# a_8889_15244# VSS.t1 VSS.t150 sg13_lv_nmos ad=57f pd=0.68u as=57f ps=0.68u w=0.3u l=0.13u
X1775 VSS.t485 a_30161_6416# a_30093_6490# VSS.t688 sg13_lv_nmos ad=0.1738p pd=1.275u as=0.2992p ps=2.44u w=0.88u l=0.13u
X1776 a_6809_10448# a_6741_10522# VDD.t1669 VDD.t8 sg13_lv_pmos ad=0.3468p pd=2.72u as=0.20145p ps=1.415u w=1.02u l=0.13u
X1777 VDD.t680 a_1029_5430# VDD.t679 VDD.t68 sg13_lv_pmos ad=0.3468p pd=2.72u as=0 ps=0 w=1.02u l=5.575u
X1778 a_23525_12114# a_23457_12150# VDD.t1324 VDD.t93 sg13_lv_pmos ad=0.1938p pd=1.4u as=0.1938p ps=1.4u w=1.02u l=0.13u
X1779 VSS.t668 a_14537_7760# a_14469_7834# VSS.t667 sg13_lv_nmos ad=0.1738p pd=1.275u as=0.2992p ps=2.44u w=0.88u l=0.13u
X1780 VSS.t857 a_4121_3728# VSS.t859 VSS.t1093 sg13_lv_nmos ad=0.1672p pd=1.26u as=0 ps=0 w=0.88u l=5.575u
X1781 a_16891_15244# a_16687_14852# VDD.t370 VDD.t5 sg13_lv_pmos ad=43.2f pd=0.66u as=0.1632p ps=1.64u w=0.48u l=0.13u
X1782 VDD.t939 a_22281_11866# VDD.t938 VDD.t281 sg13_lv_pmos ad=0.3468p pd=2.72u as=0 ps=0 w=1.02u l=5.305u
X1783 VDD.t1896 a_37905_6490# VDD.t1895 VDD.t68 sg13_lv_pmos ad=0.3468p pd=2.72u as=0 ps=0 w=1.02u l=1.945u
X1784 a_20837_9426# a_20769_9462# VDD.t296 VDD.t8 sg13_lv_pmos ad=0.1938p pd=1.4u as=0.1938p ps=1.4u w=1.02u l=0.13u
X1785 a_15800_16160# a_15732_16196# VDD.t618 VDD.t0 sg13_lv_pmos ad=0.3332p pd=2.64u as=0.3332p ps=2.64u w=0.98u l=0.76u
X1786 a_38480_5408# a_38412_5444# VDD.t1902 VDD.t68 sg13_lv_pmos ad=0.3332p pd=2.64u as=0.3332p ps=2.64u w=0.98u l=0.76u
X1787 VDD.t383 a_19593_6490# a_19661_6416# VDD.t68 sg13_lv_pmos ad=0.1938p pd=1.4u as=0.1938p ps=1.4u w=1.02u l=0.13u
X1788 a_24785_14480# a_24717_14554# VDD.t710 VDD.t100 sg13_lv_pmos ad=0.1938p pd=1.4u as=0.1938p ps=1.4u w=1.02u l=0.13u
X1789 VDD.t1488 NAND4X2_0.C a_8407_16588# VDD.t0 sg13_lv_pmos ad=0.1632p pd=1.64u as=45.6f ps=0.67u w=0.48u l=0.13u
X1790 VDD.t1591 a_9093_11866# a_9161_11792# VDD.t281 sg13_lv_pmos ad=0.1938p pd=1.4u as=0.1938p ps=1.4u w=1.02u l=0.13u
X1791 a_35217_9178# a_35285_9104# VSS.t352 VSS.t351 sg13_lv_nmos ad=0.2992p pd=2.44u as=0.1672p ps=1.26u w=0.88u l=0.13u
X1792 VSS.t861 a_7901_4050# a_7833_4086# VSS.t1439 sg13_lv_nmos ad=0.1672p pd=1.26u as=0.2992p ps=2.44u w=0.88u l=0.13u
X1793 VSS.t139 a_18989_14480# VSS.t395 VSS.t1244 sg13_lv_nmos ad=0.1738p pd=1.275u as=0 ps=0 w=0.88u l=5.305u
X1794 DFFQX1_1.D a_3385_16182# VDD.t1198 VDD.t0 sg13_lv_pmos ad=0.4488p pd=3.32u as=0.2412p ps=1.73u w=1.32u l=0.13u
X1795 a_7817_11792# a_7749_11866# VDD.t701 VDD.t281 sg13_lv_pmos ad=0.3468p pd=2.72u as=0.20145p ps=1.415u w=1.02u l=0.13u
X1796 a_37805_12114# a_37737_12150# VDD.t926 VDD.t93 sg13_lv_pmos ad=0.3468p pd=2.72u as=0.20145p ps=1.415u w=1.02u l=0.13u
X1797 VDD.t864 a_31521_2742# VDD.t863 VDD.t354 sg13_lv_pmos ad=0.1938p pd=1.4u as=0 ps=0 w=1.02u l=5.575u
X1798 AOI21BX2_1.A a_20857_15510# VDD.t1139 VDD.t5 sg13_lv_pmos ad=0.4488p pd=3.32u as=0.2412p ps=1.73u w=1.32u l=0.13u
X1799 VSS.t1384 a_11849_13136# a_11781_13210# VSS.t1524 sg13_lv_nmos ad=0.1672p pd=1.26u as=0.2992p ps=2.44u w=0.88u l=0.13u
X1800 VDD.t1680 a_35217_14554# VDD.t1679 VDD.t100 sg13_lv_pmos ad=0.1938p pd=1.4u as=0 ps=0 w=1.02u l=5.575u
X1801 VSS.t209 a_30161_5072# VSS.t212 VSS.t849 sg13_lv_nmos ad=0.1738p pd=1.275u as=0 ps=0 w=0.88u l=5.305u
X1802 VSS.t336 a_15713_4050# VSS.t314 VSS.t865 sg13_lv_nmos ad=0.1672p pd=1.26u as=0 ps=0 w=0.88u l=5.575u
X1803 VSS.t410 a_19661_6416# a_19593_6490# VSS.t409 sg13_lv_nmos ad=0.1672p pd=1.26u as=0.2992p ps=2.44u w=0.88u l=0.13u
X1804 VDD.t1216 a_12957_14838# VDD.t1215 VDD.t5 sg13_lv_pmos ad=0.1938p pd=1.4u as=0 ps=0 w=1.02u l=5.575u
X1805 a_17321_15244# a_16687_14852# a_17091_15045# VSS.t376 sg13_lv_nmos ad=57f pd=0.68u as=57f ps=0.68u w=0.3u l=0.13u
X1806 VDD.t656 a_36393_8118# VDD.t655 VDD.t29 sg13_lv_pmos ad=0.3468p pd=2.72u as=0 ps=0 w=1.02u l=5.305u
X1807 VSS.t520 a_1097_9104# a_1029_9178# VSS.t621 sg13_lv_nmos ad=0.1672p pd=1.26u as=0.2992p ps=2.44u w=0.88u l=0.13u
X1808 DFFQX1_5.CK a_15318_15510# VDD.t1157 VDD.t5 sg13_lv_pmos ad=0.2508p pd=1.7u as=0.2508p ps=1.7u w=1.32u l=0.13u
X1809 NOR3X1_0.C BUFX3_2.A VDD.t1310 VDD.t5 sg13_lv_pmos ad=0.1862p pd=1.36u as=0.3332p ps=2.64u w=0.98u l=0.13u
X1810 VSS.t209 a_28649_5394# VSS.t208 VSS.t207 sg13_lv_nmos ad=0.1672p pd=1.26u as=0 ps=0 w=0.88u l=5.575u
X1811 VDD.t1002 a_35217_5146# VDD.t1000 VDD.t83 sg13_lv_pmos ad=0.1938p pd=1.4u as=0 ps=0 w=1.02u l=5.575u
X1812 VDD.t449 a_19677_4086# VDD.t447 VDD.t83 sg13_lv_pmos ad=0.3468p pd=2.72u as=0 ps=0 w=1.02u l=1.945u
X1813 a_5213_6738# a_5145_6774# VDD.t217 VDD.t39 sg13_lv_pmos ad=0.1938p pd=1.4u as=0.1938p ps=1.4u w=1.02u l=0.13u
X1814 VDD.t55 a_30093_15898# VDD.t54 VDD.t5 sg13_lv_pmos ad=0.3468p pd=2.72u as=0 ps=0 w=1.02u l=5.305u
X1815 VDD.t1176 a_18803_15170# a_18767_15244# VDD.t5 sg13_lv_pmos ad=0.2529p pd=1.545u as=43.2f ps=0.66u w=0.48u l=0.13u
X1816 VSS.t904 a_17459_15170# a_17435_14900# VSS.t905 sg13_lv_nmos ad=0.1519p pd=1.265u as=27f ps=0.48u w=0.3u l=0.13u
X1817 VSS.t811 a_24785_10448# a_24717_10522# VSS.t810 sg13_lv_nmos ad=0.1672p pd=1.26u as=0.2992p ps=2.44u w=0.88u l=0.13u
X1818 VSS.t1573 reset_n_i a_1033_10134# VSS.t1611 sg13_lv_nmos ad=0.1567p pd=1.27u as=0.102p ps=1.28u w=0.3u l=0.13u
X1819 a_12957_4086# a_13025_4050# VSS.t314 VSS.t946 sg13_lv_nmos ad=0.2992p pd=2.44u as=0.1672p ps=1.26u w=0.88u l=0.13u
X1820 DFFQX1_6.D a_21193_16182# VDD.t1220 VDD.t0 sg13_lv_pmos ad=0.4488p pd=3.32u as=0.2412p ps=1.73u w=1.32u l=0.13u
X1821 VDD.t819 a_12957_6774# a_13025_6738# VDD.t39 sg13_lv_pmos ad=0.1938p pd=1.4u as=0.1938p ps=1.4u w=1.02u l=0.13u
X1822 VSS.t160 BUFX3_17.A a_17833_15510# VSS.t1273 sg13_lv_nmos ad=0.1567p pd=1.27u as=0.102p ps=1.28u w=0.3u l=0.13u
X1823 VSS.t197 a_5213_5394# VSS.t57 VSS.t196 sg13_lv_nmos ad=0.1672p pd=1.26u as=0 ps=0 w=0.88u l=5.575u
X1824 VSS.t869 a_32597_14480# VSS.t872 VSS.t871 sg13_lv_nmos ad=0.1672p pd=1.26u as=0 ps=0 w=0.88u l=5.575u
X1825 VDD.t989 a_14469_3802# VDD.t988 VDD.t354 sg13_lv_pmos ad=0.3468p pd=2.72u as=0 ps=0 w=1.02u l=5.305u
X1826 VSS.t374 a_20837_8082# VSS.t179 VSS.t1078 sg13_lv_nmos ad=0.1672p pd=1.26u as=0 ps=0 w=0.88u l=5.575u
X1827 VDD.t1548 a_31269_13494# VDD.t1547 VDD.t100 sg13_lv_pmos ad=0.3468p pd=2.72u as=0 ps=0 w=1.02u l=5.575u
X1828 VSS.t588 a_31505_13136# VSS.t755 VSS.t754 sg13_lv_nmos ad=0.1738p pd=1.275u as=0 ps=0 w=0.88u l=1.945u
X1829 NAND3X1_0.Y BUFX3_0.Y a_7777_14852# VSS.t84 sg13_lv_nmos ad=0.12p pd=1.4u as=57f ps=0.68u w=0.3u l=0.13u
X1830 VSS.t550 a_27473_7760# VSS.t552 VSS.t713 sg13_lv_nmos ad=0.1672p pd=1.26u as=0 ps=0 w=0.88u l=5.575u
X1831 a_27405_11866# a_27473_11792# VSS.t1098 VSS.t1290 sg13_lv_nmos ad=0.2992p pd=2.44u as=0.1672p ps=1.26u w=0.88u l=0.13u
X1832 VSS.t451 a_3785_9426# VSS.t520 VSS.t521 sg13_lv_nmos ad=0.1738p pd=1.275u as=0 ps=0 w=0.88u l=1.945u
X1833 VSS.t425 a_31505_3728# a_31437_3802# VSS.t495 sg13_lv_nmos ad=0.1738p pd=1.275u as=0.2992p ps=2.44u w=0.88u l=0.13u
X1834 VDD.t225 a_7833_6774# VDD.t226 VDD.t39 sg13_lv_pmos ad=0.1938p pd=1.4u as=0 ps=0 w=1.02u l=5.575u
X1835 VSS.t264 OR3X1_1.Y a_23425_14838# VSS.t1723 sg13_lv_nmos ad=0.2176p pd=1.96u as=0.1216p ps=1.02u w=0.64u l=0.13u
X1836 VSS.t224 a_1433_3728# a_1365_3802# VSS.t1839 sg13_lv_nmos ad=0.1672p pd=1.26u as=0.2992p ps=2.44u w=0.88u l=0.13u
X1837 VDD.t1346 a_22281_5146# VDD.t1345 VDD.t83 sg13_lv_pmos ad=0.3468p pd=2.72u as=0 ps=0 w=1.02u l=5.305u
X1838 VDD.t119 a_7241_14816# AND2X1_1.Y VDD.t5 sg13_lv_pmos ad=91.2f pd=0.86u as=0.192p ps=1.76u w=0.48u l=0.13u
X1839 VDD.t1449 a_24717_6490# a_24785_6416# VDD.t68 sg13_lv_pmos ad=0.1938p pd=1.4u as=0.1938p ps=1.4u w=1.02u l=0.13u
X1840 a_11933_13458# a_11865_13494# VDD.t1499 VDD.t100 sg13_lv_pmos ad=0.3468p pd=2.72u as=0.20145p ps=1.415u w=1.02u l=0.13u
X1841 a_19593_13210# a_19661_13136# VSS.t968 VSS.t977 sg13_lv_nmos ad=0.2992p pd=2.44u as=0.1672p ps=1.26u w=0.88u l=0.13u
X1842 VDD.t322 a_32529_6490# VDD.t320 VDD.t68 sg13_lv_pmos ad=0.1938p pd=1.4u as=0 ps=0 w=1.02u l=5.575u
X1843 a_27405_6490# a_27473_6416# VSS.t485 VSS.t486 sg13_lv_nmos ad=0.2992p pd=2.44u as=0.1672p ps=1.26u w=0.88u l=0.13u
X1844 a_35285_10448# a_35217_10522# VDD.t550 VDD.t8 sg13_lv_pmos ad=0.1938p pd=1.4u as=0.1938p ps=1.4u w=1.02u l=0.13u
X1845 VSS.t7 a_13025_10770# VSS.t509 VSS.t511 sg13_lv_nmos ad=0.1672p pd=1.26u as=0 ps=0 w=0.88u l=5.575u
X1846 a_13025_10770# a_12957_10806# VDD.t1643 VDD.t281 sg13_lv_pmos ad=0.1938p pd=1.4u as=0.1938p ps=1.4u w=1.02u l=0.13u
X1847 a_24717_7834# a_24785_7760# VSS.t550 VSS.t677 sg13_lv_nmos ad=0.2992p pd=2.44u as=0.1672p ps=1.26u w=0.88u l=0.13u
X1848 a_1097_12114# a_1029_12150# VDD.t719 VDD.t93 sg13_lv_pmos ad=0.1938p pd=1.4u as=0.1938p ps=1.4u w=1.02u l=0.13u
X1849 a_8623_14852# a_8421_14920# VDD.t381 VDD.t5 sg13_lv_pmos ad=0.3332p pd=2.64u as=0.1834p ps=1.39u w=0.98u l=0.13u
X1850 a_17069_14144# BUFX3_1.Y.t1 a_17197_14656# VSS.t1199 sg13_lv_nmos ad=0.102p pd=1.28u as=57f ps=0.68u w=0.3u l=0.13u
X1851 a_28649_4050# a_28581_4086# VDD.t1574 VDD.t83 sg13_lv_pmos ad=0.1938p pd=1.4u as=0.1938p ps=1.4u w=1.02u l=0.13u
X1852 VSS.t1507 a_31505_14480# a_31437_14554# VSS.t1787 sg13_lv_nmos ad=0.1738p pd=1.275u as=0.2992p ps=2.44u w=0.88u l=0.13u
X1853 VDD.t914 a_7833_4086# VDD.t913 VDD.t83 sg13_lv_pmos ad=0.3468p pd=2.72u as=0 ps=0 w=1.02u l=5.575u
X1854 VDD.t1817 a_19677_10806# VDD.t1816 VDD.t281 sg13_lv_pmos ad=0.3468p pd=2.72u as=0 ps=0 w=1.02u l=1.945u
X1855 VSS.t11 a_35369_16146# a_35301_16182# VSS.t10 sg13_lv_nmos ad=0.1738p pd=1.275u as=0.2992p ps=2.44u w=0.88u l=0.13u
X1856 a_7241_14816# BUFX3_1.Y.t5 a_7369_14852# VSS.t1609 sg13_lv_nmos ad=0.102p pd=1.28u as=57f ps=0.68u w=0.3u l=0.13u
X1857 a_17497_14130# BUFX3_3.A VDD.t179 VDD.t100 sg13_lv_pmos ad=0.1632p pd=1.64u as=0.2412p ps=1.73u w=0.48u l=0.13u
X1858 a_32529_10522# a_32597_10448# VSS.t18 VSS.t270 sg13_lv_nmos ad=0.2992p pd=2.44u as=0.1672p ps=1.26u w=0.88u l=0.13u
X1859 VDD.t407 a_30093_9178# VDD.t406 VDD.t29 sg13_lv_pmos ad=0.3468p pd=2.72u as=0 ps=0 w=1.02u l=5.305u
X1860 VSS.t922 a_3785_11792# a_3717_11866# VSS.t923 sg13_lv_nmos ad=0.1672p pd=1.26u as=0.2992p ps=2.44u w=0.88u l=0.13u
X1861 VSS.t441 a_18401_4050# a_18333_4086# VSS.t440 sg13_lv_nmos ad=0.1738p pd=1.275u as=0.2992p ps=2.44u w=0.88u l=0.13u
X1862 a_28649_13458# a_28581_13494# VDD.t113 VDD.t100 sg13_lv_pmos ad=0.1938p pd=1.4u as=0.1938p ps=1.4u w=1.02u l=0.13u
X1863 VDD.t289 NOR3X1_0.A a_22903_13948# VDD.t100 sg13_lv_pmos ad=0.1632p pd=1.64u as=91.2f ps=0.86u w=0.48u l=0.13u
X1864 a_5213_5394# a_5145_5430# VDD.t72 VDD.t68 sg13_lv_pmos ad=0.1938p pd=1.4u as=0.1938p ps=1.4u w=1.02u l=0.13u
X1865 VSS.t811 a_23525_10770# VSS.t764 VSS.t1626 sg13_lv_nmos ad=0.1672p pd=1.26u as=0 ps=0 w=0.88u l=5.575u
X1866 VDD.t599 a_23457_10806# VDD.t598 VDD.t281 sg13_lv_pmos ad=0.3468p pd=2.72u as=0 ps=0 w=1.02u l=5.575u
X1867 VDD.t1715 a_7749_14554# VDD.t1714 VDD.t100 sg13_lv_pmos ad=0.3468p pd=2.72u as=0 ps=0 w=1.02u l=1.945u
X1868 a_22635_14192# a_22497_14228# VSS.t896 VSS.t1559 sg13_lv_nmos ad=57f pd=0.68u as=57f ps=0.68u w=0.3u l=0.13u
X1869 VDD.t973 a_4053_10522# VDD.t972 VDD.t8 sg13_lv_pmos ad=0.1938p pd=1.4u as=0 ps=0 w=1.02u l=5.575u
X1870 a_34025_9426# a_33957_9462# VDD.t26 VDD.t8 sg13_lv_pmos ad=0.3468p pd=2.72u as=0.20145p ps=1.415u w=1.02u l=0.13u
X1871 VSS.t475 a_3785_6416# VSS.t474 VSS.t473 sg13_lv_nmos ad=0.1672p pd=1.26u as=0 ps=0 w=0.88u l=5.575u
X1872 VSS.t844 a_8153_10448# VSS.t844 VSS.t1105 sg13_lv_nmos ad=0.1738p pd=1.275u as=0 ps=0 w=0.88u l=1.945u
X1873 VSS.t197 a_7817_5072# VSS.t1785 VSS.t1784 sg13_lv_nmos ad=0.1738p pd=1.275u as=0 ps=0 w=0.88u l=1.945u
X1874 VDD.t632 a_32529_10522# a_32597_10448# VDD.t8 sg13_lv_pmos ad=0.1938p pd=1.4u as=0.1938p ps=1.4u w=1.02u l=0.13u
X1875 VDD.t251 a_12957_5430# a_13025_5394# VDD.t68 sg13_lv_pmos ad=0.1938p pd=1.4u as=0.1938p ps=1.4u w=1.02u l=0.13u
X1876 VSS.t165 a_1097_7760# VSS.t165 VSS.t166 sg13_lv_nmos ad=0.1672p pd=1.26u as=0 ps=0 w=0.88u l=5.575u
X1877 VSS.t45 a_35369_8082# a_35301_8118# VSS.t173 sg13_lv_nmos ad=0.1738p pd=1.275u as=0.2992p ps=2.44u w=0.88u l=0.13u
X1878 VDD.t787 a_31269_14838# a_31337_14802# VDD.t5 sg13_lv_pmos ad=0.1938p pd=1.4u as=0.1938p ps=1.4u w=1.02u l=0.13u
X1879 VSS.t514 a_34025_12114# VSS.t705 VSS.t1729 sg13_lv_nmos ad=0.1738p pd=1.275u as=0 ps=0 w=0.88u l=5.305u
X1880 VSS.t113 DFFQX1_7.Q a_27157_16182# VSS.t1402 sg13_lv_nmos ad=0.1567p pd=1.27u as=0.102p ps=1.28u w=0.3u l=0.13u
X1881 VSS.t787 a_20837_6738# VSS.t412 VSS.t1039 sg13_lv_nmos ad=0.1672p pd=1.26u as=0 ps=0 w=0.88u l=5.575u
X1882 a_30161_14480# a_30093_14554# VDD.t983 VDD.t100 sg13_lv_pmos ad=0.3468p pd=2.72u as=0.20145p ps=1.415u w=1.02u l=0.13u
X1883 VDD.t1691 a_9093_3802# VDD.t1690 VDD.t354 sg13_lv_pmos ad=0.1938p pd=1.4u as=0 ps=0 w=1.02u l=5.575u
X1884 VSS.t970 a_4121_10448# a_4053_10522# VSS.t969 sg13_lv_nmos ad=0.1672p pd=1.26u as=0.2992p ps=2.44u w=0.88u l=0.13u
X1885 VSS.t62 a_10589_5394# VSS.t64 VSS.t488 sg13_lv_nmos ad=0.1738p pd=1.275u as=0 ps=0 w=0.88u l=5.305u
X1886 VSS.t381 a_3785_16146# a_3717_16182# VSS.t380 sg13_lv_nmos ad=0.1738p pd=1.275u as=0.2992p ps=2.44u w=0.88u l=0.13u
X1887 BUFX24_2.A a_12714_15510# VDD.t1169 VDD.t5 sg13_lv_pmos ad=0.2508p pd=1.7u as=0.2508p ps=1.7u w=1.32u l=0.13u
X1888 VDD.t1926 a_19593_9178# VDD.t1927 VDD.t29 sg13_lv_pmos ad=0.3468p pd=2.72u as=0 ps=0 w=1.02u l=5.575u
X1889 VDD.t1761 a_24717_13210# VDD.t1760 VDD.t93 sg13_lv_pmos ad=0.1938p pd=1.4u as=0 ps=0 w=1.02u l=5.575u
X1890 VDD.t441 a_7833_5430# VDD.t440 VDD.t68 sg13_lv_pmos ad=0.1938p pd=1.4u as=0 ps=0 w=1.02u l=5.575u
X1891 VDD.t199 a_31269_8118# a_31337_8082# VDD.t29 sg13_lv_pmos ad=0.1938p pd=1.4u as=0.1938p ps=1.4u w=1.02u l=0.13u
X1892 VSS.t1573 a_1433_10448# VSS.t1573 VSS.t1576 sg13_lv_nmos ad=0.1672p pd=1.26u as=0 ps=0 w=0.88u l=5.575u
X1893 VSS.t200 a_15713_5394# VSS.t325 VSS.t326 sg13_lv_nmos ad=0.1672p pd=1.26u as=0 ps=0 w=0.88u l=5.575u
X1894 VSS.t172 a_11849_7760# VSS.t668 VSS.t1036 sg13_lv_nmos ad=0.1672p pd=1.26u as=0 ps=0 w=0.88u l=5.575u
X1895 VSS.t404 a_24365_16146# a_24297_16182# VSS.t1238 sg13_lv_nmos ad=0.1672p pd=1.26u as=0.2992p ps=2.44u w=0.88u l=0.13u
X1896 VSS.t231 a_11933_4050# a_11865_4086# VSS.t750 sg13_lv_nmos ad=0.1738p pd=1.275u as=0.2992p ps=2.44u w=0.88u l=0.13u
X1897 VSS.t1513 a_34025_13458# a_33957_13494# VSS.t1570 sg13_lv_nmos ad=0.1738p pd=1.275u as=0.2992p ps=2.44u w=0.88u l=0.13u
X1898 VDD.t1759 a_24717_13210# VDD.t1758 VDD.t93 sg13_lv_pmos ad=0.3468p pd=2.72u as=0 ps=0 w=1.02u l=5.575u
X1899 VDD.t125 a_31437_10522# VDD.t124 VDD.t8 sg13_lv_pmos ad=0.3468p pd=2.72u as=0 ps=0 w=1.02u l=1.945u
X1900 a_11933_6738# a_11865_6774# VDD.t507 VDD.t39 sg13_lv_pmos ad=0.3468p pd=2.72u as=0.20145p ps=1.415u w=1.02u l=0.13u
X1901 VSS.t663 a_15318_15510# DFFQX1_5.CK VSS.t1132 sg13_lv_nmos ad=0.1634p pd=1.24u as=0.1634p ps=1.24u w=0.86u l=0.13u
X1902 a_23693_11792# a_23625_11866# VDD.t944 VDD.t281 sg13_lv_pmos ad=0.3468p pd=2.72u as=0.20145p ps=1.415u w=1.02u l=0.13u
X1903 a_37973_15824# a_37905_15898# VDD.t165 VDD.t5 sg13_lv_pmos ad=0.3468p pd=2.72u as=0.20145p ps=1.415u w=1.02u l=0.13u
X1904 VSS.t305 a_37805_5394# VSS.t305 VSS.t306 sg13_lv_nmos ad=0.1738p pd=1.275u as=0 ps=0 w=0.88u l=1.945u
X1905 VSS.t1191 a_11009_15824# a_10941_15898# VSS.t1190 sg13_lv_nmos ad=0.1738p pd=1.275u as=0.2992p ps=2.44u w=0.88u l=0.13u
X1906 VDD.t1523 a_20181_2742# VDD.t1522 VDD.t354 sg13_lv_pmos ad=0.1938p pd=1.4u as=0 ps=0 w=1.02u l=5.575u
X1907 VDD.t1557 a_35301_16182# VDD.t1556 VDD.t0 sg13_lv_pmos ad=0.3468p pd=2.72u as=0 ps=0 w=1.02u l=5.305u
X1908 a_22383_15045# a_22245_15244# VSS.t602 VSS.t966 sg13_lv_nmos ad=57f pd=0.68u as=57f ps=0.68u w=0.3u l=0.13u
X1909 VDD.t1778 a_3717_14554# a_3785_14480# VDD.t100 sg13_lv_pmos ad=0.1938p pd=1.4u as=0.1938p ps=1.4u w=1.02u l=0.13u
X1910 BUFX24_2.A a_12714_15510# VDD.t1166 VDD.t5 sg13_lv_pmos ad=0.2508p pd=1.7u as=0.2508p ps=1.7u w=1.32u l=0.13u
X1911 VDD.t1836 a_18435_15045# a_18399_15244# VDD.t5 sg13_lv_pmos ad=91.2f pd=0.86u as=43.2f ps=0.66u w=0.48u l=0.13u
X1912 VSS.t755 a_32597_13136# a_32529_13210# VSS.t1550 sg13_lv_nmos ad=0.1672p pd=1.26u as=0.2992p ps=2.44u w=0.88u l=0.13u
X1913 VDD.t1961 a_11529_2742# VDD.t1960 VDD.t354 sg13_lv_pmos ad=0.3468p pd=2.72u as=0 ps=0 w=1.02u l=1.945u
X1914 a_19745_8082# a_19677_8118# VDD.t800 VDD.t29 sg13_lv_pmos ad=0.3468p pd=2.72u as=0.20145p ps=1.415u w=1.02u l=0.13u
X1915 VSS.t20 a_37805_10770# a_37737_10806# VSS.t19 sg13_lv_nmos ad=0.1738p pd=1.275u as=0.2992p ps=2.44u w=0.88u l=0.13u
X1916 a_8265_16258# a_8001_16258# VSS.t94 VSS.t93 sg13_lv_nmos ad=57f pd=0.68u as=61.5f ps=0.71u w=0.3u l=0.13u
X1917 a_27473_14480# a_27405_14554# VDD.t929 VDD.t100 sg13_lv_pmos ad=0.1938p pd=1.4u as=0.1938p ps=1.4u w=1.02u l=0.13u
X1918 a_7817_2706# a_7749_2742# VDD.t1336 VDD.t354 sg13_lv_pmos ad=0.3468p pd=2.72u as=0.20145p ps=1.415u w=1.02u l=0.13u
X1919 VDD.t1584 a_11781_11866# a_11849_11792# VDD.t281 sg13_lv_pmos ad=0.1938p pd=1.4u as=0.1938p ps=1.4u w=1.02u l=0.13u
X1920 a_23693_6416# a_23625_6490# VDD.t243 VDD.t68 sg13_lv_pmos ad=0.3468p pd=2.72u as=0.20145p ps=1.415u w=1.02u l=0.13u
X1921 VSS.t1121 a_7297_15682# a_7221_15952# VSS.t1232 sg13_lv_nmos ad=57f pd=0.68u as=57f ps=0.68u w=0.3u l=0.13u
X1922 VSS.t14 a_18757_15474# AOI21BX1_0.B VSS.t13 sg13_lv_nmos ad=0.1567p pd=1.27u as=0.2924p ps=2.4u w=0.86u l=0.13u
X1923 VDD.t445 a_18333_4086# VDD.t444 VDD.t83 sg13_lv_pmos ad=0.3468p pd=2.72u as=0 ps=0 w=1.02u l=5.305u
X1924 BUFX3_25.Y a_16153_14838# VSS.t362 VSS.t361 sg13_lv_nmos ad=0.2924p pd=2.4u as=0.1567p ps=1.27u w=0.86u l=0.13u
X1925 a_22779_15952# a_22399_15524# a_22665_15572# VSS.t1230 sg13_lv_nmos ad=27f pd=0.48u as=57f ps=0.68u w=0.3u l=0.13u
X1926 VSS.t206 a_27557_5394# a_27489_5430# VSS.t744 sg13_lv_nmos ad=0.1738p pd=1.275u as=0.2992p ps=2.44u w=0.88u l=0.13u
X1927 VSS.t374 a_23693_7760# a_23625_7834# VSS.t846 sg13_lv_nmos ad=0.1738p pd=1.275u as=0.2992p ps=2.44u w=0.88u l=0.13u
X1928 VSS.t11 a_37469_16146# VSS.t11 VSS.t10 sg13_lv_nmos ad=0.1738p pd=1.275u as=0 ps=0 w=0.88u l=5.305u
X1929 VSS.t663 BUFX24_2.A a_15318_15510# VSS.t1250 sg13_lv_nmos ad=0.1634p pd=1.24u as=0.2924p ps=2.4u w=0.86u l=0.13u
X1930 VSS.t355 a_22349_9104# a_22281_9178# VSS.t368 sg13_lv_nmos ad=0.1738p pd=1.275u as=0.2992p ps=2.44u w=0.88u l=0.13u
X1931 a_35217_14554# a_35285_14480# VSS.t444 VSS.t443 sg13_lv_nmos ad=0.2992p pd=2.44u as=0.1672p ps=1.26u w=0.88u l=0.13u
X1932 VSS.t238 a_14537_13136# a_14469_13210# VSS.t1356 sg13_lv_nmos ad=0.1738p pd=1.275u as=0.2992p ps=2.44u w=0.88u l=0.13u
X1933 VSS.t41 a_31337_8082# VSS.t468 VSS.t1822 sg13_lv_nmos ad=0.1672p pd=1.26u as=0 ps=0 w=0.88u l=5.575u
X1934 VDD.t895 a_27405_10522# VDD.t893 VDD.t8 sg13_lv_pmos ad=0.1938p pd=1.4u as=0 ps=0 w=1.02u l=5.575u
X1935 VSS.t20 a_35369_10770# VSS.t18 VSS.t1535 sg13_lv_nmos ad=0.1738p pd=1.275u as=0 ps=0 w=0.88u l=1.945u
X1936 AND2X1_2.Y a_8001_14852# VSS.t109 VSS.t1058 sg13_lv_nmos ad=0.12p pd=1.4u as=57f ps=0.68u w=0.3u l=0.13u
X1937 VSS.t139 OR3BX1_0.B a_18573_14575# VSS.t138 sg13_lv_nmos ad=0.102p pd=1.28u as=57f ps=0.68u w=0.3u l=0.13u
X1938 VDD.t1006 a_5145_4086# VDD.t1005 VDD.t83 sg13_lv_pmos ad=0.1938p pd=1.4u as=0 ps=0 w=1.02u l=5.575u
X1939 VSS.t336 a_16973_3728# a_16905_3802# VSS.t960 sg13_lv_nmos ad=0.1672p pd=1.26u as=0.2992p ps=2.44u w=0.88u l=0.13u
X1940 a_32597_16146# a_32529_16182# VDD.t1562 VDD.t0 sg13_lv_pmos ad=0.3468p pd=2.72u as=0.20145p ps=1.415u w=1.02u l=0.13u
X1941 a_22231_14180# a_22029_14280# VDD.t621 VDD.t100 sg13_lv_pmos ad=0.3332p pd=2.64u as=0.1834p ps=1.39u w=0.98u l=0.13u
X1942 VSS.t478 a_6473_6416# a_6405_6490# VSS.t686 sg13_lv_nmos ad=0.1738p pd=1.275u as=0.2992p ps=2.44u w=0.88u l=0.13u
X1943 VSS.t457 a_35369_6738# a_35301_6774# VSS.t1339 sg13_lv_nmos ad=0.1738p pd=1.275u as=0.2992p ps=2.44u w=0.88u l=0.13u
X1944 VSS.t1573 a_1097_10770# VSS.t1573 VSS.t1674 sg13_lv_nmos ad=0.1672p pd=1.26u as=0 ps=0 w=0.88u l=5.575u
X1945 VDD.t1920 a_12621_2742# VDD.t1919 VDD.t354 sg13_lv_pmos ad=0.1938p pd=1.4u as=0 ps=0 w=1.02u l=5.575u
X1946 VSS.t554 BUFX3_2.A a_17167_15938# VSS.t1278 sg13_lv_nmos ad=61.5f pd=0.71u as=27f ps=0.48u w=0.3u l=0.13u
X1947 VDD.t1803 a_1029_10806# VDD.t1802 VDD.t281 sg13_lv_pmos ad=0.3468p pd=2.72u as=0 ps=0 w=1.02u l=5.575u
X1948 VDD.t1712 a_34209_2742# VDD.t1711 VDD.t354 sg13_lv_pmos ad=0.3468p pd=2.72u as=0 ps=0 w=1.02u l=1.945u
X1949 VDD.t496 a_16905_10522# VDD.t495 VDD.t8 sg13_lv_pmos ad=0.3468p pd=2.72u as=0 ps=0 w=1.02u l=5.575u
X1950 a_36461_6738# a_36393_6774# VDD.t1398 VDD.t39 sg13_lv_pmos ad=0.3468p pd=2.72u as=0.20145p ps=1.415u w=1.02u l=0.13u
X1951 VDD.t1638 a_37905_14554# VDD.t1637 VDD.t100 sg13_lv_pmos ad=0.3468p pd=2.72u as=0 ps=0 w=1.02u l=1.945u
X1952 VDD.t1173 a_12714_15510# BUFX24_2.A VDD.t5 sg13_lv_pmos ad=0.2508p pd=1.7u as=0.2508p ps=1.7u w=1.32u l=0.13u
X1953 a_6809_3728# a_6741_3802# VDD.t1904 VDD.t354 sg13_lv_pmos ad=0.3468p pd=2.72u as=0.20145p ps=1.415u w=1.02u l=0.13u
X1954 VDD.t1661 a_11781_3802# a_11849_3728# VDD.t354 sg13_lv_pmos ad=0.1938p pd=1.4u as=0.1938p ps=1.4u w=1.02u l=0.13u
X1955 VSS.t813 a_27473_10448# a_27405_10522# VSS.t817 sg13_lv_nmos ad=0.1672p pd=1.26u as=0.2992p ps=2.44u w=0.88u l=0.13u
X1956 VDD.t1262 a_3717_16182# VDD.t1260 VDD.t0 sg13_lv_pmos ad=0.3468p pd=2.72u as=0 ps=0 w=1.02u l=1.945u
X1957 VDD.t1155 a_1029_14554# VDD.t1153 VDD.t100 sg13_lv_pmos ad=0.1938p pd=1.4u as=0 ps=0 w=1.02u l=5.575u
X1958 VSS.t956 a_7901_13458# VSS.t954 VSS.t955 sg13_lv_nmos ad=0.1672p pd=1.26u as=0 ps=0 w=0.88u l=5.575u
X1959 VSS.t50 a_38648_6438# a_38580_6524# VSS.t49 sg13_lv_nmos ad=0.2176p pd=1.96u as=0.2176p ps=1.96u w=0.64u l=0.76u
X1960 VSS.t796 a_15881_11792# a_15813_11866# VSS.t797 sg13_lv_nmos ad=0.1738p pd=1.275u as=0.2992p ps=2.44u w=0.88u l=0.13u
X1961 VDD.t123 a_9027_15045# a_8991_15244# VDD.t5 sg13_lv_pmos ad=91.2f pd=0.86u as=43.2f ps=0.66u w=0.48u l=0.13u
X1962 VDD.t941 a_23003_14188# a_22967_14228# VDD.t100 sg13_lv_pmos ad=0.2529p pd=1.545u as=43.2f ps=0.66u w=0.48u l=0.13u
X1963 a_5213_13458# a_5145_13494# VDD.t1597 VDD.t100 sg13_lv_pmos ad=0.1938p pd=1.4u as=0.1938p ps=1.4u w=1.02u l=0.13u
X1964 VSS.t922 a_1097_12114# VSS.t922 VSS.t1317 sg13_lv_nmos ad=0.1672p pd=1.26u as=0 ps=0 w=0.88u l=5.575u
X1965 VSS.t310 a_4460_4064# a_4392_4100# VSS.t309 sg13_lv_nmos ad=0.2176p pd=1.96u as=0.2176p ps=1.96u w=0.64u l=0.76u
X1966 VSS.t216 a_13025_5394# a_12957_5430# VSS.t1771 sg13_lv_nmos ad=0.1672p pd=1.26u as=0.2992p ps=2.44u w=0.88u l=0.13u
X1967 VDD.t1249 a_24297_16182# VDD.t1248 VDD.t0 sg13_lv_pmos ad=0.3468p pd=2.72u as=0 ps=0 w=1.02u l=5.575u
X1968 a_5129_2706# a_5061_2742# VDD.t1825 VDD.t354 sg13_lv_pmos ad=0.1938p pd=1.4u as=0.1938p ps=1.4u w=1.02u l=0.13u
X1969 VDD.t1306 a_3969_14838# VDD.t1305 VDD.t5 sg13_lv_pmos ad=0.3468p pd=2.72u as=0 ps=0 w=1.02u l=1.945u
X1970 VSS.t316 a_23693_11792# VSS.t320 VSS.t892 sg13_lv_nmos ad=0.1738p pd=1.275u as=0 ps=0 w=0.88u l=1.945u
X1971 VDD.t1010 a_11865_4086# VDD.t1009 VDD.t83 sg13_lv_pmos ad=0.3468p pd=2.72u as=0 ps=0 w=1.02u l=1.945u
X1972 XOR2X1_0.Y BUFX3_0.Y a_3309_15244# VDD.t5 sg13_lv_pmos ad=93.59999f pd=0.87u as=91.2f ps=0.86u w=0.48u l=0.13u
X1973 VDD.t882 a_33957_13494# VDD.t881 VDD.t100 sg13_lv_pmos ad=0.3468p pd=2.72u as=0 ps=0 w=1.02u l=5.305u
X1974 a_11933_5394# a_11865_5430# VDD.t245 VDD.t68 sg13_lv_pmos ad=0.3468p pd=2.72u as=0.20145p ps=1.415u w=1.02u l=0.13u
X1975 VDD.t63 a_23457_6774# VDD.t62 VDD.t39 sg13_lv_pmos ad=0.3468p pd=2.72u as=0 ps=0 w=1.02u l=5.575u
X1976 VSS.t57 a_6473_5072# VSS.t197 VSS.t1782 sg13_lv_nmos ad=0.1738p pd=1.275u as=0 ps=0 w=0.88u l=5.305u
X1977 a_5145_10806# a_5213_10770# VSS.t583 VSS.t584 sg13_lv_nmos ad=0.2992p pd=2.44u as=0.1672p ps=1.26u w=0.88u l=0.13u
X1978 VSS.t1384 a_11849_13136# VSS.t237 VSS.t1523 sg13_lv_nmos ad=0.1672p pd=1.26u as=0 ps=0 w=0.88u l=5.575u
X1979 VSS.t698 a_16973_13136# VSS.t702 VSS.t701 sg13_lv_nmos ad=0.1672p pd=1.26u as=0 ps=0 w=0.88u l=5.575u
X1980 VSS.t970 a_3785_10770# VSS.t1573 VSS.t1706 sg13_lv_nmos ad=0.1738p pd=1.275u as=0 ps=0 w=0.88u l=1.945u
X1981 VDD.t159 a_16905_9178# VDD.t157 VDD.t29 sg13_lv_pmos ad=0.1938p pd=1.4u as=0 ps=0 w=1.02u l=5.575u
X1982 VSS.t190 a_14537_6416# a_14469_6490# VSS.t189 sg13_lv_nmos ad=0.1738p pd=1.275u as=0.2992p ps=2.44u w=0.88u l=0.13u
X1983 VSS.t1423 a_15713_10770# VSS.t9 VSS.t1634 sg13_lv_nmos ad=0.1672p pd=1.26u as=0 ps=0 w=0.88u l=5.575u
X1984 VDD.t197 a_31269_8118# VDD.t196 VDD.t29 sg13_lv_pmos ad=0.3468p pd=2.72u as=0 ps=0 w=1.02u l=5.575u
X1985 VDD.t955 a_23625_3802# VDD.t954 VDD.t354 sg13_lv_pmos ad=0.3468p pd=2.72u as=0 ps=0 w=1.02u l=1.945u
X1986 a_9429_16182# a_9497_16146# VSS.t610 VSS.t609 sg13_lv_nmos ad=0.2992p pd=2.44u as=0.1672p ps=1.26u w=0.88u l=0.13u
X1987 VSS.t330 a_23525_5394# VSS.t328 VSS.t329 sg13_lv_nmos ad=0.1672p pd=1.26u as=0 ps=0 w=0.88u l=5.575u
X1988 VSS.t349 a_11933_12114# a_11865_12150# VSS.t363 sg13_lv_nmos ad=0.1738p pd=1.275u as=0.2992p ps=2.44u w=0.88u l=0.13u
X1989 VSS.t1121 DFFQX1_0.Q a_6997_16182# VSS.t1259 sg13_lv_nmos ad=0.1567p pd=1.27u as=0.102p ps=1.28u w=0.3u l=0.13u
X1990 VDD.t474 a_35217_6490# VDD.t473 VDD.t68 sg13_lv_pmos ad=0.3468p pd=2.72u as=0 ps=0 w=1.02u l=5.575u
X1991 VSS.t36 a_35285_9104# VSS.t352 VSS.t1063 sg13_lv_nmos ad=0.1672p pd=1.26u as=0 ps=0 w=0.88u l=5.575u
X1992 VSS.t103 a_3023_15792# BUFX3_12.A VSS.t1225 sg13_lv_nmos ad=0.1519p pd=1.265u as=0.102p ps=1.28u w=0.3u l=0.13u
X1993 VDD.t979 a_12957_4086# VDD.t978 VDD.t83 sg13_lv_pmos ad=0.1938p pd=1.4u as=0 ps=0 w=1.02u l=5.575u
X1994 a_21844_15932# OR3BX1_0.B a_21742_15932# VSS.t134 sg13_lv_nmos ad=0.1216p pd=1.02u as=0.1216p ps=1.02u w=0.64u l=0.13u
X1995 a_24785_9104# a_24717_9178# VDD.t641 VDD.t29 sg13_lv_pmos ad=0.1938p pd=1.4u as=0.1938p ps=1.4u w=1.02u l=0.13u
X1996 VSS.t661 a_12714_15510# BUFX24_2.A VSS.t1146 sg13_lv_nmos ad=0.1634p pd=1.24u as=0.1634p ps=1.24u w=0.86u l=0.13u
X1997 VSS.t229 a_10589_4050# a_10521_4086# VSS.t228 sg13_lv_nmos ad=0.1738p pd=1.275u as=0.2992p ps=2.44u w=0.88u l=0.13u
X1998 VSS.t453 a_31337_6738# VSS.t297 VSS.t1088 sg13_lv_nmos ad=0.1672p pd=1.26u as=0 ps=0 w=0.88u l=5.575u
X1999 VDD.t410 a_3717_8118# VDD.t409 VDD.t29 sg13_lv_pmos ad=0.3468p pd=2.72u as=0 ps=0 w=1.02u l=1.945u
X2000 VSS.t43 a_34025_8082# a_33957_8118# VSS.t1080 sg13_lv_nmos ad=0.1738p pd=1.275u as=0.2992p ps=2.44u w=0.88u l=0.13u
X2001 VSS.t925 a_6473_11792# a_6405_11866# VSS.t1303 sg13_lv_nmos ad=0.1738p pd=1.275u as=0.2992p ps=2.44u w=0.88u l=0.13u
X2002 a_35369_10770# a_35301_10806# VDD.t1354 VDD.t281 sg13_lv_pmos ad=0.3468p pd=2.72u as=0.20145p ps=1.415u w=1.02u l=0.13u
X2003 VSS.t857 a_5213_4050# a_5145_4086# VSS.t856 sg13_lv_nmos ad=0.1672p pd=1.26u as=0.2992p ps=2.44u w=0.88u l=0.13u
X2004 VSS.t305 a_36461_5394# VSS.t305 VSS.t306 sg13_lv_nmos ad=0.1738p pd=1.275u as=0 ps=0 w=0.88u l=5.305u
X2005 VSS.t918 a_27305_14802# VSS.t244 VSS.t917 sg13_lv_nmos ad=0.1738p pd=1.275u as=0 ps=0 w=0.88u l=1.945u
X2006 a_36461_5394# a_36393_5430# VDD.t262 VDD.t68 sg13_lv_pmos ad=0.3468p pd=2.72u as=0.20145p ps=1.415u w=1.02u l=0.13u
X2007 VDD.t312 a_32529_15898# VDD.t311 VDD.t5 sg13_lv_pmos ad=0.3468p pd=2.72u as=0 ps=0 w=1.02u l=5.575u
X2008 VSS.t314 a_15881_3728# VSS.t336 VSS.t335 sg13_lv_nmos ad=0.1738p pd=1.275u as=0 ps=0 w=0.88u l=1.945u
X2009 VDD.t697 a_24717_3802# VDD.t696 VDD.t354 sg13_lv_pmos ad=0.1938p pd=1.4u as=0 ps=0 w=1.02u l=5.575u
X2010 VDD.t1924 a_26145_10806# VDD.t1923 VDD.t281 sg13_lv_pmos ad=0.3468p pd=2.72u as=0 ps=0 w=1.02u l=5.305u
X2011 VDD.t922 a_15645_4086# VDD.t921 VDD.t83 sg13_lv_pmos ad=0.1938p pd=1.4u as=0 ps=0 w=1.02u l=5.575u
X2012 VDD.t773 a_7833_13494# a_7901_13458# VDD.t100 sg13_lv_pmos ad=0.1938p pd=1.4u as=0.1938p ps=1.4u w=1.02u l=0.13u
X2013 a_16973_13136# a_16905_13210# VDD.t108 VDD.t93 sg13_lv_pmos ad=0.1938p pd=1.4u as=0.1938p ps=1.4u w=1.02u l=0.13u
X2014 VSS.t312 a_13025_4050# VSS.t752 VSS.t944 sg13_lv_nmos ad=0.1672p pd=1.26u as=0 ps=0 w=0.88u l=5.575u
X2015 VSS.t706 a_32597_11792# VSS.t705 VSS.t704 sg13_lv_nmos ad=0.1672p pd=1.26u as=0 ps=0 w=0.88u l=5.575u
X2016 VSS.t251 a_37805_4050# a_37737_4086# VSS.t250 sg13_lv_nmos ad=0.1738p pd=1.275u as=0.2992p ps=2.44u w=0.88u l=0.13u
X2017 VDD.t601 a_23457_10806# a_23525_10770# VDD.t281 sg13_lv_pmos ad=0.1938p pd=1.4u as=0.1938p ps=1.4u w=1.02u l=0.13u
X2018 VDD.t1232 BUFX3_2.A a_17073_15938# VDD.t5 sg13_lv_pmos ad=98.39999f pd=0.89u as=91.2f ps=0.86u w=0.48u l=0.13u
X2019 a_7901_4050# a_7833_4086# VDD.t913 VDD.t83 sg13_lv_pmos ad=0.1938p pd=1.4u as=0.1938p ps=1.4u w=1.02u l=0.13u
X2020 VDD.t1669 a_6741_10522# VDD.t1668 VDD.t8 sg13_lv_pmos ad=0.3468p pd=2.72u as=0 ps=0 w=1.02u l=5.305u
X2021 VDD.t721 a_1029_12150# a_1097_12114# VDD.t93 sg13_lv_pmos ad=0.1938p pd=1.4u as=0.1938p ps=1.4u w=1.02u l=0.13u
X2022 OAI21X1_0.A BUFX3_16.A VSS.t160 VSS.t556 sg13_lv_nmos ad=0.102p pd=1.28u as=0.102p ps=1.28u w=0.3u l=0.13u
X2023 VDD.t1413 a_8841_2742# VDD.t1412 VDD.t354 sg13_lv_pmos ad=0.1938p pd=1.4u as=0 ps=0 w=1.02u l=5.575u
X2024 a_23525_4050# a_23457_4086# VDD.t456 VDD.t83 sg13_lv_pmos ad=0.1938p pd=1.4u as=0.1938p ps=1.4u w=1.02u l=0.13u
X2025 VDD.t401 a_7833_10806# VDD.t400 VDD.t281 sg13_lv_pmos ad=0.3468p pd=2.72u as=0 ps=0 w=1.02u l=5.575u
X2026 a_4460_6752# a_4392_6788# VDD.t815 VDD.t39 sg13_lv_pmos ad=0.3332p pd=2.64u as=0.3332p ps=2.64u w=0.98u l=0.76u
X2027 VDD.t829 a_23457_5430# VDD.t828 VDD.t68 sg13_lv_pmos ad=0.3468p pd=2.72u as=0 ps=0 w=1.02u l=5.575u
X2028 VDD.t798 a_6405_9178# VDD.t797 VDD.t29 sg13_lv_pmos ad=0.3468p pd=2.72u as=0 ps=0 w=1.02u l=5.305u
X2029 a_37973_3728# a_37905_3802# VDD.t849 VDD.t354 sg13_lv_pmos ad=0.3468p pd=2.72u as=0.20145p ps=1.415u w=1.02u l=0.13u
X2030 VSS.t216 a_11933_5394# VSS.t62 VSS.t691 sg13_lv_nmos ad=0.1738p pd=1.275u as=0 ps=0 w=0.88u l=1.945u
X2031 VDD.t1441 a_15645_13494# VDD.t1440 VDD.t100 sg13_lv_pmos ad=0.1938p pd=1.4u as=0 ps=0 w=1.02u l=5.575u
X2032 VSS.t208 a_27473_5072# VSS.t209 VSS.t980 sg13_lv_nmos ad=0.1672p pd=1.26u as=0 ps=0 w=0.88u l=5.575u
X2033 VSS.t579 a_4121_10448# VSS.t581 VSS.t972 sg13_lv_nmos ad=0.1672p pd=1.26u as=0 ps=0 w=0.88u l=5.575u
X2034 VSS.t481 a_27473_6416# VSS.t483 VSS.t482 sg13_lv_nmos ad=0.1672p pd=1.26u as=0 ps=0 w=0.88u l=5.575u
X2035 VDD.t287 a_22873_16146# OR3X1_1.A VDD.t0 sg13_lv_pmos ad=0.2412p pd=1.73u as=0.4488p ps=3.32u w=1.32u l=0.13u
X2036 VDD.t1203 AND2X1_1.Y a_7333_16182# VDD.t0 sg13_lv_pmos ad=0.2412p pd=1.73u as=0.1632p ps=1.64u w=0.48u l=0.13u
X2037 VDD.t534 a_27405_13210# VDD.t533 VDD.t93 sg13_lv_pmos ad=0.3468p pd=2.72u as=0 ps=0 w=1.02u l=5.575u
X2038 VDD.t1479 a_11865_12150# VDD.t1477 VDD.t93 sg13_lv_pmos ad=0.3468p pd=2.72u as=0 ps=0 w=1.02u l=1.945u
X2039 a_35285_3728# a_35217_3802# VDD.t1536 VDD.t354 sg13_lv_pmos ad=0.1938p pd=1.4u as=0.1938p ps=1.4u w=1.02u l=0.13u
X2040 VSS.t1503 a_10589_10770# VSS.t1688 VSS.t1836 sg13_lv_nmos ad=0.1738p pd=1.275u as=0 ps=0 w=0.88u l=5.305u
X2041 VSS.t1240 a_24365_16146# VSS.t407 VSS.t1242 sg13_lv_nmos ad=0.1672p pd=1.26u as=0 ps=0 w=0.88u l=5.575u
X2042 VSS.t156 a_32281_16146# counter_value_o[6] VSS.t1152 sg13_lv_nmos ad=0.1567p pd=1.27u as=0.2924p ps=2.4u w=0.86u l=0.13u
X2043 a_22865_14228# a_22231_14180# a_22635_14192# VSS.t990 sg13_lv_nmos ad=57f pd=0.68u as=57f ps=0.68u w=0.3u l=0.13u
X2044 VSS.t204 a_26213_5394# a_26145_5430# VSS.t203 sg13_lv_nmos ad=0.1738p pd=1.275u as=0.2992p ps=2.44u w=0.88u l=0.13u
X2045 VSS.t131 a_28649_9426# VSS.t129 VSS.t1012 sg13_lv_nmos ad=0.1672p pd=1.26u as=0 ps=0 w=0.88u l=5.575u
X2046 a_24717_6490# a_24785_6416# VSS.t481 VSS.t739 sg13_lv_nmos ad=0.2992p pd=2.44u as=0.1672p ps=1.26u w=0.88u l=0.13u
X2047 BUFX24_2.A a_12714_15510# VSS.t661 VSS.t1149 sg13_lv_nmos ad=0.2924p pd=2.4u as=0.1634p ps=1.24u w=0.86u l=0.13u
X2048 a_15713_9426# a_15645_9462# VDD.t131 VDD.t8 sg13_lv_pmos ad=0.1938p pd=1.4u as=0.1938p ps=1.4u w=1.02u l=0.13u
X2049 VSS.t1549 a_35285_13136# a_35217_13210# VSS.t1553 sg13_lv_nmos ad=0.1672p pd=1.26u as=0.2992p ps=2.44u w=0.88u l=0.13u
X2050 VDD.t118 BUFX3_26.A a_6493_14838# VDD.t5 sg13_lv_pmos ad=0.2412p pd=1.73u as=0.1632p ps=1.64u w=0.48u l=0.13u
X2051 VDD.t1470 a_10521_4086# VDD.t1469 VDD.t83 sg13_lv_pmos ad=0.3468p pd=2.72u as=0 ps=0 w=1.02u l=5.305u
X2052 VSS.t455 a_34025_6738# a_33957_6774# VSS.t1330 sg13_lv_nmos ad=0.1738p pd=1.275u as=0.2992p ps=2.44u w=0.88u l=0.13u
X2053 a_31269_5430# a_31337_5394# VSS.t490 VSS.t749 sg13_lv_nmos ad=0.2992p pd=2.44u as=0.1672p ps=1.26u w=0.88u l=0.13u
X2054 OR3X1_1.B NAND4X2_0.C VDD.t1222 VDD.t5 sg13_lv_pmos ad=0.1862p pd=1.36u as=0.1862p ps=1.36u w=0.98u l=0.13u
X2055 VDD.t1004 a_5145_4086# VDD.t1003 VDD.t83 sg13_lv_pmos ad=0.3468p pd=2.72u as=0 ps=0 w=1.02u l=5.575u
X2056 a_31505_3728# a_31437_3802# VDD.t1626 VDD.t354 sg13_lv_pmos ad=0.3468p pd=2.72u as=0.20145p ps=1.415u w=1.02u l=0.13u
X2057 a_8623_14852# a_8421_14920# VSS.t74 VSS.t400 sg13_lv_nmos ad=0.2176p pd=1.96u as=0.1193p ps=1.05u w=0.64u l=0.13u
X2058 a_20769_10806# a_20837_10770# VSS.t764 VSS.t763 sg13_lv_nmos ad=0.2992p pd=2.44u as=0.1672p ps=1.26u w=0.88u l=0.13u
X2059 VDD.t1706 a_36393_14838# VDD.t1705 VDD.t5 sg13_lv_pmos ad=0.3468p pd=2.72u as=0 ps=0 w=1.02u l=5.305u
X2060 VDD.t638 a_14469_9178# VDD.t639 VDD.t29 sg13_lv_pmos ad=0.3468p pd=2.72u as=0 ps=0 w=1.02u l=5.305u
X2061 VSS.t60 a_9161_5072# VSS.t64 VSS.t63 sg13_lv_nmos ad=0.1672p pd=1.26u as=0 ps=0 w=0.88u l=5.575u
X2062 VDD.t677 a_31437_6490# VDD.t676 VDD.t68 sg13_lv_pmos ad=0.3468p pd=2.72u as=0 ps=0 w=1.02u l=1.945u
X2063 a_16905_10522# a_16973_10448# VSS.t1393 VSS.t1425 sg13_lv_nmos ad=0.2992p pd=2.44u as=0.1672p ps=1.26u w=0.88u l=0.13u
X2064 OAI21X1_2.Y BUFX3_27.Y a_20775_14852# VSS.t600 sg13_lv_nmos ad=0.102p pd=1.28u as=57f ps=0.68u w=0.3u l=0.13u
X2065 VDD.t1607 a_37737_4086# VDD.t1606 VDD.t83 sg13_lv_pmos ad=0.3468p pd=2.72u as=0 ps=0 w=1.02u l=1.945u
X2066 a_14537_7760# a_14469_7834# VDD.t47 VDD.t39 sg13_lv_pmos ad=0.3468p pd=2.72u as=0.20145p ps=1.415u w=1.02u l=0.13u
X2067 a_18905_16146# a_18837_16182# VDD.t1245 VDD.t0 sg13_lv_pmos ad=0.3468p pd=2.72u as=0.20145p ps=1.415u w=1.02u l=0.13u
X2068 VSS.t663 a_13109_16146# VSS.t665 VSS.t666 sg13_lv_nmos ad=0.1672p pd=1.26u as=0 ps=0 w=0.88u l=5.575u
X2069 a_22350_16146# OA21X2_1.Y a_22484_16182# VSS.t1018 sg13_lv_nmos ad=0.102p pd=1.28u as=0.12375p ps=1.125u w=0.3u l=0.13u
X2070 a_6559_15572# NAND2X1_0.Y BUFX3_26.A VDD.t5 sg13_lv_pmos ad=45.6f pd=0.67u as=91.2f ps=0.86u w=0.48u l=0.13u
X2071 VSS.t264 NOR3X1_0.A a_23803_14838# VSS.t263 sg13_lv_nmos ad=0.1193p pd=1.05u as=0.12375p ps=1.125u w=0.3u l=0.13u
X2072 VSS.t67 a_36461_12114# VSS.t67 VSS.t66 sg13_lv_nmos ad=0.1738p pd=1.275u as=0 ps=0 w=0.88u l=5.305u
X2073 VSS.t181 a_19745_8082# VSS.t177 VSS.t548 sg13_lv_nmos ad=0.1738p pd=1.275u as=0 ps=0 w=0.88u l=1.945u
X2074 a_17423_15244# a_16687_14852# a_17321_15244# VDD.t5 sg13_lv_pmos ad=43.2f pd=0.66u as=91.2f ps=0.86u w=0.48u l=0.13u
X2075 a_21525_14180# OR3X1_1.B VSS.t137 VSS.t397 sg13_lv_nmos ad=57f pd=0.68u as=0.102p ps=1.28u w=0.3u l=0.13u
X2076 VDD.t625 a_19593_10522# VDD.t624 VDD.t8 sg13_lv_pmos ad=0.3468p pd=2.72u as=0 ps=0 w=1.02u l=5.575u
X2077 a_17067_14900# a_16687_14852# a_16953_15244# VSS.t375 sg13_lv_nmos ad=27f pd=0.48u as=57f ps=0.68u w=0.3u l=0.13u
X2078 VSS.t441 a_16973_3728# VSS.t419 VSS.t962 sg13_lv_nmos ad=0.1672p pd=1.26u as=0 ps=0 w=0.88u l=5.575u
X2079 VSS.t475 a_1097_6416# VSS.t475 VSS.t728 sg13_lv_nmos ad=0.1672p pd=1.26u as=0 ps=0 w=0.88u l=5.575u
X2080 VSS.t101 a_17816_14502# a_17748_14588# VSS.t1667 sg13_lv_nmos ad=0.2176p pd=1.96u as=0.2176p ps=1.96u w=0.64u l=0.76u
X2081 VDD.t1779 a_3717_14554# VDD.t1778 VDD.t100 sg13_lv_pmos ad=0.1938p pd=1.4u as=0 ps=0 w=1.02u l=5.575u
X2082 a_4460_5408# a_4392_5444# VDD.t393 VDD.t68 sg13_lv_pmos ad=0.3332p pd=2.64u as=0.3332p ps=2.64u w=0.98u l=0.76u
X2083 BUFX3_2.Y a_18085_14166# VDD.t1146 VDD.t100 sg13_lv_pmos ad=0.4488p pd=3.32u as=0.2412p ps=1.73u w=1.32u l=0.13u
X2084 a_20769_4086# a_20837_4050# VSS.t769 VSS.t1742 sg13_lv_nmos ad=0.2992p pd=2.44u as=0.1672p ps=1.26u w=0.88u l=0.13u
X2085 VDD.t309 a_1029_9178# VDD.t308 VDD.t29 sg13_lv_pmos ad=0.1938p pd=1.4u as=0 ps=0 w=1.02u l=5.575u
X2086 VDD.t1167 a_12714_15510# BUFX24_2.A VDD.t5 sg13_lv_pmos ad=0.2508p pd=1.7u as=0.2508p ps=1.7u w=1.32u l=0.13u
X2087 a_22291_13948# OR3X1_1.C a_22197_13608# VDD.t100 sg13_lv_pmos ad=71.99999f pd=0.78u as=0.1632p ps=1.64u w=0.48u l=0.13u
X2088 VDD.t826 a_20769_6774# a_20837_6738# VDD.t39 sg13_lv_pmos ad=0.1938p pd=1.4u as=0.1938p ps=1.4u w=1.02u l=0.13u
X2089 VSS.t20 a_37973_10448# VSS.t20 VSS.t19 sg13_lv_nmos ad=0.1738p pd=1.275u as=0 ps=0 w=0.88u l=1.945u
X2090 BUFX3_4.A NAND3X1_0.Y a_8265_16258# VSS.t16 sg13_lv_nmos ad=58.5f pd=0.69u as=57f ps=0.68u w=0.3u l=0.13u
X2091 VSS.t404 a_24785_15824# VSS.t407 VSS.t406 sg13_lv_nmos ad=0.1672p pd=1.26u as=0 ps=0 w=0.88u l=5.575u
X2092 a_9093_11866# a_9161_11792# VSS.t349 VSS.t350 sg13_lv_nmos ad=0.2992p pd=2.44u as=0.1672p ps=1.26u w=0.88u l=0.13u
X2093 VSS.t268 a_31337_10770# VSS.t266 VSS.t760 sg13_lv_nmos ad=0.1672p pd=1.26u as=0 ps=0 w=0.88u l=5.575u
X2094 VSS.t1364 a_18401_12114# VSS.t808 VSS.t1462 sg13_lv_nmos ad=0.1738p pd=1.275u as=0 ps=0 w=0.88u l=5.305u
X2095 VSS.t330 a_24785_5072# a_24717_5146# VSS.t1379 sg13_lv_nmos ad=0.1672p pd=1.26u as=0.2992p ps=2.44u w=0.88u l=0.13u
X2096 VSS.t821 a_27473_10448# VSS.t819 VSS.t822 sg13_lv_nmos ad=0.1672p pd=1.26u as=0 ps=0 w=0.88u l=5.575u
X2097 VSS.t1 a_9833_14802# a_9765_14838# VSS.t1464 sg13_lv_nmos ad=0.1672p pd=1.26u as=0.2992p ps=2.44u w=0.88u l=0.13u
X2098 VDD.t1777 a_3717_14554# VDD.t1776 VDD.t100 sg13_lv_pmos ad=0.3468p pd=2.72u as=0 ps=0 w=1.02u l=5.575u
X2099 a_16973_7760# a_16905_7834# VDD.t349 VDD.t39 sg13_lv_pmos ad=0.1938p pd=1.4u as=0.1938p ps=1.4u w=1.02u l=0.13u
X2100 a_11781_5146# a_11849_5072# VSS.t218 VSS.t219 sg13_lv_nmos ad=0.2992p pd=2.44u as=0.1672p ps=1.26u w=0.88u l=0.13u
X2101 a_17497_14130# BUFX3_3.A VSS.t152 VSS.t151 sg13_lv_nmos ad=0.102p pd=1.28u as=0.1567p ps=1.27u w=0.3u l=0.13u
X2102 VSS.t717 a_11849_6416# VSS.t190 VSS.t1765 sg13_lv_nmos ad=0.1672p pd=1.26u as=0 ps=0 w=0.88u l=5.575u
X2103 a_7817_7760# a_7749_7834# VDD.t594 VDD.t39 sg13_lv_pmos ad=0.3468p pd=2.72u as=0.20145p ps=1.415u w=1.02u l=0.13u
X2104 VDD.t1251 a_24297_16182# a_24365_16146# VDD.t0 sg13_lv_pmos ad=0.1938p pd=1.4u as=0.1938p ps=1.4u w=1.02u l=0.13u
X2105 VSS.t1305 a_7817_11792# VSS.t1388 VSS.t1387 sg13_lv_nmos ad=0.1738p pd=1.275u as=0 ps=0 w=0.88u l=1.945u
X2106 VDD.t795 a_28581_9462# a_28649_9426# VDD.t8 sg13_lv_pmos ad=0.1938p pd=1.4u as=0.1938p ps=1.4u w=1.02u l=0.13u
X2107 a_20000_14816# a_19932_14852# VDD.t1835 VDD.t5 sg13_lv_pmos ad=0.3332p pd=2.64u as=0.3332p ps=2.64u w=0.98u l=0.76u
X2108 VDD.t531 a_30093_5146# VDD.t530 VDD.t83 sg13_lv_pmos ad=0.3468p pd=2.72u as=0 ps=0 w=1.02u l=5.305u
X2109 VSS.t81 a_1097_14480# VSS.t81 VSS.t1714 sg13_lv_nmos ad=0.1672p pd=1.26u as=0 ps=0 w=0.88u l=5.575u
X2110 a_23457_4086# a_23525_4050# VSS.t832 VSS.t831 sg13_lv_nmos ad=0.2992p pd=2.44u as=0.1672p ps=1.26u w=0.88u l=0.13u
X2111 VSS.t231 a_11849_3728# a_11781_3802# VSS.t1537 sg13_lv_nmos ad=0.1672p pd=1.26u as=0.2992p ps=2.44u w=0.88u l=0.13u
X2112 VDD.t867 a_23625_10522# VDD.t866 VDD.t8 sg13_lv_pmos ad=0.3468p pd=2.72u as=0 ps=0 w=1.02u l=1.945u
X2113 VSS.t1411 a_23189_13458# a_23121_13494# VSS.t1410 sg13_lv_nmos ad=0.1672p pd=1.26u as=0.2992p ps=2.44u w=0.88u l=0.13u
X2114 VSS.t1098 a_30161_11792# VSS.t1100 VSS.t1663 sg13_lv_nmos ad=0.1738p pd=1.275u as=0 ps=0 w=0.88u l=5.305u
X2115 VDD.t1372 a_31269_6774# VDD.t1373 VDD.t39 sg13_lv_pmos ad=0.1938p pd=1.4u as=0 ps=0 w=1.02u l=5.575u
X2116 a_32529_7834# a_32597_7760# VSS.t45 VSS.t46 sg13_lv_nmos ad=0.2992p pd=2.44u as=0.1672p ps=1.26u w=0.88u l=0.13u
X2117 a_23803_15306# OR3X1_1.B VDD.t376 VDD.t5 sg13_lv_pmos ad=43.2f pd=0.66u as=0.1632p ps=1.64u w=0.48u l=0.13u
X2118 VSS.t935 a_19661_11792# VSS.t936 VSS.t1366 sg13_lv_nmos ad=0.1672p pd=1.26u as=0 ps=0 w=0.88u l=5.575u
X2119 VDD.t575 a_1029_8118# a_1097_8082# VDD.t29 sg13_lv_pmos ad=0.1938p pd=1.4u as=0.1938p ps=1.4u w=1.02u l=0.13u
X2120 VDD.t504 a_27405_7834# a_27473_7760# VDD.t39 sg13_lv_pmos ad=0.1938p pd=1.4u as=0.1938p ps=1.4u w=1.02u l=0.13u
X2121 a_21391_15175# OR3X1_0.Y BUFX3_29.A VDD.t5 sg13_lv_pmos ad=0.3332p pd=2.64u as=0.1862p ps=1.36u w=0.98u l=0.13u
X2122 VSS.t318 a_24785_11792# VSS.t998 VSS.t1406 sg13_lv_nmos ad=0.1672p pd=1.26u as=0 ps=0 w=0.88u l=5.575u
X2123 VSS.t312 a_14537_3728# VSS.t314 VSS.t313 sg13_lv_nmos ad=0.1738p pd=1.275u as=0 ps=0 w=0.88u l=5.305u
X2124 a_1433_3728# a_1365_3802# VDD.t1078 VDD.t354 sg13_lv_pmos ad=0.1938p pd=1.4u as=0.1938p ps=1.4u w=1.02u l=0.13u
X2125 VDD.t1106 a_9093_9178# VDD.t1104 VDD.t29 sg13_lv_pmos ad=0.1938p pd=1.4u as=0 ps=0 w=1.02u l=5.575u
X2126 a_3645_15952# a_3441_15952# VSS.t381 VSS.t1177 sg13_lv_nmos ad=27f pd=0.48u as=57f ps=0.68u w=0.3u l=0.13u
X2127 VSS.t914 a_16469_2706# VSS.t1647 VSS.t1648 sg13_lv_nmos ad=0.1672p pd=1.26u as=0 ps=0 w=0.88u l=5.575u
X2128 VSS.t281 a_28649_9426# a_28581_9462# VSS.t1010 sg13_lv_nmos ad=0.1672p pd=1.26u as=0.2992p ps=2.44u w=0.88u l=0.13u
X2129 VSS.t787 a_23693_6416# a_23625_6490# VSS.t786 sg13_lv_nmos ad=0.1738p pd=1.275u as=0.2992p ps=2.44u w=0.88u l=0.13u
X2130 VDD.t1220 BUFX3_31.A a_21193_16182# VDD.t0 sg13_lv_pmos ad=0.2412p pd=1.73u as=0.1632p ps=1.64u w=0.48u l=0.13u
X2131 VSS.t346 a_9161_11792# a_9093_11866# VSS.t347 sg13_lv_nmos ad=0.1672p pd=1.26u as=0.2992p ps=2.44u w=0.88u l=0.13u
X2132 VDD.t1042 a_13041_16182# a_13109_16146# VDD.t0 sg13_lv_pmos ad=0.1938p pd=1.4u as=0.1938p ps=1.4u w=1.02u l=0.13u
X2133 VSS.t1753 a_19745_6738# VSS.t410 VSS.t1752 sg13_lv_nmos ad=0.1738p pd=1.275u as=0 ps=0 w=0.88u l=1.945u
X2134 a_15716_14816# a_15648_14852# VDD.t1909 VDD.t5 sg13_lv_pmos ad=0.3332p pd=2.64u as=0.3332p ps=2.64u w=0.98u l=0.76u
X2135 a_3809_15952# a_3313_15779# a_3517_15682# VSS.t1755 sg13_lv_nmos ad=27f pd=0.48u as=57f ps=0.68u w=0.3u l=0.13u
X2136 VDD.t1267 a_35217_15898# VDD.t1266 VDD.t5 sg13_lv_pmos ad=0.3468p pd=2.72u as=0 ps=0 w=1.02u l=5.575u
X2137 VDD.t1340 a_19593_5146# VDD.t1339 VDD.t83 sg13_lv_pmos ad=0.3468p pd=2.72u as=0 ps=0 w=1.02u l=5.575u
X2138 a_15881_7760# a_15813_7834# VDD.t209 VDD.t39 sg13_lv_pmos ad=0.3468p pd=2.72u as=0.20145p ps=1.415u w=1.02u l=0.13u
X2139 VSS.t305 a_38480_5408# a_38412_5444# VSS.t306 sg13_lv_nmos ad=0.2176p pd=1.96u as=0.2176p ps=1.96u w=0.64u l=0.76u
X2140 VDD.t1378 a_35301_6774# VDD.t1377 VDD.t39 sg13_lv_pmos ad=0.3468p pd=2.72u as=0 ps=0 w=1.02u l=1.945u
X2141 VDD.t1550 a_31269_13494# VDD.t1549 VDD.t100 sg13_lv_pmos ad=0.1938p pd=1.4u as=0 ps=0 w=1.02u l=5.575u
X2142 a_8153_10448# a_8085_10522# VDD.t338 VDD.t8 sg13_lv_pmos ad=0.3468p pd=2.72u as=0.20145p ps=1.415u w=1.02u l=0.13u
X2143 a_22497_14228# a_22029_14280# a_22447_14608# VSS.t824 sg13_lv_nmos ad=57f pd=0.68u as=27f ps=0.48u w=0.3u l=0.13u
X2144 VSS.t514 a_35285_11792# VSS.t67 VSS.t513 sg13_lv_nmos ad=0.1672p pd=1.26u as=0 ps=0 w=0.88u l=5.575u
X2145 VSS.t94 a_7093_15779# a_7105_15532# VSS.t1109 sg13_lv_nmos ad=0.1193p pd=1.05u as=0.2176p ps=1.96u w=0.64u l=0.13u
X2146 a_23629_15474# DFFQX1_5.Q VDD.t1212 VDD.t5 sg13_lv_pmos ad=0.1632p pd=1.64u as=0.2412p ps=1.73u w=0.48u l=0.13u
X2147 VSS.t698 a_15713_13458# VSS.t241 VSS.t802 sg13_lv_nmos ad=0.1672p pd=1.26u as=0 ps=0 w=0.88u l=5.575u
X2148 VDD.t257 a_20769_5430# a_20837_5394# VDD.t68 sg13_lv_pmos ad=0.1938p pd=1.4u as=0.1938p ps=1.4u w=1.02u l=0.13u
X2149 VSS.t305 a_38648_5094# a_38580_5180# VSS.t306 sg13_lv_nmos ad=0.2176p pd=1.96u as=0.2176p ps=1.96u w=0.64u l=0.76u
X2150 AOI21BX1_0.Y AOI21BX1_0.A a_18343_15660# VDD.t5 sg13_lv_pmos ad=91.2f pd=0.86u as=91.2f ps=0.86u w=0.48u l=0.13u
X2151 VSS.t165 a_1097_8082# VSS.t165 VSS.t166 sg13_lv_nmos ad=0.1672p pd=1.26u as=0 ps=0 w=0.88u l=5.575u
X2152 VSS.t921 a_5213_12114# a_5145_12150# VSS.t1641 sg13_lv_nmos ad=0.1672p pd=1.26u as=0.2992p ps=2.44u w=0.88u l=0.13u
X2153 VSS.t7 a_15713_10770# a_15645_10806# VSS.t1632 sg13_lv_nmos ad=0.1672p pd=1.26u as=0.2992p ps=2.44u w=0.88u l=0.13u
X2154 a_21946_15932# BUFX3_27.Y a_21844_15932# VSS.t599 sg13_lv_nmos ad=0.1216p pd=1.02u as=0.1216p ps=1.02u w=0.64u l=0.13u
X2155 VSS.t328 a_23693_5072# VSS.t330 VSS.t942 sg13_lv_nmos ad=0.1738p pd=1.275u as=0 ps=0 w=0.88u l=1.945u
X2156 a_36461_13458# a_36393_13494# VDD.t1810 VDD.t100 sg13_lv_pmos ad=0.3468p pd=2.72u as=0.20145p ps=1.415u w=1.02u l=0.13u
X2157 a_22803_15536# a_22665_15572# VDD.t1032 VDD.t5 sg13_lv_pmos ad=91.2f pd=0.86u as=91.2f ps=0.86u w=0.48u l=0.13u
X2158 VSS.t771 a_24785_3728# VSS.t832 VSS.t1680 sg13_lv_nmos ad=0.1672p pd=1.26u as=0 ps=0 w=0.88u l=5.575u
X2159 VSS.t872 a_34025_14802# VSS.t869 VSS.t1127 sg13_lv_nmos ad=0.1738p pd=1.275u as=0 ps=0 w=0.88u l=5.305u
X2160 a_24717_13210# a_24785_13136# VSS.t889 VSS.t890 sg13_lv_nmos ad=0.2992p pd=2.44u as=0.1672p ps=1.26u w=0.88u l=0.13u
X2161 VDD.t427 a_16905_6490# VDD.t426 VDD.t68 sg13_lv_pmos ad=0.3468p pd=2.72u as=0 ps=0 w=1.02u l=5.575u
X2162 a_18401_8082# a_18333_8118# VDD.t1934 VDD.t29 sg13_lv_pmos ad=0.3468p pd=2.72u as=0.20145p ps=1.415u w=1.02u l=0.13u
X2163 VDD.t836 a_31269_5430# VDD.t835 VDD.t68 sg13_lv_pmos ad=0.1938p pd=1.4u as=0 ps=0 w=1.02u l=5.575u
X2164 VDD.t1798 a_23121_13494# VDD.t1797 VDD.t100 sg13_lv_pmos ad=0.3468p pd=2.72u as=0 ps=0 w=1.02u l=5.575u
X2165 VSS.t706 a_31337_12114# VSS.t1100 VSS.t1449 sg13_lv_nmos ad=0.1672p pd=1.26u as=0 ps=0 w=0.88u l=5.575u
X2166 VSS.t305 a_37973_5072# a_37905_5146# VSS.t306 sg13_lv_nmos ad=0.1738p pd=1.275u as=0.2992p ps=2.44u w=0.88u l=0.13u
X2167 a_9161_14480# a_9093_14554# VDD.t1699 VDD.t100 sg13_lv_pmos ad=0.1938p pd=1.4u as=0.1938p ps=1.4u w=1.02u l=0.13u
X2168 VDD.t1755 a_19593_3802# VDD.t1754 VDD.t354 sg13_lv_pmos ad=0.1938p pd=1.4u as=0 ps=0 w=1.02u l=5.575u
X2169 VSS.t564 a_15713_8082# a_15645_8118# VSS.t1021 sg13_lv_nmos ad=0.1672p pd=1.26u as=0.2992p ps=2.44u w=0.88u l=0.13u
X2170 VDD.t738 a_24717_7834# VDD.t737 VDD.t39 sg13_lv_pmos ad=0.3468p pd=2.72u as=0 ps=0 w=1.02u l=5.575u
X2171 VDD.t536 a_27405_13210# a_27473_13136# VDD.t93 sg13_lv_pmos ad=0.1938p pd=1.4u as=0.1938p ps=1.4u w=1.02u l=0.13u
X2172 VSS.t1327 a_19661_5072# VSS.t1044 VSS.t1328 sg13_lv_nmos ad=0.1672p pd=1.26u as=0 ps=0 w=0.88u l=5.575u
X2173 a_20837_13458# a_20769_13494# VDD.t1481 VDD.t100 sg13_lv_pmos ad=0.3468p pd=2.72u as=0.20145p ps=1.415u w=1.02u l=0.13u
X2174 VDD.t601 a_23457_10806# VDD.t602 VDD.t281 sg13_lv_pmos ad=0.1938p pd=1.4u as=0 ps=0 w=1.02u l=5.575u
X2175 BUFX24_2.A a_12714_15510# VSS.t661 VSS.t1143 sg13_lv_nmos ad=0.1634p pd=1.24u as=0.1634p ps=1.24u w=0.86u l=0.13u
X2176 a_22349_13136# a_22281_13210# VDD.t1419 VDD.t93 sg13_lv_pmos ad=0.3468p pd=2.72u as=0.20145p ps=1.415u w=1.02u l=0.13u
X2177 VDD.t1256 a_15813_14554# VDD.t1255 VDD.t100 sg13_lv_pmos ad=0.3468p pd=2.72u as=0 ps=0 w=1.02u l=1.945u
X2178 VDD.t792 a_28581_9462# VDD.t791 VDD.t8 sg13_lv_pmos ad=0.3468p pd=2.72u as=0 ps=0 w=1.02u l=5.575u
X2179 VDD.t1059 a_11781_9178# a_11849_9104# VDD.t29 sg13_lv_pmos ad=0.1938p pd=1.4u as=0.1938p ps=1.4u w=1.02u l=0.13u
X2180 VDD.t621 DFFQX1_5.CK a_22029_14280# VDD.t100 sg13_lv_pmos ad=0.1834p pd=1.39u as=0.1632p ps=1.64u w=0.48u l=0.13u
X2181 a_38480_12128# a_38412_12164# VDD.t934 VDD.t93 sg13_lv_pmos ad=0.3332p pd=2.64u as=0.3332p ps=2.64u w=0.98u l=0.76u
X2182 a_32597_11792# a_32529_11866# VDD.t1741 VDD.t281 sg13_lv_pmos ad=0.1938p pd=1.4u as=0.1938p ps=1.4u w=1.02u l=0.13u
X2183 VSS.t1308 a_26717_2706# VSS.t882 VSS.t1307 sg13_lv_nmos ad=0.1738p pd=1.275u as=0 ps=0 w=0.88u l=1.945u
X2184 VDD.t12 a_9093_10522# VDD.t11 VDD.t8 sg13_lv_pmos ad=0.1938p pd=1.4u as=0 ps=0 w=1.02u l=5.575u
X2185 VSS.t799 a_35285_13136# VSS.t799 VSS.t798 sg13_lv_nmos ad=0.1672p pd=1.26u as=0 ps=0 w=0.88u l=5.575u
X2186 VDD.t1023 a_28581_10806# VDD.t1022 VDD.t281 sg13_lv_pmos ad=0.3468p pd=2.72u as=0 ps=0 w=1.02u l=5.575u
X2187 DFFQX1_3.CK a_9674_15474# VDD.t1185 VDD.t5 sg13_lv_pmos ad=0.2508p pd=1.7u as=0.2508p ps=1.7u w=1.32u l=0.13u
X2188 VSS.t497 a_1097_13136# a_1029_13210# VSS.t835 sg13_lv_nmos ad=0.1672p pd=1.26u as=0.2992p ps=2.44u w=0.88u l=0.13u
X2189 VSS.t129 a_30161_9104# a_30093_9178# VSS.t128 sg13_lv_nmos ad=0.1738p pd=1.275u as=0.2992p ps=2.44u w=0.88u l=0.13u
X2190 VDD.t573 a_1029_8118# VDD.t574 VDD.t29 sg13_lv_pmos ad=0.3468p pd=2.72u as=0 ps=0 w=1.02u l=5.575u
X2191 a_17459_15170# a_17321_15244# VDD.t948 VDD.t5 sg13_lv_pmos ad=0.1632p pd=1.64u as=0.37935p ps=2.32u w=0.48u l=0.13u
X2192 VSS.t152 a_17497_14130# BUFX3_3.Y VSS.t1245 sg13_lv_nmos ad=0.1567p pd=1.27u as=0.2924p ps=2.4u w=0.86u l=0.13u
X2193 a_21289_15524# OR3X1_1.B VDD.t372 VDD.t5 sg13_lv_pmos ad=91.2f pd=0.86u as=0.1632p ps=1.64u w=0.48u l=0.13u
X2194 VDD.t260 a_35301_5430# VDD.t259 VDD.t68 sg13_lv_pmos ad=0.3468p pd=2.72u as=0 ps=0 w=1.02u l=1.945u
X2195 a_18589_16146# AOI21BX1_0.Y VSS.t14 VSS.t1208 sg13_lv_nmos ad=0.102p pd=1.28u as=0.1567p ps=1.27u w=0.3u l=0.13u
X2196 VDD.t1814 a_8085_3802# VDD.t1813 VDD.t354 sg13_lv_pmos ad=0.3468p pd=2.72u as=0 ps=0 w=1.02u l=1.945u
X2197 VSS.t246 a_30161_14480# a_30093_14554# VSS.t1505 sg13_lv_nmos ad=0.1738p pd=1.275u as=0.2992p ps=2.44u w=0.88u l=0.13u
X2198 VSS.t91 a_7901_9426# VSS.t89 VSS.t90 sg13_lv_nmos ad=0.1672p pd=1.26u as=0 ps=0 w=0.88u l=5.575u
X2199 VSS.t1345 a_16469_2706# a_16401_2742# VSS.t1645 sg13_lv_nmos ad=0.1672p pd=1.26u as=0.2992p ps=2.44u w=0.88u l=0.13u
X2200 VSS.t1100 a_28649_12114# VSS.t1098 VSS.t1099 sg13_lv_nmos ad=0.1672p pd=1.26u as=0 ps=0 w=0.88u l=5.575u
X2201 VSS.t475 a_1097_6738# VSS.t475 VSS.t728 sg13_lv_nmos ad=0.1672p pd=1.26u as=0 ps=0 w=0.88u l=5.575u
X2202 a_19273_15292# OAI21X1_0.A VDD.t1195 VDD.t5 sg13_lv_pmos ad=91.2f pd=0.86u as=0.1632p ps=1.64u w=0.48u l=0.13u
X2203 a_3717_14554# a_3785_14480# VSS.t76 VSS.t909 sg13_lv_nmos ad=0.2992p pd=2.44u as=0.1672p ps=1.26u w=0.88u l=0.13u
X2204 VDD.t488 a_5145_12150# VDD.t487 VDD.t93 sg13_lv_pmos ad=0.3468p pd=2.72u as=0 ps=0 w=1.02u l=5.575u
X2205 VSS.t544 a_23525_9426# VSS.t542 VSS.t1007 sg13_lv_nmos ad=0.1672p pd=1.26u as=0 ps=0 w=0.88u l=5.575u
X2206 a_1097_16146# a_1029_16182# VDD.t1134 VDD.t0 sg13_lv_pmos ad=0.3468p pd=2.72u as=0.20145p ps=1.415u w=1.02u l=0.13u
X2207 a_15881_14480# a_15813_14554# VDD.t1256 VDD.t100 sg13_lv_pmos ad=0.3468p pd=2.72u as=0.20145p ps=1.415u w=1.02u l=0.13u
X2208 VDD.t1064 a_23625_9178# VDD.t1063 VDD.t29 sg13_lv_pmos ad=0.3468p pd=2.72u as=0 ps=0 w=1.02u l=1.945u
X2209 VSS.t916 a_19157_2706# VSS.t914 VSS.t915 sg13_lv_nmos ad=0.1738p pd=1.275u as=0 ps=0 w=0.88u l=1.945u
X2210 VDD.t1333 a_16905_5146# VDD.t1332 VDD.t83 sg13_lv_pmos ad=0.1938p pd=1.4u as=0 ps=0 w=1.02u l=5.575u
X2211 NOR3X1_0.Y OR3X1_1.B VSS.t262 VSS.t389 sg13_lv_nmos ad=57f pd=0.68u as=57f ps=0.68u w=0.3u l=0.13u
X2212 VSS.t113 a_27473_15824# VSS.t115 VSS.t114 sg13_lv_nmos ad=0.1672p pd=1.26u as=0 ps=0 w=0.88u l=5.575u
X2213 a_11781_11866# a_11849_11792# VSS.t1491 VSS.t1522 sg13_lv_nmos ad=0.2992p pd=2.44u as=0.1672p ps=1.26u w=0.88u l=0.13u
X2214 a_14537_10448# a_14469_10522# VDD.t732 VDD.t8 sg13_lv_pmos ad=0.3468p pd=2.72u as=0.20145p ps=1.415u w=1.02u l=0.13u
X2215 a_15645_13494# a_15713_13458# VSS.t702 VSS.t804 sg13_lv_nmos ad=0.2992p pd=2.44u as=0.1672p ps=1.26u w=0.88u l=0.13u
X2216 VSS.t254 a_27473_3728# a_27405_3802# VSS.t984 sg13_lv_nmos ad=0.1672p pd=1.26u as=0.2992p ps=2.44u w=0.88u l=0.13u
X2217 VDD.t1283 a_6405_14554# VDD.t1282 VDD.t100 sg13_lv_pmos ad=0.3468p pd=2.72u as=0 ps=0 w=1.02u l=5.305u
X2218 a_20837_4050# a_20769_4086# VDD.t1628 VDD.t83 sg13_lv_pmos ad=0.1938p pd=1.4u as=0.1938p ps=1.4u w=1.02u l=0.13u
X2219 a_10589_9426# a_10521_9462# VDD.t1048 VDD.t8 sg13_lv_pmos ad=0.3468p pd=2.72u as=0.20145p ps=1.415u w=1.02u l=0.13u
X2220 VSS.t124 a_19661_9104# a_19593_9178# VSS.t357 sg13_lv_nmos ad=0.1672p pd=1.26u as=0.2992p ps=2.44u w=0.88u l=0.13u
X2221 a_16953_15244# a_16485_14920# a_16903_14900# VSS.t378 sg13_lv_nmos ad=57f pd=0.68u as=27f ps=0.48u w=0.3u l=0.13u
X2222 VSS.t229 a_9161_3728# VSS.t231 VSS.t1500 sg13_lv_nmos ad=0.1672p pd=1.26u as=0 ps=0 w=0.88u l=5.575u
X2223 VDD.t1444 a_7749_6490# VDD.t1443 VDD.t68 sg13_lv_pmos ad=0.3468p pd=2.72u as=0 ps=0 w=1.02u l=1.945u
X2224 VDD.t1164 a_15318_15510# DFFQX1_5.CK VDD.t5 sg13_lv_pmos ad=0.2508p pd=1.7u as=0.2508p ps=1.7u w=1.32u l=0.13u
X2225 VSS.t466 a_28649_8082# VSS.t552 VSS.t1818 sg13_lv_nmos ad=0.1672p pd=1.26u as=0 ps=0 w=0.88u l=5.575u
X2226 a_18989_14480# a_18921_14554# VDD.t398 VDD.t100 sg13_lv_pmos ad=0.3468p pd=2.72u as=0.20145p ps=1.415u w=1.02u l=0.13u
X2227 a_24785_5072# a_24717_5146# VDD.t1453 VDD.t83 sg13_lv_pmos ad=0.1938p pd=1.4u as=0.1938p ps=1.4u w=1.02u l=0.13u
X2228 VSS.t204 a_24785_5072# VSS.t206 VSS.t1381 sg13_lv_nmos ad=0.1672p pd=1.26u as=0 ps=0 w=0.88u l=5.575u
X2229 VSS.t192 a_15713_6738# a_15645_6774# VSS.t469 sg13_lv_nmos ad=0.1672p pd=1.26u as=0.2992p ps=2.44u w=0.88u l=0.13u
X2230 VSS.t295 a_5381_15824# a_5313_15898# VSS.t1196 sg13_lv_nmos ad=0.1738p pd=1.275u as=0.2992p ps=2.44u w=0.88u l=0.13u
X2231 OR3X1_1.B BUFX3_0.Y a_8422_15932# VSS.t79 sg13_lv_nmos ad=0.2176p pd=1.96u as=0.1216p ps=1.02u w=0.64u l=0.13u
X2232 a_21979_14852# a_21777_14920# VDD.t622 VDD.t5 sg13_lv_pmos ad=0.3332p pd=2.64u as=0.1834p ps=1.39u w=0.98u l=0.13u
X2233 a_19681_14802# BUFX3_23.A VSS.t1264 VSS.t1263 sg13_lv_nmos ad=0.102p pd=1.28u as=0.1567p ps=1.27u w=0.3u l=0.13u
X2234 VDD.t645 a_24717_9178# VDD.t643 VDD.t29 sg13_lv_pmos ad=0.1938p pd=1.4u as=0 ps=0 w=1.02u l=5.575u
X2235 a_9181_16146# DFFQX1_3.Q VSS.t1165 VSS.t1166 sg13_lv_nmos ad=0.102p pd=1.28u as=0.1567p ps=1.27u w=0.3u l=0.13u
X2236 a_30161_3728# a_30093_3802# VDD.t355 VDD.t354 sg13_lv_pmos ad=0.3468p pd=2.72u as=0.20145p ps=1.415u w=1.02u l=0.13u
X2237 a_9161_7760# a_9093_7834# VDD.t1938 VDD.t39 sg13_lv_pmos ad=0.1938p pd=1.4u as=0.1938p ps=1.4u w=1.02u l=0.13u
X2238 VSS.t1118 NAND3X1_0.B a_6247_15938# VSS.t1213 sg13_lv_nmos ad=61.5f pd=0.71u as=27f ps=0.48u w=0.3u l=0.13u
X2239 VDD.t1622 a_16905_11866# a_16973_11792# VDD.t281 sg13_lv_pmos ad=0.1938p pd=1.4u as=0.1938p ps=1.4u w=1.02u l=0.13u
X2240 a_37469_16146# a_37401_16182# VDD.t2 VDD.t0 sg13_lv_pmos ad=0.3468p pd=2.72u as=0.20145p ps=1.415u w=1.02u l=0.13u
X2241 VSS.t783 a_5213_8082# VSS.t559 VSS.t1812 sg13_lv_nmos ad=0.1672p pd=1.26u as=0 ps=0 w=0.88u l=5.575u
X2242 VDD.t597 DFFQX1_4.Q a_17077_16182# VDD.t0 sg13_lv_pmos ad=0.2412p pd=1.73u as=0.1632p ps=1.64u w=0.48u l=0.13u
X2243 VSS.t526 a_5213_9426# VSS.t523 VSS.t525 sg13_lv_nmos ad=0.1672p pd=1.26u as=0 ps=0 w=0.88u l=5.575u
X2244 a_13025_9426# a_12957_9462# VDD.t358 VDD.t8 sg13_lv_pmos ad=0.1938p pd=1.4u as=0.1938p ps=1.4u w=1.02u l=0.13u
X2245 VDD.t1265 a_19093_15474# AOI21BX1_0.A VDD.t5 sg13_lv_pmos ad=0.2412p pd=1.73u as=0.4488p ps=3.32u w=1.32u l=0.13u
X2246 VDD.t1807 a_1029_10806# VDD.t1805 VDD.t281 sg13_lv_pmos ad=0.1938p pd=1.4u as=0 ps=0 w=1.02u l=5.575u
X2247 VDD.t1375 a_33957_6774# VDD.t1374 VDD.t39 sg13_lv_pmos ad=0.3468p pd=2.72u as=0 ps=0 w=1.02u l=5.305u
X2248 VDD.t188 a_30093_10522# VDD.t187 VDD.t8 sg13_lv_pmos ad=0.3468p pd=2.72u as=0 ps=0 w=1.02u l=5.305u
X2249 a_35217_3802# a_35285_3728# VSS.t251 VSS.t250 sg13_lv_nmos ad=0.2992p pd=2.44u as=0.1672p ps=1.26u w=0.88u l=0.13u
X2250 a_28581_5430# a_28649_5394# VSS.t212 VSS.t213 sg13_lv_nmos ad=0.2992p pd=2.44u as=0.1672p ps=1.26u w=0.88u l=0.13u
X2251 VDD.t215 a_37905_7834# VDD.t214 VDD.t39 sg13_lv_pmos ad=0.3468p pd=2.72u as=0 ps=0 w=1.02u l=1.945u
X2252 VDD.t992 BUFX3_29.A a_21865_13494# VDD.t100 sg13_lv_pmos ad=0.2412p pd=1.73u as=0.1632p ps=1.64u w=0.48u l=0.13u
X2253 a_37973_9104# a_37905_9178# VDD.t1067 VDD.t29 sg13_lv_pmos ad=0.3468p pd=2.72u as=0.20145p ps=1.415u w=1.02u l=0.13u
X2254 a_27405_9178# a_27473_9104# VSS.t129 VSS.t279 sg13_lv_nmos ad=0.2992p pd=2.44u as=0.1672p ps=1.26u w=0.88u l=0.13u
X2255 a_22383_15045# a_22245_15244# VDD.t991 VDD.t5 sg13_lv_pmos ad=91.2f pd=0.86u as=91.2f ps=0.86u w=0.48u l=0.13u
X2256 VSS.t233 a_27809_2706# VSS.t1478 VSS.t1477 sg13_lv_nmos ad=0.1672p pd=1.26u as=0 ps=0 w=0.88u l=5.575u
X2257 VDD.t1094 a_7833_9462# a_7901_9426# VDD.t8 sg13_lv_pmos ad=0.1938p pd=1.4u as=0.1938p ps=1.4u w=1.02u l=0.13u
X2258 VDD.t51 a_19593_7834# a_19661_7760# VDD.t39 sg13_lv_pmos ad=0.1938p pd=1.4u as=0.1938p ps=1.4u w=1.02u l=0.13u
X2259 VDD.t1251 a_24297_16182# VDD.t1250 VDD.t0 sg13_lv_pmos ad=0.1938p pd=1.4u as=0 ps=0 w=1.02u l=5.575u
X2260 VDD.t1914 a_28581_12150# a_28649_12114# VDD.t93 sg13_lv_pmos ad=0.1938p pd=1.4u as=0.1938p ps=1.4u w=1.02u l=0.13u
X2261 VDD.t762 a_6405_5146# VDD.t761 VDD.t83 sg13_lv_pmos ad=0.3468p pd=2.72u as=0 ps=0 w=1.02u l=5.305u
X2262 VSS.t20 a_36461_10770# a_36393_10806# VSS.t19 sg13_lv_nmos ad=0.1738p pd=1.275u as=0.2992p ps=2.44u w=0.88u l=0.13u
X2263 VDD.t146 a_17091_15045# a_17055_15244# VDD.t5 sg13_lv_pmos ad=91.2f pd=0.86u as=43.2f ps=0.66u w=0.48u l=0.13u
X2264 VSS.t1044 a_22349_5072# VSS.t328 VSS.t1045 sg13_lv_nmos ad=0.1738p pd=1.275u as=0 ps=0 w=0.88u l=5.305u
X2265 VDD.t24 a_23457_9462# a_23525_9426# VDD.t8 sg13_lv_pmos ad=0.1938p pd=1.4u as=0.1938p ps=1.4u w=1.02u l=0.13u
X2266 a_1029_5430# a_1097_5394# VSS.t53 VSS.t436 sg13_lv_nmos ad=0.2992p pd=2.44u as=0.1672p ps=1.26u w=0.88u l=0.13u
X2267 VSS.t356 a_20837_9426# a_20769_9462# VSS.t1052 sg13_lv_nmos ad=0.1672p pd=1.26u as=0.2992p ps=2.44u w=0.88u l=0.13u
X2268 VSS.t310 a_3785_4050# VSS.t224 VSS.t855 sg13_lv_nmos ad=0.1738p pd=1.275u as=0 ps=0 w=0.88u l=1.945u
X2269 a_35285_9104# a_35217_9178# VDD.t1111 VDD.t29 sg13_lv_pmos ad=0.1938p pd=1.4u as=0.1938p ps=1.4u w=1.02u l=0.13u
X2270 VSS.t89 a_8492_9126# a_8424_9212# VSS.t1059 sg13_lv_nmos ad=0.2176p pd=1.96u as=0.2176p ps=1.96u w=0.64u l=0.76u
X2271 VDD.t1269 a_35217_15898# a_35285_15824# VDD.t5 sg13_lv_pmos ad=0.1938p pd=1.4u as=0.1938p ps=1.4u w=1.02u l=0.13u
X2272 VSS.t799 a_38648_13158# a_38580_13244# VSS.t798 sg13_lv_nmos ad=0.2176p pd=1.96u as=0.2176p ps=1.96u w=0.64u l=0.76u
X2273 a_12356_15846# a_12288_15932# VDD.t1142 VDD.t5 sg13_lv_pmos ad=0.3332p pd=2.64u as=0.3332p ps=2.64u w=0.98u l=0.76u
X2274 VDD.t1843 a_24549_14838# VDD.t1842 VDD.t5 sg13_lv_pmos ad=0.1938p pd=1.4u as=0 ps=0 w=1.02u l=5.575u
X2275 a_37805_13458# a_37737_13494# VDD.t1507 VDD.t100 sg13_lv_pmos ad=0.3468p pd=2.72u as=0.20145p ps=1.415u w=1.02u l=0.13u
X2276 VSS.t81 a_3721_14802# AND2X1_3.B VSS.t591 sg13_lv_nmos ad=0.1567p pd=1.27u as=0.2924p ps=2.4u w=0.86u l=0.13u
X2277 VSS.t3 a_11849_14480# a_11781_14554# VSS.t1601 sg13_lv_nmos ad=0.1672p pd=1.26u as=0.2992p ps=2.44u w=0.88u l=0.13u
X2278 VSS.t886 a_23189_13458# VSS.t1411 VSS.t1412 sg13_lv_nmos ad=0.1672p pd=1.26u as=0 ps=0 w=0.88u l=5.575u
X2279 VDD.t303 a_1029_15898# VDD.t302 VDD.t5 sg13_lv_pmos ad=0.3468p pd=2.72u as=0 ps=0 w=1.02u l=5.305u
X2280 VDD.t275 a_19593_13210# VDD.t274 VDD.t93 sg13_lv_pmos ad=0.1938p pd=1.4u as=0 ps=0 w=1.02u l=5.575u
X2281 a_27809_16146# a_27741_16182# VDD.t140 VDD.t0 sg13_lv_pmos ad=0.1938p pd=1.4u as=0.1938p ps=1.4u w=1.02u l=0.13u
X2282 VDD.t1178 BUFX3_17.A a_17833_15510# VDD.t5 sg13_lv_pmos ad=0.2412p pd=1.73u as=0.1632p ps=1.64u w=0.48u l=0.13u
X2283 VDD.t1841 a_24549_14838# VDD.t1840 VDD.t5 sg13_lv_pmos ad=0.3468p pd=2.72u as=0 ps=0 w=1.02u l=5.575u
X2284 VSS.t1590 a_24617_14802# VSS.t448 VSS.t1589 sg13_lv_nmos ad=0.1672p pd=1.26u as=0 ps=0 w=0.88u l=5.575u
X2285 VSS.t1423 a_18401_10770# a_18333_10806# VSS.t1761 sg13_lv_nmos ad=0.1738p pd=1.275u as=0.2992p ps=2.44u w=0.88u l=0.13u
X2286 VSS.t448 a_24301_14802# NOR3X1_0.A VSS.t1206 sg13_lv_nmos ad=0.1567p pd=1.27u as=0.2924p ps=2.4u w=0.86u l=0.13u
X2287 VSS.t485 a_28649_6738# VSS.t483 VSS.t1312 sg13_lv_nmos ad=0.1672p pd=1.26u as=0 ps=0 w=0.88u l=5.575u
X2288 VSS.t922 a_1097_11792# VSS.t922 VSS.t1316 sg13_lv_nmos ad=0.1672p pd=1.26u as=0 ps=0 w=0.88u l=5.575u
X2289 a_5213_8082# a_5145_8118# VDD.t412 VDD.t29 sg13_lv_pmos ad=0.1938p pd=1.4u as=0.1938p ps=1.4u w=1.02u l=0.13u
X2290 VSS.t608 a_9674_15474# DFFQX1_3.CK VSS.t1170 sg13_lv_nmos ad=0.1634p pd=1.24u as=0.1634p ps=1.24u w=0.86u l=0.13u
X2291 VSS.t813 a_26213_10770# VSS.t815 VSS.t1487 sg13_lv_nmos ad=0.1738p pd=1.275u as=0 ps=0 w=0.88u l=5.305u
X2292 VSS.t320 a_24785_11792# a_24717_11866# VSS.t1403 sg13_lv_nmos ad=0.1672p pd=1.26u as=0.2992p ps=2.44u w=0.88u l=0.13u
X2293 VSS.t1305 a_5213_12114# VSS.t925 VSS.t1643 sg13_lv_nmos ad=0.1672p pd=1.26u as=0 ps=0 w=0.88u l=5.575u
X2294 a_15713_10770# a_15645_10806# VDD.t1819 VDD.t281 sg13_lv_pmos ad=0.1938p pd=1.4u as=0.1938p ps=1.4u w=1.02u l=0.13u
X2295 VDD.t1890 a_3717_6490# VDD.t1889 VDD.t68 sg13_lv_pmos ad=0.3468p pd=2.72u as=0 ps=0 w=1.02u l=5.575u
X2296 a_31505_9104# a_31437_9178# VDD.t1932 VDD.t29 sg13_lv_pmos ad=0.3468p pd=2.72u as=0.20145p ps=1.415u w=1.02u l=0.13u
X2297 VSS.t520 a_3785_9104# VSS.t523 VSS.t639 sg13_lv_nmos ad=0.1672p pd=1.26u as=0 ps=0 w=0.88u l=5.575u
X2298 VSS.t177 a_19661_7760# VSS.t181 VSS.t180 sg13_lv_nmos ad=0.1672p pd=1.26u as=0 ps=0 w=0.88u l=5.575u
X2299 VDD.t649 a_12957_8118# a_13025_8082# VDD.t29 sg13_lv_pmos ad=0.1938p pd=1.4u as=0.1938p ps=1.4u w=1.02u l=0.13u
X2300 a_22447_14608# DFFQX1_5.D VSS.t602 VSS.t1838 sg13_lv_nmos ad=27f pd=0.48u as=0.102p ps=1.28u w=0.3u l=0.13u
X2301 VSS.t284 a_5213_6738# VSS.t478 VSS.t683 sg13_lv_nmos ad=0.1672p pd=1.26u as=0 ps=0 w=0.88u l=5.575u
X2302 VSS.t158 a_32597_15824# VSS.t11 VSS.t1750 sg13_lv_nmos ad=0.1672p pd=1.26u as=0 ps=0 w=0.88u l=5.575u
X2303 VDD.t1383 a_14469_5146# VDD.t1384 VDD.t83 sg13_lv_pmos ad=0.3468p pd=2.72u as=0 ps=0 w=1.02u l=5.305u
X2304 VSS.t278 a_26213_9426# VSS.t544 VSS.t631 sg13_lv_nmos ad=0.1738p pd=1.275u as=0 ps=0 w=0.88u l=5.305u
X2305 a_11849_14480# a_11781_14554# VDD.t102 VDD.t100 sg13_lv_pmos ad=0.1938p pd=1.4u as=0.1938p ps=1.4u w=1.02u l=0.13u
X2306 VDD.t429 a_16905_6490# a_16973_6416# VDD.t68 sg13_lv_pmos ad=0.1938p pd=1.4u as=0.1938p ps=1.4u w=1.02u l=0.13u
X2307 VDD.t1854 a_28581_14838# VDD.t1853 VDD.t5 sg13_lv_pmos ad=0.1938p pd=1.4u as=0 ps=0 w=1.02u l=5.575u
X2308 VSS.t1507 a_31505_14480# VSS.t870 VSS.t1786 sg13_lv_nmos ad=0.1738p pd=1.275u as=0 ps=0 w=0.88u l=1.945u
X2309 a_32529_6490# a_32597_6416# VSS.t457 VSS.t458 sg13_lv_nmos ad=0.2992p pd=2.44u as=0.1672p ps=1.26u w=0.88u l=0.13u
X2310 VDD.t81 a_33957_5430# VDD.t80 VDD.t68 sg13_lv_pmos ad=0.3468p pd=2.72u as=0 ps=0 w=1.02u l=5.305u
X2311 VSS.t170 a_10589_8082# VSS.t1070 VSS.t1071 sg13_lv_nmos ad=0.1738p pd=1.275u as=0 ps=0 w=0.88u l=5.305u
X2312 VSS.t11 a_35369_16146# VSS.t11 VSS.t10 sg13_lv_nmos ad=0.1738p pd=1.275u as=0 ps=0 w=0.88u l=5.305u
X2313 VDD.t314 a_32529_15898# VDD.t313 VDD.t5 sg13_lv_pmos ad=0.1938p pd=1.4u as=0 ps=0 w=1.02u l=5.575u
X2314 VDD.t1360 a_28581_6774# VDD.t1359 VDD.t39 sg13_lv_pmos ad=0.1938p pd=1.4u as=0 ps=0 w=1.02u l=5.575u
X2315 a_16905_7834# a_16973_7760# VSS.t177 VSS.t575 sg13_lv_nmos ad=0.2992p pd=2.44u as=0.1672p ps=1.26u w=0.88u l=0.13u
X2316 VSS.t301 a_32597_5072# VSS.t490 VSS.t852 sg13_lv_nmos ad=0.1672p pd=1.26u as=0 ps=0 w=0.88u l=5.575u
X2317 VDD.t343 a_7833_8118# VDD.t342 VDD.t29 sg13_lv_pmos ad=0.1938p pd=1.4u as=0 ps=0 w=1.02u l=5.575u
X2318 a_34025_4050# a_33957_4086# VDD.t90 VDD.t83 sg13_lv_pmos ad=0.3468p pd=2.72u as=0.20145p ps=1.415u w=1.02u l=0.13u
X2319 a_3131_15770# a_3313_15779# a_3277_15952# VSS.t1754 sg13_lv_nmos ad=57f pd=0.68u as=27f ps=0.48u w=0.3u l=0.13u
X2320 VSS.t395 a_20000_14816# a_19932_14852# VSS.t1125 sg13_lv_nmos ad=0.2176p pd=1.96u as=0.2176p ps=1.96u w=0.64u l=0.76u
X2321 VSS.t573 a_15713_8082# VSS.t566 VSS.t1023 sg13_lv_nmos ad=0.1672p pd=1.26u as=0 ps=0 w=0.88u l=5.575u
X2322 a_18343_15660# AOI21BX1_0.B AOI21BX1_0.Y VDD.t5 sg13_lv_pmos ad=0.168p pd=1.66u as=91.2f ps=0.86u w=0.48u l=0.13u
X2323 VDD.t1947 a_32529_7834# VDD.t1944 VDD.t39 sg13_lv_pmos ad=0.1938p pd=1.4u as=0 ps=0 w=1.02u l=5.575u
X2324 VDD.t740 a_24717_7834# a_24785_7760# VDD.t39 sg13_lv_pmos ad=0.1938p pd=1.4u as=0.1938p ps=1.4u w=1.02u l=0.13u
X2325 a_6473_13136# a_6405_13210# VDD.t278 VDD.t93 sg13_lv_pmos ad=0.3468p pd=2.72u as=0.20145p ps=1.415u w=1.02u l=0.13u
X2326 VSS.t935 a_20837_12114# a_20769_12150# VSS.t937 sg13_lv_nmos ad=0.1672p pd=1.26u as=0.2992p ps=2.44u w=0.88u l=0.13u
X2327 a_35285_11792# a_35217_11866# VDD.t1791 VDD.t281 sg13_lv_pmos ad=0.1938p pd=1.4u as=0.1938p ps=1.4u w=1.02u l=0.13u
X2328 VDD.t185 a_11781_10522# VDD.t184 VDD.t8 sg13_lv_pmos ad=0.1938p pd=1.4u as=0 ps=0 w=1.02u l=5.575u
X2329 a_37153_16146# BUFX3_41.A VDD.t461 VDD.t0 sg13_lv_pmos ad=0.1632p pd=1.64u as=0.2412p ps=1.73u w=0.48u l=0.13u
X2330 VDD.t1767 a_16401_2742# a_16469_2706# VDD.t354 sg13_lv_pmos ad=0.1938p pd=1.4u as=0.1938p ps=1.4u w=1.02u l=0.13u
X2331 a_21195_16000# OR3X1_1.C VSS.t393 VSS.t570 sg13_lv_nmos ad=57f pd=0.68u as=57f ps=0.68u w=0.3u l=0.13u
X2332 a_31505_14480# a_31437_14554# VDD.t1874 VDD.t100 sg13_lv_pmos ad=0.3468p pd=2.72u as=0.20145p ps=1.415u w=1.02u l=0.13u
X2333 a_1097_13458# a_1029_13494# VDD.t1319 VDD.t100 sg13_lv_pmos ad=0.1938p pd=1.4u as=0.1938p ps=1.4u w=1.02u l=0.13u
X2334 DFFQX1_5.CK a_15318_15510# VSS.t1137 VSS.t1140 sg13_lv_nmos ad=0.2924p pd=2.4u as=0.1634p ps=1.24u w=0.86u l=0.13u
X2335 a_21613_13458# BUFX3_27.A VDD.t1210 VDD.t100 sg13_lv_pmos ad=0.1632p pd=1.64u as=0.2412p ps=1.73u w=0.48u l=0.13u
X2336 VSS.t262 OR3X1_1.A a_22197_13608# VSS.t672 sg13_lv_nmos ad=61.5f pd=0.71u as=57f ps=0.68u w=0.3u l=0.13u
X2337 VDD.t334 a_1029_5146# VDD.t333 VDD.t83 sg13_lv_pmos ad=0.1938p pd=1.4u as=0 ps=0 w=1.02u l=5.575u
X2338 VDD.t1977 a_1029_6774# VDD.t1976 VDD.t39 sg13_lv_pmos ad=0.1938p pd=1.4u as=0 ps=0 w=1.02u l=5.575u
X2339 VDD.t1175 a_32281_16146# counter_value_o[6] VDD.t0 sg13_lv_pmos ad=0.2412p pd=1.73u as=0.4488p ps=3.32u w=1.32u l=0.13u
X2340 VDD.t1239 a_19341_15898# VDD.t1238 VDD.t5 sg13_lv_pmos ad=0.3468p pd=2.72u as=0 ps=0 w=1.02u l=5.305u
X2341 VSS.t504 a_7817_2706# a_7749_2742# VSS.t503 sg13_lv_nmos ad=0.1738p pd=1.275u as=0.2992p ps=2.44u w=0.88u l=0.13u
X2342 VDD.t752 a_27405_6490# VDD.t750 VDD.t68 sg13_lv_pmos ad=0.1938p pd=1.4u as=0 ps=0 w=1.02u l=5.575u
X2343 VSS.t97 a_37805_8082# VSS.t97 VSS.t96 sg13_lv_nmos ad=0.1738p pd=1.275u as=0 ps=0 w=0.88u l=1.945u
X2344 VSS.t386 a_31505_15824# a_31437_15898# VSS.t1187 sg13_lv_nmos ad=0.1738p pd=1.275u as=0.2992p ps=2.44u w=0.88u l=0.13u
X2345 VDD.t182 a_11781_10522# VDD.t181 VDD.t8 sg13_lv_pmos ad=0.3468p pd=2.72u as=0 ps=0 w=1.02u l=5.575u
X2346 a_27980_14816# a_27912_14852# VDD.t1709 VDD.t5 sg13_lv_pmos ad=0.3332p pd=2.64u as=0.3332p ps=2.64u w=0.98u l=0.76u
X2347 VDD.t297 a_20769_9462# VDD.t296 VDD.t8 sg13_lv_pmos ad=0.3468p pd=2.72u as=0 ps=0 w=1.02u l=5.575u
X2348 a_20181_2742# a_20249_2706# VSS.t911 VSS.t1486 sg13_lv_nmos ad=0.2992p pd=2.44u as=0.1672p ps=1.26u w=0.88u l=0.13u
X2349 VDD.t671 a_11781_6490# VDD.t670 VDD.t68 sg13_lv_pmos ad=0.3468p pd=2.72u as=0 ps=0 w=1.02u l=5.575u
X2350 VSS.t766 a_22349_10448# a_22281_10522# VSS.t1732 sg13_lv_nmos ad=0.1738p pd=1.275u as=0.2992p ps=2.44u w=0.88u l=0.13u
X2351 VDD.t1242 a_7297_15682# a_7221_15952# VDD.t5 sg13_lv_pmos ad=91.2f pd=0.86u as=91.2f ps=0.86u w=0.48u l=0.13u
X2352 a_32529_11866# a_32597_11792# VSS.t514 VSS.t709 sg13_lv_nmos ad=0.2992p pd=2.44u as=0.1672p ps=1.26u w=0.88u l=0.13u
X2353 BUFX3_16.A a_17749_16182# VSS.t160 VSS.t1031 sg13_lv_nmos ad=0.2924p pd=2.4u as=0.1567p ps=1.27u w=0.86u l=0.13u
X2354 VSS.t295 a_5804_16160# a_5736_16196# VSS.t1203 sg13_lv_nmos ad=0.2176p pd=1.96u as=0.2176p ps=1.96u w=0.64u l=0.76u
X2355 a_1365_3802# a_1433_3728# VSS.t224 VSS.t1842 sg13_lv_nmos ad=0.2992p pd=2.44u as=0.1672p ps=1.26u w=0.88u l=0.13u
X2356 a_34025_14802# a_33957_14838# VDD.t1847 VDD.t5 sg13_lv_pmos ad=0.3468p pd=2.72u as=0.20145p ps=1.415u w=1.02u l=0.13u
X2357 a_26213_9426# a_26145_9462# VDD.t190 VDD.t8 sg13_lv_pmos ad=0.3468p pd=2.72u as=0.20145p ps=1.415u w=1.02u l=0.13u
X2358 a_22603_15572# a_22399_15524# VDD.t1241 VDD.t5 sg13_lv_pmos ad=43.2f pd=0.66u as=0.1632p ps=1.64u w=0.48u l=0.13u
X2359 a_7297_15682# a_7093_15779# a_7437_15572# VDD.t5 sg13_lv_pmos ad=91.2f pd=0.86u as=43.2f ps=0.66u w=0.48u l=0.13u
X2360 VSS.t362 a_15716_14816# a_15648_14852# VSS.t1261 sg13_lv_nmos ad=0.2176p pd=1.96u as=0.2176p ps=1.96u w=0.64u l=0.76u
X2361 VSS.t1688 a_9161_10448# VSS.t1503 VSS.t1689 sg13_lv_nmos ad=0.1672p pd=1.26u as=0 ps=0 w=0.88u l=5.575u
X2362 VDD.t711 a_24717_14554# a_24785_14480# VDD.t100 sg13_lv_pmos ad=0.1938p pd=1.4u as=0.1938p ps=1.4u w=1.02u l=0.13u
X2363 VSS.t338 a_27221_13458# VSS.t889 VSS.t1789 sg13_lv_nmos ad=0.1738p pd=1.275u as=0 ps=0 w=0.88u l=1.945u
X2364 VSS.t550 a_27557_8082# a_27489_8118# VSS.t549 sg13_lv_nmos ad=0.1738p pd=1.275u as=0.2992p ps=2.44u w=0.88u l=0.13u
X2365 VSS.t383 a_3785_16146# VSS.t381 VSS.t382 sg13_lv_nmos ad=0.1738p pd=1.275u as=0 ps=0 w=0.88u l=1.945u
X2366 VSS.t11 a_37153_16146# counter_value_o[7] VSS.t10 sg13_lv_nmos ad=0.1567p pd=1.27u as=0.2924p ps=2.4u w=0.86u l=0.13u
X2367 VSS.t444 a_36461_14802# VSS.t444 VSS.t443 sg13_lv_nmos ad=0.1738p pd=1.275u as=0 ps=0 w=0.88u l=5.305u
X2368 a_37973_10448# a_37905_10522# VDD.t128 VDD.t8 sg13_lv_pmos ad=0.3468p pd=2.72u as=0.20145p ps=1.415u w=1.02u l=0.13u
X2369 AOI21BX2_0.A a_21529_16182# VSS.t133 VSS.t603 sg13_lv_nmos ad=0.2924p pd=2.4u as=0.1567p ps=1.27u w=0.86u l=0.13u
X2370 VSS.t72 a_21613_13458# BUFX3_27.Y VSS.t1446 sg13_lv_nmos ad=0.1567p pd=1.27u as=0.2924p ps=2.4u w=0.86u l=0.13u
X2371 BUFX3_25.Y a_16153_14838# VDD.t357 VDD.t5 sg13_lv_pmos ad=0.4488p pd=3.32u as=0.2412p ps=1.73u w=1.32u l=0.13u
X2372 a_3785_12114# a_3717_12150# VDD.t1503 VDD.t93 sg13_lv_pmos ad=0.3468p pd=2.72u as=0.20145p ps=1.415u w=1.02u l=0.13u
X2373 VDD.t490 a_5145_12150# a_5213_12114# VDD.t93 sg13_lv_pmos ad=0.1938p pd=1.4u as=0.1938p ps=1.4u w=1.02u l=0.13u
X2374 VDD.t1355 a_35301_10806# VDD.t1354 VDD.t281 sg13_lv_pmos ad=0.3468p pd=2.72u as=0 ps=0 w=1.02u l=1.945u
X2375 VDD.t1699 a_9093_14554# VDD.t1698 VDD.t100 sg13_lv_pmos ad=0.3468p pd=2.72u as=0 ps=0 w=1.02u l=5.575u
X2376 VDD.t1742 a_32529_11866# a_32597_11792# VDD.t281 sg13_lv_pmos ad=0.1938p pd=1.4u as=0.1938p ps=1.4u w=1.02u l=0.13u
X2377 VSS.t526 a_6473_9104# a_6405_9178# VSS.t535 sg13_lv_nmos ad=0.1738p pd=1.275u as=0.2992p ps=2.44u w=0.88u l=0.13u
X2378 VSS.t1549 a_34025_13458# VSS.t1513 VSS.t1571 sg13_lv_nmos ad=0.1738p pd=1.275u as=0 ps=0 w=0.88u l=5.305u
X2379 a_28581_12150# a_28649_12114# VSS.t1100 VSS.t1101 sg13_lv_nmos ad=0.2992p pd=2.44u as=0.1672p ps=1.26u w=0.88u l=0.13u
X2380 a_12621_2742# a_12689_2706# VSS.t1344 VSS.t1374 sg13_lv_nmos ad=0.2992p pd=2.44u as=0.1672p ps=1.26u w=0.88u l=0.13u
X2381 VDD.t997 a_9093_5146# VDD.t995 VDD.t83 sg13_lv_pmos ad=0.1938p pd=1.4u as=0 ps=0 w=1.02u l=5.575u
X2382 VSS.t1191 a_11009_15824# VSS.t610 VSS.t1192 sg13_lv_nmos ad=0.1738p pd=1.275u as=0 ps=0 w=0.88u l=5.305u
X2383 VSS.t143 a_10589_6738# VSS.t141 VSS.t142 sg13_lv_nmos ad=0.1738p pd=1.275u as=0 ps=0 w=0.88u l=5.305u
X2384 a_20869_15292# OR3X1_1.B VDD.t374 VDD.t5 sg13_lv_pmos ad=91.2f pd=0.86u as=0.1632p ps=1.64u w=0.48u l=0.13u
X2385 VDD.t1969 a_20769_12150# VDD.t1970 VDD.t93 sg13_lv_pmos ad=0.1938p pd=1.4u as=0 ps=0 w=1.02u l=5.575u
X2386 VDD.t1954 a_28581_5430# VDD.t1955 VDD.t68 sg13_lv_pmos ad=0.1938p pd=1.4u as=0 ps=0 w=1.02u l=5.575u
X2387 VDD.t371 DFFQX1_3.CK a_16485_14920# VDD.t5 sg13_lv_pmos ad=0.1834p pd=1.39u as=0.1632p ps=1.64u w=0.48u l=0.13u
X2388 VSS.t20 a_37805_10770# VSS.t20 VSS.t19 sg13_lv_nmos ad=0.1738p pd=1.275u as=0 ps=0 w=0.88u l=1.945u
X2389 VSS.t303 a_35285_5072# a_35217_5146# VSS.t302 sg13_lv_nmos ad=0.1672p pd=1.26u as=0.2992p ps=2.44u w=0.88u l=0.13u
X2390 VSS.t431 a_15713_6738# VSS.t428 VSS.t471 sg13_lv_nmos ad=0.1672p pd=1.26u as=0 ps=0 w=0.88u l=5.575u
X2391 VDD.t1436 a_22635_14192# a_22599_14228# VDD.t100 sg13_lv_pmos ad=91.2f pd=0.86u as=43.2f ps=0.66u w=0.48u l=0.13u
X2392 VSS.t172 a_13025_8082# a_12957_8118# VSS.t1072 sg13_lv_nmos ad=0.1672p pd=1.26u as=0.2992p ps=2.44u w=0.88u l=0.13u
X2393 VDD.t1967 a_20769_12150# VDD.t1966 VDD.t93 sg13_lv_pmos ad=0.3468p pd=2.72u as=0 ps=0 w=1.02u l=5.575u
X2394 XOR2X1_0.A a_2629_15510# VDD.t660 VDD.t5 sg13_lv_pmos ad=0.4488p pd=3.32u as=0.2412p ps=1.73u w=1.32u l=0.13u
X2395 a_9674_15474# BUFX24_2.A VDD.t1193 VDD.t5 sg13_lv_pmos ad=0.2508p pd=1.7u as=0.2508p ps=1.7u w=1.32u l=0.13u
X2396 VDD.t952 a_31437_11866# VDD.t951 VDD.t281 sg13_lv_pmos ad=0.3468p pd=2.72u as=0 ps=0 w=1.02u l=1.945u
X2397 VSS.t137 OR3X1_0.Y a_21493_14838# VSS.t1734 sg13_lv_nmos ad=0.2176p pd=1.96u as=0.1216p ps=1.02u w=0.64u l=0.13u
X2398 a_11933_8082# a_11865_8118# VDD.t418 VDD.t29 sg13_lv_pmos ad=0.3468p pd=2.72u as=0.20145p ps=1.415u w=1.02u l=0.13u
X2399 a_19745_10770# a_19677_10806# VDD.t1816 VDD.t281 sg13_lv_pmos ad=0.3468p pd=2.72u as=0.20145p ps=1.415u w=1.02u l=0.13u
X2400 VDD.t684 a_1029_5430# VDD.t682 VDD.t68 sg13_lv_pmos ad=0.1938p pd=1.4u as=0 ps=0 w=1.02u l=5.575u
X2401 VDD.t1138 a_3325_15532# a_3821_15572# VDD.t5 sg13_lv_pmos ad=0.1632p pd=1.64u as=43.2f ps=0.66u w=0.48u l=0.13u
X2402 VSS.t50 a_37805_6738# VSS.t50 VSS.t49 sg13_lv_nmos ad=0.1738p pd=1.275u as=0 ps=0 w=0.88u l=1.945u
X2403 a_38480_10784# a_38412_10820# VDD.t1314 VDD.t281 sg13_lv_pmos ad=0.3332p pd=2.64u as=0.3332p ps=2.64u w=0.98u l=0.76u
X2404 VDD.t548 OR3X1_1.A a_22377_13948# VDD.t100 sg13_lv_pmos ad=0.108p pd=0.93u as=86.39999f ps=0.84u w=0.48u l=0.13u
X2405 VSS.t352 a_36461_9426# a_36393_9462# VSS.t351 sg13_lv_nmos ad=0.1738p pd=1.275u as=0.2992p ps=2.44u w=0.88u l=0.13u
X2406 VSS.t238 a_14537_13136# VSS.t241 VSS.t1355 sg13_lv_nmos ad=0.1738p pd=1.275u as=0 ps=0 w=0.88u l=5.305u
X2407 a_23323_15175# a_23121_14906# VDD.t959 VDD.t5 sg13_lv_pmos ad=0.1862p pd=1.36u as=0.1834p ps=1.39u w=0.98u l=0.13u
X2408 a_21619_14180# NAND2X1_1.Y a_21525_14180# VDD.t100 sg13_lv_pmos ad=71.99999f pd=0.78u as=0.1632p ps=1.64u w=0.48u l=0.13u
X2409 VDD.t1572 a_3717_10806# VDD.t1571 VDD.t281 sg13_lv_pmos ad=0.3468p pd=2.72u as=0 ps=0 w=1.02u l=1.945u
X2410 VSS.t1541 a_22349_3728# a_22281_3802# VSS.t1542 sg13_lv_nmos ad=0.1738p pd=1.275u as=0.2992p ps=2.44u w=0.88u l=0.13u
X2411 a_6153_15938# NAND2X1_0.Y VDD.t747 VDD.t5 sg13_lv_pmos ad=91.2f pd=0.86u as=0.1632p ps=1.64u w=0.48u l=0.13u
X2412 VSS.t105 DFFQX1_3.CK a_16485_14920# VSS.t459 sg13_lv_nmos ad=0.1193p pd=1.05u as=0.102p ps=1.28u w=0.3u l=0.13u
X2413 VSS.t870 a_32597_14480# a_32529_14554# VSS.t873 sg13_lv_nmos ad=0.1672p pd=1.26u as=0.2992p ps=2.44u w=0.88u l=0.13u
X2414 VSS.t202 a_19745_5394# a_19677_5430# VSS.t1775 sg13_lv_nmos ad=0.1738p pd=1.275u as=0.2992p ps=2.44u w=0.88u l=0.13u
X2415 VSS.t564 a_15881_7760# a_15813_7834# VSS.t563 sg13_lv_nmos ad=0.1738p pd=1.275u as=0.2992p ps=2.44u w=0.88u l=0.13u
X2416 a_22350_16146# BUFX3_1.Y.t7 VDD.t377 VDD.t0 sg13_lv_pmos ad=0.1212p pd=0.985u as=0.1834p ps=1.39u w=0.48u l=0.13u
X2417 VDD.t623 DFFQX1_5.CK a_22197_15624# VDD.t5 sg13_lv_pmos ad=0.1834p pd=1.39u as=0.1632p ps=1.64u w=0.48u l=0.13u
X2418 VSS.t1284 a_3785_2706# a_3717_2742# VSS.t1283 sg13_lv_nmos ad=0.1738p pd=1.275u as=0.2992p ps=2.44u w=0.88u l=0.13u
X2419 VSS.t29 a_14537_9104# a_14469_9178# VSS.t275 sg13_lv_nmos ad=0.1738p pd=1.275u as=0.2992p ps=2.44u w=0.88u l=0.13u
X2420 a_23693_7760# a_23625_7834# VDD.t735 VDD.t39 sg13_lv_pmos ad=0.3468p pd=2.72u as=0.20145p ps=1.415u w=1.02u l=0.13u
X2421 VSS.t674 a_23525_8082# VSS.t374 VSS.t1026 sg13_lv_nmos ad=0.1672p pd=1.26u as=0 ps=0 w=0.88u l=5.575u
X2422 a_6247_15938# NAND2X1_0.Y a_6153_15938# VSS.t732 sg13_lv_nmos ad=27f pd=0.48u as=0.102p ps=1.28u w=0.3u l=0.13u
X2423 a_26213_12114# a_26145_12150# VDD.t715 VDD.t93 sg13_lv_pmos ad=0.3468p pd=2.72u as=0.20145p ps=1.415u w=1.02u l=0.13u
X2424 DFFQX1_3.CK a_9674_15474# VDD.t1189 VDD.t5 sg13_lv_pmos ad=0.2508p pd=1.7u as=0.2508p ps=1.7u w=1.32u l=0.13u
X2425 VDD.t1765 a_16401_2742# VDD.t1764 VDD.t354 sg13_lv_pmos ad=0.3468p pd=2.72u as=0 ps=0 w=1.02u l=5.575u
X2426 VSS.t481 a_27557_6738# a_27489_6774# VSS.t1299 sg13_lv_nmos ad=0.1738p pd=1.275u as=0.2992p ps=2.44u w=0.88u l=0.13u
X2427 VDD.t328 a_7833_12150# VDD.t327 VDD.t93 sg13_lv_pmos ad=0.1938p pd=1.4u as=0 ps=0 w=1.02u l=5.575u
X2428 a_27557_9426# a_27489_9462# VDD.t378 VDD.t8 sg13_lv_pmos ad=0.3468p pd=2.72u as=0.20145p ps=1.415u w=1.02u l=0.13u
X2429 VDD.t1930 a_19593_9178# VDD.t1928 VDD.t29 sg13_lv_pmos ad=0.1938p pd=1.4u as=0 ps=0 w=1.02u l=5.575u
X2430 a_35217_15898# a_35285_15824# VSS.t11 VSS.t10 sg13_lv_nmos ad=0.2992p pd=2.44u as=0.1672p ps=1.26u w=0.88u l=0.13u
X2431 VSS.t1603 a_14537_14480# a_14469_14554# VSS.t1657 sg13_lv_nmos ad=0.1738p pd=1.275u as=0.2992p ps=2.44u w=0.88u l=0.13u
X2432 VDD.t1529 a_27405_11866# VDD.t1528 VDD.t281 sg13_lv_pmos ad=0.1938p pd=1.4u as=0 ps=0 w=1.02u l=5.575u
X2433 VSS.t1436 a_31589_2706# VSS.t1434 VSS.t1435 sg13_lv_nmos ad=0.1672p pd=1.26u as=0 ps=0 w=0.88u l=5.575u
X2434 VDD.t1664 reset_n_i a_1033_10134# VDD.t8 sg13_lv_pmos ad=0.2412p pd=1.73u as=0.1632p ps=1.64u w=0.48u l=0.13u
X2435 VDD.t468 a_1029_6490# a_1097_6416# VDD.t68 sg13_lv_pmos ad=0.1938p pd=1.4u as=0.1938p ps=1.4u w=1.02u l=0.13u
X2436 VSS.t97 a_36461_8082# VSS.t97 VSS.t96 sg13_lv_nmos ad=0.1738p pd=1.275u as=0 ps=0 w=0.88u l=5.305u
X2437 VDD.t1877 a_27237_14838# VDD.t1876 VDD.t5 sg13_lv_pmos ad=0.3468p pd=2.72u as=0 ps=0 w=1.02u l=1.945u
X2438 VDD.t1419 a_22281_13210# VDD.t1418 VDD.t93 sg13_lv_pmos ad=0.3468p pd=2.72u as=0 ps=0 w=1.02u l=5.305u
X2439 BUFX3_0.Y a_1033_3414# VSS.t224 VSS.t902 sg13_lv_nmos ad=0.2924p pd=2.4u as=0.1567p ps=1.27u w=0.86u l=0.13u
X2440 a_12689_2706# a_12621_2742# VDD.t1917 VDD.t354 sg13_lv_pmos ad=0.1938p pd=1.4u as=0.1938p ps=1.4u w=1.02u l=0.13u
X2441 a_1029_7834# a_1097_7760# VSS.t165 VSS.t168 sg13_lv_nmos ad=0.2992p pd=2.44u as=0.1672p ps=1.26u w=0.88u l=0.13u
X2442 DFFQX1_5.CK a_15318_15510# VDD.t1160 VDD.t5 sg13_lv_pmos ad=0.2508p pd=1.7u as=0.2508p ps=1.7u w=1.32u l=0.13u
X2443 VDD.t1621 a_16905_11866# VDD.t1620 VDD.t281 sg13_lv_pmos ad=0.3468p pd=2.72u as=0 ps=0 w=1.02u l=5.575u
X2444 a_36461_8082# a_36393_8118# VDD.t655 VDD.t29 sg13_lv_pmos ad=0.3468p pd=2.72u as=0.20145p ps=1.415u w=1.02u l=0.13u
X2445 VSS.t700 a_19661_13136# VSS.t70 VSS.t975 sg13_lv_nmos ad=0.1672p pd=1.26u as=0 ps=0 w=0.88u l=5.575u
X2446 a_31589_16146# a_31521_16182# VDD.t1553 VDD.t0 sg13_lv_pmos ad=0.3468p pd=2.72u as=0.20145p ps=1.415u w=1.02u l=0.13u
X2447 VSS.t952 a_7817_13136# a_7749_13210# VSS.t1673 sg13_lv_nmos ad=0.1738p pd=1.275u as=0.2992p ps=2.44u w=0.88u l=0.13u
X2448 a_8218_15932# XOR2X1_0.A VSS.t94 VSS.t145 sg13_lv_nmos ad=0.1216p pd=1.02u as=0.2176p ps=1.96u w=0.64u l=0.13u
X2449 VDD.t1786 clock_i a_12714_15510# VDD.t5 sg13_lv_pmos ad=0.2508p pd=1.7u as=0.4488p ps=3.32u w=1.32u l=0.13u
X2450 VSS.t998 a_27473_11792# a_27405_11866# VSS.t1288 sg13_lv_nmos ad=0.1672p pd=1.26u as=0.2992p ps=2.44u w=0.88u l=0.13u
X2451 VDD.t904 a_11781_5146# a_11849_5072# VDD.t83 sg13_lv_pmos ad=0.1938p pd=1.4u as=0.1938p ps=1.4u w=1.02u l=0.13u
X2452 a_24785_15824# a_24717_15898# VDD.t1296 VDD.t5 sg13_lv_pmos ad=0.1938p pd=1.4u as=0.1938p ps=1.4u w=1.02u l=0.13u
X2453 VSS.t97 a_38648_7782# a_38580_7868# VSS.t96 sg13_lv_nmos ad=0.2176p pd=1.96u as=0.2176p ps=1.96u w=0.64u l=0.76u
X2454 VDD.t1882 a_9093_13210# a_9161_13136# VDD.t93 sg13_lv_pmos ad=0.1938p pd=1.4u as=0.1938p ps=1.4u w=1.02u l=0.13u
X2455 VDD.t59 a_15645_6774# VDD.t57 VDD.t39 sg13_lv_pmos ad=0.3468p pd=2.72u as=0 ps=0 w=1.02u l=5.575u
X2456 VSS.t595 a_5213_14802# a_5145_14838# VSS.t594 sg13_lv_nmos ad=0.1738p pd=1.275u as=0.2992p ps=2.44u w=0.88u l=0.13u
X2457 VSS.t497 a_1097_13458# VSS.t497 VSS.t837 sg13_lv_nmos ad=0.1672p pd=1.26u as=0 ps=0 w=0.88u l=5.575u
X2458 VSS.t439 a_4460_5408# a_4392_5444# VSS.t1833 sg13_lv_nmos ad=0.2176p pd=1.96u as=0.2176p ps=1.96u w=0.64u l=0.76u
X2459 VSS.t1364 a_19745_12114# a_19677_12150# VSS.t1563 sg13_lv_nmos ad=0.1738p pd=1.275u as=0.2992p ps=2.44u w=0.88u l=0.13u
X2460 VSS.t197 a_7901_5394# a_7833_5430# VSS.t740 sg13_lv_nmos ad=0.1672p pd=1.26u as=0.2992p ps=2.44u w=0.88u l=0.13u
X2461 VSS.t717 a_13025_6738# a_12957_6774# VSS.t716 sg13_lv_nmos ad=0.1672p pd=1.26u as=0.2992p ps=2.44u w=0.88u l=0.13u
X2462 VSS.t1121 BUFX3_26.Y a_6661_16182# VSS.t1180 sg13_lv_nmos ad=0.1567p pd=1.27u as=0.102p ps=1.28u w=0.3u l=0.13u
X2463 VSS.t137 OR3BX1_0.B a_21313_14656# VSS.t136 sg13_lv_nmos ad=0.102p pd=1.28u as=57f ps=0.68u w=0.3u l=0.13u
X2464 a_7817_13136# a_7749_13210# VDD.t1838 VDD.t93 sg13_lv_pmos ad=0.3468p pd=2.72u as=0.20145p ps=1.415u w=1.02u l=0.13u
X2465 VDD.t1892 a_3717_6490# a_3785_6416# VDD.t68 sg13_lv_pmos ad=0.1938p pd=1.4u as=0.1938p ps=1.4u w=1.02u l=0.13u
X2466 VSS.t262 OR3X1_1.C a_22197_13608# VSS.t569 sg13_lv_nmos ad=0.102p pd=1.28u as=0.102p ps=1.28u w=0.3u l=0.13u
X2467 a_18435_15045# a_18297_15244# VSS.t101 VSS.t1715 sg13_lv_nmos ad=57f pd=0.68u as=57f ps=0.68u w=0.3u l=0.13u
X2468 a_3717_7834# a_3785_7760# VSS.t559 VSS.t558 sg13_lv_nmos ad=0.2992p pd=2.44u as=0.1672p ps=1.26u w=0.88u l=0.13u
X2469 VDD.t139 a_3023_15792# BUFX3_12.A VDD.t5 sg13_lv_pmos ad=0.2529p pd=1.545u as=0.1632p ps=1.64u w=0.48u l=0.13u
X2470 VDD.t1071 a_23457_8118# VDD.t1070 VDD.t29 sg13_lv_pmos ad=0.3468p pd=2.72u as=0 ps=0 w=1.02u l=5.575u
X2471 VDD.t630 a_32529_10522# VDD.t631 VDD.t8 sg13_lv_pmos ad=0.3468p pd=2.72u as=0 ps=0 w=1.02u l=5.575u
X2472 VDD.t1271 a_35217_15898# VDD.t1269 VDD.t5 sg13_lv_pmos ad=0.1938p pd=1.4u as=0 ps=0 w=1.02u l=5.575u
X2473 VDD.t1424 a_15813_3802# VDD.t1425 VDD.t354 sg13_lv_pmos ad=0.3468p pd=2.72u as=0 ps=0 w=1.02u l=1.945u
X2474 VSS.t325 a_15713_5394# VSS.t222 VSS.t324 sg13_lv_nmos ad=0.1672p pd=1.26u as=0 ps=0 w=0.88u l=5.575u
X2475 VSS.t172 a_11933_8082# VSS.t170 VSS.t171 sg13_lv_nmos ad=0.1738p pd=1.275u as=0 ps=0 w=0.88u l=1.945u
X2476 a_18031_14852# a_17829_14920# VDD.t288 VDD.t5 sg13_lv_pmos ad=0.3332p pd=2.64u as=0.1834p ps=1.39u w=0.98u l=0.13u
X2477 VSS.t3 a_11849_14480# VSS.t1605 VSS.t1604 sg13_lv_nmos ad=0.1672p pd=1.26u as=0 ps=0 w=0.88u l=5.575u
X2478 VSS.t776 a_35285_3728# VSS.t251 VSS.t1418 sg13_lv_nmos ad=0.1672p pd=1.26u as=0 ps=0 w=0.88u l=5.575u
X2479 VSS.t170 a_11849_7760# VSS.t172 VSS.t1035 sg13_lv_nmos ad=0.1672p pd=1.26u as=0 ps=0 w=0.88u l=5.575u
X2480 a_21979_14852# a_21777_14920# VSS.t602 VSS.t1659 sg13_lv_nmos ad=0.2176p pd=1.96u as=0.1193p ps=1.05u w=0.64u l=0.13u
X2481 VDD.t785 a_31269_14838# VDD.t784 VDD.t5 sg13_lv_pmos ad=0.3468p pd=2.72u as=0 ps=0 w=1.02u l=5.575u
X2482 VSS.t870 a_31337_14802# VSS.t1507 VSS.t1718 sg13_lv_nmos ad=0.1672p pd=1.26u as=0 ps=0 w=0.88u l=5.575u
X2483 a_35369_2706# a_35301_2742# VDD.t510 VDD.t354 sg13_lv_pmos ad=0.1938p pd=1.4u as=0.1938p ps=1.4u w=1.02u l=0.13u
X2484 VDD.t556 a_36393_9462# VDD.t555 VDD.t8 sg13_lv_pmos ad=0.3468p pd=2.72u as=0 ps=0 w=1.02u l=5.305u
X2485 VSS.t504 a_5129_2706# VSS.t1544 VSS.t1543 sg13_lv_nmos ad=0.1672p pd=1.26u as=0 ps=0 w=0.88u l=5.575u
X2486 VDD.t748 a_27405_6490# VDD.t749 VDD.t68 sg13_lv_pmos ad=0.3468p pd=2.72u as=0 ps=0 w=1.02u l=5.575u
X2487 VSS.t278 a_27473_9104# VSS.t281 VSS.t280 sg13_lv_nmos ad=0.1672p pd=1.26u as=0 ps=0 w=0.88u l=5.575u
X2488 VSS.t316 a_23525_12114# a_23457_12150# VSS.t315 sg13_lv_nmos ad=0.1672p pd=1.26u as=0.2992p ps=2.44u w=0.88u l=0.13u
X2489 VSS.t212 a_31505_5072# a_31437_5146# VSS.t299 sg13_lv_nmos ad=0.1738p pd=1.275u as=0.2992p ps=2.44u w=0.88u l=0.13u
X2490 VDD.t518 a_9093_6490# a_9161_6416# VDD.t68 sg13_lv_pmos ad=0.1938p pd=1.4u as=0.1938p ps=1.4u w=1.02u l=0.13u
X2491 VDD.t1349 a_23625_5146# VDD.t1348 VDD.t83 sg13_lv_pmos ad=0.3468p pd=2.72u as=0 ps=0 w=1.02u l=1.945u
X2492 VSS.t352 a_35369_9426# VSS.t36 VSS.t1057 sg13_lv_nmos ad=0.1738p pd=1.275u as=0 ps=0 w=0.88u l=1.945u
X2493 a_19580_16160# a_19512_16196# VDD.t1226 VDD.t0 sg13_lv_pmos ad=0.3332p pd=2.64u as=0.3332p ps=2.64u w=0.98u l=0.76u
X2494 VSS.t735 a_23525_6738# VSS.t787 VSS.t1294 sg13_lv_nmos ad=0.1672p pd=1.26u as=0 ps=0 w=0.88u l=5.575u
X2495 DFFQX1_3.CK a_9674_15474# VSS.t608 VSS.t1171 sg13_lv_nmos ad=0.1634p pd=1.24u as=0.1634p ps=1.24u w=0.86u l=0.13u
X2496 VSS.t1384 a_11933_13458# a_11865_13494# VSS.t1496 sg13_lv_nmos ad=0.1738p pd=1.275u as=0.2992p ps=2.44u w=0.88u l=0.13u
X2497 a_12957_5430# a_13025_5394# VSS.t222 VSS.t1772 sg13_lv_nmos ad=0.2992p pd=2.44u as=0.1672p ps=1.26u w=0.88u l=0.13u
X2498 VSS.t383 a_4373_15824# VSS.t293 VSS.t1236 sg13_lv_nmos ad=0.1738p pd=1.275u as=0 ps=0 w=0.88u l=1.945u
X2499 VDD.t1708 a_23461_14130# DFFQX1_5.D VDD.t100 sg13_lv_pmos ad=0.2412p pd=1.73u as=0.4488p ps=3.32u w=1.32u l=0.13u
X2500 VDD.t1641 a_10521_10806# VDD.t1640 VDD.t281 sg13_lv_pmos ad=0.3468p pd=2.72u as=0 ps=0 w=1.02u l=5.305u
X2501 a_9093_7834# a_9161_7760# VSS.t170 VSS.t1086 sg13_lv_nmos ad=0.2992p pd=2.44u as=0.1672p ps=1.26u w=0.88u l=0.13u
X2502 VSS.t651 a_26213_8082# a_26145_8118# VSS.t650 sg13_lv_nmos ad=0.1738p pd=1.275u as=0.2992p ps=2.44u w=0.88u l=0.13u
X2503 VDD.t1773 a_27741_2742# a_27809_2706# VDD.t354 sg13_lv_pmos ad=0.1938p pd=1.4u as=0.1938p ps=1.4u w=1.02u l=0.13u
X2504 VDD.t810 a_35217_7834# VDD.t809 VDD.t39 sg13_lv_pmos ad=0.3468p pd=2.72u as=0 ps=0 w=1.02u l=5.575u
X2505 VDD.t732 a_14469_10522# VDD.t731 VDD.t8 sg13_lv_pmos ad=0.3468p pd=2.72u as=0 ps=0 w=1.02u l=5.305u
X2506 a_24717_9178# a_24785_9104# VSS.t278 VSS.t546 sg13_lv_nmos ad=0.2992p pd=2.44u as=0.1672p ps=1.26u w=0.88u l=0.13u
X2507 VSS.t665 a_14117_15824# a_14049_15898# VSS.t1219 sg13_lv_nmos ad=0.1738p pd=1.275u as=0.2992p ps=2.44u w=0.88u l=0.13u
X2508 VSS.t3 a_9833_14802# VSS.t1467 VSS.t1468 sg13_lv_nmos ad=0.1672p pd=1.26u as=0 ps=0 w=0.88u l=5.575u
X2509 a_1097_11792# a_1029_11866# VDD.t965 VDD.t281 sg13_lv_pmos ad=0.1938p pd=1.4u as=0.1938p ps=1.4u w=1.02u l=0.13u
X2510 a_9833_14802# a_9765_14838# VDD.t778 VDD.t5 sg13_lv_pmos ad=0.1938p pd=1.4u as=0.1938p ps=1.4u w=1.02u l=0.13u
X2511 VSS.t499 a_3785_13136# VSS.t501 VSS.t500 sg13_lv_nmos ad=0.1672p pd=1.26u as=0 ps=0 w=0.88u l=5.575u
X2512 a_31269_8118# a_31337_8082# VSS.t43 VSS.t1824 sg13_lv_nmos ad=0.2992p pd=2.44u as=0.1672p ps=1.26u w=0.88u l=0.13u
X2513 a_30161_9104# a_30093_9178# VDD.t407 VDD.t29 sg13_lv_pmos ad=0.3468p pd=2.72u as=0.20145p ps=1.415u w=1.02u l=0.13u
X2514 VSS.t508 a_11849_10448# VSS.t509 VSS.t1640 sg13_lv_nmos ad=0.1672p pd=1.26u as=0 ps=0 w=0.88u l=5.575u
X2515 VSS.t50 a_36461_6738# VSS.t50 VSS.t49 sg13_lv_nmos ad=0.1738p pd=1.275u as=0 ps=0 w=0.88u l=5.305u
X2516 VSS.t38 a_31337_9426# VSS.t34 VSS.t634 sg13_lv_nmos ad=0.1672p pd=1.26u as=0 ps=0 w=0.88u l=5.575u
X2517 VSS.t612 BUFX24_2.A a_9674_15474# VSS.t1252 sg13_lv_nmos ad=0.1634p pd=1.24u as=0.1634p ps=1.24u w=0.86u l=0.13u
X2518 VDD.t1800 a_23121_13494# VDD.t1801 VDD.t100 sg13_lv_pmos ad=0.1938p pd=1.4u as=0 ps=0 w=1.02u l=5.575u
X2519 VDD.t1455 a_24717_5146# VDD.t1454 VDD.t83 sg13_lv_pmos ad=0.1938p pd=1.4u as=0 ps=0 w=1.02u l=5.575u
X2520 VSS.t1360 a_28649_4050# VSS.t423 VSS.t1359 sg13_lv_nmos ad=0.1672p pd=1.26u as=0 ps=0 w=0.88u l=5.575u
X2521 a_13025_12114# a_12957_12150# VDD.t1388 VDD.t93 sg13_lv_pmos ad=0.1938p pd=1.4u as=0.1938p ps=1.4u w=1.02u l=0.13u
X2522 VSS.t1507 a_28649_14802# VSS.t246 VSS.t1618 sg13_lv_nmos ad=0.1672p pd=1.26u as=0 ps=0 w=0.88u l=5.575u
X2523 a_28649_14802# a_28581_14838# VDD.t1850 VDD.t5 sg13_lv_pmos ad=0.1938p pd=1.4u as=0.1938p ps=1.4u w=1.02u l=0.13u
X2524 a_15713_4050# a_15645_4086# VDD.t919 VDD.t83 sg13_lv_pmos ad=0.1938p pd=1.4u as=0.1938p ps=1.4u w=1.02u l=0.13u
X2525 a_34277_2706# a_34209_2742# VDD.t1711 VDD.t354 sg13_lv_pmos ad=0.3468p pd=2.72u as=0.20145p ps=1.415u w=1.02u l=0.13u
X2526 VDD.t755 a_15645_5430# VDD.t753 VDD.t68 sg13_lv_pmos ad=0.3468p pd=2.72u as=0 ps=0 w=1.02u l=5.575u
X2527 a_22873_16146# BUFX3_38.Y VSS.t154 VSS.t257 sg13_lv_nmos ad=0.102p pd=1.28u as=0.1567p ps=1.27u w=0.3u l=0.13u
X2528 VSS.t1083 a_9161_7760# a_9093_7834# VSS.t1084 sg13_lv_nmos ad=0.1672p pd=1.26u as=0.2992p ps=2.44u w=0.88u l=0.13u
X2529 a_3451_14838# BUFX3_0.Y XOR2X1_0.Y VSS.t82 sg13_lv_nmos ad=28.5f pd=0.49u as=57f ps=0.68u w=0.3u l=0.13u
X2530 VDD.t1321 a_1029_13494# a_1097_13458# VDD.t100 sg13_lv_pmos ad=0.1938p pd=1.4u as=0.1938p ps=1.4u w=1.02u l=0.13u
X2531 VDD.t1666 a_19677_12150# VDD.t1665 VDD.t93 sg13_lv_pmos ad=0.3468p pd=2.72u as=0 ps=0 w=1.02u l=1.945u
X2532 VSS.t410 a_19661_6416# VSS.t414 VSS.t413 sg13_lv_nmos ad=0.1672p pd=1.26u as=0 ps=0 w=0.88u l=5.575u
X2533 VDD.t467 a_1029_6490# VDD.t466 VDD.t68 sg13_lv_pmos ad=0.3468p pd=2.72u as=0 ps=0 w=1.02u l=5.575u
X2534 VSS.t799 a_37973_13136# a_37905_13210# VSS.t798 sg13_lv_nmos ad=0.1738p pd=1.275u as=0.2992p ps=2.44u w=0.88u l=0.13u
X2535 VSS.t520 a_1097_9104# VSS.t520 VSS.t622 sg13_lv_nmos ad=0.1672p pd=1.26u as=0 ps=0 w=0.88u l=5.575u
X2536 VDD.t338 a_8085_10522# VDD.t337 VDD.t8 sg13_lv_pmos ad=0.3468p pd=2.72u as=0 ps=0 w=1.02u l=1.945u
X2537 OA21X2_1.Y a_23709_14838# VSS.t264 VSS.t1722 sg13_lv_nmos ad=0.2176p pd=1.96u as=0.1193p ps=1.05u w=0.64u l=0.13u
X2538 VSS.t566 a_16973_7760# VSS.t573 VSS.t572 sg13_lv_nmos ad=0.1672p pd=1.26u as=0 ps=0 w=0.88u l=5.575u
X2539 VSS.t612 a_9674_15474# DFFQX1_3.CK VSS.t1174 sg13_lv_nmos ad=0.1634p pd=1.24u as=0.1634p ps=1.24u w=0.86u l=0.13u
X2540 a_7437_15572# a_7221_15952# VDD.t1242 VDD.t5 sg13_lv_pmos ad=43.2f pd=0.66u as=91.2f ps=0.86u w=0.48u l=0.13u
X2541 a_37973_5072# a_37905_5146# VDD.t908 VDD.t83 sg13_lv_pmos ad=0.3468p pd=2.72u as=0.20145p ps=1.415u w=1.02u l=0.13u
X2542 VSS.t717 a_11933_6738# VSS.t143 VSS.t1830 sg13_lv_nmos ad=0.1738p pd=1.275u as=0 ps=0 w=0.88u l=1.945u
X2543 VDD.t220 a_5145_6774# a_5213_6738# VDD.t39 sg13_lv_pmos ad=0.1938p pd=1.4u as=0.1938p ps=1.4u w=1.02u l=0.13u
X2544 a_27473_3728# a_27405_3802# VDD.t1868 VDD.t354 sg13_lv_pmos ad=0.1938p pd=1.4u as=0.1938p ps=1.4u w=1.02u l=0.13u
X2545 VSS.t200 a_18401_5394# a_18333_5430# VSS.t199 sg13_lv_nmos ad=0.1738p pd=1.275u as=0.2992p ps=2.44u w=0.88u l=0.13u
X2546 BUFX3_4.A a_8001_16258# VDD.t136 VDD.t0 sg13_lv_pmos ad=91.2f pd=0.86u as=98.39999f ps=0.89u w=0.48u l=0.13u
X2547 a_16905_6490# a_16973_6416# VSS.t410 VSS.t429 sg13_lv_nmos ad=0.2992p pd=2.44u as=0.1672p ps=1.26u w=0.88u l=0.13u
X2548 VDD.t1326 a_23457_12150# VDD.t1324 VDD.t93 sg13_lv_pmos ad=0.3468p pd=2.72u as=0 ps=0 w=1.02u l=5.575u
X2549 VDD.t712 a_24717_14554# VDD.t711 VDD.t100 sg13_lv_pmos ad=0.1938p pd=1.4u as=0 ps=0 w=1.02u l=5.575u
X2550 VSS.t137 BUFX3_1.Y.t3 a_21189_14906# VSS.t1202 sg13_lv_nmos ad=0.1193p pd=1.05u as=0.102p ps=1.28u w=0.3u l=0.13u
X2551 a_11849_6416# a_11781_6490# VDD.t671 VDD.t68 sg13_lv_pmos ad=0.1938p pd=1.4u as=0.1938p ps=1.4u w=1.02u l=0.13u
X2552 a_35285_5072# a_35217_5146# VDD.t998 VDD.t83 sg13_lv_pmos ad=0.1938p pd=1.4u as=0.1938p ps=1.4u w=1.02u l=0.13u
X2553 VSS.t1284 a_1097_2706# VSS.t1284 VSS.t1792 sg13_lv_nmos ad=0.1672p pd=1.26u as=0 ps=0 w=0.88u l=5.575u
X2554 VSS.t26 a_11849_9104# VSS.t29 VSS.t540 sg13_lv_nmos ad=0.1672p pd=1.26u as=0 ps=0 w=0.88u l=5.575u
X2555 VDD.t1500 a_11865_13494# VDD.t1499 VDD.t100 sg13_lv_pmos ad=0.3468p pd=2.72u as=0 ps=0 w=1.02u l=1.945u
X2556 VSS.t737 a_26213_6738# a_26145_6774# VSS.t1297 sg13_lv_nmos ad=0.1738p pd=1.275u as=0.2992p ps=2.44u w=0.88u l=0.13u
X2557 VDD.t377 a_22350_16146# BUFX3_31.A VDD.t0 sg13_lv_pmos ad=0.1834p pd=1.39u as=0.3479p ps=2.67u w=0.98u l=0.13u
X2558 VSS.t1137 a_15318_15510# DFFQX1_5.CK VSS.t1136 sg13_lv_nmos ad=0.1634p pd=1.24u as=0.1634p ps=1.24u w=0.86u l=0.13u
X2559 a_26717_2706# a_26649_2742# VDD.t1474 VDD.t354 sg13_lv_pmos ad=0.3468p pd=2.72u as=0.20145p ps=1.415u w=1.02u l=0.13u
X2560 VDD.t710 a_24717_14554# VDD.t709 VDD.t100 sg13_lv_pmos ad=0.3468p pd=2.72u as=0 ps=0 w=1.02u l=5.575u
X2561 VSS.t922 a_1097_12114# a_1029_12150# VSS.t1314 sg13_lv_nmos ad=0.1672p pd=1.26u as=0.2992p ps=2.44u w=0.88u l=0.13u
X2562 VSS.t1483 a_20249_2706# VSS.t916 VSS.t1482 sg13_lv_nmos ad=0.1672p pd=1.26u as=0 ps=0 w=0.88u l=5.575u
X2563 a_12714_15510# clock_i VSS.t661 VSS.t1665 sg13_lv_nmos ad=0.1634p pd=1.24u as=0.1634p ps=1.24u w=0.86u l=0.13u
X2564 NAND3X1_0.Y NAND3X1_0.B VDD.t1221 VDD.t5 sg13_lv_pmos ad=91.2f pd=0.86u as=0.1632p ps=1.64u w=0.48u l=0.13u
X2565 VSS.t872 a_35285_14480# a_35217_14554# VSS.t948 sg13_lv_nmos ad=0.1672p pd=1.26u as=0.2992p ps=2.44u w=0.88u l=0.13u
X2566 VSS.t844 a_9161_10448# VSS.t1688 VSS.t1687 sg13_lv_nmos ad=0.1672p pd=1.26u as=0 ps=0 w=0.88u l=5.575u
X2567 a_30161_15824# a_30093_15898# VDD.t55 VDD.t5 sg13_lv_pmos ad=0.3468p pd=2.72u as=0.20145p ps=1.415u w=1.02u l=0.13u
X2568 VDD.t1337 a_7749_2742# VDD.t1336 VDD.t354 sg13_lv_pmos ad=0.3468p pd=2.72u as=0 ps=0 w=1.02u l=1.945u
X2569 VSS.t224 a_1433_3728# VSS.t224 VSS.t1840 sg13_lv_nmos ad=0.1672p pd=1.26u as=0 ps=0 w=0.88u l=5.575u
X2570 VSS.t894 a_5129_2706# a_5061_2742# VSS.t1545 sg13_lv_nmos ad=0.1672p pd=1.26u as=0.2992p ps=2.44u w=0.88u l=0.13u
X2571 VSS.t233 a_30497_2706# a_30429_2742# VSS.t232 sg13_lv_nmos ad=0.1738p pd=1.275u as=0.2992p ps=2.44u w=0.88u l=0.13u
X2572 VDD.t603 AND2X1_3.B a_2625_14852# VDD.t5 sg13_lv_pmos ad=91.2f pd=0.86u as=91.2f ps=0.86u w=0.48u l=0.13u
X2573 a_31269_6774# a_31337_6738# VSS.t455 VSS.t1090 sg13_lv_nmos ad=0.2992p pd=2.44u as=0.1672p ps=1.26u w=0.88u l=0.13u
X2574 VDD.t1480 a_17069_14144# AND2X1_0.Y VDD.t100 sg13_lv_pmos ad=91.2f pd=0.86u as=0.192p ps=1.76u w=0.48u l=0.13u
X2575 VDD.t1055 a_31269_9462# a_31337_9426# VDD.t8 sg13_lv_pmos ad=0.1938p pd=1.4u as=0.1938p ps=1.4u w=1.02u l=0.13u
X2576 a_31505_5072# a_31437_5146# VDD.t689 VDD.t83 sg13_lv_pmos ad=0.3468p pd=2.72u as=0.20145p ps=1.415u w=1.02u l=0.13u
X2577 a_16905_11866# a_16973_11792# VSS.t1364 VSS.t1567 sg13_lv_nmos ad=0.2992p pd=2.44u as=0.1672p ps=1.26u w=0.88u l=0.13u
X2578 VDD.t1689 a_9093_3802# VDD.t1688 VDD.t354 sg13_lv_pmos ad=0.3468p pd=2.72u as=0 ps=0 w=1.02u l=5.575u
X2579 VSS.t62 a_11933_5394# a_11865_5430# VSS.t690 sg13_lv_nmos ad=0.1738p pd=1.275u as=0.2992p ps=2.44u w=0.88u l=0.13u
X2580 VDD.t137 a_31437_7834# VDD.t138 VDD.t39 sg13_lv_pmos ad=0.3468p pd=2.72u as=0 ps=0 w=1.02u l=1.945u
X2581 VSS.t248 a_27980_14816# a_27912_14852# VSS.t1049 sg13_lv_nmos ad=0.2176p pd=1.96u as=0.2176p ps=1.96u w=0.64u l=0.76u
X2582 VDD.t1577 a_28581_4086# a_28649_4050# VDD.t83 sg13_lv_pmos ad=0.1938p pd=1.4u as=0.1938p ps=1.4u w=1.02u l=0.13u
X2583 a_32597_6416# a_32529_6490# VDD.t318 VDD.t68 sg13_lv_pmos ad=0.1938p pd=1.4u as=0.1938p ps=1.4u w=1.02u l=0.13u
X2584 a_23693_13136# a_23625_13210# VDD.t1416 VDD.t93 sg13_lv_pmos ad=0.3468p pd=2.72u as=0.20145p ps=1.415u w=1.02u l=0.13u
X2585 VSS.t370 a_23693_9104# a_23625_9178# VSS.t1807 sg13_lv_nmos ad=0.1738p pd=1.275u as=0.2992p ps=2.44u w=0.88u l=0.13u
X2586 a_19661_10448# a_19593_10522# VDD.t625 VDD.t8 sg13_lv_pmos ad=0.1938p pd=1.4u as=0.1938p ps=1.4u w=1.02u l=0.13u
X2587 VSS.t799 a_36461_13458# VSS.t799 VSS.t798 sg13_lv_nmos ad=0.1738p pd=1.275u as=0 ps=0 w=0.88u l=5.305u
X2588 a_8492_14502# a_8424_14588# VDD.t1789 VDD.t100 sg13_lv_pmos ad=0.3332p pd=2.64u as=0.3332p ps=2.64u w=0.98u l=0.76u
X2589 VDD.t1493 a_19593_11866# VDD.t1492 VDD.t281 sg13_lv_pmos ad=0.3468p pd=2.72u as=0 ps=0 w=1.02u l=5.575u
X2590 VSS.t325 a_16973_5072# a_16905_5146# VSS.t1319 sg13_lv_nmos ad=0.1672p pd=1.26u as=0.2992p ps=2.44u w=0.88u l=0.13u
X2591 a_19745_9426# a_19677_9462# VDD.t293 VDD.t8 sg13_lv_pmos ad=0.3468p pd=2.72u as=0.20145p ps=1.415u w=1.02u l=0.13u
X2592 a_24029_2706# a_23961_2742# VDD.t876 VDD.t354 sg13_lv_pmos ad=0.1938p pd=1.4u as=0.1938p ps=1.4u w=1.02u l=0.13u
X2593 VSS.t131 a_31337_9426# a_31269_9462# VSS.t632 sg13_lv_nmos ad=0.1672p pd=1.26u as=0.2992p ps=2.44u w=0.88u l=0.13u
X2594 a_27473_15824# a_27405_15898# VDD.t606 VDD.t5 sg13_lv_pmos ad=0.1938p pd=1.4u as=0.1938p ps=1.4u w=1.02u l=0.13u
X2595 VSS.t885 a_25877_13458# a_25809_13494# VSS.t1834 sg13_lv_nmos ad=0.1738p pd=1.275u as=0.2992p ps=2.44u w=0.88u l=0.13u
X2596 VDD.t75 a_5145_5430# a_5213_5394# VDD.t68 sg13_lv_pmos ad=0.1938p pd=1.4u as=0.1938p ps=1.4u w=1.02u l=0.13u
X2597 VDD.t1722 a_11781_13210# a_11849_13136# VDD.t93 sg13_lv_pmos ad=0.1938p pd=1.4u as=0.1938p ps=1.4u w=1.02u l=0.13u
X2598 VSS.t67 a_37973_11792# VSS.t67 VSS.t66 sg13_lv_nmos ad=0.1738p pd=1.275u as=0 ps=0 w=0.88u l=1.945u
X2599 VSS.t983 a_28649_4050# a_28581_4086# VSS.t1358 sg13_lv_nmos ad=0.1672p pd=1.26u as=0.2992p ps=2.44u w=0.88u l=0.13u
X2600 VDD.t1120 a_20769_8118# a_20837_8082# VDD.t29 sg13_lv_pmos ad=0.1938p pd=1.4u as=0.1938p ps=1.4u w=1.02u l=0.13u
X2601 VSS.t700 a_18401_13458# VSS.t702 VSS.t1495 sg13_lv_nmos ad=0.1738p pd=1.275u as=0 ps=0 w=0.88u l=5.305u
X2602 VSS.t154 DFFQX1_5.CK a_22197_15624# VSS.t618 sg13_lv_nmos ad=0.1193p pd=1.05u as=0.102p ps=1.28u w=0.3u l=0.13u
X2603 a_12957_12150# a_13025_12114# VSS.t796 VSS.t1493 sg13_lv_nmos ad=0.2992p pd=2.44u as=0.1672p ps=1.26u w=0.88u l=0.13u
X2604 VSS.t1096 a_27473_11792# VSS.t1098 VSS.t1289 sg13_lv_nmos ad=0.1672p pd=1.26u as=0 ps=0 w=0.88u l=5.575u
X2605 VSS.t36 a_34025_9426# VSS.t38 VSS.t534 sg13_lv_nmos ad=0.1738p pd=1.275u as=0 ps=0 w=0.88u l=5.305u
X2606 VSS.t520 a_3785_9426# a_3717_9462# VSS.t519 sg13_lv_nmos ad=0.1738p pd=1.275u as=0.2992p ps=2.44u w=0.88u l=0.13u
X2607 VDD.t65 a_23457_6774# VDD.t64 VDD.t39 sg13_lv_pmos ad=0.1938p pd=1.4u as=0 ps=0 w=1.02u l=5.575u
X2608 VDD.t60 a_15645_6774# a_15713_6738# VDD.t39 sg13_lv_pmos ad=0.1938p pd=1.4u as=0.1938p ps=1.4u w=1.02u l=0.13u
X2609 VSS.t158 a_32597_16146# VSS.t156 VSS.t157 sg13_lv_nmos ad=0.1738p pd=1.275u as=0 ps=0 w=0.88u l=5.305u
X2610 a_16953_15244# BUFX3_25.Y a_16891_15244# VDD.t5 sg13_lv_pmos ad=91.2f pd=0.86u as=43.2f ps=0.66u w=0.48u l=0.13u
X2611 VDD.t550 a_35217_10522# VDD.t549 VDD.t8 sg13_lv_pmos ad=0.3468p pd=2.72u as=0 ps=0 w=1.02u l=5.575u
X2612 VSS.t509 a_13025_10770# VSS.t508 VSS.t507 sg13_lv_nmos ad=0.1672p pd=1.26u as=0 ps=0 w=0.88u l=5.575u
X2613 a_18534_14670# BUFX3_2.Y OR3BX1_0.Y VSS.t1456 sg13_lv_nmos ad=35.25f pd=0.535u as=0.1365p ps=1.51u w=0.3u l=0.13u
X2614 VDD.t1646 a_12957_10806# VDD.t1643 VDD.t281 sg13_lv_pmos ad=0.3468p pd=2.72u as=0 ps=0 w=1.02u l=5.575u
X2615 VDD.t1848 a_33957_14838# VDD.t1847 VDD.t5 sg13_lv_pmos ad=0.3468p pd=2.72u as=0 ps=0 w=1.02u l=5.305u
X2616 VDD.t719 a_1029_12150# VDD.t718 VDD.t93 sg13_lv_pmos ad=0.3468p pd=2.72u as=0 ps=0 w=1.02u l=5.575u
X2617 a_1029_10806# a_1097_10770# VSS.t1573 VSS.t1677 sg13_lv_nmos ad=0.2992p pd=2.44u as=0.1672p ps=1.26u w=0.88u l=0.13u
X2618 VSS.t318 a_26213_12114# a_26145_12150# VSS.t996 sg13_lv_nmos ad=0.1738p pd=1.275u as=0.2992p ps=2.44u w=0.88u l=0.13u
X2619 VDD.t944 a_23625_11866# VDD.t943 VDD.t281 sg13_lv_pmos ad=0.3468p pd=2.72u as=0 ps=0 w=1.02u l=1.945u
X2620 VDD.t165 a_37905_15898# VDD.t164 VDD.t5 sg13_lv_pmos ad=0.3468p pd=2.72u as=0 ps=0 w=1.02u l=1.945u
X2621 a_3785_9104# a_3717_9178# VDD.t150 VDD.t29 sg13_lv_pmos ad=0.1938p pd=1.4u as=0.1938p ps=1.4u w=1.02u l=0.13u
X2622 VDD.t199 a_31269_8118# VDD.t198 VDD.t29 sg13_lv_pmos ad=0.1938p pd=1.4u as=0 ps=0 w=1.02u l=5.575u
X2623 VDD.t285 a_5145_10806# VDD.t286 VDD.t281 sg13_lv_pmos ad=0.1938p pd=1.4u as=0 ps=0 w=1.02u l=5.575u
X2624 VSS.t310 a_4121_3728# a_4053_3802# VSS.t1091 sg13_lv_nmos ad=0.1672p pd=1.26u as=0.2992p ps=2.44u w=0.88u l=0.13u
X2625 VSS.t318 a_23525_12114# VSS.t320 VSS.t321 sg13_lv_nmos ad=0.1672p pd=1.26u as=0 ps=0 w=0.88u l=5.575u
X2626 VDD.t476 a_35217_6490# VDD.t475 VDD.t68 sg13_lv_pmos ad=0.1938p pd=1.4u as=0 ps=0 w=1.02u l=5.575u
X2627 VSS.t192 a_15881_6416# a_15813_6490# VSS.t730 sg13_lv_nmos ad=0.1738p pd=1.275u as=0.2992p ps=2.44u w=0.88u l=0.13u
X2628 VDD.t936 a_3717_2742# VDD.t935 VDD.t354 sg13_lv_pmos ad=0.3468p pd=2.72u as=0 ps=0 w=1.02u l=1.945u
X2629 VSS.t1284 a_1097_2706# a_1029_2742# VSS.t1790 sg13_lv_nmos ad=0.1672p pd=1.26u as=0.2992p ps=2.44u w=0.88u l=0.13u
X2630 VSS.t20 a_38480_10784# a_38412_10820# VSS.t19 sg13_lv_nmos ad=0.2176p pd=1.96u as=0.2176p ps=1.96u w=0.64u l=0.76u
X2631 a_22937_2706# a_22869_2742# VDD.t1484 VDD.t354 sg13_lv_pmos ad=0.3468p pd=2.72u as=0.20145p ps=1.415u w=1.02u l=0.13u
X2632 a_2444_16160# a_2376_16196# VDD.t292 VDD.t0 sg13_lv_pmos ad=0.3332p pd=2.64u as=0.3332p ps=2.64u w=0.98u l=0.76u
X2633 VDD.t1237 BUFX3_4.A a_7669_16182# VDD.t0 sg13_lv_pmos ad=0.2412p pd=1.73u as=0.1632p ps=1.64u w=0.48u l=0.13u
X2634 a_9497_16146# a_9429_16182# VDD.t1034 VDD.t0 sg13_lv_pmos ad=0.1938p pd=1.4u as=0.1938p ps=1.4u w=1.02u l=0.13u
X2635 VSS.t1305 a_7901_12114# a_7833_12150# VSS.t1580 sg13_lv_nmos ad=0.1672p pd=1.26u as=0.2992p ps=2.44u w=0.88u l=0.13u
X2636 VDD.t237 a_27489_6774# VDD.t236 VDD.t39 sg13_lv_pmos ad=0.3468p pd=2.72u as=0 ps=0 w=1.02u l=1.945u
X2637 a_7069_15572# a_6803_15792# VDD.t1243 VDD.t5 sg13_lv_pmos ad=43.2f pd=0.66u as=0.2529p ps=1.545u w=0.48u l=0.13u
X2638 a_18665_15244# a_18031_14852# a_18435_15045# VSS.t1595 sg13_lv_nmos ad=57f pd=0.68u as=57f ps=0.68u w=0.3u l=0.13u
X2639 a_24549_14838# a_24617_14802# VSS.t244 VSS.t1592 sg13_lv_nmos ad=0.2992p pd=2.44u as=0.1672p ps=1.26u w=0.88u l=0.13u
X2640 NAND2X1_0.Y NAND2X1_0.A VDD.t1278 VDD.t5 sg13_lv_pmos ad=91.2f pd=0.86u as=0.1632p ps=1.64u w=0.48u l=0.13u
X2641 NAND3X1_0.B a_6325_16182# VSS.t1118 VSS.t1195 sg13_lv_nmos ad=0.2924p pd=2.4u as=0.1567p ps=1.27u w=0.86u l=0.13u
X2642 a_27741_16182# a_27809_16146# VSS.t117 VSS.t901 sg13_lv_nmos ad=0.2992p pd=2.44u as=0.1672p ps=1.26u w=0.88u l=0.13u
X2643 VSS.t264 a_23777_14480# a_23709_14554# VSS.t396 sg13_lv_nmos ad=0.1738p pd=1.275u as=0.2992p ps=2.44u w=0.88u l=0.13u
X2644 a_27405_13210# a_27473_13136# VSS.t342 VSS.t343 sg13_lv_nmos ad=0.2992p pd=2.44u as=0.1672p ps=1.26u w=0.88u l=0.13u
X2645 VSS.t50 a_38480_6752# a_38412_6788# VSS.t49 sg13_lv_nmos ad=0.2176p pd=1.96u as=0.2176p ps=1.96u w=0.64u l=0.76u
X2646 VSS.t197 a_7817_5072# a_7749_5146# VSS.t1783 sg13_lv_nmos ad=0.1738p pd=1.275u as=0.2992p ps=2.44u w=0.88u l=0.13u
X2647 VDD.t367 a_35301_8118# VDD.t366 VDD.t29 sg13_lv_pmos ad=0.3468p pd=2.72u as=0 ps=0 w=1.02u l=1.945u
X2648 VDD.t1053 a_31269_9462# VDD.t1052 VDD.t8 sg13_lv_pmos ad=0.3468p pd=2.72u as=0 ps=0 w=1.02u l=5.575u
X2649 VDD.t1130 a_25809_13494# VDD.t1129 VDD.t100 sg13_lv_pmos ad=0.3468p pd=2.72u as=0 ps=0 w=1.02u l=5.305u
X2650 VDD.t240 a_22281_6490# VDD.t239 VDD.t68 sg13_lv_pmos ad=0.3468p pd=2.72u as=0 ps=0 w=1.02u l=5.305u
X2651 a_1029_6490# a_1097_6416# VSS.t475 VSS.t727 sg13_lv_nmos ad=0.2992p pd=2.44u as=0.1672p ps=1.26u w=0.88u l=0.13u
X2652 a_9181_15474# AND2X1_2.Y VSS.t1165 VSS.t1166 sg13_lv_nmos ad=0.102p pd=1.28u as=0.1567p ps=1.27u w=0.3u l=0.13u
X2653 VSS.t222 a_15881_5072# VSS.t325 VSS.t1042 sg13_lv_nmos ad=0.1738p pd=1.275u as=0 ps=0 w=0.88u l=1.945u
X2654 BUFX3_16.A a_17749_16182# VDD.t596 VDD.t0 sg13_lv_pmos ad=0.4488p pd=3.32u as=0.2412p ps=1.73u w=1.32u l=0.13u
X2655 VDD.t1575 a_28581_4086# VDD.t1574 VDD.t83 sg13_lv_pmos ad=0.3468p pd=2.72u as=0 ps=0 w=1.02u l=5.575u
X2656 a_35369_16146# a_35301_16182# VDD.t1556 VDD.t0 sg13_lv_pmos ad=0.3468p pd=2.72u as=0.20145p ps=1.415u w=1.02u l=0.13u
X2657 a_8001_14852# BUFX3_1.Y.t4 VDD.t1044 VDD.t5 sg13_lv_pmos ad=91.2f pd=0.86u as=0.1632p ps=1.64u w=0.48u l=0.13u
X2658 VSS.t1573 a_1433_10448# VSS.t1573 VSS.t1575 sg13_lv_nmos ad=0.1672p pd=1.26u as=0 ps=0 w=0.88u l=5.575u
X2659 VSS.t64 a_10589_5394# a_10521_5430# VSS.t487 sg13_lv_nmos ad=0.1738p pd=1.275u as=0.2992p ps=2.44u w=0.88u l=0.13u
X2660 counter_value_o[5] a_27157_16182# VSS.t113 VSS.t1237 sg13_lv_nmos ad=0.2924p pd=2.4u as=0.1567p ps=1.27u w=0.86u l=0.13u
X2661 VSS.t499 a_5213_13458# a_5145_13494# VSS.t1736 sg13_lv_nmos ad=0.1672p pd=1.26u as=0.2992p ps=2.44u w=0.88u l=0.13u
X2662 VDD.t756 a_15645_5430# a_15713_5394# VDD.t68 sg13_lv_pmos ad=0.1938p pd=1.4u as=0.1938p ps=1.4u w=1.02u l=0.13u
X2663 VDD.t1046 a_3717_9462# VDD.t1045 VDD.t8 sg13_lv_pmos ad=0.3468p pd=2.72u as=0 ps=0 w=1.02u l=1.945u
X2664 VSS.t160 BUFX3_1.Y.t6 a_18165_15510# VSS.t1607 sg13_lv_nmos ad=57f pd=0.68u as=0.102p ps=1.28u w=0.3u l=0.13u
X2665 VDD.t967 a_1029_11866# a_1097_11792# VDD.t281 sg13_lv_pmos ad=0.1938p pd=1.4u as=0.1938p ps=1.4u w=1.02u l=0.13u
X2666 VDD.t831 a_23457_5430# VDD.t832 VDD.t68 sg13_lv_pmos ad=0.1938p pd=1.4u as=0 ps=0 w=1.02u l=5.575u
X2667 VDD.t817 a_12957_6774# VDD.t816 VDD.t39 sg13_lv_pmos ad=0.3468p pd=2.72u as=0 ps=0 w=1.02u l=5.575u
X2668 VDD.t461 a_37153_16146# counter_value_o[7] VDD.t0 sg13_lv_pmos ad=0.2412p pd=1.73u as=0.4488p ps=3.32u w=1.32u l=0.13u
X2669 a_35369_12114# a_35301_12150# VDD.t539 VDD.t93 sg13_lv_pmos ad=0.3468p pd=2.72u as=0.20145p ps=1.415u w=1.02u l=0.13u
X2670 VSS.t813 a_27557_10770# a_27489_10806# VSS.t1509 sg13_lv_nmos ad=0.1738p pd=1.275u as=0.2992p ps=2.44u w=0.88u l=0.13u
X2671 VSS.t661 a_13109_16146# a_13041_16182# VSS.t660 sg13_lv_nmos ad=0.1672p pd=1.26u as=0.2992p ps=2.44u w=0.88u l=0.13u
X2672 VSS.t55 a_5213_5394# a_5145_5430# VSS.t194 sg13_lv_nmos ad=0.1672p pd=1.26u as=0.2992p ps=2.44u w=0.88u l=0.13u
X2673 DFFQX1_2.D a_17833_15510# VSS.t160 VSS.t1155 sg13_lv_nmos ad=0.2924p pd=2.4u as=0.1567p ps=1.27u w=0.86u l=0.13u
X2674 a_28581_14838# a_28649_14802# VSS.t1507 VSS.t1619 sg13_lv_nmos ad=0.2992p pd=2.44u as=0.1672p ps=1.26u w=0.88u l=0.13u
X2675 VDD.t1662 a_11781_3802# VDD.t1661 VDD.t354 sg13_lv_pmos ad=0.1938p pd=1.4u as=0 ps=0 w=1.02u l=5.575u
X2676 a_6473_9104# a_6405_9178# VDD.t798 VDD.t29 sg13_lv_pmos ad=0.3468p pd=2.72u as=0.20145p ps=1.415u w=1.02u l=0.13u
X2677 AOI21BX2_0.A a_21529_16182# VDD.t615 VDD.t0 sg13_lv_pmos ad=0.4488p pd=3.32u as=0.2412p ps=1.73u w=1.32u l=0.13u
X2678 VDD.t1210 a_21613_13458# BUFX3_27.Y VDD.t100 sg13_lv_pmos ad=0.2412p pd=1.73u as=0.4488p ps=3.32u w=1.32u l=0.13u
X2679 a_24717_14554# a_24785_14480# VSS.t244 VSS.t1683 sg13_lv_nmos ad=0.2992p pd=2.44u as=0.1672p ps=1.26u w=0.88u l=0.13u
X2680 a_3717_6490# a_3785_6416# VSS.t478 VSS.t479 sg13_lv_nmos ad=0.2992p pd=2.44u as=0.1672p ps=1.26u w=0.88u l=0.13u
X2681 VDD.t349 a_16905_7834# VDD.t350 VDD.t39 sg13_lv_pmos ad=0.3468p pd=2.72u as=0 ps=0 w=1.02u l=5.575u
X2682 VDD.t498 a_16905_10522# VDD.t497 VDD.t8 sg13_lv_pmos ad=0.1938p pd=1.4u as=0 ps=0 w=1.02u l=5.575u
X2683 VSS.t7 a_15881_10448# VSS.t9 VSS.t8 sg13_lv_nmos ad=0.1738p pd=1.275u as=0 ps=0 w=0.88u l=1.945u
X2684 VSS.t497 a_3785_13136# a_3717_13210# VSS.t496 sg13_lv_nmos ad=0.1672p pd=1.26u as=0.2992p ps=2.44u w=0.88u l=0.13u
X2685 VDD.t716 a_26145_12150# VDD.t715 VDD.t93 sg13_lv_pmos ad=0.3468p pd=2.72u as=0 ps=0 w=1.02u l=5.305u
X2686 VSS.t229 a_7901_4050# VSS.t1377 VSS.t1441 sg13_lv_nmos ad=0.1672p pd=1.26u as=0 ps=0 w=0.88u l=5.575u
X2687 VSS.t143 a_11849_6416# VSS.t717 VSS.t1764 sg13_lv_nmos ad=0.1672p pd=1.26u as=0 ps=0 w=0.88u l=5.575u
X2688 VSS.t755 a_31337_13458# VSS.t588 VSS.t1511 sg13_lv_nmos ad=0.1672p pd=1.26u as=0 ps=0 w=0.88u l=5.575u
X2689 a_3441_15952# a_3313_15779# a_3131_15770# VDD.t5 sg13_lv_pmos ad=91.2f pd=0.86u as=91.2f ps=0.86u w=0.48u l=0.13u
X2690 a_38648_6438# a_38580_6524# VDD.t1898 VDD.t68 sg13_lv_pmos ad=0.3332p pd=2.64u as=0.3332p ps=2.64u w=0.98u l=0.76u
X2691 VDD.t1828 a_5061_2742# a_5129_2706# VDD.t354 sg13_lv_pmos ad=0.1938p pd=1.4u as=0.1938p ps=1.4u w=1.02u l=0.13u
X2692 VSS.t218 a_13025_5394# VSS.t216 VSS.t1773 sg13_lv_nmos ad=0.1672p pd=1.26u as=0 ps=0 w=0.88u l=5.575u
X2693 a_9257_15244# a_8623_14852# a_9027_15045# VSS.t111 sg13_lv_nmos ad=57f pd=0.68u as=57f ps=0.68u w=0.3u l=0.13u
X2694 VSS.t395 a_20333_14480# VSS.t395 VSS.t1431 sg13_lv_nmos ad=0.1738p pd=1.275u as=0 ps=0 w=0.88u l=1.945u
X2695 VSS.t305 a_37805_5394# a_37737_5430# VSS.t306 sg13_lv_nmos ad=0.1738p pd=1.275u as=0.2992p ps=2.44u w=0.88u l=0.13u
X2696 a_7833_10806# a_7901_10770# VSS.t1688 VSS.t1725 sg13_lv_nmos ad=0.2992p pd=2.44u as=0.1672p ps=1.26u w=0.88u l=0.13u
X2697 VDD.t1327 a_23457_12150# a_23525_12114# VDD.t93 sg13_lv_pmos ad=0.1938p pd=1.4u as=0.1938p ps=1.4u w=1.02u l=0.13u
X2698 VDD.t1343 a_19593_5146# VDD.t1342 VDD.t83 sg13_lv_pmos ad=0.1938p pd=1.4u as=0 ps=0 w=1.02u l=5.575u
X2699 VDD.t929 a_27405_14554# VDD.t931 VDD.t100 sg13_lv_pmos ad=0.3468p pd=2.72u as=0 ps=0 w=1.02u l=5.575u
X2700 VSS.t832 a_23525_4050# VSS.t771 VSS.t834 sg13_lv_nmos ad=0.1672p pd=1.26u as=0 ps=0 w=0.88u l=5.575u
X2701 a_19661_3728# a_19593_3802# VDD.t1753 VDD.t354 sg13_lv_pmos ad=0.1938p pd=1.4u as=0.1938p ps=1.4u w=1.02u l=0.13u
X2702 VSS.t757 a_31337_10770# a_31269_10806# VSS.t756 sg13_lv_nmos ad=0.1672p pd=1.26u as=0.2992p ps=2.44u w=0.88u l=0.13u
X2703 BUFX3_28.A a_23121_14906# VSS.t896 VSS.t932 sg13_lv_nmos ad=0.1216p pd=1.02u as=0.1193p ps=1.05u w=0.64u l=0.13u
X2704 VSS.t423 a_30161_3728# a_30093_3802# VSS.t422 sg13_lv_nmos ad=0.1738p pd=1.275u as=0.2992p ps=2.44u w=0.88u l=0.13u
X2705 a_18031_14852# a_17829_14920# VSS.t101 VSS.t258 sg13_lv_nmos ad=0.2176p pd=1.96u as=0.1193p ps=1.05u w=0.64u l=0.13u
X2706 a_9093_6490# a_9161_6416# VSS.t143 VSS.t188 sg13_lv_nmos ad=0.2992p pd=2.44u as=0.1672p ps=1.26u w=0.88u l=0.13u
X2707 VSS.t43 a_32597_7760# VSS.t45 VSS.t44 sg13_lv_nmos ad=0.1672p pd=1.26u as=0 ps=0 w=0.88u l=5.575u
X2708 VDD.t357 AND2X1_0.Y a_16153_14838# VDD.t5 sg13_lv_pmos ad=0.2412p pd=1.73u as=0.1632p ps=1.64u w=0.48u l=0.13u
X2709 VDD.t326 a_7833_12150# VDD.t325 VDD.t93 sg13_lv_pmos ad=0.3468p pd=2.72u as=0 ps=0 w=1.02u l=5.575u
X2710 VDD.t1900 a_27489_5430# VDD.t1899 VDD.t68 sg13_lv_pmos ad=0.3468p pd=2.72u as=0 ps=0 w=1.02u l=1.945u
X2711 DFFQX1_7.Q a_22751_15170# VDD.t957 VDD.t5 sg13_lv_pmos ad=0.1632p pd=1.64u as=0.2529p ps=1.545u w=0.48u l=0.13u
X2712 a_38480_13472# a_38412_13508# VDD.t1616 VDD.t100 sg13_lv_pmos ad=0.3332p pd=2.64u as=0.3332p ps=2.64u w=0.98u l=0.76u
X2713 VDD.t1593 a_9093_11866# VDD.t1591 VDD.t281 sg13_lv_pmos ad=0.1938p pd=1.4u as=0 ps=0 w=1.02u l=5.575u
X2714 a_10589_4050# a_10521_4086# VDD.t1469 VDD.t83 sg13_lv_pmos ad=0.3468p pd=2.72u as=0.20145p ps=1.415u w=1.02u l=0.13u
X2715 VSS.t444 a_35285_14480# VSS.t444 VSS.t443 sg13_lv_nmos ad=0.1672p pd=1.26u as=0 ps=0 w=0.88u l=5.575u
X2716 VSS.t81 a_1097_14480# a_1029_14554# VSS.t1150 sg13_lv_nmos ad=0.1672p pd=1.26u as=0.2992p ps=2.44u w=0.88u l=0.13u
X2717 a_28581_8118# a_28649_8082# VSS.t468 VSS.t1820 sg13_lv_nmos ad=0.2992p pd=2.44u as=0.1672p ps=1.26u w=0.88u l=0.13u
X2718 a_8407_16588# NAND3X1_0.Y BUFX3_4.A VDD.t0 sg13_lv_pmos ad=45.6f pd=0.67u as=91.2f ps=0.86u w=0.48u l=0.13u
X2719 a_18573_14575# OR3BX1_0.B a_18749_14180# VDD.t100 sg13_lv_pmos ad=0.1632p pd=1.64u as=43.2f ps=0.66u w=0.48u l=0.13u
X2720 VSS.t76 BUFX3_26.A a_6493_14838# VSS.t1266 sg13_lv_nmos ad=0.1567p pd=1.27u as=0.102p ps=1.28u w=0.3u l=0.13u
X2721 VSS.t97 a_35285_7760# VSS.t97 VSS.t96 sg13_lv_nmos ad=0.1672p pd=1.26u as=0 ps=0 w=0.88u l=5.575u
X2722 VDD.t559 a_15813_9178# VDD.t558 VDD.t29 sg13_lv_pmos ad=0.3468p pd=2.72u as=0 ps=0 w=1.02u l=1.945u
X2723 VSS.t117 a_30161_15824# a_30093_15898# VSS.t384 sg13_lv_nmos ad=0.1738p pd=1.275u as=0.2992p ps=2.44u w=0.88u l=0.13u
X2724 a_17435_14900# a_16485_14920# a_17321_15244# VSS.t379 sg13_lv_nmos ad=27f pd=0.48u as=57f ps=0.68u w=0.3u l=0.13u
X2725 VDD.t1158 a_15318_15510# DFFQX1_5.CK VDD.t5 sg13_lv_pmos ad=0.2508p pd=1.7u as=0.2508p ps=1.7u w=1.32u l=0.13u
X2726 a_22349_3728# a_22281_3802# VDD.t1568 VDD.t354 sg13_lv_pmos ad=0.3468p pd=2.72u as=0.20145p ps=1.415u w=1.02u l=0.13u
X2727 VDD.t161 OR3BX1_0.B NOR3X1_0.C VDD.t5 sg13_lv_pmos ad=0.1862p pd=1.36u as=0.1862p ps=1.36u w=0.98u l=0.13u
X2728 VSS.t588 a_28649_13458# VSS.t342 VSS.t587 sg13_lv_nmos ad=0.1672p pd=1.26u as=0 ps=0 w=0.88u l=5.575u
X2729 VSS.t53 a_3785_5072# a_3717_5146# VSS.t52 sg13_lv_nmos ad=0.1672p pd=1.26u as=0.2992p ps=2.44u w=0.88u l=0.13u
X2730 a_35369_6738# a_35301_6774# VDD.t1377 VDD.t39 sg13_lv_pmos ad=0.3468p pd=2.72u as=0.20145p ps=1.415u w=1.02u l=0.13u
X2731 a_17337_15938# a_17073_15938# VSS.t554 VSS.t1222 sg13_lv_nmos ad=57f pd=0.68u as=61.5f ps=0.71u w=0.3u l=0.13u
X2732 VSS.t859 a_5213_4050# VSS.t857 VSS.t858 sg13_lv_nmos ad=0.1672p pd=1.26u as=0 ps=0 w=0.88u l=5.575u
X2733 VSS.t419 a_19661_3728# a_19593_3802# VSS.t1692 sg13_lv_nmos ad=0.1672p pd=1.26u as=0.2992p ps=2.44u w=0.88u l=0.13u
X2734 VSS.t185 a_9161_6416# a_9093_6490# VSS.t184 sg13_lv_nmos ad=0.1672p pd=1.26u as=0.2992p ps=2.44u w=0.88u l=0.13u
X2735 VDD.t1598 a_5145_13494# VDD.t1597 VDD.t100 sg13_lv_pmos ad=0.3468p pd=2.72u as=0 ps=0 w=1.02u l=5.575u
X2736 a_13025_4050# a_12957_4086# VDD.t976 VDD.t83 sg13_lv_pmos ad=0.1938p pd=1.4u as=0.1938p ps=1.4u w=1.02u l=0.13u
X2737 VSS.t383 a_4460_16160# a_4392_16196# VSS.t1184 sg13_lv_nmos ad=0.2176p pd=1.96u as=0.2176p ps=1.96u w=0.64u l=0.76u
X2738 VDD.t121 NAND2X1_0.A NAND3X1_0.Y VDD.t5 sg13_lv_pmos ad=91.2f pd=0.86u as=91.2f ps=0.86u w=0.48u l=0.13u
X2739 a_1029_8118# a_1097_8082# VSS.t165 VSS.t168 sg13_lv_nmos ad=0.2992p pd=2.44u as=0.1672p ps=1.26u w=0.88u l=0.13u
X2740 VSS.t811 a_24785_10448# VSS.t815 VSS.t814 sg13_lv_nmos ad=0.1672p pd=1.26u as=0 ps=0 w=0.88u l=5.575u
X2741 VDD.t613 BUFX3_27.Y a_21705_14180# VDD.t100 sg13_lv_pmos ad=0.108p pd=0.93u as=86.39999f ps=0.84u w=0.48u l=0.13u
X2742 VDD.t249 a_12957_5430# VDD.t248 VDD.t68 sg13_lv_pmos ad=0.3468p pd=2.72u as=0 ps=0 w=1.02u l=5.575u
X2743 VSS.t520 a_1097_9426# VSS.t520 VSS.t623 sg13_lv_nmos ad=0.1672p pd=1.26u as=0 ps=0 w=0.88u l=5.575u
X2744 VDD.t1040 a_13041_16182# VDD.t1039 VDD.t0 sg13_lv_pmos ad=0.3468p pd=2.72u as=0 ps=0 w=1.02u l=5.575u
X2745 VSS.t200 a_16973_5072# VSS.t202 VSS.t1321 sg13_lv_nmos ad=0.1672p pd=1.26u as=0 ps=0 w=0.88u l=5.575u
X2746 a_14537_11792# a_14469_11866# VDD.t1381 VDD.t281 sg13_lv_pmos ad=0.3468p pd=2.72u as=0.20145p ps=1.415u w=1.02u l=0.13u
X2747 VDD.t615 OAI21X1_1.Y a_21529_16182# VDD.t0 sg13_lv_pmos ad=0.2412p pd=1.73u as=0.1632p ps=1.64u w=0.48u l=0.13u
X2748 VSS.t428 a_16973_6416# VSS.t431 VSS.t430 sg13_lv_nmos ad=0.1672p pd=1.26u as=0 ps=0 w=0.88u l=5.575u
X2749 a_17069_14144# BUFX3_3.Y VDD.t1480 VDD.t100 sg13_lv_pmos ad=91.2f pd=0.86u as=91.2f ps=0.86u w=0.48u l=0.13u
X2750 VDD.t6 a_18757_15474# AOI21BX1_0.B VDD.t5 sg13_lv_pmos ad=0.2412p pd=1.73u as=0.4488p ps=3.32u w=1.32u l=0.13u
X2751 VDD.t917 a_7833_4086# a_7901_4050# VDD.t83 sg13_lv_pmos ad=0.1938p pd=1.4u as=0.1938p ps=1.4u w=1.02u l=0.13u
X2752 VDD.t594 a_7749_7834# VDD.t593 VDD.t39 sg13_lv_pmos ad=0.3468p pd=2.72u as=0 ps=0 w=1.02u l=1.945u
X2753 VDD.t1275 BUFX24_2.A a_15318_15510# VDD.t5 sg13_lv_pmos ad=0.2508p pd=1.7u as=0.4488p ps=3.32u w=1.32u l=0.13u
X2754 a_38648_5094# a_38580_5180# VDD.t483 VDD.t83 sg13_lv_pmos ad=0.3332p pd=2.64u as=0.3332p ps=2.64u w=0.98u l=0.76u
X2755 VDD.t369 a_3721_14802# AND2X1_3.B VDD.t5 sg13_lv_pmos ad=0.2412p pd=1.73u as=0.4488p ps=3.32u w=1.32u l=0.13u
X2756 VDD.t544 a_32529_3802# a_32597_3728# VDD.t354 sg13_lv_pmos ad=0.1938p pd=1.4u as=0.1938p ps=1.4u w=1.02u l=0.13u
X2757 NOR3X1_0.C OR3X1_1.A a_21946_15932# VSS.t671 sg13_lv_nmos ad=0.2176p pd=1.96u as=0.1216p ps=1.02u w=0.64u l=0.13u
X2758 a_18297_15244# a_17829_14920# a_18247_14900# VSS.t259 sg13_lv_nmos ad=57f pd=0.68u as=27f ps=0.48u w=0.3u l=0.13u
X2759 VDD.t459 a_23457_4086# a_23525_4050# VDD.t83 sg13_lv_pmos ad=0.1938p pd=1.4u as=0.1938p ps=1.4u w=1.02u l=0.13u
X2760 VSS.t421 a_20837_4050# a_20769_4086# VSS.t1740 sg13_lv_nmos ad=0.1672p pd=1.26u as=0.2992p ps=2.44u w=0.88u l=0.13u
X2761 VSS.t610 a_9497_16146# VSS.t612 VSS.t613 sg13_lv_nmos ad=0.1672p pd=1.26u as=0 ps=0 w=0.88u l=5.575u
X2762 VDD.t462 a_24301_14802# NOR3X1_0.A VDD.t5 sg13_lv_pmos ad=0.2412p pd=1.73u as=0.4488p ps=3.32u w=1.32u l=0.13u
X2763 a_7241_14816# AND2X1_1.B VDD.t119 VDD.t5 sg13_lv_pmos ad=91.2f pd=0.86u as=91.2f ps=0.86u w=0.48u l=0.13u
X2764 a_23033_15572# a_22197_15624# a_22803_15536# VDD.t5 sg13_lv_pmos ad=91.2f pd=0.86u as=91.2f ps=0.86u w=0.48u l=0.13u
X2765 VDD.t1729 a_1029_2742# a_1097_2706# VDD.t354 sg13_lv_pmos ad=0.1938p pd=1.4u as=0.1938p ps=1.4u w=1.02u l=0.13u
X2766 VDD.t234 a_26145_6774# VDD.t233 VDD.t39 sg13_lv_pmos ad=0.3468p pd=2.72u as=0 ps=0 w=1.02u l=5.305u
X2767 VDD.t552 a_35217_10522# a_35285_10448# VDD.t8 sg13_lv_pmos ad=0.1938p pd=1.4u as=0.1938p ps=1.4u w=1.02u l=0.13u
X2768 a_30161_5072# a_30093_5146# VDD.t531 VDD.t83 sg13_lv_pmos ad=0.3468p pd=2.72u as=0.20145p ps=1.415u w=1.02u l=0.13u
X2769 a_37805_6738# a_37737_6774# VDD.t1126 VDD.t39 sg13_lv_pmos ad=0.3468p pd=2.72u as=0.20145p ps=1.415u w=1.02u l=0.13u
X2770 VDD.t1644 a_12957_10806# a_13025_10770# VDD.t281 sg13_lv_pmos ad=0.1938p pd=1.4u as=0.1938p ps=1.4u w=1.02u l=0.13u
X2771 a_32281_16146# DFFQX1_5.Q VDD.t1175 VDD.t0 sg13_lv_pmos ad=0.1632p pd=1.64u as=0.2412p ps=1.73u w=0.48u l=0.13u
X2772 VSS.t154 a_22803_15536# a_22779_15952# VSS.t1130 sg13_lv_nmos ad=57f pd=0.68u as=27f ps=0.48u w=0.3u l=0.13u
X2773 a_20769_5430# a_20837_5394# VSS.t328 VSS.t1780 sg13_lv_nmos ad=0.2992p pd=2.44u as=0.1672p ps=1.26u w=0.88u l=0.13u
X2774 a_27405_3802# a_27473_3728# VSS.t423 VSS.t986 sg13_lv_nmos ad=0.2992p pd=2.44u as=0.1672p ps=1.26u w=0.88u l=0.13u
X2775 VSS.t62 a_11849_5072# a_11781_5146# VSS.t214 sg13_lv_nmos ad=0.1672p pd=1.26u as=0.2992p ps=2.44u w=0.88u l=0.13u
X2776 VDD.t1466 a_23171_15532# a_23135_15572# VDD.t5 sg13_lv_pmos ad=0.2529p pd=1.545u as=43.2f ps=0.66u w=0.48u l=0.13u
X2777 VSS.t608 a_9497_16146# a_9429_16182# VSS.t607 sg13_lv_nmos ad=0.1672p pd=1.26u as=0.2992p ps=2.44u w=0.88u l=0.13u
X2778 a_32529_9178# a_32597_9104# VSS.t36 VSS.t35 sg13_lv_nmos ad=0.2992p pd=2.44u as=0.1672p ps=1.26u w=0.88u l=0.13u
X2779 counter_value_o[1] a_6997_16182# VSS.t1121 VSS.t1122 sg13_lv_nmos ad=0.2924p pd=2.4u as=0.1567p ps=1.27u w=0.86u l=0.13u
X2780 a_22057_16196# BUFX3_2.A a_21955_16196# VSS.t1277 sg13_lv_nmos ad=57f pd=0.68u as=57f ps=0.68u w=0.3u l=0.13u
X2781 VDD.t1395 a_30429_2742# VDD.t1394 VDD.t354 sg13_lv_pmos ad=0.3468p pd=2.72u as=0 ps=0 w=1.02u l=1.945u
X2782 VDD.t347 a_33957_8118# VDD.t346 VDD.t29 sg13_lv_pmos ad=0.3468p pd=2.72u as=0 ps=0 w=1.02u l=5.305u
X2783 VDD.t1538 a_35217_3802# a_35285_3728# VDD.t354 sg13_lv_pmos ad=0.1938p pd=1.4u as=0.1938p ps=1.4u w=1.02u l=0.13u
X2784 VDD.t1826 a_5061_2742# VDD.t1825 VDD.t354 sg13_lv_pmos ad=0.3468p pd=2.72u as=0 ps=0 w=1.02u l=5.575u
X2785 VDD.t1402 a_30093_11866# VDD.t1401 VDD.t281 sg13_lv_pmos ad=0.3468p pd=2.72u as=0 ps=0 w=1.02u l=5.305u
X2786 VSS.t241 a_15881_13136# a_15813_13210# VSS.t1323 sg13_lv_nmos ad=0.1738p pd=1.275u as=0.2992p ps=2.44u w=0.88u l=0.13u
X2787 VSS.t218 a_14537_5072# VSS.t222 VSS.t221 sg13_lv_nmos ad=0.1738p pd=1.275u as=0 ps=0 w=0.88u l=5.305u
X2788 a_28581_6774# a_28649_6738# VSS.t1311 VSS.t1310 sg13_lv_nmos ad=0.2992p pd=2.44u as=0.1672p ps=1.26u w=0.88u l=0.13u
X2789 a_2719_14852# BUFX3_1.Y a_2625_14852# VSS.t1608 sg13_lv_nmos ad=57f pd=0.68u as=0.102p ps=1.28u w=0.3u l=0.13u
X2790 VSS.t922 a_3785_11792# VSS.t921 VSS.t920 sg13_lv_nmos ad=0.1672p pd=1.26u as=0 ps=0 w=0.88u l=5.575u
X2791 VSS.t346 a_8492_11814# a_8424_11900# VSS.t1318 sg13_lv_nmos ad=0.2176p pd=1.96u as=0.2176p ps=1.96u w=0.64u l=0.76u
X2792 VSS.t41 a_32597_7760# a_32529_7834# VSS.t40 sg13_lv_nmos ad=0.1672p pd=1.26u as=0.2992p ps=2.44u w=0.88u l=0.13u
X2793 VSS.t1411 a_23693_13136# VSS.t886 VSS.t1461 sg13_lv_nmos ad=0.1738p pd=1.275u as=0 ps=0 w=0.88u l=1.945u
X2794 a_27473_9104# a_27405_9178# VDD.t561 VDD.t29 sg13_lv_pmos ad=0.1938p pd=1.4u as=0.1938p ps=1.4u w=1.02u l=0.13u
X2795 a_22484_16182# BUFX3_1.Y.t7 VSS.t154 VSS.t1201 sg13_lv_nmos ad=0.12375p pd=1.125u as=0.1193p ps=1.05u w=0.3u l=0.13u
X2796 a_4460_12128# a_4392_12164# VDD.t1809 VDD.t93 sg13_lv_pmos ad=0.3332p pd=2.64u as=0.3332p ps=2.64u w=0.98u l=0.76u
X2797 VDD.t1311 BUFX3_2.A a_17479_15572# VDD.t5 sg13_lv_pmos ad=0.1632p pd=1.64u as=45.6f ps=0.67u w=0.48u l=0.13u
X2798 a_23803_14838# OR3X1_1.B a_23709_14838# VSS.t396 sg13_lv_nmos ad=0.12375p pd=1.125u as=0.102p ps=1.28u w=0.3u l=0.13u
X2799 VDD.t116 a_28581_13494# a_28649_13458# VDD.t100 sg13_lv_pmos ad=0.1938p pd=1.4u as=0.1938p ps=1.4u w=1.02u l=0.13u
X2800 a_23457_5430# a_23525_5394# VSS.t204 VSS.t332 sg13_lv_nmos ad=0.2992p pd=2.44u as=0.1672p ps=1.26u w=0.88u l=0.13u
X2801 a_35369_5394# a_35301_5430# VDD.t259 VDD.t68 sg13_lv_pmos ad=0.3468p pd=2.72u as=0.20145p ps=1.415u w=1.02u l=0.13u
X2802 VSS.t254 a_26213_4050# VSS.t832 VSS.t1292 sg13_lv_nmos ad=0.1738p pd=1.275u as=0 ps=0 w=0.88u l=5.305u
X2803 a_8153_3728# a_8085_3802# VDD.t1814 VDD.t354 sg13_lv_pmos ad=0.3468p pd=2.72u as=0.20145p ps=1.415u w=1.02u l=0.13u
X2804 a_19593_7834# a_19661_7760# VSS.t179 VSS.t178 sg13_lv_nmos ad=0.2992p pd=2.44u as=0.1672p ps=1.26u w=0.88u l=0.13u
X2805 a_17337_15938# BUFX3_2.A BUFX3_3.A VSS.t1279 sg13_lv_nmos ad=0.102p pd=1.28u as=58.5f ps=0.69u w=0.3u l=0.13u
X2806 a_1029_6774# a_1097_6738# VSS.t475 VSS.t727 sg13_lv_nmos ad=0.2992p pd=2.44u as=0.1672p ps=1.26u w=0.88u l=0.13u
X2807 VDD.t1089 a_1029_9462# a_1097_9426# VDD.t8 sg13_lv_pmos ad=0.1938p pd=1.4u as=0.1938p ps=1.4u w=1.02u l=0.13u
X2808 VDD.t634 a_32529_10522# VDD.t632 VDD.t8 sg13_lv_pmos ad=0.1938p pd=1.4u as=0 ps=0 w=1.02u l=5.575u
X2809 VSS.t444 a_38648_14502# a_38580_14588# VSS.t443 sg13_lv_nmos ad=0.2176p pd=1.96u as=0.2176p ps=1.96u w=0.64u l=0.76u
X2810 VDD.t787 a_31269_14838# VDD.t786 VDD.t5 sg13_lv_pmos ad=0.1938p pd=1.4u as=0 ps=0 w=1.02u l=5.575u
X2811 BUFX3_3.A a_17073_15938# VDD.t1232 VDD.t5 sg13_lv_pmos ad=91.2f pd=0.86u as=98.39999f ps=0.89u w=0.48u l=0.13u
X2812 VSS.t970 a_4121_10448# VSS.t579 VSS.t971 sg13_lv_nmos ad=0.1672p pd=1.26u as=0 ps=0 w=0.88u l=5.575u
X2813 a_5145_9462# a_5213_9426# VSS.t87 VSS.t524 sg13_lv_nmos ad=0.2992p pd=2.44u as=0.1672p ps=1.26u w=0.88u l=0.13u
X2814 VDD.t1171 a_12714_15510# BUFX24_2.A VDD.t5 sg13_lv_pmos ad=0.2508p pd=1.7u as=0.2508p ps=1.7u w=1.32u l=0.13u
X2815 VSS.t124 a_18401_9426# VSS.t126 VSS.t629 sg13_lv_nmos ad=0.1738p pd=1.275u as=0 ps=0 w=0.88u l=5.305u
X2816 VDD.t1037 a_9429_16182# a_9497_16146# VDD.t0 sg13_lv_pmos ad=0.1938p pd=1.4u as=0.1938p ps=1.4u w=1.02u l=0.13u
X2817 VSS.t952 a_5213_13458# VSS.t501 VSS.t1737 sg13_lv_nmos ad=0.1672p pd=1.26u as=0 ps=0 w=0.88u l=5.575u
X2818 VDD.t1629 a_20769_4086# VDD.t1628 VDD.t83 sg13_lv_pmos ad=0.3468p pd=2.72u as=0 ps=0 w=1.02u l=5.575u
X2819 VSS.t97 a_37973_7760# VSS.t97 VSS.t96 sg13_lv_nmos ad=0.1738p pd=1.275u as=0 ps=0 w=0.88u l=1.945u
X2820 VDD.t203 a_3717_7834# VDD.t202 VDD.t39 sg13_lv_pmos ad=0.3468p pd=2.72u as=0 ps=0 w=1.02u l=5.575u
X2821 VSS.t407 a_24365_16146# VSS.t404 VSS.t1241 sg13_lv_nmos ad=0.1672p pd=1.26u as=0 ps=0 w=0.88u l=5.575u
X2822 VSS.t1096 a_28649_12114# a_28581_12150# VSS.t1095 sg13_lv_nmos ad=0.1672p pd=1.26u as=0.2992p ps=2.44u w=0.88u l=0.13u
X2823 VSS.t554 a_17497_16146# BUFX3_2.A VSS.t553 sg13_lv_nmos ad=0.1567p pd=1.27u as=0.2924p ps=2.4u w=0.86u l=0.13u
X2824 VSS.t501 a_6473_13136# a_6405_13210# VSS.t1695 sg13_lv_nmos ad=0.1738p pd=1.275u as=0.2992p ps=2.44u w=0.88u l=0.13u
X2825 a_37805_5394# a_37737_5430# VDD.t758 VDD.t68 sg13_lv_pmos ad=0.3468p pd=2.72u as=0.20145p ps=1.415u w=1.02u l=0.13u
X2826 VDD.t78 a_26145_5430# VDD.t77 VDD.t68 sg13_lv_pmos ad=0.3468p pd=2.72u as=0 ps=0 w=1.02u l=5.305u
X2827 VDD.t1102 a_9093_9178# VDD.t1101 VDD.t29 sg13_lv_pmos ad=0.3468p pd=2.72u as=0 ps=0 w=1.02u l=5.575u
X2828 VSS.t520 a_1097_9426# a_1029_9462# VSS.t621 sg13_lv_nmos ad=0.1672p pd=1.26u as=0.2992p ps=2.44u w=0.88u l=0.13u
X2829 a_36461_14802# a_36393_14838# VDD.t1705 VDD.t5 sg13_lv_pmos ad=0.3468p pd=2.72u as=0.20145p ps=1.415u w=1.02u l=0.13u
X2830 VDD.t826 a_20769_6774# VDD.t825 VDD.t39 sg13_lv_pmos ad=0.1938p pd=1.4u as=0 ps=0 w=1.02u l=5.575u
X2831 VSS.t330 a_24785_5072# VSS.t204 VSS.t1380 sg13_lv_nmos ad=0.1672p pd=1.26u as=0 ps=0 w=0.88u l=5.575u
X2832 DFFQX1_5.CK a_15318_15510# VSS.t663 VSS.t1133 sg13_lv_nmos ad=0.1634p pd=1.24u as=0.1634p ps=1.24u w=0.86u l=0.13u
X2833 a_26213_4050# a_26145_4086# VDD.t1783 VDD.t83 sg13_lv_pmos ad=0.3468p pd=2.72u as=0.20145p ps=1.415u w=1.02u l=0.13u
X2834 a_5129_16146# a_5061_16182# VDD.t1147 VDD.t0 sg13_lv_pmos ad=0.3468p pd=2.72u as=0.20145p ps=1.415u w=1.02u l=0.13u
X2835 VDD.t351 a_16905_7834# a_16973_7760# VDD.t39 sg13_lv_pmos ad=0.1938p pd=1.4u as=0.1938p ps=1.4u w=1.02u l=0.13u
X2836 VSS.t386 a_31505_15824# VSS.t156 VSS.t1186 sg13_lv_nmos ad=0.1738p pd=1.275u as=0 ps=0 w=0.88u l=1.945u
X2837 DFFQX1_5.Q a_23003_14188# VDD.t941 VDD.t100 sg13_lv_pmos ad=0.1632p pd=1.64u as=0.2529p ps=1.545u w=0.48u l=0.13u
X2838 VSS.t268 a_34025_10770# a_33957_10806# VSS.t1705 sg13_lv_nmos ad=0.1738p pd=1.275u as=0.2992p ps=2.44u w=0.88u l=0.13u
X2839 VDD.t1035 a_9429_16182# VDD.t1034 VDD.t0 sg13_lv_pmos ad=0.3468p pd=2.72u as=0 ps=0 w=1.02u l=5.575u
X2840 a_22613_15244# a_21979_14852# a_22383_15045# VSS.t711 sg13_lv_nmos ad=57f pd=0.68u as=57f ps=0.68u w=0.3u l=0.13u
X2841 VDD.t36 a_28581_8118# VDD.t37 VDD.t29 sg13_lv_pmos ad=0.1938p pd=1.4u as=0 ps=0 w=1.02u l=5.575u
X2842 a_1097_9104# a_1029_9178# VDD.t306 VDD.t29 sg13_lv_pmos ad=0.1938p pd=1.4u as=0.1938p ps=1.4u w=1.02u l=0.13u
X2843 a_18435_15045# a_18297_15244# VDD.t1836 VDD.t5 sg13_lv_pmos ad=91.2f pd=0.86u as=91.2f ps=0.86u w=0.48u l=0.13u
X2844 VDD.t543 a_32529_3802# VDD.t542 VDD.t354 sg13_lv_pmos ad=0.3468p pd=2.72u as=0 ps=0 w=1.02u l=5.575u
X2845 VSS.t766 a_22349_10448# VSS.t764 VSS.t1733 sg13_lv_nmos ad=0.1738p pd=1.275u as=0 ps=0 w=0.88u l=5.305u
X2846 VSS.t755 a_32597_13136# VSS.t1513 VSS.t1551 sg13_lv_nmos ad=0.1672p pd=1.26u as=0 ps=0 w=0.88u l=5.575u
X2847 VDD.t1029 a_37737_10806# VDD.t1028 VDD.t281 sg13_lv_pmos ad=0.3468p pd=2.72u as=0 ps=0 w=1.02u l=1.945u
X2848 VDD.t930 a_27405_14554# a_27473_14480# VDD.t100 sg13_lv_pmos ad=0.1938p pd=1.4u as=0.1938p ps=1.4u w=1.02u l=0.13u
X2849 VSS.t764 a_20837_10770# VSS.t766 VSS.t767 sg13_lv_nmos ad=0.1672p pd=1.26u as=0 ps=0 w=0.88u l=5.575u
X2850 a_31337_10770# a_31269_10806# VDD.t1013 VDD.t281 sg13_lv_pmos ad=0.1938p pd=1.4u as=0.1938p ps=1.4u w=1.02u l=0.13u
X2851 VDD.t148 AND2X1_2.B a_8001_14852# VDD.t5 sg13_lv_pmos ad=91.2f pd=0.86u as=91.2f ps=0.86u w=0.48u l=0.13u
X2852 VSS.t70 a_20837_13458# a_20769_13494# VSS.t69 sg13_lv_nmos ad=0.1738p pd=1.275u as=0.2992p ps=2.44u w=0.88u l=0.13u
X2853 VSS.t1423 a_16973_10448# VSS.t1393 VSS.t1424 sg13_lv_nmos ad=0.1672p pd=1.26u as=0 ps=0 w=0.88u l=5.575u
X2854 a_7425_15952# a_7221_15952# VSS.t1121 VSS.t1844 sg13_lv_nmos ad=27f pd=0.48u as=57f ps=0.68u w=0.3u l=0.13u
X2855 VDD.t1586 a_11781_11866# VDD.t1584 VDD.t281 sg13_lv_pmos ad=0.1938p pd=1.4u as=0 ps=0 w=1.02u l=5.575u
X2856 VDD.t1727 a_1029_2742# VDD.t1726 VDD.t354 sg13_lv_pmos ad=0.3468p pd=2.72u as=0 ps=0 w=1.02u l=5.575u
X2857 VSS.t81 a_1097_14802# a_1029_14838# VSS.t1150 sg13_lv_nmos ad=0.1738p pd=1.275u as=0.2992p ps=2.44u w=0.88u l=0.13u
X2858 VSS.t1121 AND2X1_1.Y a_7333_16182# VSS.t1198 sg13_lv_nmos ad=0.1567p pd=1.27u as=0.102p ps=1.28u w=0.3u l=0.13u
X2859 a_15318_15510# BUFX24_2.A VSS.t663 VSS.t1254 sg13_lv_nmos ad=0.1634p pd=1.24u as=0.1634p ps=1.24u w=0.86u l=0.13u
X2860 VDD.t577 a_1029_8118# VDD.t575 VDD.t29 sg13_lv_pmos ad=0.1938p pd=1.4u as=0 ps=0 w=1.02u l=5.575u
X2861 VSS.t665 a_13109_16146# VSS.t661 VSS.t664 sg13_lv_nmos ad=0.1672p pd=1.26u as=0 ps=0 w=0.88u l=5.575u
X2862 a_18401_9426# a_18333_9462# VDD.t463 VDD.t8 sg13_lv_pmos ad=0.3468p pd=2.72u as=0.20145p ps=1.415u w=1.02u l=0.13u
X2863 VDD.t1582 a_11781_11866# VDD.t1581 VDD.t281 sg13_lv_pmos ad=0.3468p pd=2.72u as=0 ps=0 w=1.02u l=5.575u
X2864 VSS.t53 a_1097_5072# VSS.t53 VSS.t435 sg13_lv_nmos ad=0.1672p pd=1.26u as=0 ps=0 w=0.88u l=5.575u
X2865 VDD.t505 a_27405_7834# VDD.t504 VDD.t39 sg13_lv_pmos ad=0.1938p pd=1.4u as=0 ps=0 w=1.02u l=5.575u
X2866 a_1433_10448# a_1365_10522# VDD.t897 VDD.t8 sg13_lv_pmos ad=0.1938p pd=1.4u as=0.1938p ps=1.4u w=1.02u l=0.13u
X2867 VSS.t1478 a_27809_2706# VSS.t1308 VSS.t1480 sg13_lv_nmos ad=0.1672p pd=1.26u as=0 ps=0 w=0.88u l=5.575u
X2868 a_31269_12150# a_31337_12114# VSS.t705 VSS.t1448 sg13_lv_nmos ad=0.2992p pd=2.44u as=0.1672p ps=1.26u w=0.88u l=0.13u
X2869 VSS.t936 a_22349_11792# a_22281_11866# VSS.t1578 sg13_lv_nmos ad=0.1738p pd=1.275u as=0.2992p ps=2.44u w=0.88u l=0.13u
X2870 VDD.t804 a_11781_7834# VDD.t803 VDD.t39 sg13_lv_pmos ad=0.3468p pd=2.72u as=0 ps=0 w=1.02u l=5.575u
X2871 VDD.t1198 AND2X1_3.Y a_3385_16182# VDD.t0 sg13_lv_pmos ad=0.2412p pd=1.73u as=0.1632p ps=1.64u w=0.48u l=0.13u
X2872 VDD.t1079 a_1365_3802# a_1433_3728# VDD.t354 sg13_lv_pmos ad=0.1938p pd=1.4u as=0.1938p ps=1.4u w=1.02u l=0.13u
X2873 VSS.t177 a_19745_8082# a_19677_8118# VSS.t547 sg13_lv_nmos ad=0.1738p pd=1.275u as=0.2992p ps=2.44u w=0.88u l=0.13u
X2874 VSS.t663 a_15800_16160# a_15732_16196# VSS.t1156 sg13_lv_nmos ad=0.2176p pd=1.96u as=0.2176p ps=1.96u w=0.64u l=0.76u
X2875 a_31337_6738# a_31269_6774# VDD.t1369 VDD.t39 sg13_lv_pmos ad=0.1938p pd=1.4u as=0.1938p ps=1.4u w=1.02u l=0.13u
X2876 a_3045_15244# BUFX3_0.Y VSS.t81 VSS.t80 sg13_lv_nmos ad=57f pd=0.68u as=0.102p ps=1.28u w=0.3u l=0.13u
X2877 VDD.t1327 a_23457_12150# VDD.t1328 VDD.t93 sg13_lv_pmos ad=0.1938p pd=1.4u as=0 ps=0 w=1.02u l=5.575u
X2878 VSS.t345 a_9161_11792# VSS.t349 VSS.t348 sg13_lv_nmos ad=0.1672p pd=1.26u as=0 ps=0 w=0.88u l=5.575u
X2879 BUFX24_2.A a_12714_15510# VDD.t1173 VDD.t5 sg13_lv_pmos ad=0.4488p pd=3.32u as=0.2508p ps=1.7u w=1.32u l=0.13u
X2880 VSS.t813 a_27473_10448# VSS.t821 VSS.t820 sg13_lv_nmos ad=0.1672p pd=1.26u as=0 ps=0 w=0.88u l=5.575u
X2881 a_32597_13136# a_32529_13210# VDD.t1747 VDD.t93 sg13_lv_pmos ad=0.1938p pd=1.4u as=0.1938p ps=1.4u w=1.02u l=0.13u
X2882 VSS.t365 a_11933_12114# VSS.t349 VSS.t364 sg13_lv_nmos ad=0.1738p pd=1.275u as=0 ps=0 w=0.88u l=1.945u
X2883 a_37973_11792# a_37905_11866# VDD.t323 VDD.t281 sg13_lv_pmos ad=0.3468p pd=2.72u as=0.20145p ps=1.415u w=1.02u l=0.13u
X2884 a_3785_5072# a_3717_5146# VDD.t266 VDD.t83 sg13_lv_pmos ad=0.1938p pd=1.4u as=0.1938p ps=1.4u w=1.02u l=0.13u
X2885 VSS.t55 a_3785_5072# VSS.t57 VSS.t56 sg13_lv_nmos ad=0.1672p pd=1.26u as=0 ps=0 w=0.88u l=5.575u
X2886 VSS.t251 a_36461_4050# a_36393_4086# VSS.t250 sg13_lv_nmos ad=0.1738p pd=1.275u as=0.2992p ps=2.44u w=0.88u l=0.13u
X2887 a_9027_15045# a_8889_15244# VDD.t123 VDD.t5 sg13_lv_pmos ad=91.2f pd=0.86u as=91.2f ps=0.86u w=0.48u l=0.13u
X2888 VDD.t1600 a_5145_13494# a_5213_13458# VDD.t100 sg13_lv_pmos ad=0.1938p pd=1.4u as=0.1938p ps=1.4u w=1.02u l=0.13u
X2889 VDD.t1912 a_28581_12150# VDD.t1911 VDD.t93 sg13_lv_pmos ad=0.3468p pd=2.72u as=0 ps=0 w=1.02u l=5.575u
X2890 VSS.t468 a_31505_7760# VSS.t41 VSS.t679 sg13_lv_nmos ad=0.1738p pd=1.275u as=0 ps=0 w=0.88u l=1.945u
X2891 a_8492_9126# a_8424_9212# VDD.t1100 VDD.t29 sg13_lv_pmos ad=0.3332p pd=2.64u as=0.3332p ps=2.64u w=0.98u l=0.76u
X2892 a_3785_13458# a_3717_13494# VDD.t873 VDD.t100 sg13_lv_pmos ad=0.3468p pd=2.72u as=0.20145p ps=1.415u w=1.02u l=0.13u
X2893 a_7901_10770# a_7833_10806# VDD.t400 VDD.t281 sg13_lv_pmos ad=0.1938p pd=1.4u as=0.1938p ps=1.4u w=1.02u l=0.13u
X2894 VSS.t1688 a_7901_10770# VSS.t844 VSS.t1727 sg13_lv_nmos ad=0.1672p pd=1.26u as=0 ps=0 w=0.88u l=5.575u
X2895 a_38648_13158# a_38580_13244# VDD.t790 VDD.t93 sg13_lv_pmos ad=0.3332p pd=2.64u as=0.3332p ps=2.64u w=0.98u l=0.76u
X2896 VDD.t1088 a_1029_9462# VDD.t1086 VDD.t8 sg13_lv_pmos ad=0.3468p pd=2.72u as=0 ps=0 w=1.02u l=5.575u
X2897 VDD.t257 a_20769_5430# VDD.t256 VDD.t68 sg13_lv_pmos ad=0.1938p pd=1.4u as=0 ps=0 w=1.02u l=5.575u
X2898 VDD.t154 a_3717_9178# VDD.t152 VDD.t29 sg13_lv_pmos ad=0.1938p pd=1.4u as=0 ps=0 w=1.02u l=5.575u
X2899 a_27557_10770# a_27489_10806# VDD.t1634 VDD.t281 sg13_lv_pmos ad=0.3468p pd=2.72u as=0.20145p ps=1.415u w=1.02u l=0.13u
X2900 a_18749_14180# OR3X1_1.B VDD.t375 VDD.t100 sg13_lv_pmos ad=43.2f pd=0.66u as=0.1044p ps=0.915u w=0.48u l=0.13u
X2901 a_15645_9462# a_15713_9426# VSS.t126 VSS.t1802 sg13_lv_nmos ad=0.2992p pd=2.44u as=0.1672p ps=1.26u w=0.88u l=0.13u
X2902 a_28581_13494# a_28649_13458# VSS.t588 VSS.t589 sg13_lv_nmos ad=0.2992p pd=2.44u as=0.1672p ps=1.26u w=0.88u l=0.13u
X2903 VSS.t206 a_27473_5072# a_27405_5146# VSS.t978 sg13_lv_nmos ad=0.1672p pd=1.26u as=0.2992p ps=2.44u w=0.88u l=0.13u
X2904 VDD.t481 a_7093_15779# a_7105_15532# VDD.t5 sg13_lv_pmos ad=0.1834p pd=1.39u as=0.3332p ps=2.64u w=0.98u l=0.13u
X2905 a_38480_9440# a_38412_9476# VDD.t382 VDD.t8 sg13_lv_pmos ad=0.3332p pd=2.64u as=0.3332p ps=2.64u w=0.98u l=0.76u
X2906 a_12957_14838# a_13025_14802# VSS.t362 VSS.t1798 sg13_lv_nmos ad=0.2992p pd=2.44u as=0.1672p ps=1.26u w=0.88u l=0.13u
X2907 VSS.t64 a_9161_5072# VSS.t62 VSS.t65 sg13_lv_nmos ad=0.1672p pd=1.26u as=0 ps=0 w=0.88u l=5.575u
X2908 a_27557_4050# a_27489_4086# VDD.t703 VDD.t83 sg13_lv_pmos ad=0.3468p pd=2.72u as=0.20145p ps=1.415u w=1.02u l=0.13u
X2909 VSS.t381 a_1097_16146# VSS.t381 VSS.t1003 sg13_lv_nmos ad=0.1738p pd=1.275u as=0 ps=0 w=0.88u l=5.305u
X2910 VDD.t1822 a_15645_10806# a_15713_10770# VDD.t281 sg13_lv_pmos ad=0.1938p pd=1.4u as=0.1938p ps=1.4u w=1.02u l=0.13u
X2911 NOR3X1_0.C BUFX3_27.Y VDD.t161 VDD.t5 sg13_lv_pmos ad=0.1862p pd=1.36u as=0.1862p ps=1.36u w=0.98u l=0.13u
X2912 VSS.t783 a_7901_8082# a_7833_8118# VSS.t1813 sg13_lv_nmos ad=0.1672p pd=1.26u as=0.2992p ps=2.44u w=0.88u l=0.13u
X2913 VDD.t1483 a_20769_13494# VDD.t1481 VDD.t100 sg13_lv_pmos ad=0.3468p pd=2.72u as=0 ps=0 w=1.02u l=1.945u
X2914 VSS.t455 a_32597_6416# VSS.t457 VSS.t456 sg13_lv_nmos ad=0.1672p pd=1.26u as=0 ps=0 w=0.88u l=5.575u
X2915 VSS.t312 a_14537_3728# a_14469_3802# VSS.t311 sg13_lv_nmos ad=0.1738p pd=1.275u as=0.2992p ps=2.44u w=0.88u l=0.13u
X2916 VSS.t566 a_15713_8082# VSS.t564 VSS.t1022 sg13_lv_nmos ad=0.1672p pd=1.26u as=0 ps=0 w=0.88u l=5.575u
X2917 VSS.t1603 a_14537_14480# VSS.t362 VSS.t1658 sg13_lv_nmos ad=0.1738p pd=1.275u as=0 ps=0 w=0.88u l=5.305u
X2918 a_9093_13210# a_9161_13136# VSS.t1384 VSS.t1530 sg13_lv_nmos ad=0.2992p pd=2.44u as=0.1672p ps=1.26u w=0.88u l=0.13u
X2919 a_24785_10448# a_24717_10522# VDD.t885 VDD.t8 sg13_lv_pmos ad=0.1938p pd=1.4u as=0.1938p ps=1.4u w=1.02u l=0.13u
X2920 a_18247_14900# DFFQX1_2.D VSS.t101 VSS.t100 sg13_lv_nmos ad=27f pd=0.48u as=0.102p ps=1.28u w=0.3u l=0.13u
X2921 VSS.t156 a_32597_15824# a_32529_15898# VSS.t155 sg13_lv_nmos ad=0.1672p pd=1.26u as=0.2992p ps=2.44u w=0.88u l=0.13u
X2922 a_31337_5394# a_31269_5430# VDD.t833 VDD.t68 sg13_lv_pmos ad=0.1938p pd=1.4u as=0.1938p ps=1.4u w=1.02u l=0.13u
X2923 VSS.t410 a_19745_6738# a_19677_6774# VSS.t1751 sg13_lv_nmos ad=0.1738p pd=1.275u as=0.2992p ps=2.44u w=0.88u l=0.13u
X2924 VDD.t948 a_17459_15170# a_17423_15244# VDD.t5 sg13_lv_pmos ad=0.2529p pd=1.545u as=43.2f ps=0.66u w=0.48u l=0.13u
X2925 VSS.t105 a_17091_15045# a_17067_14900# VSS.t147 sg13_lv_nmos ad=57f pd=0.68u as=27f ps=0.48u w=0.3u l=0.13u
X2926 a_4121_3728# a_4053_3802# VDD.t1542 VDD.t354 sg13_lv_pmos ad=0.1938p pd=1.4u as=0.1938p ps=1.4u w=1.02u l=0.13u
X2927 VDD.t1061 a_11781_9178# VDD.t1059 VDD.t29 sg13_lv_pmos ad=0.1938p pd=1.4u as=0 ps=0 w=1.02u l=5.575u
X2928 VSS.t661 a_12793_16146# counter_value_o[2] VSS.t1224 sg13_lv_nmos ad=0.1567p pd=1.27u as=0.2924p ps=2.4u w=0.86u l=0.13u
X2929 VSS.t1121 a_6911_15770# a_6803_15792# VSS.t1247 sg13_lv_nmos ad=0.22785p pd=1.9u as=0.102p ps=1.28u w=0.3u l=0.13u
X2930 BUFX3_23.A a_18803_15170# VDD.t1176 VDD.t5 sg13_lv_pmos ad=0.1632p pd=1.64u as=0.2529p ps=1.545u w=0.48u l=0.13u
X2931 a_35217_5146# a_35285_5072# VSS.t305 VSS.t306 sg13_lv_nmos ad=0.2992p pd=2.44u as=0.1672p ps=1.26u w=0.88u l=0.13u
X2932 VSS.t50 a_35285_6416# VSS.t50 VSS.t49 sg13_lv_nmos ad=0.1672p pd=1.26u as=0 ps=0 w=0.88u l=5.575u
X2933 a_12957_8118# a_13025_8082# VSS.t564 VSS.t1073 sg13_lv_nmos ad=0.2992p pd=2.44u as=0.1672p ps=1.26u w=0.88u l=0.13u
X2934 a_21955_16196# OR3BX1_0.B VSS.t133 VSS.t132 sg13_lv_nmos ad=57f pd=0.68u as=0.102p ps=1.28u w=0.3u l=0.13u
X2935 VSS.t952 a_7817_13136# VSS.t1672 VSS.t1671 sg13_lv_nmos ad=0.1738p pd=1.275u as=0 ps=0 w=0.88u l=1.945u
X2936 a_6473_5072# a_6405_5146# VDD.t762 VDD.t83 sg13_lv_pmos ad=0.3468p pd=2.72u as=0.20145p ps=1.415u w=1.02u l=0.13u
X2937 VSS.t31 a_13025_9426# VSS.t29 VSS.t30 sg13_lv_nmos ad=0.1672p pd=1.26u as=0 ps=0 w=0.88u l=5.575u
X2938 VDD.t773 a_7833_13494# VDD.t774 VDD.t100 sg13_lv_pmos ad=0.1938p pd=1.4u as=0 ps=0 w=1.02u l=5.575u
X2939 VDD.t109 a_16905_13210# a_16973_13136# VDD.t93 sg13_lv_pmos ad=0.1938p pd=1.4u as=0.1938p ps=1.4u w=1.02u l=0.13u
X2940 VDD.t522 a_30093_6490# VDD.t521 VDD.t68 sg13_lv_pmos ad=0.3468p pd=2.72u as=0 ps=0 w=1.02u l=5.305u
X2941 VDD.t554 a_35217_10522# VDD.t552 VDD.t8 sg13_lv_pmos ad=0.1938p pd=1.4u as=0 ps=0 w=1.02u l=5.575u
X2942 a_4373_15824# a_4305_15898# VDD.t391 VDD.t5 sg13_lv_pmos ad=0.3468p pd=2.72u as=0.20145p ps=1.415u w=1.02u l=0.13u
X2943 a_7297_15682# a_7105_15532# a_7425_15952# VSS.t417 sg13_lv_nmos ad=57f pd=0.68u as=27f ps=0.48u w=0.3u l=0.13u
X2944 VDD.t1644 a_12957_10806# VDD.t1647 VDD.t281 sg13_lv_pmos ad=0.1938p pd=1.4u as=0 ps=0 w=1.02u l=5.575u
X2945 VDD.t1964 a_36393_4086# VDD.t1963 VDD.t83 sg13_lv_pmos ad=0.3468p pd=2.72u as=0 ps=0 w=1.02u l=5.305u
X2946 VSS.t53 a_1097_5072# a_1029_5146# VSS.t433 sg13_lv_nmos ad=0.1672p pd=1.26u as=0.2992p ps=2.44u w=0.88u l=0.13u
X2947 a_19661_9104# a_19593_9178# VDD.t1926 VDD.t29 sg13_lv_pmos ad=0.1938p pd=1.4u as=0.1938p ps=1.4u w=1.02u l=0.13u
X2948 VSS.t342 a_30161_13136# VSS.t588 VSS.t988 sg13_lv_nmos ad=0.1738p pd=1.275u as=0 ps=0 w=0.88u l=5.305u
X2949 VDD.t722 a_1029_12150# VDD.t721 VDD.t93 sg13_lv_pmos ad=0.1938p pd=1.4u as=0 ps=0 w=1.02u l=5.575u
X2950 VSS.t935 a_19745_12114# VSS.t1364 VSS.t1562 sg13_lv_nmos ad=0.1738p pd=1.275u as=0 ps=0 w=0.88u l=1.945u
X2951 VSS.t70 a_19661_13136# VSS.t968 VSS.t976 sg13_lv_nmos ad=0.1672p pd=1.26u as=0 ps=0 w=0.88u l=5.575u
X2952 VDD.t43 a_1029_7834# a_1097_7760# VDD.t39 sg13_lv_pmos ad=0.1938p pd=1.4u as=0.1938p ps=1.4u w=1.02u l=0.13u
X2953 a_37805_14802# a_37737_14838# VDD.t706 VDD.t5 sg13_lv_pmos ad=0.3468p pd=2.72u as=0.20145p ps=1.415u w=1.02u l=0.13u
X2954 VSS.t885 a_24785_13136# VSS.t889 VSS.t888 sg13_lv_nmos ad=0.1672p pd=1.26u as=0 ps=0 w=0.88u l=5.575u
X2955 VSS.t251 a_35369_4050# VSS.t776 VSS.t995 sg13_lv_nmos ad=0.1738p pd=1.275u as=0 ps=0 w=0.88u l=1.945u
X2956 NAND3X1_0.B a_6325_16182# VDD.t1202 VDD.t0 sg13_lv_pmos ad=0.4488p pd=3.32u as=0.2412p ps=1.73u w=1.32u l=0.13u
X2957 VSS.t393 BUFX3_31.A a_21193_16182# VSS.t1217 sg13_lv_nmos ad=0.1567p pd=1.27u as=0.102p ps=1.28u w=0.3u l=0.13u
X2958 a_23457_10806# a_23525_10770# VSS.t815 VSS.t1625 sg13_lv_nmos ad=0.2992p pd=2.44u as=0.1672p ps=1.26u w=0.88u l=0.13u
X2959 VSS.t993 a_7817_14480# a_7749_14554# VSS.t1587 sg13_lv_nmos ad=0.1738p pd=1.275u as=0.2992p ps=2.44u w=0.88u l=0.13u
X2960 a_16469_16146# a_16401_16182# VDD.t1123 VDD.t0 sg13_lv_pmos ad=0.3468p pd=2.72u as=0.20145p ps=1.415u w=1.02u l=0.13u
X2961 VSS.t954 a_9161_13136# a_9093_13210# VSS.t1528 sg13_lv_nmos ad=0.1672p pd=1.26u as=0.2992p ps=2.44u w=0.88u l=0.13u
X2962 VDD.t579 a_15645_8118# VDD.t578 VDD.t29 sg13_lv_pmos ad=0.3468p pd=2.72u as=0 ps=0 w=1.02u l=5.575u
X2963 VSS.t268 a_32597_10448# VSS.t18 VSS.t269 sg13_lv_nmos ad=0.1672p pd=1.26u as=0 ps=0 w=0.88u l=5.575u
X2964 a_23709_14838# NOR3X1_0.C a_23803_15306# VDD.t5 sg13_lv_pmos ad=0.1212p pd=0.985u as=43.2f ps=0.66u w=0.48u l=0.13u
X2965 VSS.t1344 a_12689_2706# VSS.t1371 VSS.t1373 sg13_lv_nmos ad=0.1672p pd=1.26u as=0 ps=0 w=0.88u l=5.575u
X2966 VSS.t700 a_19745_13458# a_19677_13494# VSS.t1585 sg13_lv_nmos ad=0.1738p pd=1.275u as=0.2992p ps=2.44u w=0.88u l=0.13u
X2967 VSS.t254 a_27473_3728# VSS.t983 VSS.t982 sg13_lv_nmos ad=0.1672p pd=1.26u as=0 ps=0 w=0.88u l=5.575u
X2968 VSS.t284 a_7901_6738# a_7833_6774# VSS.t283 sg13_lv_nmos ad=0.1672p pd=1.26u as=0.2992p ps=2.44u w=0.88u l=0.13u
X2969 VSS.t48 a_4460_6752# a_4392_6788# VSS.t47 sg13_lv_nmos ad=0.2176p pd=1.96u as=0.2176p ps=1.96u w=0.64u l=0.76u
X2970 a_20333_14480# a_20265_14554# VDD.t1618 VDD.t100 sg13_lv_pmos ad=0.3468p pd=2.72u as=0.20145p ps=1.415u w=1.02u l=0.13u
X2971 VSS.t439 a_3785_5394# VSS.t53 VSS.t438 sg13_lv_nmos ad=0.1738p pd=1.275u as=0 ps=0 w=0.88u l=1.945u
X2972 a_22979_14608# a_22029_14280# a_22865_14228# VSS.t825 sg13_lv_nmos ad=27f pd=0.48u as=57f ps=0.68u w=0.3u l=0.13u
X2973 a_3785_11792# a_3717_11866# VDD.t1858 VDD.t281 sg13_lv_pmos ad=0.1938p pd=1.4u as=0.1938p ps=1.4u w=1.02u l=0.13u
X2974 VDD.t385 a_19593_6490# VDD.t384 VDD.t68 sg13_lv_pmos ad=0.3468p pd=2.72u as=0 ps=0 w=1.02u l=5.575u
X2975 VDD.t205 a_3717_7834# a_3785_7760# VDD.t39 sg13_lv_pmos ad=0.1938p pd=1.4u as=0.1938p ps=1.4u w=1.02u l=0.13u
X2976 VSS.t124 a_19661_9104# VSS.t356 VSS.t358 sg13_lv_nmos ad=0.1672p pd=1.26u as=0 ps=0 w=0.88u l=5.575u
X2977 VSS.t778 a_31337_4050# VSS.t774 VSS.t1349 sg13_lv_nmos ad=0.1672p pd=1.26u as=0 ps=0 w=0.88u l=5.575u
X2978 a_22349_9104# a_22281_9178# VDD.t1108 VDD.t29 sg13_lv_pmos ad=0.3468p pd=2.72u as=0.20145p ps=1.415u w=1.02u l=0.13u
X2979 counter_value_o[5] a_27157_16182# VDD.t1254 VDD.t0 sg13_lv_pmos ad=0.4488p pd=3.32u as=0.2412p ps=1.73u w=1.32u l=0.13u
X2980 VSS.t158 a_33941_16146# a_33873_16182# VSS.t627 sg13_lv_nmos ad=0.1738p pd=1.275u as=0.2992p ps=2.44u w=0.88u l=0.13u
X2981 VSS.t466 a_30161_7760# VSS.t468 VSS.t467 sg13_lv_nmos ad=0.1738p pd=1.275u as=0 ps=0 w=0.88u l=5.305u
X2982 a_18401_10770# a_18333_10806# VDD.t1433 VDD.t281 sg13_lv_pmos ad=0.3468p pd=2.72u as=0.20145p ps=1.415u w=1.02u l=0.13u
X2983 a_20249_16146# a_20181_16182# VDD.t1293 VDD.t0 sg13_lv_pmos ad=0.3468p pd=2.72u as=0.20145p ps=1.415u w=1.02u l=0.13u
X2984 VSS.t665 a_14117_15824# VSS.t665 VSS.t1220 sg13_lv_nmos ad=0.1738p pd=1.275u as=0 ps=0 w=0.88u l=1.945u
X2985 VSS.t78 a_7241_14816# AND2X1_1.Y VSS.t77 sg13_lv_nmos ad=57f pd=0.68u as=0.12p ps=1.4u w=0.3u l=0.13u
X2986 VDD.t1741 a_32529_11866# VDD.t1740 VDD.t281 sg13_lv_pmos ad=0.3468p pd=2.72u as=0 ps=0 w=1.02u l=5.575u
X2987 VDD.t1386 a_15813_5146# VDD.t1385 VDD.t83 sg13_lv_pmos ad=0.3468p pd=2.72u as=0 ps=0 w=1.02u l=1.945u
X2988 VSS.t281 a_27557_9426# VSS.t278 VSS.t532 sg13_lv_nmos ad=0.1738p pd=1.275u as=0 ps=0 w=0.88u l=1.945u
X2989 VSS.t1549 a_35285_13136# VSS.t799 VSS.t1555 sg13_lv_nmos ad=0.1672p pd=1.26u as=0 ps=0 w=0.88u l=5.575u
X2990 VSS.t428 a_15713_6738# VSS.t192 VSS.t470 sg13_lv_nmos ad=0.1672p pd=1.26u as=0 ps=0 w=0.88u l=5.575u
X2991 a_24717_3802# a_24785_3728# VSS.t254 VSS.t1679 sg13_lv_nmos ad=0.2992p pd=2.44u as=0.1672p ps=1.26u w=0.88u l=0.13u
X2992 VSS.t573 a_18401_8082# a_18333_8118# VSS.t649 sg13_lv_nmos ad=0.1738p pd=1.275u as=0.2992p ps=2.44u w=0.88u l=0.13u
X2993 a_23209_16146# NOR3X1_0.Y VDD.t147 VDD.t0 sg13_lv_pmos ad=0.1632p pd=1.64u as=0.2412p ps=1.73u w=0.48u l=0.13u
X2994 VSS.t882 a_26717_2706# a_26649_2742# VSS.t1306 sg13_lv_nmos ad=0.1738p pd=1.275u as=0.2992p ps=2.44u w=0.88u l=0.13u
X2995 VDD.t502 a_27405_7834# VDD.t501 VDD.t39 sg13_lv_pmos ad=0.3468p pd=2.72u as=0 ps=0 w=1.02u l=5.575u
X2996 a_16905_9178# a_16973_9104# VSS.t124 VSS.t123 sg13_lv_nmos ad=0.2992p pd=2.44u as=0.1672p ps=1.26u w=0.88u l=0.13u
X2997 a_5213_9426# a_5145_9462# VDD.t15 VDD.t8 sg13_lv_pmos ad=0.1938p pd=1.4u as=0.1938p ps=1.4u w=1.02u l=0.13u
X2998 VSS.t381 DFFQX1_1.D a_3809_15952# VSS.t1256 sg13_lv_nmos ad=0.102p pd=1.28u as=27f ps=0.48u w=0.3u l=0.13u
X2999 a_1029_11866# a_1097_11792# VSS.t922 VSS.t1315 sg13_lv_nmos ad=0.2992p pd=2.44u as=0.1672p ps=1.26u w=0.88u l=0.13u
X3000 VDD.t120 BUFX3_0.Y OR3X1_1.B VDD.t5 sg13_lv_pmos ad=0.3332p pd=2.64u as=0.1862p ps=1.36u w=0.98u l=0.13u
X3001 VDD.t1939 a_9093_7834# a_9161_7760# VDD.t39 sg13_lv_pmos ad=0.1938p pd=1.4u as=0.1938p ps=1.4u w=1.02u l=0.13u
X3002 VSS.t757 a_31505_10448# a_31437_10522# VSS.t841 sg13_lv_nmos ad=0.1738p pd=1.275u as=0.2992p ps=2.44u w=0.88u l=0.13u
X3003 a_15713_12114# a_15645_12150# VDD.t1648 VDD.t93 sg13_lv_pmos ad=0.1938p pd=1.4u as=0.1938p ps=1.4u w=1.02u l=0.13u
X3004 VSS.t514 a_35369_12114# a_35301_12150# VSS.t826 sg13_lv_nmos ad=0.1738p pd=1.275u as=0.2992p ps=2.44u w=0.88u l=0.13u
X3005 a_12957_6774# a_13025_6738# VSS.t719 VSS.t718 sg13_lv_nmos ad=0.2992p pd=2.44u as=0.1672p ps=1.26u w=0.88u l=0.13u
X3006 OAI21X1_0.A BUFX3_16.A VDD.t592 VDD.t0 sg13_lv_pmos ad=0.1632p pd=1.64u as=0.1632p ps=1.64u w=0.48u l=0.13u
X3007 a_6473_14480# a_6405_14554# VDD.t1283 VDD.t100 sg13_lv_pmos ad=0.3468p pd=2.72u as=0.20145p ps=1.415u w=1.02u l=0.13u
X3008 a_22801_13948# NOR3X1_0.C NOR3X1_0.Y VDD.t100 sg13_lv_pmos ad=91.2f pd=0.86u as=0.1632p ps=1.64u w=0.48u l=0.13u
X3009 VDD.t1381 a_14469_11866# VDD.t1380 VDD.t281 sg13_lv_pmos ad=0.3468p pd=2.72u as=0 ps=0 w=1.02u l=5.305u
X3010 VSS.t725 a_35369_2706# VSS.t725 VSS.t1046 sg13_lv_nmos ad=0.1672p pd=1.26u as=0 ps=0 w=0.88u l=5.575u
X3011 VSS.t453 a_32597_6416# a_32529_6490# VSS.t452 sg13_lv_nmos ad=0.1672p pd=1.26u as=0.2992p ps=2.44u w=0.88u l=0.13u
X3012 VDD.t361 a_12957_9462# a_13025_9426# VDD.t8 sg13_lv_pmos ad=0.1938p pd=1.4u as=0.1938p ps=1.4u w=1.02u l=0.13u
X3013 a_4121_10448# a_4053_10522# VDD.t971 VDD.t8 sg13_lv_pmos ad=0.1938p pd=1.4u as=0.1938p ps=1.4u w=1.02u l=0.13u
X3014 VSS.t1098 a_28649_12114# VSS.t1096 VSS.t1097 sg13_lv_nmos ad=0.1672p pd=1.26u as=0 ps=0 w=0.88u l=5.575u
X3015 a_4460_10784# a_4392_10820# VDD.t947 VDD.t281 sg13_lv_pmos ad=0.3332p pd=2.64u as=0.3332p ps=2.64u w=0.98u l=0.76u
X3016 VSS.t595 a_3785_14480# VSS.t76 VSS.t908 sg13_lv_nmos ad=0.1672p pd=1.26u as=0 ps=0 w=0.88u l=5.575u
X3017 a_19593_6490# a_19661_6416# VSS.t412 VSS.t411 sg13_lv_nmos ad=0.2992p pd=2.44u as=0.1672p ps=1.26u w=0.88u l=0.13u
X3018 VDD.t569 a_32529_9178# a_32597_9104# VDD.t29 sg13_lv_pmos ad=0.1938p pd=1.4u as=0.1938p ps=1.4u w=1.02u l=0.13u
X3019 VSS.t602 BUFX3_27.Y a_21525_14180# VSS.t601 sg13_lv_nmos ad=61.5f pd=0.71u as=57f ps=0.68u w=0.3u l=0.13u
R0 VDD.n15 VDD.t180 17.3063
R1 VDD.n92 VDD.t1140 17.2797
R2 VDD.n74 VDD.t1224 17.2797
R3 VDD.n67 VDD.t1232 17.2797
R4 VDD.n67 VDD.t1311 17.2797
R5 VDD.n335 VDD.t1488 17.2797
R6 VDD.n68 VDD.t136 17.2797
R7 VDD.n92 VDD.t747 17.2628
R8 VDD.n67 VDD.t373 17.2628
R9 VDD.n68 VDD.t7 17.2628
R10 VDD.n18 VDD.t1012 17.2417
R11 VDD.n18 VDD.t1436 17.2417
R12 VDD.n73 VDD.t991 17.2417
R13 VDD.n73 VDD.t724 17.2417
R14 VDD.n15 VDD.t1836 17.2417
R15 VDD.n15 VDD.t1684 17.2417
R16 VDD.n67 VDD.t146 17.2417
R17 VDD.n67 VDD.t370 17.2417
R18 VDD.n79 VDD.t123 17.2417
R19 VDD.n79 VDD.t149 17.2417
R20 VDD.n17 VDD.t1194 17.2417
R21 VDD.n17 VDD.t1138 17.2417
R22 VDD.n75 VDD.t1242 17.2417
R23 VDD.n75 VDD.t389 17.2417
R24 VDD.n73 VDD.t1241 17.2417
R25 VDD.n73 VDD.t1032 17.2417
R26 VDD.n194 VDD.t376 17.2377
R27 VDD.n12 VDD.t1062 17.2377
R28 VDD.n16 VDD.t168 17.2349
R29 VDD.n14 VDD.t289 17.2274
R30 VDD.n169 VDD.t1480 17.2274
R31 VDD.n169 VDD.t1205 17.2274
R32 VDD.n41 VDD.t1313 17.2274
R33 VDD.n41 VDD.t163 17.2274
R34 VDD.n77 VDD.t614 17.2274
R35 VDD.n76 VDD.t374 17.2274
R36 VDD.n63 VDD.t162 17.2274
R37 VDD.n15 VDD.t1195 17.2274
R38 VDD.n87 VDD.t148 17.2274
R39 VDD.n87 VDD.t1044 17.2274
R40 VDD.n75 VDD.t1696 17.2274
R41 VDD.n75 VDD.t119 17.2274
R42 VDD.n75 VDD.t122 17.2274
R43 VDD.n75 VDD.t1278 17.2274
R44 VDD.n16 VDD.t603 17.2274
R45 VDD.n16 VDD.t1695 17.2274
R46 VDD.n77 VDD.t372 17.2274
R47 VDD.n77 VDD.t664 17.2274
R48 VDD.n11 VDD.t592 17.2274
R49 VDD.n73 VDD.t957 5.74893
R50 VDD.n15 VDD.t948 5.74893
R51 VDD.n193 VDD.t1466 5.74893
R52 VDD.n64 VDD.t1506 17.1486
R53 VDD.n18 VDD.t548 17.1401
R54 VDD.n18 VDD.t613 17.1401
R55 VDD.n87 VDD.t121 17.1401
R56 VDD.n75 VDD.t1221 17.1401
R57 VDD.n111 VDD.t611 17.1401
R58 VDD.n111 VDD.t160 17.1401
R59 VDD.n64 VDD.t375 17.1375
R60 VDD.n15 VDD.t1694 17.0005
R61 VDD.n329 VDD.n95 14.0919
R62 VDD.n99 VDD.n339 14.0919
R63 VDD.n104 VDD.n12 14.0919
R64 VDD.n452 VDD.n425 14.0919
R65 VDD.n8 VDD.n451 14.0919
R66 VDD.n43 VDD.n456 14.0919
R67 VDD.n42 VDD.n108 14.0919
R68 VDD.n16 VDD.n95 13.5005
R69 VDD.n95 VDD.n435 13.5005
R70 VDD.n438 VDD.n96 13.5005
R71 VDD.n96 VDD.n437 13.5005
R72 VDD.n93 VDD.n334 13.5005
R73 VDD.n445 VDD.n93 13.5005
R74 VDD.n94 VDD.n447 13.5005
R75 VDD.n448 VDD.n94 13.5005
R76 VDD.n455 VDD 13.5005
R77 VDD VDD.n332 13.5005
R78 VDD.n83 VDD.n99 13.5005
R79 VDD.n156 VDD.n99 13.5005
R80 VDD.n100 VDD.n158 13.5005
R81 VDD.n159 VDD.n100 13.5005
R82 VDD.n160 VDD.n97 13.5005
R83 VDD.n97 VDD.n162 13.5005
R84 VDD.n163 VDD.n98 13.5005
R85 VDD.n165 VDD.n98 13.5005
R86 VDD.n456 VDD.n167 13.5005
R87 VDD.n453 VDD.n452 13.5005
R88 VDD.n451 VDD.n450 13.5005
R89 VDD.n104 VDD.n73 13.5005
R90 VDD.n14 VDD.n104 13.5005
R91 VDD.n277 VDD.n102 13.5005
R92 VDD.n102 VDD.n439 13.5005
R93 VDD.n274 VDD.n103 13.5005
R94 VDD.n103 VDD.n440 13.5005
R95 VDD.n270 VDD.n101 13.5005
R96 VDD.n101 VDD.n449 13.5005
R97 VDD.n426 VDD.n105 13.5005
R98 VDD.n105 VDD.n442 13.5005
R99 VDD.n443 VDD.n107 13.5005
R100 VDD.n107 VDD.n441 13.5005
R101 VDD.n428 VDD.n106 13.5005
R102 VDD.n106 VDD.n431 13.5005
R103 VDD.n108 VDD.n432 13.5005
R104 VDD.n108 VDD.n433 13.5005
R105 VDD.n22 VDD.t0 11.5891
R106 VDD.n28 VDD.t354 11.5884
R107 VDD.t83 VDD.n118 11.5884
R108 VDD.t68 VDD.n123 11.5884
R109 VDD.n128 VDD.t39 11.5884
R110 VDD.t29 VDD.n134 11.5884
R111 VDD.t8 VDD.n139 11.5884
R112 VDD.t281 VDD.n145 11.5884
R113 VDD.n150 VDD.t93 11.5884
R114 VDD.n152 VDD.t100 11.5884
R115 VDD.n155 VDD.t5 11.5884
R116 VDD.t0 VDD.n421 11.5884
R117 VDD.n88 VDD.n89 0.6737
R118 VDD.n418 VDD.t354 11.5866
R119 VDD.n417 VDD.t354 11.5866
R120 VDD.n44 VDD.t354 11.5866
R121 VDD.n9 VDD.t354 5.68755
R122 VDD.n21 VDD.t354 11.5866
R123 VDD.t83 VDD.n116 11.5866
R124 VDD.t83 VDD.n114 11.5866
R125 VDD.n167 VDD.t83 11.5866
R126 VDD.n288 VDD.t83 11.5866
R127 VDD.t68 VDD.n121 11.5866
R128 VDD.n120 VDD.t68 11.5866
R129 VDD.n165 VDD.t68 11.5866
R130 VDD.n287 VDD.t68 11.5866
R131 VDD.n127 VDD.t39 11.5866
R132 VDD.n125 VDD.t39 11.5866
R133 VDD.n163 VDD.t39 11.5866
R134 VDD.n286 VDD.t39 11.5866
R135 VDD.t29 VDD.n132 11.5866
R136 VDD.t29 VDD.n130 11.5866
R137 VDD.n162 VDD.t29 11.5866
R138 VDD.n285 VDD.t29 11.5866
R139 VDD.n137 VDD.t8 11.5866
R140 VDD.n135 VDD.t8 11.5866
R141 VDD.n160 VDD.t8 11.5866
R142 VDD.n25 VDD.t8 11.5866
R143 VDD.t281 VDD.n143 11.5866
R144 VDD.n141 VDD.t281 11.5866
R145 VDD.n159 VDD.t281 11.5866
R146 VDD.n284 VDD.t281 11.5866
R147 VDD.n149 VDD.t93 11.5866
R148 VDD.n147 VDD.t93 11.5866
R149 VDD.n158 VDD.t93 11.5866
R150 VDD.n283 VDD.t93 11.5866
R151 VDD.n151 VDD.t100 11.5866
R152 VDD.n41 VDD.t100 11.5866
R153 VDD.n156 VDD.t100 11.5866
R154 VDD.n282 VDD.t100 11.5866
R155 VDD.n154 VDD.t5 11.5866
R156 VDD.n76 VDD.t5 11.5866
R157 VDD.n83 VDD.t5 11.5866
R158 VDD.n91 VDD.t5 11.5866
R159 VDD.t0 VDD.n39 11.5866
R160 VDD.t0 VDD.n420 11.5866
R161 VDD.t0 VDD.n19 11.5866
R162 VDD.t0 VDD.n23 11.5866
R163 VDD.t0 VDD.n168 11.5866
R164 VDD.n70 VDD.t0 11.5866
R165 VDD.n335 VDD.t0 11.5866
R166 VDD.n89 VDD.t354 5.45751
R167 VDD.n252 VDD.t354 5.48625
R168 VDD.n413 VDD.t354 5.58509
R169 VDD.t83 VDD.n46 11.5858
R170 VDD.t83 VDD.n30 11.5858
R171 VDD.t83 VDD.n249 11.5858
R172 VDD.n251 VDD.t83 11.5858
R173 VDD.t68 VDD.n48 11.5858
R174 VDD.t68 VDD.n243 11.5858
R175 VDD.n245 VDD.t68 11.5858
R176 VDD.n247 VDD.t68 11.5858
R177 VDD.n50 VDD.t39 11.5858
R178 VDD.n239 VDD.t39 11.5858
R179 VDD.n241 VDD.t39 11.5858
R180 VDD.n242 VDD.t39 11.5858
R181 VDD.t29 VDD.n52 11.5858
R182 VDD.t29 VDD.n34 11.5858
R183 VDD.t29 VDD.n236 11.5858
R184 VDD.n238 VDD.t29 11.5858
R185 VDD.n54 VDD.t8 11.5858
R186 VDD.n232 VDD.t8 11.5858
R187 VDD.n233 VDD.t8 11.5858
R188 VDD.n234 VDD.t8 11.5858
R189 VDD.t281 VDD.n56 11.5858
R190 VDD.t281 VDD.n228 11.5858
R191 VDD.n230 VDD.t281 11.5858
R192 VDD.n231 VDD.t281 11.5858
R193 VDD.n58 VDD.t93 11.5858
R194 VDD.n223 VDD.t93 11.5858
R195 VDD.n225 VDD.t93 11.5858
R196 VDD.n227 VDD.t93 11.5858
R197 VDD.n60 VDD.t100 11.5858
R198 VDD.n410 VDD.t100 11.5858
R199 VDD.n169 VDD.t100 11.5858
R200 VDD.n222 VDD.t100 11.5858
R201 VDD.n62 VDD.t5 11.5858
R202 VDD.n414 VDD.t5 11.5858
R203 VDD.n67 VDD.t5 11.5858
R204 VDD.n79 VDD.t5 11.5858
R205 VDD.n327 VDD.t946 8.74576
R206 VDD.n328 VDD.t1664 8.74576
R207 VDD.n18 VDD.t992 8.74576
R208 VDD.n18 VDD.t1210 8.74576
R209 VDD.n65 VDD.t179 8.74576
R210 VDD.n65 VDD.t1146 8.74576
R211 VDD.n14 VDD.t1708 8.74576
R212 VDD.n414 VDD.t462 8.74576
R213 VDD.n63 VDD.t1289 8.74576
R214 VDD.n82 VDD.t357 8.74576
R215 VDD.n74 VDD.t118 8.74576
R216 VDD.n17 VDD.t369 8.74576
R217 VDD.n16 VDD.t660 8.74576
R218 VDD.n91 VDD.t659 8.74576
R219 VDD.n79 VDD.t1179 8.74576
R220 VDD.n15 VDD.t1178 8.74576
R221 VDD.n15 VDD.t6 8.74576
R222 VDD.n15 VDD.t1265 8.74576
R223 VDD.n77 VDD.t1139 8.74576
R224 VDD.n194 VDD.t1212 8.74576
R225 VDD.n194 VDD.t1132 8.74576
R226 VDD.n338 VDD.t461 8.74576
R227 VDD.n42 VDD.t1175 8.74576
R228 VDD.n90 VDD.t1254 8.74576
R229 VDD.n19 VDD.t925 8.74576
R230 VDD.n12 VDD.t147 8.74576
R231 VDD.n12 VDD.t287 8.74576
R232 VDD.n112 VDD.t615 8.74576
R233 VDD.n112 VDD.t1220 8.74576
R234 VDD.n337 VDD.t1211 8.74576
R235 VDD.n11 VDD.t596 8.74576
R236 VDD.n11 VDD.t590 8.74576
R237 VDD.n10 VDD.t597 8.74576
R238 VDD.n339 VDD.t1234 8.74576
R239 VDD.n336 VDD.t1292 8.74576
R240 VDD.n68 VDD.t1237 8.74576
R241 VDD.n68 VDD.t1203 8.74576
R242 VDD.n110 VDD.t1144 8.74576
R243 VDD.n110 VDD.t1143 8.74576
R244 VDD.n109 VDD.t1202 8.74576
R245 VDD.n330 VDD.t1198 8.74576
R246 VDD.n329 VDD.t619 8.74576
R247 VDD.n14 VDD.t941 5.74893
R248 VDD.n75 VDD.t1243 5.74893
R249 VDD.n193 VDD.n253 0.0676812
R250 VDD.n87 VDD.t1222 8.67593
R251 VDD.n87 VDD.t120 8.67593
R252 VDD.n73 VDD.t161 8.67593
R253 VDD.n73 VDD.t665 8.67593
R254 VDD.n69 VDD.t1273 8.66463
R255 VDD.n83 VDD.t1786 8.66463
R256 VDD.n81 VDD.t1275 8.66463
R257 VDD.n338 VDD.t2 7.81911
R258 VDD.n341 VDD.t1135 7.81822
R259 VDD.n171 VDD.t483 6.31201
R260 VDD.n173 VDD.t1898 6.31201
R261 VDD.n175 VDD.t743 6.31201
R262 VDD.n177 VDD.t572 6.31201
R263 VDD.n179 VDD.t291 6.31201
R264 VDD.n181 VDD.t963 6.31201
R265 VDD.n183 VDD.t790 6.31201
R266 VDD.n185 VDD.t950 6.31201
R267 VDD.n187 VDD.t1468 6.31201
R268 VDD.n347 VDD.t1686 6.16807
R269 VDD.n327 VDD.t1727 6.052
R270 VDD.n328 VDD.t1088 6.052
R271 VDD.n21 VDD.t1885 6.02369
R272 VDD.n171 VDD.t1570 6.02369
R273 VDD.n7 VDD.t1464 6.02369
R274 VDD.n173 VDD.t1902 6.02369
R275 VDD.n6 VDD.t393 6.02369
R276 VDD.n175 VDD.t1426 6.02369
R277 VDD.n5 VDD.t815 6.02369
R278 VDD.n177 VDD.t38 6.02369
R279 VDD.n4 VDD.t1069 6.02369
R280 VDD.n179 VDD.t382 6.02369
R281 VDD.n195 VDD.t130 6.02369
R282 VDD.n181 VDD.t1314 6.02369
R283 VDD.n3 VDD.t947 6.02369
R284 VDD.n183 VDD.t934 6.02369
R285 VDD.n2 VDD.t1809 6.02369
R286 VDD.n185 VDD.t1616 6.02369
R287 VDD.n72 VDD.t280 6.02369
R288 VDD.n1 VDD.t1587 6.02369
R289 VDD.n187 VDD.t1687 6.02369
R290 VDD.n153 VDD.t1709 6.02369
R291 VDD.n63 VDD.t1835 6.02369
R292 VDD.n81 VDD.t1909 6.02369
R293 VDD.n346 VDD.t1 6.02369
R294 VDD.n345 VDD.t1559 6.02369
R295 VDD.n343 VDD.t1973 6.02369
R296 VDD.n23 VDD.t1226 6.02369
R297 VDD.n419 VDD.t618 6.02369
R298 VDD.n342 VDD.t1204 6.02369
R299 VDD.n22 VDD.t1231 6.02369
R300 VDD.n341 VDD.t292 6.02369
R301 VDD.n347 VDD.t1609 6.02326
R302 VDD.n250 VDD.t1956 6.02326
R303 VDD.n246 VDD.t472 6.02326
R304 VDD.n257 VDD.t1491 6.02326
R305 VDD.n237 VDD.t1100 6.02326
R306 VDD.n260 VDD.t1580 6.02326
R307 VDD.n226 VDD.t1031 6.02326
R308 VDD.n263 VDD.t1789 6.02326
R309 VDD.n65 VDD.t1704 6.02326
R310 VDD.n280 VDD.t1142 6.02326
R311 VDD.n170 VDD.t1566 6.02326
R312 VDD.n253 VDD.t959 5.92381
R313 VDD.n77 VDD.t1208 5.92381
R314 VDD.n73 VDD.t622 5.88785
R315 VDD.n15 VDD.t288 5.88785
R316 VDD.n82 VDD.t371 5.88785
R317 VDD.n87 VDD.t381 5.88785
R318 VDD.n87 VDD.t167 5.88707
R319 VDD.n77 VDD.t1310 5.88707
R320 VDD.n18 VDD.t621 5.88607
R321 VDD.n17 VDD.t482 5.88607
R322 VDD.n87 VDD.t481 5.88607
R323 VDD.n73 VDD.t623 5.88607
R324 VDD.n347 VDD.t1285 5.85973
R325 VDD.n254 VDD.t513 5.85973
R326 VDD.n254 VDD.t510 5.85973
R327 VDD.n29 VDD.t1711 5.85973
R328 VDD.n425 VDD.t864 5.85973
R329 VDD.n415 VDD.t860 5.85973
R330 VDD.n265 VDD.t1394 5.85973
R331 VDD.n13 VDD.t1773 5.85973
R332 VDD.n13 VDD.t1770 5.85973
R333 VDD.n27 VDD.t1474 5.85973
R334 VDD.n354 VDD.t879 5.85973
R335 VDD.n354 VDD.t876 5.85973
R336 VDD.n8 VDD.t1484 5.85973
R337 VDD.n352 VDD.t1523 5.85973
R338 VDD.n352 VDD.t1520 5.85973
R339 VDD.n416 VDD.t1430 5.85973
R340 VDD.n349 VDD.t1767 5.85973
R341 VDD.n349 VDD.t1764 5.85973
R342 VDD.n78 VDD.t1906 5.85973
R343 VDD.n348 VDD.t1920 5.85973
R344 VDD.n348 VDD.t1917 5.85973
R345 VDD.n44 VDD.t1960 5.85973
R346 VDD.n40 VDD.t1413 5.85973
R347 VDD.n40 VDD.t1409 5.85973
R348 VDD.n9 VDD.t1336 5.85973
R349 VDD.n24 VDD.t1828 5.85973
R350 VDD.n24 VDD.t1825 5.85973
R351 VDD.n21 VDD.t935 5.85973
R352 VDD.n331 VDD.t1729 5.85973
R353 VDD.n331 VDD.t1726 5.85973
R354 VDD.n171 VDD.t1606 5.85973
R355 VDD.n172 VDD.t1963 5.85973
R356 VDD.n117 VDD.t1083 5.85973
R357 VDD.n406 VDD.t90 5.85973
R358 VDD.n46 VDD.t1367 5.85973
R359 VDD.n46 VDD.t1363 5.85973
R360 VDD.n200 VDD.t1577 5.85973
R361 VDD.n200 VDD.t1574 5.85973
R362 VDD.n115 VDD.t703 5.85973
R363 VDD.n407 VDD.t1783 5.85973
R364 VDD.n30 VDD.t459 5.85973
R365 VDD.n30 VDD.t456 5.85973
R366 VDD.n199 VDD.t1631 5.85973
R367 VDD.n199 VDD.t1628 5.85973
R368 VDD.n113 VDD.t447 5.85973
R369 VDD.n408 VDD.t444 5.85973
R370 VDD.n249 VDD.t922 5.85973
R371 VDD.n249 VDD.t919 5.85973
R372 VDD.n198 VDD.t979 5.85973
R373 VDD.n198 VDD.t976 5.85973
R374 VDD.n166 VDD.t1009 5.85973
R375 VDD.n409 VDD.t1469 5.85973
R376 VDD.n251 VDD.t917 5.85973
R377 VDD.n251 VDD.t913 5.85973
R378 VDD.n289 VDD.t1006 5.85973
R379 VDD.n289 VDD.t1003 5.85973
R380 VDD.n7 VDD.t910 5.85973
R381 VDD.n356 VDD.t85 5.85973
R382 VDD.n356 VDD.t87 5.85973
R383 VDD.n173 VDD.t758 5.85973
R384 VDD.n174 VDD.t262 5.85973
R385 VDD.n122 VDD.t259 5.85973
R386 VDD.n401 VDD.t80 5.85973
R387 VDD.n48 VDD.t836 5.85973
R388 VDD.n48 VDD.t833 5.85973
R389 VDD.n203 VDD.t1954 5.85973
R390 VDD.n203 VDD.t1951 5.85973
R391 VDD.n402 VDD.t1899 5.85973
R392 VDD.n403 VDD.t77 5.85973
R393 VDD.n243 VDD.t831 5.85973
R394 VDD.n243 VDD.t828 5.85973
R395 VDD.n202 VDD.t257 5.85973
R396 VDD.n202 VDD.t253 5.85973
R397 VDD.n119 VDD.t685 5.85973
R398 VDD.n404 VDD.t524 5.85973
R399 VDD.n245 VDD.t756 5.85973
R400 VDD.n245 VDD.t753 5.85973
R401 VDD.n201 VDD.t251 5.85973
R402 VDD.n201 VDD.t248 5.85973
R403 VDD.n164 VDD.t245 5.85973
R404 VDD.n405 VDD.t394 5.85973
R405 VDD.n247 VDD.t441 5.85973
R406 VDD.n247 VDD.t438 5.85973
R407 VDD.n294 VDD.t75 5.85973
R408 VDD.n294 VDD.t72 5.85973
R409 VDD.n6 VDD.t435 5.85973
R410 VDD.n357 VDD.t680 5.85973
R411 VDD.n357 VDD.t682 5.85973
R412 VDD.n175 VDD.t1126 5.85973
R413 VDD.n176 VDD.t1398 5.85973
R414 VDD.n395 VDD.t1377 5.85973
R415 VDD.n396 VDD.t1374 5.85973
R416 VDD.n50 VDD.t1372 5.85973
R417 VDD.n50 VDD.t1369 5.85973
R418 VDD.n206 VDD.t1360 5.85973
R419 VDD.n206 VDD.t1357 5.85973
R420 VDD.n126 VDD.t236 5.85973
R421 VDD.n397 VDD.t233 5.85973
R422 VDD.n239 VDD.t65 5.85973
R423 VDD.n239 VDD.t62 5.85973
R424 VDD.n205 VDD.t826 5.85973
R425 VDD.n205 VDD.t822 5.85973
R426 VDD.n124 VDD.t230 5.85973
R427 VDD.n398 VDD.t227 5.85973
R428 VDD.n241 VDD.t60 5.85973
R429 VDD.n241 VDD.t57 5.85973
R430 VDD.n204 VDD.t819 5.85973
R431 VDD.n204 VDD.t816 5.85973
R432 VDD.n399 VDD.t507 5.85973
R433 VDD.n400 VDD.t744 5.85973
R434 VDD.n242 VDD.t225 5.85973
R435 VDD.n242 VDD.t222 5.85973
R436 VDD.n299 VDD.t220 5.85973
R437 VDD.n299 VDD.t217 5.85973
R438 VDD.n5 VDD.t1948 5.85973
R439 VDD.n358 VDD.t1975 5.85973
R440 VDD.n358 VDD.t1976 5.85973
R441 VDD.n177 VDD.t587 5.85973
R442 VDD.n178 VDD.t655 5.85973
R443 VDD.n133 VDD.t366 5.85973
R444 VDD.n391 VDD.t346 5.85973
R445 VDD.n52 VDD.t199 5.85973
R446 VDD.n52 VDD.t196 5.85973
R447 VDD.n209 VDD.t36 5.85973
R448 VDD.n209 VDD.t33 5.85973
R449 VDD.n131 VDD.t584 5.85973
R450 VDD.n392 VDD.t652 5.85973
R451 VDD.n34 VDD.t1073 5.85973
R452 VDD.n34 VDD.t1070 5.85973
R453 VDD.n208 VDD.t1120 5.85973
R454 VDD.n208 VDD.t1117 5.85973
R455 VDD.n129 VDD.t800 5.85973
R456 VDD.n393 VDD.t1934 5.85973
R457 VDD.n236 VDD.t581 5.85973
R458 VDD.n236 VDD.t578 5.85973
R459 VDD.n207 VDD.t649 5.85973
R460 VDD.n207 VDD.t646 5.85973
R461 VDD.n161 VDD.t418 5.85973
R462 VDD.n394 VDD.t363 5.85973
R463 VDD.n238 VDD.t343 5.85973
R464 VDD.n238 VDD.t340 5.85973
R465 VDD.n304 VDD.t416 5.85973
R466 VDD.n304 VDD.t412 5.85973
R467 VDD.n4 VDD.t409 5.85973
R468 VDD.n359 VDD.t573 5.85973
R469 VDD.n359 VDD.t575 5.85973
R470 VDD.n179 VDD.t193 5.85973
R471 VDD.n180 VDD.t555 5.85973
R472 VDD.n138 VDD.t1096 5.85973
R473 VDD.n385 VDD.t26 5.85973
R474 VDD.n54 VDD.t1055 5.85973
R475 VDD.n54 VDD.t1052 5.85973
R476 VDD.n212 VDD.t795 5.85973
R477 VDD.n212 VDD.t791 5.85973
R478 VDD.n136 VDD.t378 5.85973
R479 VDD.n386 VDD.t190 5.85973
R480 VDD.n232 VDD.t24 5.85973
R481 VDD.n232 VDD.t20 5.85973
R482 VDD.n211 VDD.t299 5.85973
R483 VDD.n211 VDD.t296 5.85973
R484 VDD.n387 VDD.t293 5.85973
R485 VDD.n388 VDD.t463 5.85973
R486 VDD.n233 VDD.t134 5.85973
R487 VDD.n233 VDD.t131 5.85973
R488 VDD.n210 VDD.t361 5.85973
R489 VDD.n210 VDD.t358 5.85973
R490 VDD.n389 VDD.t635 5.85973
R491 VDD.n390 VDD.t1048 5.85973
R492 VDD.n234 VDD.t1094 5.85973
R493 VDD.n234 VDD.t1091 5.85973
R494 VDD.n85 VDD.t18 5.85973
R495 VDD.n85 VDD.t15 5.85973
R496 VDD.n195 VDD.t1045 5.85973
R497 VDD.n333 VDD.t1089 5.85973
R498 VDD.n333 VDD.t1086 5.85973
R499 VDD.n181 VDD.t1028 5.85973
R500 VDD.n182 VDD.t1510 5.85973
R501 VDD.n144 VDD.t1354 5.85973
R502 VDD.n380 VDD.t1717 5.85973
R503 VDD.n56 VDD.t1017 5.85973
R504 VDD.n56 VDD.t1013 5.85973
R505 VDD.n215 VDD.t1025 5.85973
R506 VDD.n215 VDD.t1022 5.85973
R507 VDD.n142 VDD.t1634 5.85973
R508 VDD.n381 VDD.t1923 5.85973
R509 VDD.n228 VDD.t601 5.85973
R510 VDD.n228 VDD.t598 5.85973
R511 VDD.n214 VDD.t728 5.85973
R512 VDD.n214 VDD.t725 5.85973
R513 VDD.n140 VDD.t1816 5.85973
R514 VDD.n382 VDD.t1433 5.85973
R515 VDD.n230 VDD.t1822 5.85973
R516 VDD.n230 VDD.t1819 5.85973
R517 VDD.n213 VDD.t1644 5.85973
R518 VDD.n213 VDD.t1643 5.85973
R519 VDD.n383 VDD.t775 5.85973
R520 VDD.n384 VDD.t1640 5.85973
R521 VDD.n231 VDD.t404 5.85973
R522 VDD.n231 VDD.t400 5.85973
R523 VDD.n313 VDD.t285 5.85973
R524 VDD.n313 VDD.t282 5.85973
R525 VDD.n3 VDD.t1571 5.85973
R526 VDD.n360 VDD.t1803 5.85973
R527 VDD.n360 VDD.t1805 5.85973
R528 VDD.n183 VDD.t926 5.85973
R529 VDD.n184 VDD.t845 5.85973
R530 VDD.n375 VDD.t539 5.85973
R531 VDD.n376 VDD.t1421 5.85973
R532 VDD.n58 VDD.t98 5.85973
R533 VDD.n58 VDD.t94 5.85973
R534 VDD.n218 VDD.t1914 5.85973
R535 VDD.n218 VDD.t1911 5.85973
R536 VDD.n148 VDD.t484 5.85973
R537 VDD.n377 VDD.t715 5.85973
R538 VDD.n223 VDD.t1327 5.85973
R539 VDD.n223 VDD.t1324 5.85973
R540 VDD.n217 VDD.t1969 5.85973
R541 VDD.n217 VDD.t1966 5.85973
R542 VDD.n146 VDD.t1665 5.85973
R543 VDD.n378 VDD.t1594 5.85973
R544 VDD.n225 VDD.t1651 5.85973
R545 VDD.n225 VDD.t1648 5.85973
R546 VDD.n216 VDD.t1391 5.85973
R547 VDD.n216 VDD.t1388 5.85973
R548 VDD.n157 VDD.t1477 5.85973
R549 VDD.n379 VDD.t870 5.85973
R550 VDD.n227 VDD.t328 5.85973
R551 VDD.n227 VDD.t325 5.85973
R552 VDD.n318 VDD.t490 5.85973
R553 VDD.n318 VDD.t487 5.85973
R554 VDD.n2 VDD.t1503 5.85973
R555 VDD.n361 VDD.t719 5.85973
R556 VDD.n361 VDD.t721 5.85973
R557 VDD.n185 VDD.t1507 5.85973
R558 VDD.n186 VDD.t1810 5.85973
R559 VDD.n371 VDD.t1351 5.85973
R560 VDD.n372 VDD.t881 5.85973
R561 VDD.n60 VDD.t1550 5.85973
R562 VDD.n60 VDD.t1547 5.85973
R563 VDD.n220 VDD.t116 5.85973
R564 VDD.n220 VDD.t113 5.85973
R565 VDD.n72 VDD.t1019 5.85973
R566 VDD.n71 VDD.t1129 5.85973
R567 VDD.n410 VDD.t1800 5.85973
R568 VDD.n14 VDD.t1797 5.85973
R569 VDD.n41 VDD.t1481 5.85973
R570 VDD.n363 VDD.t1603 5.85973
R571 VDD.n266 VDD.t1671 5.85973
R572 VDD.n169 VDD.t1441 5.85973
R573 VDD.n169 VDD.t1437 5.85973
R574 VDD.n219 VDD.t1735 5.85973
R575 VDD.n219 VDD.t1732 5.85973
R576 VDD.n373 VDD.t1499 5.85973
R577 VDD.n374 VDD.t1532 5.85973
R578 VDD.n222 VDD.t773 5.85973
R579 VDD.n222 VDD.t770 5.85973
R580 VDD.n323 VDD.t1600 5.85973
R581 VDD.n323 VDD.t1597 5.85973
R582 VDD.n1 VDD.t873 5.85973
R583 VDD.n362 VDD.t1319 5.85973
R584 VDD.n362 VDD.t1321 5.85973
R585 VDD.n187 VDD.t706 5.85973
R586 VDD.n188 VDD.t1705 5.85973
R587 VDD.n369 VDD.t960 5.85973
R588 VDD.n370 VDD.t1847 5.85973
R589 VDD.n62 VDD.t787 5.85973
R590 VDD.n62 VDD.t784 5.85973
R591 VDD.n221 VDD.t1854 5.85973
R592 VDD.n221 VDD.t1850 5.85973
R593 VDD.n153 VDD.t1876 5.85973
R594 VDD.n189 VDD.t1843 5.85973
R595 VDD.n189 VDD.t1840 5.85973
R596 VDD.n170 VDD.t1216 5.85973
R597 VDD.n84 VDD.t1213 5.85973
R598 VDD.n69 VDD.t781 5.85973
R599 VDD.n69 VDD.t778 5.85973
R600 VDD.n92 VDD.t176 5.85973
R601 VDD.n17 VDD.t1305 5.85973
R602 VDD.n192 VDD.t1200 5.85973
R603 VDD.n346 VDD.t1556 5.85973
R604 VDD.n345 VDD.t1864 5.85973
R605 VDD.n344 VDD.t1562 5.85973
R606 VDD.n39 VDD.t1553 5.85973
R607 VDD.n0 VDD.t985 5.85973
R608 VDD.n367 VDD.t143 5.85973
R609 VDD.n367 VDD.t140 5.85973
R610 VDD.n366 VDD.t1251 5.85973
R611 VDD.n366 VDD.t1248 5.85973
R612 VDD.n343 VDD.t1293 5.85973
R613 VDD.n23 VDD.t1245 5.85973
R614 VDD.n10 VDD.t1123 5.85973
R615 VDD.n365 VDD.t1042 5.85973
R616 VDD.n365 VDD.t1039 5.85973
R617 VDD.n364 VDD.t1037 5.85973
R618 VDD.n364 VDD.t1034 5.85973
R619 VDD.n342 VDD.t1147 5.85973
R620 VDD.n22 VDD.t1260 5.85973
R621 VDD.n341 VDD.t1134 5.85973
R622 VDD.n411 VDD.t1286 5.8595
R623 VDD.n411 VDD.t514 5.8595
R624 VDD.n28 VDD.t511 5.8595
R625 VDD.n29 VDD.t1712 5.8595
R626 VDD.n29 VDD.t863 5.8595
R627 VDD.n88 VDD.t861 5.8595
R628 VDD.n66 VDD.t1395 5.8595
R629 VDD.n66 VDD.t1772 5.8595
R630 VDD.n418 VDD.t1771 5.8595
R631 VDD.n27 VDD.t1475 5.8595
R632 VDD.n27 VDD.t880 5.8595
R633 VDD.n8 VDD.t877 5.8595
R634 VDD.n8 VDD.t1485 5.8595
R635 VDD.n8 VDD.t1522 5.8595
R636 VDD.n417 VDD.t1521 5.8595
R637 VDD.n424 VDD.t1431 5.8595
R638 VDD.n424 VDD.t1766 5.8595
R639 VDD.n78 VDD.t1765 5.8595
R640 VDD.n368 VDD.t1907 5.8595
R641 VDD.n368 VDD.t1919 5.8595
R642 VDD.n44 VDD.t1918 5.8595
R643 VDD.n422 VDD.t1961 5.8595
R644 VDD.n422 VDD.t1412 5.8595
R645 VDD.n412 VDD.t1410 5.8595
R646 VDD.n9 VDD.t1337 5.8595
R647 VDD.n9 VDD.t1827 5.8595
R648 VDD.n21 VDD.t1826 5.8595
R649 VDD.n197 VDD.t936 5.8595
R650 VDD.n197 VDD.t1728 5.8595
R651 VDD.n172 VDD.t1607 5.8595
R652 VDD.n118 VDD.t1964 5.8595
R653 VDD.n406 VDD.t1084 5.8595
R654 VDD.n293 VDD.t91 5.8595
R655 VDD.n293 VDD.t1366 5.8595
R656 VDD.n45 VDD.t1364 5.8595
R657 VDD.n45 VDD.t1576 5.8595
R658 VDD.n116 VDD.t1575 5.8595
R659 VDD.n407 VDD.t705 5.8595
R660 VDD.n292 VDD.t1784 5.8595
R661 VDD.n292 VDD.t460 5.8595
R662 VDD.n31 VDD.t457 5.8595
R663 VDD.n31 VDD.t1630 5.8595
R664 VDD.n114 VDD.t1629 5.8595
R665 VDD.n408 VDD.t449 5.8595
R666 VDD.n291 VDD.t445 5.8595
R667 VDD.n291 VDD.t921 5.8595
R668 VDD.n267 VDD.t920 5.8595
R669 VDD.n267 VDD.t978 5.8595
R670 VDD.n167 VDD.t977 5.8595
R671 VDD.n409 VDD.t1010 5.8595
R672 VDD.n290 VDD.t1470 5.8595
R673 VDD.n290 VDD.t916 5.8595
R674 VDD.n255 VDD.t914 5.8595
R675 VDD.n255 VDD.t1005 5.8595
R676 VDD.n288 VDD.t1004 5.8595
R677 VDD.n454 VDD.t84 5.8595
R678 VDD.n7 VDD.t89 5.8595
R679 VDD.n7 VDD.t911 5.8595
R680 VDD.n174 VDD.t759 5.8595
R681 VDD.n123 VDD.t263 5.8595
R682 VDD.n401 VDD.t260 5.8595
R683 VDD.n298 VDD.t81 5.8595
R684 VDD.n298 VDD.t835 5.8595
R685 VDD.n47 VDD.t834 5.8595
R686 VDD.n47 VDD.t1955 5.8595
R687 VDD.n121 VDD.t1952 5.8595
R688 VDD.n403 VDD.t1900 5.8595
R689 VDD.n297 VDD.t78 5.8595
R690 VDD.n297 VDD.t832 5.8595
R691 VDD.n32 VDD.t829 5.8595
R692 VDD.n32 VDD.t256 5.8595
R693 VDD.n120 VDD.t254 5.8595
R694 VDD.n404 VDD.t686 5.8595
R695 VDD.n296 VDD.t526 5.8595
R696 VDD.n296 VDD.t757 5.8595
R697 VDD.n268 VDD.t755 5.8595
R698 VDD.n268 VDD.t252 5.8595
R699 VDD.n165 VDD.t249 5.8595
R700 VDD.n405 VDD.t246 5.8595
R701 VDD.n295 VDD.t395 5.8595
R702 VDD.n295 VDD.t440 5.8595
R703 VDD.n256 VDD.t439 5.8595
R704 VDD.n256 VDD.t76 5.8595
R705 VDD.n287 VDD.t73 5.8595
R706 VDD.n427 VDD.t679 5.8595
R707 VDD.n6 VDD.t684 5.8595
R708 VDD.n6 VDD.t436 5.8595
R709 VDD.n176 VDD.t1127 5.8595
R710 VDD.n128 VDD.t1399 5.8595
R711 VDD.n396 VDD.t1378 5.8595
R712 VDD.n303 VDD.t1375 5.8595
R713 VDD.n303 VDD.t1373 5.8595
R714 VDD.n49 VDD.t1370 5.8595
R715 VDD.n49 VDD.t1359 5.8595
R716 VDD.n127 VDD.t1358 5.8595
R717 VDD.n397 VDD.t237 5.8595
R718 VDD.n302 VDD.t234 5.8595
R719 VDD.n302 VDD.t64 5.8595
R720 VDD.n33 VDD.t63 5.8595
R721 VDD.n33 VDD.t825 5.8595
R722 VDD.n125 VDD.t823 5.8595
R723 VDD.n398 VDD.t231 5.8595
R724 VDD.n301 VDD.t229 5.8595
R725 VDD.n301 VDD.t61 5.8595
R726 VDD.n269 VDD.t59 5.8595
R727 VDD.n269 VDD.t818 5.8595
R728 VDD.n163 VDD.t817 5.8595
R729 VDD.n400 VDD.t508 5.8595
R730 VDD.n300 VDD.t746 5.8595
R731 VDD.n300 VDD.t226 5.8595
R732 VDD.n258 VDD.t223 5.8595
R733 VDD.n258 VDD.t221 5.8595
R734 VDD.n286 VDD.t218 5.8595
R735 VDD.n446 VDD.t1974 5.8595
R736 VDD.n5 VDD.t1977 5.8595
R737 VDD.n5 VDD.t1949 5.8595
R738 VDD.n178 VDD.t588 5.8595
R739 VDD.n134 VDD.t656 5.8595
R740 VDD.n391 VDD.t367 5.8595
R741 VDD.n308 VDD.t347 5.8595
R742 VDD.n308 VDD.t198 5.8595
R743 VDD.n51 VDD.t197 5.8595
R744 VDD.n51 VDD.t37 5.8595
R745 VDD.n132 VDD.t34 5.8595
R746 VDD.n392 VDD.t585 5.8595
R747 VDD.n307 VDD.t653 5.8595
R748 VDD.n307 VDD.t1072 5.8595
R749 VDD.n35 VDD.t1071 5.8595
R750 VDD.n35 VDD.t1119 5.8595
R751 VDD.n130 VDD.t1118 5.8595
R752 VDD.n393 VDD.t801 5.8595
R753 VDD.n306 VDD.t1935 5.8595
R754 VDD.n306 VDD.t580 5.8595
R755 VDD.n271 VDD.t579 5.8595
R756 VDD.n271 VDD.t648 5.8595
R757 VDD.n162 VDD.t647 5.8595
R758 VDD.n394 VDD.t419 5.8595
R759 VDD.n305 VDD.t364 5.8595
R760 VDD.n305 VDD.t342 5.8595
R761 VDD.n259 VDD.t341 5.8595
R762 VDD.n259 VDD.t415 5.8595
R763 VDD.n285 VDD.t413 5.8595
R764 VDD.n444 VDD.t574 5.8595
R765 VDD.n4 VDD.t577 5.8595
R766 VDD.n4 VDD.t410 5.8595
R767 VDD.n180 VDD.t194 5.8595
R768 VDD.n139 VDD.t556 5.8595
R769 VDD.n385 VDD.t1097 5.8595
R770 VDD.n312 VDD.t28 5.8595
R771 VDD.n312 VDD.t1056 5.8595
R772 VDD.n53 VDD.t1053 5.8595
R773 VDD.n53 VDD.t794 5.8595
R774 VDD.n137 VDD.t792 5.8595
R775 VDD.n386 VDD.t379 5.8595
R776 VDD.n311 VDD.t191 5.8595
R777 VDD.n311 VDD.t23 5.8595
R778 VDD.n36 VDD.t21 5.8595
R779 VDD.n36 VDD.t298 5.8595
R780 VDD.n135 VDD.t297 5.8595
R781 VDD.n388 VDD.t295 5.8595
R782 VDD.n310 VDD.t465 5.8595
R783 VDD.n310 VDD.t135 5.8595
R784 VDD.n273 VDD.t132 5.8595
R785 VDD.n273 VDD.t362 5.8595
R786 VDD.n160 VDD.t359 5.8595
R787 VDD.n390 VDD.t637 5.8595
R788 VDD.n309 VDD.t1050 5.8595
R789 VDD.n309 VDD.t1095 5.8595
R790 VDD.n191 VDD.t1092 5.8595
R791 VDD.n191 VDD.t19 5.8595
R792 VDD.n25 VDD.t16 5.8595
R793 VDD.n196 VDD.t1046 5.8595
R794 VDD.n196 VDD.t1090 5.8595
R795 VDD.n182 VDD.t1029 5.8595
R796 VDD.n145 VDD.t1511 5.8595
R797 VDD.n380 VDD.t1355 5.8595
R798 VDD.n317 VDD.t1718 5.8595
R799 VDD.n317 VDD.t1016 5.8595
R800 VDD.n55 VDD.t1014 5.8595
R801 VDD.n55 VDD.t1024 5.8595
R802 VDD.n143 VDD.t1023 5.8595
R803 VDD.n381 VDD.t1635 5.8595
R804 VDD.n316 VDD.t1924 5.8595
R805 VDD.n316 VDD.t602 5.8595
R806 VDD.n37 VDD.t599 5.8595
R807 VDD.n37 VDD.t727 5.8595
R808 VDD.n141 VDD.t726 5.8595
R809 VDD.n382 VDD.t1817 5.8595
R810 VDD.n315 VDD.t1434 5.8595
R811 VDD.n315 VDD.t1821 5.8595
R812 VDD.n275 VDD.t1820 5.8595
R813 VDD.n275 VDD.t1647 5.8595
R814 VDD.n159 VDD.t1646 5.8595
R815 VDD.n384 VDD.t776 5.8595
R816 VDD.n314 VDD.t1641 5.8595
R817 VDD.n314 VDD.t403 5.8595
R818 VDD.n261 VDD.t401 5.8595
R819 VDD.n261 VDD.t286 5.8595
R820 VDD.n284 VDD.t284 5.8595
R821 VDD.n436 VDD.t1802 5.8595
R822 VDD.n3 VDD.t1807 5.8595
R823 VDD.n3 VDD.t1572 5.8595
R824 VDD.n184 VDD.t927 5.8595
R825 VDD.n150 VDD.t847 5.8595
R826 VDD.n376 VDD.t540 5.8595
R827 VDD.n322 VDD.t1422 5.8595
R828 VDD.n322 VDD.t97 5.8595
R829 VDD.n57 VDD.t95 5.8595
R830 VDD.n57 VDD.t1913 5.8595
R831 VDD.n149 VDD.t1912 5.8595
R832 VDD.n377 VDD.t485 5.8595
R833 VDD.n321 VDD.t716 5.8595
R834 VDD.n321 VDD.t1328 5.8595
R835 VDD.n38 VDD.t1326 5.8595
R836 VDD.n38 VDD.t1970 5.8595
R837 VDD.n147 VDD.t1967 5.8595
R838 VDD.n378 VDD.t1666 5.8595
R839 VDD.n320 VDD.t1595 5.8595
R840 VDD.n320 VDD.t1650 5.8595
R841 VDD.n276 VDD.t1649 5.8595
R842 VDD.n276 VDD.t1390 5.8595
R843 VDD.n158 VDD.t1389 5.8595
R844 VDD.n379 VDD.t1479 5.8595
R845 VDD.n319 VDD.t871 5.8595
R846 VDD.n319 VDD.t327 5.8595
R847 VDD.n262 VDD.t326 5.8595
R848 VDD.n262 VDD.t489 5.8595
R849 VDD.n283 VDD.t488 5.8595
R850 VDD.n429 VDD.t718 5.8595
R851 VDD.n2 VDD.t722 5.8595
R852 VDD.n2 VDD.t1504 5.8595
R853 VDD.n186 VDD.t1508 5.8595
R854 VDD.n152 VDD.t1811 5.8595
R855 VDD.n372 VDD.t1352 5.8595
R856 VDD.n325 VDD.t882 5.8595
R857 VDD.n325 VDD.t1549 5.8595
R858 VDD.n59 VDD.t1548 5.8595
R859 VDD.n59 VDD.t117 5.8595
R860 VDD.n151 VDD.t114 5.8595
R861 VDD.n71 VDD.t1020 5.8595
R862 VDD.n86 VDD.t1130 5.8595
R863 VDD.n86 VDD.t1801 5.8595
R864 VDD.n14 VDD.t1798 5.8595
R865 VDD.n41 VDD.t1483 5.8595
R866 VDD.n266 VDD.t1604 5.8595
R867 VDD.n64 VDD.t1672 5.8595
R868 VDD.n65 VDD.t1440 5.8595
R869 VDD.n279 VDD.t1438 5.8595
R870 VDD.n279 VDD.t1736 5.8595
R871 VDD.n156 VDD.t1734 5.8595
R872 VDD.n374 VDD.t1500 5.8595
R873 VDD.n324 VDD.t1533 5.8595
R874 VDD.n324 VDD.t774 5.8595
R875 VDD.n264 VDD.t771 5.8595
R876 VDD.n264 VDD.t1599 5.8595
R877 VDD.n282 VDD.t1598 5.8595
R878 VDD.n434 VDD.t1318 5.8595
R879 VDD.n1 VDD.t1323 5.8595
R880 VDD.n1 VDD.t874 5.8595
R881 VDD.n188 VDD.t707 5.8595
R882 VDD.n155 VDD.t1706 5.8595
R883 VDD.n370 VDD.t961 5.8595
R884 VDD.n326 VDD.t1848 5.8595
R885 VDD.n326 VDD.t786 5.8595
R886 VDD.n61 VDD.t785 5.8595
R887 VDD.n61 VDD.t1853 5.8595
R888 VDD.n154 VDD.t1851 5.8595
R889 VDD.n281 VDD.t1877 5.8595
R890 VDD.n281 VDD.t1842 5.8595
R891 VDD.n414 VDD.t1841 5.8595
R892 VDD.n81 VDD.t1215 5.8595
R893 VDD.n83 VDD.t1214 5.8595
R894 VDD.n280 VDD.t780 5.8595
R895 VDD.n80 VDD.t779 5.8595
R896 VDD.n91 VDD.t178 5.8595
R897 VDD.n17 VDD.t1306 5.8595
R898 VDD.n430 VDD.t1199 5.8595
R899 VDD.n338 VDD.t3 5.8595
R900 VDD.n421 VDD.t1557 5.8595
R901 VDD.n344 VDD.t1865 5.8595
R902 VDD.n42 VDD.t1563 5.8595
R903 VDD.n39 VDD.t1554 5.8595
R904 VDD.n0 VDD.t986 5.8595
R905 VDD.n0 VDD.t142 5.8595
R906 VDD.n420 VDD.t141 5.8595
R907 VDD.n90 VDD.t1250 5.8595
R908 VDD.n19 VDD.t1249 5.8595
R909 VDD.n23 VDD.t1294 5.8595
R910 VDD.n337 VDD.t1246 5.8595
R911 VDD.n168 VDD.t1124 5.8595
R912 VDD.n419 VDD.t1043 5.8595
R913 VDD.n339 VDD.t1040 5.8595
R914 VDD.n70 VDD.t1038 5.8595
R915 VDD.n336 VDD.t1035 5.8595
R916 VDD.n22 VDD.t1149 5.8595
R917 VDD.n330 VDD.t1262 5.8595
R918 VDD.n331 VDD.t1078 5.85929
R919 VDD.n332 VDD.t1079 5.85929
R920 VDD.n20 VDD.t1542 5.85929
R921 VDD.n20 VDD.t1544 5.85929
R922 VDD.n9 VDD.t1904 5.85929
R923 VDD.n9 VDD.t1814 5.85929
R924 VDD.n40 VDD.t1689 5.85929
R925 VDD.n40 VDD.t1690 5.85929
R926 VDD.n43 VDD.t1659 5.85929
R927 VDD.n43 VDD.t1661 5.85929
R928 VDD.n78 VDD.t989 5.85929
R929 VDD.n78 VDD.t1424 5.85929
R930 VDD.n350 VDD.t451 5.85929
R931 VDD.n350 VDD.t452 5.85929
R932 VDD.n351 VDD.t1753 5.85929
R933 VDD.n351 VDD.t1754 5.85929
R934 VDD.n8 VDD.t1568 5.85929
R935 VDD.n8 VDD.t955 5.85929
R936 VDD.n26 VDD.t695 5.85929
R937 VDD.n26 VDD.t696 5.85929
R938 VDD.n13 VDD.t1868 5.85929
R939 VDD.n13 VDD.t1870 5.85929
R940 VDD.n88 VDD.t355 5.85929
R941 VDD.n88 VDD.t1626 5.85929
R942 VDD.n355 VDD.t543 5.85929
R943 VDD.n355 VDD.t544 5.85929
R944 VDD.n254 VDD.t1536 5.85929
R945 VDD.n254 VDD.t1538 5.85929
R946 VDD.n347 VDD.t849 5.85929
R947 VDD.n356 VDD.t332 5.85929
R948 VDD.n356 VDD.t333 5.85929
R949 VDD.n288 VDD.t266 5.85929
R950 VDD.n288 VDD.t268 5.85929
R951 VDD.n255 VDD.t762 5.85929
R952 VDD.n250 VDD.t528 5.85929
R953 VDD.n290 VDD.t993 5.85929
R954 VDD.n290 VDD.t995 5.85929
R955 VDD.n167 VDD.t902 5.85929
R956 VDD.n167 VDD.t904 5.85929
R957 VDD.n267 VDD.t1383 5.85929
R958 VDD.n248 VDD.t1386 5.85929
R959 VDD.n291 VDD.t1331 5.85929
R960 VDD.n291 VDD.t1332 5.85929
R961 VDD.n114 VDD.t1340 5.85929
R962 VDD.n114 VDD.t1342 5.85929
R963 VDD.n31 VDD.t1346 5.85929
R964 VDD.n31 VDD.t1349 5.85929
R965 VDD.n292 VDD.t1453 5.85929
R966 VDD.n292 VDD.t1454 5.85929
R967 VDD.n116 VDD.t765 5.85929
R968 VDD.n116 VDD.t766 5.85929
R969 VDD.n45 VDD.t531 5.85929
R970 VDD.n46 VDD.t689 5.85929
R971 VDD.n293 VDD.t1459 5.85929
R972 VDD.n293 VDD.t1461 5.85929
R973 VDD.n118 VDD.t998 5.85929
R974 VDD.n118 VDD.t1000 5.85929
R975 VDD.n171 VDD.t908 5.85929
R976 VDD.n357 VDD.t467 5.85929
R977 VDD.n357 VDD.t468 5.85929
R978 VDD.n287 VDD.t1890 5.85929
R979 VDD.n287 VDD.t1892 5.85929
R980 VDD.n256 VDD.t70 5.85929
R981 VDD.n246 VDD.t1444 5.85929
R982 VDD.n295 VDD.t516 5.85929
R983 VDD.n295 VDD.t518 5.85929
R984 VDD.n165 VDD.t671 5.85929
R985 VDD.n165 VDD.t672 5.85929
R986 VDD.n268 VDD.t421 5.85929
R987 VDD.n244 VDD.t424 5.85929
R988 VDD.n296 VDD.t427 5.85929
R989 VDD.n296 VDD.t429 5.85929
R990 VDD.n120 VDD.t385 5.85929
R991 VDD.n120 VDD.t383 5.85929
R992 VDD.n32 VDD.t240 5.85929
R993 VDD.n32 VDD.t243 5.85929
R994 VDD.n297 VDD.t1447 5.85929
R995 VDD.n297 VDD.t1449 5.85929
R996 VDD.n121 VDD.t748 5.85929
R997 VDD.n121 VDD.t750 5.85929
R998 VDD.n47 VDD.t522 5.85929
R999 VDD.n48 VDD.t677 5.85929
R1000 VDD.n298 VDD.t318 5.85929
R1001 VDD.n298 VDD.t320 5.85929
R1002 VDD.n123 VDD.t474 5.85929
R1003 VDD.n123 VDD.t475 5.85929
R1004 VDD.n173 VDD.t1896 5.85929
R1005 VDD.n358 VDD.t41 5.85929
R1006 VDD.n358 VDD.t43 5.85929
R1007 VDD.n286 VDD.t203 5.85929
R1008 VDD.n286 VDD.t205 5.85929
R1009 VDD.n258 VDD.t662 5.85929
R1010 VDD.n257 VDD.t594 5.85929
R1011 VDD.n300 VDD.t1938 5.85929
R1012 VDD.n300 VDD.t1939 5.85929
R1013 VDD.n163 VDD.t804 5.85929
R1014 VDD.n163 VDD.t805 5.85929
R1015 VDD.n269 VDD.t47 5.85929
R1016 VDD.n240 VDD.t209 5.85929
R1017 VDD.n301 VDD.t349 5.85929
R1018 VDD.n301 VDD.t351 5.85929
R1019 VDD.n125 VDD.t49 5.85929
R1020 VDD.n125 VDD.t51 5.85929
R1021 VDD.n33 VDD.t212 5.85929
R1022 VDD.n33 VDD.t735 5.85929
R1023 VDD.n302 VDD.t738 5.85929
R1024 VDD.n302 VDD.t740 5.85929
R1025 VDD.n127 VDD.t502 5.85929
R1026 VDD.n127 VDD.t504 5.85929
R1027 VDD.n49 VDD.t668 5.85929
R1028 VDD.n50 VDD.t137 5.85929
R1029 VDD.n303 VDD.t1943 5.85929
R1030 VDD.n303 VDD.t1944 5.85929
R1031 VDD.n128 VDD.t810 5.85929
R1032 VDD.n128 VDD.t812 5.85929
R1033 VDD.n175 VDD.t215 5.85929
R1034 VDD.n359 VDD.t306 5.85929
R1035 VDD.n359 VDD.t308 5.85929
R1036 VDD.n285 VDD.t150 5.85929
R1037 VDD.n285 VDD.t152 5.85929
R1038 VDD.n259 VDD.t798 5.85929
R1039 VDD.n237 VDD.t31 5.85929
R1040 VDD.n305 VDD.t1102 5.85929
R1041 VDD.n305 VDD.t1104 5.85929
R1042 VDD.n162 VDD.t1057 5.85929
R1043 VDD.n162 VDD.t1059 5.85929
R1044 VDD.n271 VDD.t638 5.85929
R1045 VDD.n235 VDD.t559 5.85929
R1046 VDD.n306 VDD.t155 5.85929
R1047 VDD.n306 VDD.t157 5.85929
R1048 VDD.n130 VDD.t1926 5.85929
R1049 VDD.n130 VDD.t1928 5.85929
R1050 VDD.n35 VDD.t1108 5.85929
R1051 VDD.n35 VDD.t1064 5.85929
R1052 VDD.n307 VDD.t641 5.85929
R1053 VDD.n307 VDD.t643 5.85929
R1054 VDD.n132 VDD.t561 5.85929
R1055 VDD.n132 VDD.t562 5.85929
R1056 VDD.n51 VDD.t407 5.85929
R1057 VDD.n52 VDD.t1932 5.85929
R1058 VDD.n308 VDD.t567 5.85929
R1059 VDD.n308 VDD.t569 5.85929
R1060 VDD.n134 VDD.t1111 5.85929
R1061 VDD.n134 VDD.t1113 5.85929
R1062 VDD.n177 VDD.t1067 5.85929
R1063 VDD.n333 VDD.t897 5.85929
R1064 VDD.n334 VDD.t899 5.85929
R1065 VDD.n25 VDD.t971 5.85929
R1066 VDD.n25 VDD.t972 5.85929
R1067 VDD.n191 VDD.t1669 5.85929
R1068 VDD.n190 VDD.t338 5.85929
R1069 VDD.n309 VDD.t10 5.85929
R1070 VDD.n309 VDD.t11 5.85929
R1071 VDD.n160 VDD.t182 5.85929
R1072 VDD.n160 VDD.t184 5.85929
R1073 VDD.n273 VDD.t732 5.85929
R1074 VDD.n272 VDD.t493 5.85929
R1075 VDD.n310 VDD.t496 5.85929
R1076 VDD.n310 VDD.t497 5.85929
R1077 VDD.n135 VDD.t625 5.85929
R1078 VDD.n135 VDD.t626 5.85929
R1079 VDD.n36 VDD.t858 5.85929
R1080 VDD.n36 VDD.t867 5.85929
R1081 VDD.n311 VDD.t885 5.85929
R1082 VDD.n311 VDD.t886 5.85929
R1083 VDD.n137 VDD.t891 5.85929
R1084 VDD.n137 VDD.t893 5.85929
R1085 VDD.n53 VDD.t188 5.85929
R1086 VDD.n54 VDD.t125 5.85929
R1087 VDD.n312 VDD.t630 5.85929
R1088 VDD.n312 VDD.t632 5.85929
R1089 VDD.n139 VDD.t550 5.85929
R1090 VDD.n139 VDD.t552 5.85929
R1091 VDD.n179 VDD.t128 5.85929
R1092 VDD.n360 VDD.t965 5.85929
R1093 VDD.n360 VDD.t967 5.85929
R1094 VDD.n284 VDD.t1858 5.85929
R1095 VDD.n284 VDD.t1860 5.85929
R1096 VDD.n261 VDD.t1655 5.85929
R1097 VDD.n260 VDD.t701 5.85929
R1098 VDD.n314 VDD.t1589 5.85929
R1099 VDD.n314 VDD.t1591 5.85929
R1100 VDD.n159 VDD.t1582 5.85929
R1101 VDD.n159 VDD.t1584 5.85929
R1102 VDD.n275 VDD.t1381 5.85929
R1103 VDD.n229 VDD.t1738 5.85929
R1104 VDD.n315 VDD.t1621 5.85929
R1105 VDD.n315 VDD.t1622 5.85929
R1106 VDD.n141 VDD.t1493 5.85929
R1107 VDD.n141 VDD.t1495 5.85929
R1108 VDD.n37 VDD.t939 5.85929
R1109 VDD.n37 VDD.t944 5.85929
R1110 VDD.n316 VDD.t852 5.85929
R1111 VDD.n316 VDD.t853 5.85929
R1112 VDD.n143 VDD.t1527 5.85929
R1113 VDD.n143 VDD.t1528 5.85929
R1114 VDD.n55 VDD.t1402 5.85929
R1115 VDD.n56 VDD.t952 5.85929
R1116 VDD.n317 VDD.t1741 5.85929
R1117 VDD.n317 VDD.t1742 5.85929
R1118 VDD.n145 VDD.t1791 5.85929
R1119 VDD.n145 VDD.t1793 5.85929
R1120 VDD.n181 VDD.t323 5.85929
R1121 VDD.n361 VDD.t1515 5.85929
R1122 VDD.n361 VDD.t1516 5.85929
R1123 VDD.n283 VDD.t1404 5.85929
R1124 VDD.n283 VDD.t1405 5.85929
R1125 VDD.n262 VDD.t278 5.85929
R1126 VDD.n226 VDD.t1838 5.85929
R1127 VDD.n319 VDD.t1880 5.85929
R1128 VDD.n319 VDD.t1882 5.85929
R1129 VDD.n158 VDD.t1721 5.85929
R1130 VDD.n158 VDD.t1722 5.85929
R1131 VDD.n276 VDD.t1675 5.85929
R1132 VDD.n224 VDD.t1316 5.85929
R1133 VDD.n320 VDD.t108 5.85929
R1134 VDD.n320 VDD.t109 5.85929
R1135 VDD.n147 VDD.t272 5.85929
R1136 VDD.n147 VDD.t274 5.85929
R1137 VDD.n38 VDD.t1419 5.85929
R1138 VDD.n38 VDD.t1416 5.85929
R1139 VDD.n321 VDD.t1759 5.85929
R1140 VDD.n321 VDD.t1760 5.85929
R1141 VDD.n149 VDD.t534 5.85929
R1142 VDD.n149 VDD.t536 5.85929
R1143 VDD.n57 VDD.t1958 5.85929
R1144 VDD.n58 VDD.t692 5.85929
R1145 VDD.n322 VDD.t1747 5.85929
R1146 VDD.n322 VDD.t1749 5.85929
R1147 VDD.n150 VDD.t840 5.85929
R1148 VDD.n150 VDD.t841 5.85929
R1149 VDD.n183 VDD.t1428 5.85929
R1150 VDD.n362 VDD.t1151 5.85929
R1151 VDD.n362 VDD.t1153 5.85929
R1152 VDD.n282 VDD.t1777 5.85929
R1153 VDD.n282 VDD.t1778 5.85929
R1154 VDD.n264 VDD.t1283 5.85929
R1155 VDD.n263 VDD.t1715 5.85929
R1156 VDD.n324 VDD.t1699 5.85929
R1157 VDD.n324 VDD.t1701 5.85929
R1158 VDD.n156 VDD.t102 5.85929
R1159 VDD.n156 VDD.t104 5.85929
R1160 VDD.n279 VDD.t173 5.85929
R1161 VDD.n278 VDD.t1256 5.85929
R1162 VDD.n363 VDD.t398 5.85929
R1163 VDD.n41 VDD.t1618 5.85929
R1164 VDD.n14 VDD.t1833 5.85929
R1165 VDD.n86 VDD.t710 5.85929
R1166 VDD.n86 VDD.t711 5.85929
R1167 VDD.n151 VDD.t929 5.85929
R1168 VDD.n151 VDD.t930 5.85929
R1169 VDD.n59 VDD.t983 5.85929
R1170 VDD.n60 VDD.t1874 5.85929
R1171 VDD.n325 VDD.t1611 5.85929
R1172 VDD.n325 VDD.t1612 5.85929
R1173 VDD.n152 VDD.t1678 5.85929
R1174 VDD.n152 VDD.t1679 5.85929
R1175 VDD.n185 VDD.t1638 5.85929
R1176 VDD.n192 VDD.t303 5.85929
R1177 VDD.n91 VDD.t391 5.85929
R1178 VDD.n92 VDD.t433 5.85929
R1179 VDD.n280 VDD.t1182 5.85929
R1180 VDD.n170 VDD.t1229 5.85929
R1181 VDD.n76 VDD.t1239 5.85929
R1182 VDD.n189 VDD.t1296 5.85929
R1183 VDD.n189 VDD.t1297 5.85929
R1184 VDD.n154 VDD.t606 5.85929
R1185 VDD.n154 VDD.t608 5.85929
R1186 VDD.n61 VDD.t55 5.85929
R1187 VDD.n62 VDD.t1981 5.85929
R1188 VDD.n326 VDD.t312 5.85929
R1189 VDD.n326 VDD.t313 5.85929
R1190 VDD.n155 VDD.t1267 5.85929
R1191 VDD.n155 VDD.t1269 5.85929
R1192 VDD.n187 VDD.t165 5.85929
R1193 VDD.n327 VDD.t1077 5.85906
R1194 VDD.n197 VDD.t1080 5.85906
R1195 VDD.n197 VDD.t1541 5.85906
R1196 VDD.n24 VDD.t1546 5.85906
R1197 VDD.n24 VDD.t1903 5.85906
R1198 VDD.n9 VDD.t1813 5.85906
R1199 VDD.n412 VDD.t1688 5.85906
R1200 VDD.n44 VDD.t1691 5.85906
R1201 VDD.n44 VDD.t1658 5.85906
R1202 VDD.n423 VDD.t1662 5.85906
R1203 VDD.n423 VDD.t988 5.85906
R1204 VDD.n78 VDD.t1425 5.85906
R1205 VDD.n413 VDD.t450 5.85906
R1206 VDD.n416 VDD.t453 5.85906
R1207 VDD.n416 VDD.t1752 5.85906
R1208 VDD.n340 VDD.t1755 5.85906
R1209 VDD.n340 VDD.t1567 5.85906
R1210 VDD.n8 VDD.t954 5.85906
R1211 VDD.n353 VDD.t694 5.85906
R1212 VDD.n27 VDD.t697 5.85906
R1213 VDD.n27 VDD.t1867 5.85906
R1214 VDD.n66 VDD.t1872 5.85906
R1215 VDD.n66 VDD.t356 5.85906
R1216 VDD.n88 VDD.t1627 5.85906
R1217 VDD.n415 VDD.t542 5.85906
R1218 VDD.n28 VDD.t545 5.85906
R1219 VDD.n28 VDD.t1535 5.85906
R1220 VDD.n411 VDD.t1539 5.85906
R1221 VDD.n411 VDD.t848 5.85906
R1222 VDD.n454 VDD.t331 5.85906
R1223 VDD.n7 VDD.t334 5.85906
R1224 VDD.n7 VDD.t265 5.85906
R1225 VDD.n289 VDD.t270 5.85906
R1226 VDD.n289 VDD.t761 5.85906
R1227 VDD.n255 VDD.t527 5.85906
R1228 VDD.n251 VDD.t994 5.85906
R1229 VDD.n409 VDD.t997 5.85906
R1230 VDD.n409 VDD.t903 5.85906
R1231 VDD.n198 VDD.t906 5.85906
R1232 VDD.n198 VDD.t1384 5.85906
R1233 VDD.n267 VDD.t1385 5.85906
R1234 VDD.n249 VDD.t1330 5.85906
R1235 VDD.n408 VDD.t1333 5.85906
R1236 VDD.n408 VDD.t1339 5.85906
R1237 VDD.n199 VDD.t1343 5.85906
R1238 VDD.n199 VDD.t1345 5.85906
R1239 VDD.n31 VDD.t1348 5.85906
R1240 VDD.n30 VDD.t1452 5.85906
R1241 VDD.n407 VDD.t1455 5.85906
R1242 VDD.n407 VDD.t764 5.85906
R1243 VDD.n200 VDD.t767 5.85906
R1244 VDD.n200 VDD.t530 5.85906
R1245 VDD.n45 VDD.t688 5.85906
R1246 VDD.n46 VDD.t1458 5.85906
R1247 VDD.n406 VDD.t1463 5.85906
R1248 VDD.n406 VDD.t999 5.85906
R1249 VDD.n172 VDD.t1002 5.85906
R1250 VDD.n172 VDD.t907 5.85906
R1251 VDD.n427 VDD.t466 5.85906
R1252 VDD.n6 VDD.t469 5.85906
R1253 VDD.n6 VDD.t1889 5.85906
R1254 VDD.n294 VDD.t1894 5.85906
R1255 VDD.n294 VDD.t69 5.85906
R1256 VDD.n256 VDD.t1443 5.85906
R1257 VDD.n247 VDD.t515 5.85906
R1258 VDD.n405 VDD.t520 5.85906
R1259 VDD.n405 VDD.t670 5.85906
R1260 VDD.n201 VDD.t673 5.85906
R1261 VDD.n201 VDD.t422 5.85906
R1262 VDD.n268 VDD.t423 5.85906
R1263 VDD.n245 VDD.t426 5.85906
R1264 VDD.n404 VDD.t431 5.85906
R1265 VDD.n404 VDD.t384 5.85906
R1266 VDD.n202 VDD.t388 5.85906
R1267 VDD.n202 VDD.t239 5.85906
R1268 VDD.n32 VDD.t242 5.85906
R1269 VDD.n243 VDD.t1446 5.85906
R1270 VDD.n403 VDD.t1451 5.85906
R1271 VDD.n403 VDD.t749 5.85906
R1272 VDD.n203 VDD.t752 5.85906
R1273 VDD.n203 VDD.t521 5.85906
R1274 VDD.n47 VDD.t676 5.85906
R1275 VDD.n48 VDD.t317 5.85906
R1276 VDD.n401 VDD.t322 5.85906
R1277 VDD.n401 VDD.t473 5.85906
R1278 VDD.n174 VDD.t476 5.85906
R1279 VDD.n174 VDD.t1895 5.85906
R1280 VDD.n446 VDD.t40 5.85906
R1281 VDD.n5 VDD.t45 5.85906
R1282 VDD.n5 VDD.t202 5.85906
R1283 VDD.n299 VDD.t207 5.85906
R1284 VDD.n299 VDD.t661 5.85906
R1285 VDD.n258 VDD.t593 5.85906
R1286 VDD.n242 VDD.t1937 5.85906
R1287 VDD.n400 VDD.t1940 5.85906
R1288 VDD.n400 VDD.t803 5.85906
R1289 VDD.n204 VDD.t806 5.85906
R1290 VDD.n204 VDD.t46 5.85906
R1291 VDD.n269 VDD.t208 5.85906
R1292 VDD.n241 VDD.t350 5.85906
R1293 VDD.n398 VDD.t353 5.85906
R1294 VDD.n398 VDD.t50 5.85906
R1295 VDD.n205 VDD.t53 5.85906
R1296 VDD.n205 VDD.t211 5.85906
R1297 VDD.n33 VDD.t734 5.85906
R1298 VDD.n239 VDD.t737 5.85906
R1299 VDD.n397 VDD.t742 5.85906
R1300 VDD.n397 VDD.t501 5.85906
R1301 VDD.n206 VDD.t505 5.85906
R1302 VDD.n206 VDD.t667 5.85906
R1303 VDD.n49 VDD.t138 5.85906
R1304 VDD.n50 VDD.t1945 5.85906
R1305 VDD.n396 VDD.t1947 5.85906
R1306 VDD.n396 VDD.t809 5.85906
R1307 VDD.n176 VDD.t814 5.85906
R1308 VDD.n176 VDD.t214 5.85906
R1309 VDD.n444 VDD.t305 5.85906
R1310 VDD.n4 VDD.t309 5.85906
R1311 VDD.n4 VDD.t151 5.85906
R1312 VDD.n304 VDD.t154 5.85906
R1313 VDD.n304 VDD.t797 5.85906
R1314 VDD.n259 VDD.t30 5.85906
R1315 VDD.n238 VDD.t1101 5.85906
R1316 VDD.n394 VDD.t1106 5.85906
R1317 VDD.n394 VDD.t1058 5.85906
R1318 VDD.n207 VDD.t1061 5.85906
R1319 VDD.n207 VDD.t639 5.85906
R1320 VDD.n271 VDD.t558 5.85906
R1321 VDD.n236 VDD.t156 5.85906
R1322 VDD.n393 VDD.t159 5.85906
R1323 VDD.n393 VDD.t1927 5.85906
R1324 VDD.n208 VDD.t1930 5.85906
R1325 VDD.n208 VDD.t1107 5.85906
R1326 VDD.n35 VDD.t1063 5.85906
R1327 VDD.n34 VDD.t640 5.85906
R1328 VDD.n392 VDD.t645 5.85906
R1329 VDD.n392 VDD.t563 5.85906
R1330 VDD.n209 VDD.t565 5.85906
R1331 VDD.n209 VDD.t406 5.85906
R1332 VDD.n51 VDD.t1931 5.85906
R1333 VDD.n52 VDD.t566 5.85906
R1334 VDD.n391 VDD.t571 5.85906
R1335 VDD.n391 VDD.t1110 5.85906
R1336 VDD.n178 VDD.t1115 5.85906
R1337 VDD.n178 VDD.t1066 5.85906
R1338 VDD.n328 VDD.t896 5.85906
R1339 VDD.n196 VDD.t901 5.85906
R1340 VDD.n196 VDD.t970 5.85906
R1341 VDD.n85 VDD.t973 5.85906
R1342 VDD.n85 VDD.t1668 5.85906
R1343 VDD.n191 VDD.t337 5.85906
R1344 VDD.n234 VDD.t9 5.85906
R1345 VDD.n390 VDD.t12 5.85906
R1346 VDD.n390 VDD.t181 5.85906
R1347 VDD.n210 VDD.t185 5.85906
R1348 VDD.n210 VDD.t731 5.85906
R1349 VDD.n273 VDD.t494 5.85906
R1350 VDD.n233 VDD.t495 5.85906
R1351 VDD.n388 VDD.t498 5.85906
R1352 VDD.n388 VDD.t624 5.85906
R1353 VDD.n211 VDD.t627 5.85906
R1354 VDD.n211 VDD.t857 5.85906
R1355 VDD.n36 VDD.t866 5.85906
R1356 VDD.n232 VDD.t884 5.85906
R1357 VDD.n386 VDD.t887 5.85906
R1358 VDD.n386 VDD.t890 5.85906
R1359 VDD.n212 VDD.t895 5.85906
R1360 VDD.n212 VDD.t187 5.85906
R1361 VDD.n53 VDD.t124 5.85906
R1362 VDD.n54 VDD.t631 5.85906
R1363 VDD.n385 VDD.t634 5.85906
R1364 VDD.n385 VDD.t549 5.85906
R1365 VDD.n180 VDD.t554 5.85906
R1366 VDD.n180 VDD.t127 5.85906
R1367 VDD.n436 VDD.t964 5.85906
R1368 VDD.n3 VDD.t969 5.85906
R1369 VDD.n3 VDD.t1857 5.85906
R1370 VDD.n313 VDD.t1862 5.85906
R1371 VDD.n313 VDD.t1654 5.85906
R1372 VDD.n261 VDD.t700 5.85906
R1373 VDD.n231 VDD.t1588 5.85906
R1374 VDD.n384 VDD.t1593 5.85906
R1375 VDD.n384 VDD.t1581 5.85906
R1376 VDD.n213 VDD.t1586 5.85906
R1377 VDD.n213 VDD.t1380 5.85906
R1378 VDD.n275 VDD.t1737 5.85906
R1379 VDD.n230 VDD.t1620 5.85906
R1380 VDD.n382 VDD.t1623 5.85906
R1381 VDD.n382 VDD.t1492 5.85906
R1382 VDD.n214 VDD.t1496 5.85906
R1383 VDD.n214 VDD.t938 5.85906
R1384 VDD.n37 VDD.t943 5.85906
R1385 VDD.n228 VDD.t851 5.85906
R1386 VDD.n381 VDD.t854 5.85906
R1387 VDD.n381 VDD.t1526 5.85906
R1388 VDD.n215 VDD.t1529 5.85906
R1389 VDD.n215 VDD.t1401 5.85906
R1390 VDD.n55 VDD.t951 5.85906
R1391 VDD.n56 VDD.t1740 5.85906
R1392 VDD.n380 VDD.t1743 5.85906
R1393 VDD.n380 VDD.t1790 5.85906
R1394 VDD.n182 VDD.t1795 5.85906
R1395 VDD.n182 VDD.t324 5.85906
R1396 VDD.n429 VDD.t1514 5.85906
R1397 VDD.n2 VDD.t1517 5.85906
R1398 VDD.n2 VDD.t1406 5.85906
R1399 VDD.n318 VDD.t1408 5.85906
R1400 VDD.n318 VDD.t277 5.85906
R1401 VDD.n262 VDD.t1837 5.85906
R1402 VDD.n227 VDD.t1879 5.85906
R1403 VDD.n379 VDD.t1884 5.85906
R1404 VDD.n379 VDD.t1720 5.85906
R1405 VDD.n216 VDD.t1723 5.85906
R1406 VDD.n216 VDD.t1674 5.85906
R1407 VDD.n276 VDD.t1315 5.85906
R1408 VDD.n225 VDD.t107 5.85906
R1409 VDD.n378 VDD.t110 5.85906
R1410 VDD.n378 VDD.t271 5.85906
R1411 VDD.n217 VDD.t275 5.85906
R1412 VDD.n217 VDD.t1418 5.85906
R1413 VDD.n38 VDD.t1415 5.85906
R1414 VDD.n223 VDD.t1758 5.85906
R1415 VDD.n377 VDD.t1761 5.85906
R1416 VDD.n377 VDD.t533 5.85906
R1417 VDD.n218 VDD.t538 5.85906
R1418 VDD.n218 VDD.t1957 5.85906
R1419 VDD.n57 VDD.t691 5.85906
R1420 VDD.n58 VDD.t1746 5.85906
R1421 VDD.n376 VDD.t1751 5.85906
R1422 VDD.n376 VDD.t839 5.85906
R1423 VDD.n184 VDD.t842 5.85906
R1424 VDD.n184 VDD.t1427 5.85906
R1425 VDD.n434 VDD.t1150 5.85906
R1426 VDD.n1 VDD.t1155 5.85906
R1427 VDD.n1 VDD.t1776 5.85906
R1428 VDD.n323 VDD.t1779 5.85906
R1429 VDD.n323 VDD.t1282 5.85906
R1430 VDD.n264 VDD.t1714 5.85906
R1431 VDD.n222 VDD.t1698 5.85906
R1432 VDD.n374 VDD.t1703 5.85906
R1433 VDD.n374 VDD.t101 5.85906
R1434 VDD.n219 VDD.t106 5.85906
R1435 VDD.n219 VDD.t172 5.85906
R1436 VDD.n279 VDD.t1255 5.85906
R1437 VDD.n64 VDD.t397 5.85906
R1438 VDD.n363 VDD.t1617 5.85906
R1439 VDD.n14 VDD.t1832 5.85906
R1440 VDD.n410 VDD.t709 5.85906
R1441 VDD.n72 VDD.t712 5.85906
R1442 VDD.n72 VDD.t931 5.85906
R1443 VDD.n220 VDD.t933 5.85906
R1444 VDD.n220 VDD.t982 5.85906
R1445 VDD.n59 VDD.t1873 5.85906
R1446 VDD.n60 VDD.t1610 5.85906
R1447 VDD.n372 VDD.t1613 5.85906
R1448 VDD.n372 VDD.t1677 5.85906
R1449 VDD.n186 VDD.t1680 5.85906
R1450 VDD.n186 VDD.t1637 5.85906
R1451 VDD.n430 VDD.t302 5.85906
R1452 VDD.n17 VDD.t390 5.85906
R1453 VDD.n91 VDD.t432 5.85906
R1454 VDD.n69 VDD.t1181 5.85906
R1455 VDD.n84 VDD.t1228 5.85906
R1456 VDD.n63 VDD.t1238 5.85906
R1457 VDD.n414 VDD.t1298 5.85906
R1458 VDD.n281 VDD.t1300 5.85906
R1459 VDD.n281 VDD.t605 5.85906
R1460 VDD.n221 VDD.t610 5.85906
R1461 VDD.n221 VDD.t54 5.85906
R1462 VDD.n61 VDD.t1980 5.85906
R1463 VDD.n62 VDD.t311 5.85906
R1464 VDD.n370 VDD.t314 5.85906
R1465 VDD.n370 VDD.t1266 5.85906
R1466 VDD.n188 VDD.t1271 5.85906
R1467 VDD.n188 VDD.t164 5.85906
R1468 VDD.n194 VDD.t290 5.85824
R1469 VDD.n12 VDD.t377 5.85824
R1470 VDD.n80 VDD.t1185 5.85746
R1471 VDD.n80 VDD.t1187 5.85746
R1472 VDD.n80 VDD.t1189 5.85746
R1473 VDD.n80 VDD.t1191 5.85746
R1474 VDD.n69 VDD.t1193 5.85746
R1475 VDD.n83 VDD.t1166 5.85746
R1476 VDD.n84 VDD.t1167 5.85746
R1477 VDD.n84 VDD.t1169 5.85746
R1478 VDD.n84 VDD.t1171 5.85746
R1479 VDD.n84 VDD.t1173 5.85746
R1480 VDD.n81 VDD.t1157 5.85746
R1481 VDD.n81 VDD.t1158 5.85746
R1482 VDD.n82 VDD.t1160 5.85746
R1483 VDD.n82 VDD.t1162 5.85746
R1484 VDD.n82 VDD.t1164 5.85746
R1485 VDD.n15 VDD.t1176 5.74893
R1486 VDD.n80 VDD.t170 5.74893
R1487 VDD.n16 VDD.t139 5.74893
R1488 VDD.n39 VDD.n0 2.85706
R1489 VDD.n412 VDD.n9 2.47886
R1490 VDD.n0 VDD.n367 2.39816
R1491 VDD.n90 VDD.n366 2.39816
R1492 VDD.n419 VDD.n365 2.39816
R1493 VDD.n70 VDD.n364 2.39816
R1494 VDD.n28 VDD.n254 2.39816
R1495 VDD.n281 VDD.n189 2.39816
R1496 VDD.n412 VDD.n40 2.39816
R1497 VDD.n66 VDD.n13 2.39816
R1498 VDD.n18 VDD.n14 2.35123
R1499 VDD.n222 VDD.n324 2.22284
R1500 VDD.n321 VDD.n223 2.22284
R1501 VDD.n320 VDD.n225 2.22284
R1502 VDD.n319 VDD.n227 2.22284
R1503 VDD.n316 VDD.n228 2.22284
R1504 VDD.n315 VDD.n230 2.22284
R1505 VDD.n231 VDD.n314 2.22284
R1506 VDD.n311 VDD.n232 2.22284
R1507 VDD.n233 VDD.n310 2.22284
R1508 VDD.n234 VDD.n309 2.22284
R1509 VDD.n307 VDD.n34 2.22284
R1510 VDD.n306 VDD.n236 2.22284
R1511 VDD.n305 VDD.n238 2.22284
R1512 VDD.n302 VDD.n239 2.22284
R1513 VDD.n301 VDD.n241 2.22284
R1514 VDD.n242 VDD.n300 2.22284
R1515 VDD.n243 VDD.n297 2.22284
R1516 VDD.n296 VDD.n245 2.22284
R1517 VDD.n295 VDD.n247 2.22284
R1518 VDD.n292 VDD.n30 2.22284
R1519 VDD.n291 VDD.n249 2.22284
R1520 VDD.n290 VDD.n251 2.22284
R1521 VDD.n221 VDD.n154 2.22284
R1522 VDD.n220 VDD.n151 2.22284
R1523 VDD.n156 VDD.n219 2.22284
R1524 VDD.n218 VDD.n149 2.22284
R1525 VDD.n216 VDD.n158 2.22284
R1526 VDD.n215 VDD.n143 2.22284
R1527 VDD.n213 VDD.n159 2.22284
R1528 VDD.n212 VDD.n137 2.22284
R1529 VDD.n160 VDD.n210 2.22284
R1530 VDD.n209 VDD.n132 2.22284
R1531 VDD.n207 VDD.n162 2.22284
R1532 VDD.n206 VDD.n127 2.22284
R1533 VDD.n204 VDD.n163 2.22284
R1534 VDD.n203 VDD.n121 2.22284
R1535 VDD.n201 VDD.n165 2.22284
R1536 VDD.n200 VDD.n116 2.22284
R1537 VDD.n198 VDD.n167 2.22284
R1538 VDD.n25 VDD.n85 2.22284
R1539 VDD.n20 VDD.n24 2.22284
R1540 VDD.n323 VDD.n264 2.13519
R1541 VDD.n262 VDD.n318 2.13519
R1542 VDD.n313 VDD.n261 2.13519
R1543 VDD.n259 VDD.n304 2.13519
R1544 VDD.n299 VDD.n258 2.13519
R1545 VDD.n256 VDD.n294 2.13519
R1546 VDD.n255 VDD.n289 2.13519
R1547 VDD.n71 VDD.n86 2.13519
R1548 VDD.n11 VDD.n10 2.11628
R1549 VDD.n63 VDD.n15 2.10888
R1550 VDD.n7 VDD.n455 2.07503
R1551 VDD.n6 VDD.n448 2.07503
R1552 VDD.n447 VDD.n5 2.07503
R1553 VDD.n4 VDD.n445 2.07503
R1554 VDD.n437 VDD.n3 2.07503
R1555 VDD.n2 VDD.n438 2.07503
R1556 VDD.n435 VDD.n1 2.07503
R1557 VDD.n356 VDD.n454 2.04753
R1558 VDD.n357 VDD.n427 2.04753
R1559 VDD.n358 VDD.n446 2.04753
R1560 VDD.n359 VDD.n444 2.04753
R1561 VDD.n360 VDD.n436 2.04753
R1562 VDD.n361 VDD.n429 2.04753
R1563 VDD.n362 VDD.n434 2.04753
R1564 VDD.n364 VDD.n336 2.04753
R1565 VDD.n365 VDD.n339 2.04753
R1566 VDD.n366 VDD.n19 2.04753
R1567 VDD.n367 VDD.n420 2.04753
R1568 VDD.n111 VDD.n12 2.02519
R1569 VDD.n22 VDD.n330 2.00628
R1570 VDD.n289 VDD.n288 1.99081
R1571 VDD.n294 VDD.n287 1.99081
R1572 VDD.n286 VDD.n299 1.99081
R1573 VDD.n304 VDD.n285 1.99081
R1574 VDD.n284 VDD.n313 1.99081
R1575 VDD.n318 VDD.n283 1.99081
R1576 VDD.n282 VDD.n323 1.99081
R1577 VDD.n8 VDD.n340 1.99081
R1578 VDD.n409 VDD.n290 1.95988
R1579 VDD.n408 VDD.n291 1.95988
R1580 VDD.n407 VDD.n292 1.95988
R1581 VDD.n406 VDD.n293 1.95988
R1582 VDD.n405 VDD.n295 1.95988
R1583 VDD.n404 VDD.n296 1.95988
R1584 VDD.n297 VDD.n403 1.95988
R1585 VDD.n401 VDD.n298 1.95988
R1586 VDD.n300 VDD.n400 1.95988
R1587 VDD.n398 VDD.n301 1.95988
R1588 VDD.n397 VDD.n302 1.95988
R1589 VDD.n303 VDD.n396 1.95988
R1590 VDD.n394 VDD.n305 1.95988
R1591 VDD.n393 VDD.n306 1.95988
R1592 VDD.n392 VDD.n307 1.95988
R1593 VDD.n391 VDD.n308 1.95988
R1594 VDD.n309 VDD.n390 1.95988
R1595 VDD.n310 VDD.n388 1.95988
R1596 VDD.n386 VDD.n311 1.95988
R1597 VDD.n385 VDD.n312 1.95988
R1598 VDD.n314 VDD.n384 1.95988
R1599 VDD.n382 VDD.n315 1.95988
R1600 VDD.n381 VDD.n316 1.95988
R1601 VDD.n380 VDD.n317 1.95988
R1602 VDD.n379 VDD.n319 1.95988
R1603 VDD.n378 VDD.n320 1.95988
R1604 VDD.n377 VDD.n321 1.95988
R1605 VDD.n322 VDD.n376 1.95988
R1606 VDD.n324 VDD.n374 1.95988
R1607 VDD.n325 VDD.n372 1.95988
R1608 VDD.n192 VDD.n430 1.95988
R1609 VDD.n326 VDD.n370 1.95988
R1610 VDD.n421 VDD.n346 1.95988
R1611 VDD.n23 VDD.n343 1.95472
R1612 VDD.n73 VDD.n253 1.9456
R1613 VDD.n41 VDD.n18 1.92894
R1614 VDD.n17 VDD.n16 1.91982
R1615 VDD.n38 VDD.n277 1.91691
R1616 VDD.n439 VDD.n37 1.91691
R1617 VDD.n36 VDD.n274 1.91691
R1618 VDD.n440 VDD.n35 1.91691
R1619 VDD.n33 VDD.n270 1.91691
R1620 VDD.n449 VDD.n32 1.91691
R1621 VDD.n450 VDD.n31 1.91691
R1622 VDD.n254 VDD.n411 1.90316
R1623 VDD.n418 VDD.n27 1.87738
R1624 VDD.n169 VDD.n65 1.87394
R1625 VDD.n333 VDD.n328 1.85503
R1626 VDD.n331 VDD.n327 1.85503
R1627 VDD.n267 VDD.n198 1.84644
R1628 VDD.n45 VDD.n200 1.84644
R1629 VDD.n268 VDD.n201 1.84644
R1630 VDD.n47 VDD.n203 1.84644
R1631 VDD.n269 VDD.n204 1.84644
R1632 VDD.n49 VDD.n206 1.84644
R1633 VDD.n271 VDD.n207 1.84644
R1634 VDD.n51 VDD.n209 1.84644
R1635 VDD.n210 VDD.n273 1.84644
R1636 VDD.n53 VDD.n212 1.84644
R1637 VDD.n275 VDD.n213 1.84644
R1638 VDD.n55 VDD.n215 1.84644
R1639 VDD.n276 VDD.n216 1.84644
R1640 VDD.n57 VDD.n218 1.84644
R1641 VDD.n219 VDD.n279 1.84644
R1642 VDD.n59 VDD.n220 1.84644
R1643 VDD.n61 VDD.n221 1.84644
R1644 VDD.n433 VDD.n62 1.84472
R1645 VDD.n432 VDD.n60 1.84472
R1646 VDD.n431 VDD.n58 1.84472
R1647 VDD.n428 VDD.n56 1.84472
R1648 VDD.n441 VDD.n54 1.84472
R1649 VDD.n443 VDD.n52 1.84472
R1650 VDD.n442 VDD.n50 1.84472
R1651 VDD.n426 VDD.n48 1.84472
R1652 VDD.n453 VDD.n46 1.84472
R1653 VDD.n67 VDD.n82 1.83784
R1654 VDD.n84 VDD.n83 1.8155
R1655 VDD.n195 VDD.n25 1.8155
R1656 VDD.n21 VDD.n20 1.8155
R1657 VDD.n19 VDD.n12 1.81206
R1658 VDD.n87 VDD.n75 1.80519
R1659 VDD.n69 VDD.n80 1.79487
R1660 VDD.n94 VDD 1.77458
R1661 VDD.n339 VDD.n70 1.76394
R1662 VDD.n189 VDD.n414 1.75878
R1663 VDD.n82 VDD.n81 1.75362
R1664 VDD.n277 VDD.n217 1.75019
R1665 VDD.n439 VDD.n214 1.75019
R1666 VDD.n274 VDD.n211 1.75019
R1667 VDD.n440 VDD.n208 1.75019
R1668 VDD.n270 VDD.n205 1.75019
R1669 VDD.n449 VDD.n202 1.75019
R1670 VDD.n450 VDD.n199 1.75019
R1671 VDD.n78 VDD.n368 1.74847
R1672 VDD.n422 VDD.n44 1.74847
R1673 VDD.n73 VDD.n77 1.733
R1674 VDD.n410 VDD.n14 1.733
R1675 VDD.n76 VDD.n63 1.71237
R1676 VDD.n85 VDD.n191 1.70206
R1677 VDD.n86 VDD.n410 1.70206
R1678 VDD.n42 VDD.n39 1.70034
R1679 VDD.n433 VDD.n326 1.68316
R1680 VDD.n432 VDD.n325 1.68316
R1681 VDD.n431 VDD.n322 1.68316
R1682 VDD.n317 VDD.n428 1.68316
R1683 VDD.n441 VDD.n312 1.68316
R1684 VDD.n308 VDD.n443 1.68316
R1685 VDD.n442 VDD.n303 1.68316
R1686 VDD.n298 VDD.n426 1.68316
R1687 VDD.n293 VDD.n453 1.68316
R1688 VDD.n199 VDD.n114 1.67112
R1689 VDD.n202 VDD.n120 1.67112
R1690 VDD.n205 VDD.n125 1.67112
R1691 VDD.n208 VDD.n130 1.67112
R1692 VDD.n135 VDD.n211 1.67112
R1693 VDD.n214 VDD.n141 1.67112
R1694 VDD.n217 VDD.n147 1.67112
R1695 VDD.n151 VDD.n72 1.67112
R1696 VDD.n346 VDD.n338 1.6505
R1697 VDD.n288 VDD.n7 1.6505
R1698 VDD.n287 VDD.n6 1.6505
R1699 VDD.n5 VDD.n286 1.6505
R1700 VDD.n285 VDD.n4 1.6505
R1701 VDD.n3 VDD.n284 1.6505
R1702 VDD.n283 VDD.n2 1.6505
R1703 VDD.n1 VDD.n282 1.6505
R1704 VDD.n355 VDD.n29 1.64534
R1705 VDD.n363 VDD.n41 1.64019
R1706 VDD.n40 VDD.n422 1.61441
R1707 VDD.n118 VDD.n172 1.58347
R1708 VDD.n123 VDD.n174 1.58347
R1709 VDD.n128 VDD.n176 1.58347
R1710 VDD.n134 VDD.n178 1.58347
R1711 VDD.n139 VDD.n180 1.58347
R1712 VDD.n145 VDD.n182 1.58347
R1713 VDD.n150 VDD.n184 1.58347
R1714 VDD.n152 VDD.n186 1.58347
R1715 VDD.n280 VDD.n69 1.58347
R1716 VDD.n155 VDD.n188 1.58347
R1717 VDD.n24 VDD.n9 1.55769
R1718 VDD.n265 VDD.n66 1.55769
R1719 VDD.n80 VDD.n79 1.54857
R1720 VDD.n170 VDD.n84 1.52675
R1721 VDD.n154 VDD.n153 1.52675
R1722 VDD.n335 VDD.n68 1.52503
R1723 VDD.n345 VDD.n344 1.51128
R1724 VDD.n264 VDD.n263 1.51128
R1725 VDD.n226 VDD.n262 1.51128
R1726 VDD.n261 VDD.n260 1.51128
R1727 VDD.n237 VDD.n259 1.51128
R1728 VDD.n258 VDD.n257 1.51128
R1729 VDD.n246 VDD.n256 1.51128
R1730 VDD.n250 VDD.n255 1.51128
R1731 VDD.n188 VDD.n187 1.51128
R1732 VDD.n186 VDD.n185 1.51128
R1733 VDD.n184 VDD.n183 1.51128
R1734 VDD.n182 VDD.n181 1.51128
R1735 VDD.n180 VDD.n179 1.51128
R1736 VDD.n178 VDD.n177 1.51128
R1737 VDD.n176 VDD.n175 1.51128
R1738 VDD.n174 VDD.n173 1.51128
R1739 VDD.n172 VDD.n171 1.51128
R1740 VDD.n72 VDD.n71 1.51128
R1741 VDD.n75 VDD.n74 1.50904
R1742 VDD.n91 VDD.n17 1.50097
R1743 VDD.n420 VDD.n90 1.47519
R1744 VDD.n13 VDD.n418 1.47003
R1745 VDD.n342 VDD.n22 1.46488
R1746 VDD.n167 VDD.n166 1.44941
R1747 VDD.n165 VDD.n164 1.44941
R1748 VDD.n399 VDD.n163 1.44941
R1749 VDD.n162 VDD.n161 1.44941
R1750 VDD.n389 VDD.n160 1.44941
R1751 VDD.n383 VDD.n159 1.44941
R1752 VDD.n158 VDD.n157 1.44941
R1753 VDD.n373 VDD.n156 1.44941
R1754 VDD.n369 VDD.n155 1.44941
R1755 VDD.n371 VDD.n152 1.44941
R1756 VDD.n375 VDD.n150 1.44941
R1757 VDD.n149 VDD.n148 1.44941
R1758 VDD.n147 VDD.n146 1.44941
R1759 VDD.n145 VDD.n144 1.44941
R1760 VDD.n143 VDD.n142 1.44941
R1761 VDD.n141 VDD.n140 1.44941
R1762 VDD.n139 VDD.n138 1.44941
R1763 VDD.n137 VDD.n136 1.44941
R1764 VDD.n387 VDD.n135 1.44941
R1765 VDD.n134 VDD.n133 1.44941
R1766 VDD.n132 VDD.n131 1.44941
R1767 VDD.n130 VDD.n129 1.44941
R1768 VDD.n395 VDD.n128 1.44941
R1769 VDD.n127 VDD.n126 1.44941
R1770 VDD.n125 VDD.n124 1.44941
R1771 VDD.n123 VDD.n122 1.44941
R1772 VDD.n402 VDD.n121 1.44941
R1773 VDD.n120 VDD.n119 1.44941
R1774 VDD.n118 VDD.n117 1.44941
R1775 VDD.n116 VDD.n115 1.44941
R1776 VDD.n114 VDD.n113 1.44941
R1777 VDD.n415 VDD.n89 0.673654
R1778 VDD.n67 VDD.n15 1.42592
R1779 VDD.n191 VDD.n190 1.41331
R1780 VDD.n278 VDD.n169 1.41331
R1781 VDD.n74 VDD.n92 1.40987
R1782 VDD.n92 VDD.n91 1.39784
R1783 VDD.n329 VDD.n341 1.39097
R1784 VDD.n16 VDD.n192 1.39097
R1785 VDD.n8 VDD.n252 1.38449
R1786 VDD.n251 VDD.n250 1.38238
R1787 VDD.n247 VDD.n246 1.38238
R1788 VDD.n257 VDD.n242 1.38238
R1789 VDD.n238 VDD.n237 1.38238
R1790 VDD.n260 VDD.n231 1.38238
R1791 VDD.n227 VDD.n226 1.38238
R1792 VDD.n263 VDD.n222 1.38238
R1793 VDD.n352 VDD.n351 1.36175
R1794 VDD.n411 VDD.n347 1.33597
R1795 VDD.n153 VDD.n281 1.33597
R1796 VDD.n197 VDD.n21 1.33597
R1797 VDD.n196 VDD.n195 1.33597
R1798 VDD.n336 VDD.n335 1.31534
R1799 VDD.n112 VDD.n111 1.31363
R1800 VDD.n249 VDD.n248 1.30503
R1801 VDD.n31 VDD.n30 1.30503
R1802 VDD.n245 VDD.n244 1.30503
R1803 VDD.n243 VDD.n32 1.30503
R1804 VDD.n241 VDD.n240 1.30503
R1805 VDD.n239 VDD.n33 1.30503
R1806 VDD.n236 VDD.n235 1.30503
R1807 VDD.n35 VDD.n34 1.30503
R1808 VDD.n272 VDD.n233 1.30503
R1809 VDD.n232 VDD.n36 1.30503
R1810 VDD.n230 VDD.n229 1.30503
R1811 VDD.n228 VDD.n37 1.30503
R1812 VDD.n225 VDD.n224 1.30503
R1813 VDD.n223 VDD.n38 1.30503
R1814 VDD.n435 VDD.n362 1.30331
R1815 VDD.n438 VDD.n361 1.30331
R1816 VDD.n437 VDD.n360 1.30331
R1817 VDD.n445 VDD.n359 1.30331
R1818 VDD.n447 VDD.n358 1.30331
R1819 VDD.n448 VDD.n357 1.30331
R1820 VDD.n455 VDD.n356 1.30331
R1821 VDD.n334 VDD.n333 1.30331
R1822 VDD.n332 VDD.n331 1.30331
R1823 VDD.n64 VDD.n266 1.29988
R1824 VDD.n26 VDD.n354 1.29988
R1825 VDD.n353 VDD.n252 0.616169
R1826 VDD.n421 VDD.n345 1.29472
R1827 VDD.n194 VDD.n193 1.28202
R1828 VDD.n425 VDD.n355 1.27581
R1829 VDD.n27 VDD.n26 1.27409
R1830 VDD.n330 VDD.n329 1.27066
R1831 VDD.n368 VDD.n423 1.26894
R1832 VDD.n62 VDD.n61 1.26894
R1833 VDD.n60 VDD.n59 1.26894
R1834 VDD.n279 VDD.n278 1.26894
R1835 VDD.n58 VDD.n57 1.26894
R1836 VDD.n224 VDD.n276 1.26894
R1837 VDD.n56 VDD.n55 1.26894
R1838 VDD.n229 VDD.n275 1.26894
R1839 VDD.n54 VDD.n53 1.26894
R1840 VDD.n273 VDD.n272 1.26894
R1841 VDD.n52 VDD.n51 1.26894
R1842 VDD.n235 VDD.n271 1.26894
R1843 VDD.n50 VDD.n49 1.26894
R1844 VDD.n240 VDD.n269 1.26894
R1845 VDD.n48 VDD.n47 1.26894
R1846 VDD.n244 VDD.n268 1.26894
R1847 VDD.n46 VDD.n45 1.26894
R1848 VDD.n248 VDD.n267 1.26894
R1849 VDD.n337 VDD.n11 1.26722
R1850 VDD.n44 VDD.n43 1.25862
R1851 VDD.n65 VDD.n64 1.25175
R1852 VDD.n414 VDD.n194 1.22253
R1853 VDD.n350 VDD.n349 1.21737
R1854 VDD.n83 VDD.n280 1.20191
R1855 VDD.n109 VDD.n342 1.19847
R1856 VDD.n81 VDD.n170 1.19675
R1857 VDD.n344 VDD.n42 1.18816
R1858 VDD.n108 VDD.n106 1.18322
R1859 VDD.n107 VDD.n106 1.18322
R1860 VDD.n107 VDD.n105 1.18322
R1861 VDD.n452 VDD.n105 1.18322
R1862 VDD.n104 VDD.n102 1.18322
R1863 VDD.n103 VDD.n102 1.18322
R1864 VDD.n103 VDD.n101 1.18322
R1865 VDD.n451 VDD.n101 1.18322
R1866 VDD.n100 VDD.n99 1.18322
R1867 VDD.n100 VDD.n97 1.18322
R1868 VDD.n98 VDD.n97 1.18322
R1869 VDD.n456 VDD.n98 1.18322
R1870 VDD.n96 VDD.n95 1.18322
R1871 VDD.n96 VDD.n93 1.18322
R1872 VDD.n94 VDD.n93 1.18322
R1873 VDD.n349 VDD.n413 1.18128
R1874 VDD.n424 VDD.n350 1.18128
R1875 VDD.n79 VDD.n87 1.17956
R1876 VDD.n23 VDD.n337 1.16066
R1877 VDD.n190 VDD.n234 1.16066
R1878 VDD.n166 VDD.n409 1.1555
R1879 VDD.n113 VDD.n408 1.1555
R1880 VDD.n115 VDD.n407 1.1555
R1881 VDD.n117 VDD.n406 1.1555
R1882 VDD.n164 VDD.n405 1.1555
R1883 VDD.n119 VDD.n404 1.1555
R1884 VDD.n403 VDD.n402 1.1555
R1885 VDD.n122 VDD.n401 1.1555
R1886 VDD.n400 VDD.n399 1.1555
R1887 VDD.n124 VDD.n398 1.1555
R1888 VDD.n126 VDD.n397 1.1555
R1889 VDD.n396 VDD.n395 1.1555
R1890 VDD.n161 VDD.n394 1.1555
R1891 VDD.n129 VDD.n393 1.1555
R1892 VDD.n131 VDD.n392 1.1555
R1893 VDD.n133 VDD.n391 1.1555
R1894 VDD.n390 VDD.n389 1.1555
R1895 VDD.n388 VDD.n387 1.1555
R1896 VDD.n136 VDD.n386 1.1555
R1897 VDD.n138 VDD.n385 1.1555
R1898 VDD.n384 VDD.n383 1.1555
R1899 VDD.n140 VDD.n382 1.1555
R1900 VDD.n142 VDD.n381 1.1555
R1901 VDD.n144 VDD.n380 1.1555
R1902 VDD.n157 VDD.n379 1.1555
R1903 VDD.n146 VDD.n378 1.1555
R1904 VDD.n148 VDD.n377 1.1555
R1905 VDD.n376 VDD.n375 1.1555
R1906 VDD.n374 VDD.n373 1.1555
R1907 VDD.n372 VDD.n371 1.1555
R1908 VDD.n370 VDD.n369 1.1555
R1909 VDD.n68 VDD.n110 1.1555
R1910 VDD.n110 VDD.n109 1.1555
R1911 VDD.n78 VDD.n413 1.14075
R1912 VDD.n423 VDD.n348 1.12972
R1913 VDD.n343 VDD.n112 1.12113
R1914 VDD.n10 VDD.n168 1.10909
R1915 VDD.n332 VDD.n197 1.09534
R1916 VDD.n334 VDD.n196 1.09534
R1917 VDD.n348 VDD.n43 1.09362
R1918 VDD.n425 VDD.n415 1.07644
R1919 VDD.n29 VDD.n28 1.073
R1920 VDD.n88 VDD.n265 1.073
R1921 VDD.n354 VDD.n353 1.05237
R1922 VDD.n416 VDD.n424 1.04206
R1923 VDD.n351 VDD.n417 1.03691
R1924 VDD.n340 VDD.n352 1.03691
R1925 VDD.n77 VDD.n76 1.03175
R1926 VDD.n168 VDD.n419 1.02659
R1927 VDD.n417 VDD.n416 1.01113
R1928 VDD.n266 VDD.n363 1.01113
R1929 VSS.t1791 VSS.t1792 11027.8
R1930 VSS.t1543 VSS.t1546 11027.8
R1931 VSS.t1336 VSS.t1334 11027.8
R1932 VSS.t1373 VSS.t1369 11027.8
R1933 VSS.t1646 VSS.t1648 11027.8
R1934 VSS.t1482 VSS.t1485 11027.8
R1935 VSS.t879 VSS.t881 11027.8
R1936 VSS.t1477 VSS.t1480 11027.8
R1937 VSS.t1437 VSS.t1435 11027.8
R1938 VSS.t435 VSS.t434 6118.15
R1939 VSS.t729 VSS.t728 6118.15
R1940 VSS.t167 VSS.t166 6118.15
R1941 VSS.t623 VSS.t622 6118.15
R1942 VSS.t1317 VSS.t1316 6118.15
R1943 VSS.t837 VSS.t836 6118.15
R1944 VSS.t1792 VSS.t1793 5990.74
R1945 VSS.t1547 VSS.t1543 5990.74
R1946 VSS.t1338 VSS.t1336 5990.74
R1947 VSS.t1374 VSS.t1373 5990.74
R1948 VSS.t1648 VSS.t1649 5990.74
R1949 VSS.t1485 VSS.t1486 5990.74
R1950 VSS.t881 VSS.t883 5990.74
R1951 VSS.t1481 VSS.t1477 5990.74
R1952 VSS.t1438 VSS.t1437 5990.74
R1953 VSS.t1790 VSS.t1791 5981.48
R1954 VSS.t1546 VSS.t1545 5981.48
R1955 VSS.t1334 VSS.t1332 5981.48
R1956 VSS.t1369 VSS.t1372 5981.48
R1957 VSS.t1645 VSS.t1646 5981.48
R1958 VSS.t1484 VSS.t1482 5981.48
R1959 VSS.t877 VSS.t879 5981.48
R1960 VSS.t1480 VSS.t1479 5981.48
R1961 VSS.t1435 VSS.t1433 5981.48
R1962 VSS.n22 VSS.t505 5351.85
R1963 VSS.n23 VSS.t1651 5351.85
R1964 VSS.n102 VSS.t1343 5351.85
R1965 VSS.t915 VSS.n101 5351.85
R1966 VSS.t912 VSS.n100 5351.85
R1967 VSS.t1307 VSS.n99 5351.85
R1968 VSS.n97 VSS.t234 5351.85
R1969 VSS.t1046 VSS.t724 5351.85
R1970 VSS.t1684 VSS.t1591 5255.14
R1971 VSS.n126 VSS.t1790 5090.36
R1972 VSS.n118 VSS.t1002 4904.19
R1973 VSS.t1608 VSS.t1713 4880.14
R1974 VSS.t226 VSS.t1840 4392.12
R1975 VSS.t1676 VSS.t1575 4392.12
R1976 VSS.t899 VSS.t116 4392.12
R1977 VSS.t1285 VSS.t893 4185.19
R1978 VSS.n126 VSS.n125 4169.6
R1979 VSS.n125 VSS.n124 4169.6
R1980 VSS.n124 VSS.n123 4169.6
R1981 VSS.n123 VSS.n122 4169.6
R1982 VSS.n122 VSS.n121 4169.6
R1983 VSS.n121 VSS.n120 4169.6
R1984 VSS.n120 VSS.n119 4169.6
R1985 VSS.n119 VSS.n118 4169.6
R1986 VSS.t1003 VSS.t1032 4047.95
R1987 VSS.t406 VSS.t1242 3960.62
R1988 VSS.t1749 VSS.t627 3585.62
R1989 VSS.t893 VSS.n21 3500
R1990 VSS.t1093 VSS.t1094 3323.63
R1991 VSS.t1539 VSS.t1536 3323.63
R1992 VSS.t1693 VSS.t1694 3323.63
R1993 VSS.t986 VSS.t985 3323.63
R1994 VSS.t436 VSS.t435 3323.63
R1995 VSS.t217 VSS.t219 3323.63
R1996 VSS.t1328 VSS.t1329 3323.63
R1997 VSS.t980 VSS.t981 3323.63
R1998 VSS.t727 VSS.t729 3323.63
R1999 VSS.t1766 VSS.t1765 3323.63
R2000 VSS.t411 VSS.t415 3323.63
R2001 VSS.t486 VSS.t484 3323.63
R2002 VSS.t168 VSS.t167 3323.63
R2003 VSS.t1036 VSS.t1034 3323.63
R2004 VSS.t178 VSS.t182 3323.63
R2005 VSS.t714 VSS.t715 3323.63
R2006 VSS.t624 VSS.t623 3323.63
R2007 VSS.t540 VSS.t538 3323.63
R2008 VSS.t359 VSS.t354 3323.63
R2009 VSS.t282 VSS.t279 3323.63
R2010 VSS.t973 VSS.t972 3323.63
R2011 VSS.t1638 VSS.t1640 3323.63
R2012 VSS.t1396 VSS.t1394 3323.63
R2013 VSS.t822 VSS.t818 3323.63
R2014 VSS.t1315 VSS.t1317 3323.63
R2015 VSS.t1521 VSS.t1522 3323.63
R2016 VSS.t1367 VSS.t1366 3323.63
R2017 VSS.t1289 VSS.t1290 3323.63
R2018 VSS.t838 VSS.t837 3323.63
R2019 VSS.t1525 VSS.t1526 3323.63
R2020 VSS.t341 VSS.t343 3323.63
R2021 VSS.t5 VSS.t2 3323.63
R2022 VSS.t1602 VSS.t1606 3323.63
R2023 VSS.t249 VSS.t245 3323.63
R2024 VSS.t856 VSS.t858 3318.49
R2025 VSS.t944 VSS.t943 3318.49
R2026 VSS.t1740 VSS.t1739 3318.49
R2027 VSS.t1357 VSS.t1358 3318.49
R2028 VSS.t434 VSS.t433 3318.49
R2029 VSS.t1771 VSS.t1773 3318.49
R2030 VSS.t1777 VSS.t1778 3318.49
R2031 VSS.t210 VSS.t207 3318.49
R2032 VSS.t728 VSS.t726 3318.49
R2033 VSS.t720 VSS.t716 3318.49
R2034 VSS.t1038 VSS.t1037 3318.49
R2035 VSS.t1312 VSS.t1309 3318.49
R2036 VSS.t166 VSS.t164 3318.49
R2037 VSS.t1072 VSS.t1074 3318.49
R2038 VSS.t1077 VSS.t1076 3318.49
R2039 VSS.t1817 VSS.t1818 3318.49
R2040 VSS.t622 VSS.t621 3318.49
R2041 VSS.t27 VSS.t28 3318.49
R2042 VSS.t1054 VSS.t1052 3318.49
R2043 VSS.t1010 VSS.t1011 3318.49
R2044 VSS.t580 VSS.t578 3318.49
R2045 VSS.t507 VSS.t510 3318.49
R2046 VSS.t761 VSS.t765 3318.49
R2047 VSS.t1452 VSS.t1453 3318.49
R2048 VSS.t1316 VSS.t1314 3318.49
R2049 VSS.t1489 VSS.t1490 3318.49
R2050 VSS.t934 VSS.t937 3318.49
R2051 VSS.t1095 VSS.t1097 3318.49
R2052 VSS.t836 VSS.t835 3318.49
R2053 VSS.t239 VSS.t236 3318.49
R2054 VSS.t585 VSS.t586 3318.49
R2055 VSS.t1466 VSS.t1464 3318.49
R2056 VSS.t1796 VSS.t1795 3318.49
R2057 VSS.t1617 VSS.t1616 3318.49
R2058 VSS.t1834 VSS.t1835 3195.21
R2059 VSS.t1151 VSS.t1150 3195.21
R2060 VSS.t1002 VSS.t1003 3195.21
R2061 VSS.t155 VSS.t157 3195.21
R2062 VSS.t1782 VSS.t198 3092.47
R2063 VSS.t681 VSS.t687 3092.47
R2064 VSS.t1828 VSS.t1810 3092.47
R2065 VSS.t536 VSS.t524 3092.47
R2066 VSS.t1304 VSS.t1644 3092.47
R2067 VSS.t1696 VSS.t1738 3092.47
R2068 VSS.t888 VSS.t1788 3077.05
R2069 VSS.t1499 VSS.t1442 2969.18
R2070 VSS.t961 VSS.t867 2969.18
R2071 VSS.t831 VSS.t1680 2969.18
R2072 VSS.t777 VSS.t1350 2969.18
R2073 VSS.t63 VSS.t741 2969.18
R2074 VSS.t1320 VSS.t323 2969.18
R2075 VSS.t1380 VSS.t332 2969.18
R2076 VSS.t852 VSS.t749 2969.18
R2077 VSS.t287 VSS.t186 2969.18
R2078 VSS.t472 VSS.t430 2969.18
R2079 VSS.t1296 VSS.t736 2969.18
R2080 VSS.t1090 VSS.t454 2969.18
R2081 VSS.t1082 VSS.t1816 2969.18
R2082 VSS.t572 VSS.t1024 2969.18
R2083 VSS.t675 VSS.t1028 2969.18
R2084 VSS.t42 VSS.t1824 2969.18
R2085 VSS.t642 VSS.t92 2969.18
R2086 VSS.t1802 VSS.t125 2969.18
R2087 VSS.t543 VSS.t1008 2969.18
R2088 VSS.t37 VSS.t635 2969.18
R2089 VSS.t1725 VSS.t1687 2969.18
R2090 VSS.t1422 VSS.t1635 2969.18
R2091 VSS.t814 VSS.t1625 2969.18
R2092 VSS.t267 VSS.t758 2969.18
R2093 VSS.t344 VSS.t1583 2969.18
R2094 VSS.t1564 VSS.t809 2969.18
R2095 VSS.t1405 VSS.t317 2969.18
R2096 VSS.t704 VSS.t1448 2969.18
R2097 VSS.t1529 VSS.t957 2969.18
R2098 VSS.t804 VSS.t701 2969.18
R2099 VSS.n73 VSS.t1461 2969.18
R2100 VSS.t1551 VSS.t1514 2969.18
R2101 VSS.t868 VSS.t1717 2969.18
R2102 VSS.t385 VSS.n58 2969.18
R2103 VSS.t1498 VSS.t1441 2964.04
R2104 VSS.t960 VSS.t866 2964.04
R2105 VSS.t834 VSS.t1678 2964.04
R2106 VSS.t773 VSS.t1349 2964.04
R2107 VSS.t1781 VSS.t196 2964.04
R2108 VSS.t59 VSS.t743 2964.04
R2109 VSS.t1319 VSS.t326 2964.04
R2110 VSS.t1379 VSS.t331 2964.04
R2111 VSS.t850 VSS.t748 2964.04
R2112 VSS.t683 VSS.t686 2964.04
R2113 VSS.t286 VSS.t184 2964.04
R2114 VSS.t471 VSS.t427 2964.04
R2115 VSS.t1295 VSS.t734 2964.04
R2116 VSS.t1089 VSS.t452 2964.04
R2117 VSS.t1827 VSS.t1812 2964.04
R2118 VSS.t1084 VSS.t1815 2964.04
R2119 VSS.t571 VSS.t1023 2964.04
R2120 VSS.t673 VSS.t1027 2964.04
R2121 VSS.t40 VSS.t1823 2964.04
R2122 VSS.t535 VSS.t527 2964.04
R2123 VSS.t641 VSS.t90 2964.04
R2124 VSS.t1801 VSS.t122 2964.04
R2125 VSS.t541 VSS.t1007 2964.04
R2126 VSS.t33 VSS.t634 2964.04
R2127 VSS.t1727 VSS.t1686 2964.04
R2128 VSS.t1421 VSS.t1634 2964.04
R2129 VSS.t810 VSS.t1627 2964.04
R2130 VSS.t265 VSS.t760 2964.04
R2131 VSS.t1303 VSS.t1643 2964.04
R2132 VSS.t347 VSS.t1582 2964.04
R2133 VSS.t1565 VSS.t807 2964.04
R2134 VSS.t1403 VSS.t321 2964.04
R2135 VSS.t707 VSS.t1450 2964.04
R2136 VSS.t1695 VSS.t1737 2964.04
R2137 VSS.t1528 VSS.t955 2964.04
R2138 VSS.t803 VSS.t697 2964.04
R2139 VSS.t1550 VSS.t1512 2964.04
R2140 VSS.t873 VSS.t1719 2964.04
R2141 VSS.n27 VSS.t906 2845.89
R2142 VSS.t2 VSS.t1466 2666.1
R2143 VSS.t1283 VSS.t1285 2648.15
R2144 VSS.t505 VSS.t503 2648.15
R2145 VSS.t1651 VSS.t1650 2648.15
R2146 VSS.t1343 VSS.t1346 2648.15
R2147 VSS.t913 VSS.t915 2648.15
R2148 VSS.t910 VSS.t912 2648.15
R2149 VSS.t1306 VSS.t1307 2648.15
R2150 VSS.t234 VSS.t232 2648.15
R2151 VSS.t724 VSS.t722 2648.15
R2152 VSS.t1460 VSS.t1410 2589.04
R2153 VSS.t1685 VSS.t1592 2460.62
R2154 VSS.t1682 VSS.t1589 2455.48
R2155 VSS.t1465 VSS.t1601 2404.11
R2156 VSS.n96 VSS.t1833 2373.29
R2157 VSS.n49 VSS.t47 2373.29
R2158 VSS.n48 VSS.t646 2373.29
R2159 VSS.n111 VSS.t450 2373.29
R2160 VSS.n37 VSS.t875 2373.29
R2161 VSS.n115 VSS.t1474 2373.29
R2162 VSS.t1789 VSS.t940 2321.92
R2163 VSS.t917 VSS.t1049 2321.92
R2164 VSS.t1472 VSS.t1220 2321.92
R2165 VSS.t1784 VSS.t742 2280.82
R2166 VSS.t285 VSS.t289 2280.82
R2167 VSS.t784 VSS.t1814 2280.82
R2168 VSS.t1805 VSS.t88 2280.82
R2169 VSS.t1387 VSS.t1581 2280.82
R2170 VSS.t1671 VSS.t953 2280.82
R2171 VSS.t1250 VSS.t666 2260.27
R2172 VSS.t609 VSS.t1178 2250
R2173 VSS.t230 VSS.t1501 2229.45
R2174 VSS.t442 VSS.t963 2229.45
R2175 VSS.t1679 VSS.t1292 2229.45
R2176 VSS.t1459 VSS.t775 2229.45
R2177 VSS.t488 VSS.t61 2229.45
R2178 VSS.t201 VSS.t1322 2229.45
R2179 VSS.t205 VSS.t1382 2229.45
R2180 VSS.t491 VSS.t851 2229.45
R2181 VSS.t188 VSS.t142 2229.45
R2182 VSS.t429 VSS.t685 2229.45
R2183 VSS.t739 VSS.t1298 2229.45
R2184 VSS.t458 VSS.t1331 2229.45
R2185 VSS.t1071 VSS.t1086 2229.45
R2186 VSS.t648 VSS.t575 2229.45
R2187 VSS.t652 VSS.t677 2229.45
R2188 VSS.t1081 VSS.t46 2229.45
R2189 VSS.t272 VSS.t644 2229.45
R2190 VSS.t123 VSS.t629 2229.45
R2191 VSS.t631 VSS.t546 2229.45
R2192 VSS.t534 VSS.t35 2229.45
R2193 VSS.t1690 VSS.t1836 2229.45
R2194 VSS.t1762 VSS.t1425 2229.45
R2195 VSS.t1487 VSS.t812 2229.45
R2196 VSS.t1704 VSS.t270 2229.45
R2197 VSS.t1613 VSS.t350 2229.45
R2198 VSS.t1462 VSS.t1567 2229.45
R2199 VSS.t997 VSS.t1404 2229.45
R2200 VSS.t1729 VSS.t709 2229.45
R2201 VSS.t1383 VSS.t1530 2229.45
R2202 VSS.t699 VSS.t1495 2229.45
R2203 VSS.t1571 VSS.t1552 2229.45
R2204 VSS.t909 VSS.t596 2229.45
R2205 VSS.t1127 VSS.t874 2229.45
R2206 VSS.t1241 VSS.t406 2157.53
R2207 VSS.t1242 VSS.t408 2157.53
R2208 VSS.t1545 VSS.n21 2111.11
R2209 VSS.t1332 VSS.n22 2111.11
R2210 VSS.t1372 VSS.n23 2111.11
R2211 VSS.n102 VSS.t1645 2111.11
R2212 VSS.n101 VSS.t1484 2111.11
R2213 VSS.n100 VSS.t877 2111.11
R2214 VSS.n99 VSS.t1479 2111.11
R2215 VSS.t1433 VSS.n97 2111.11
R2216 VSS.t195 VSS.t58 2106.16
R2217 VSS.t479 VSS.t682 2106.16
R2218 VSS.t1811 VSS.t558 2106.16
R2219 VSS.t525 VSS.t638 2106.16
R2220 VSS.t1642 VSS.t926 2106.16
R2221 VSS.t1735 VSS.t502 2106.16
R2222 VSS.t228 VSS.t1500 2101.03
R2223 VSS.t440 VSS.t962 2101.03
R2224 VSS.t1681 VSS.t1291 2101.03
R2225 VSS.t1458 VSS.t779 2101.03
R2226 VSS.t194 VSS.t56 2101.03
R2227 VSS.t487 VSS.t65 2101.03
R2228 VSS.t199 VSS.t1321 2101.03
R2229 VSS.t203 VSS.t1381 2101.03
R2230 VSS.t489 VSS.t853 2101.03
R2231 VSS.t477 VSS.t680 2101.03
R2232 VSS.t187 VSS.t140 2101.03
R2233 VSS.t432 VSS.t684 2101.03
R2234 VSS.t738 VSS.t1297 2101.03
R2235 VSS.t456 VSS.t1330 2101.03
R2236 VSS.t1809 VSS.t562 2101.03
R2237 VSS.t1069 VSS.t1085 2101.03
R2238 VSS.t649 VSS.t574 2101.03
R2239 VSS.t650 VSS.t676 2101.03
R2240 VSS.t1080 VSS.t44 2101.03
R2241 VSS.t522 VSS.t640 2101.03
R2242 VSS.t271 VSS.t643 2101.03
R2243 VSS.t127 VSS.t628 2101.03
R2244 VSS.t630 VSS.t545 2101.03
R2245 VSS.t533 VSS.t39 2101.03
R2246 VSS.t1689 VSS.t1837 2101.03
R2247 VSS.t1761 VSS.t1424 2101.03
R2248 VSS.t1488 VSS.t816 2101.03
R2249 VSS.t1705 VSS.t269 2101.03
R2250 VSS.t1641 VSS.t924 2101.03
R2251 VSS.t1612 VSS.t348 2101.03
R2252 VSS.t1463 VSS.t1566 2101.03
R2253 VSS.t996 VSS.t1406 2101.03
R2254 VSS.t1728 VSS.t708 2101.03
R2255 VSS.t1736 VSS.t500 2101.03
R2256 VSS.t1385 VSS.t1527 2101.03
R2257 VSS.t703 VSS.t1494 2101.03
R2258 VSS.t1570 VSS.t1548 2101.03
R2259 VSS.t908 VSS.t594 2101.03
R2260 VSS.t1126 VSS.t871 2101.03
R2261 VSS.t604 VSS.t1152 2085.62
R2262 VSS.t1409 VSS.t884 2080.48
R2263 VSS.t309 VSS.t1091 2065.07
R2264 VSS.t1636 VSS.t969 2065.07
R2265 VSS.t1221 VSS.t1748 2065.07
R2266 VSS.t1272 VSS.t1757 2003.42
R2267 VSS.t1440 VSS.n26 1982.88
R2268 VSS.n107 VSS.t865 1982.88
R2269 VSS.t833 VSS.n105 1982.88
R2270 VSS.n104 VSS.t1348 1982.88
R2271 VSS.t324 VSS.n92 1982.88
R2272 VSS.t329 VSS.n90 1982.88
R2273 VSS.t747 VSS.n88 1982.88
R2274 VSS.n52 VSS.t470 1982.88
R2275 VSS.n54 VSS.t1294 1982.88
R2276 VSS.n56 VSS.t1088 1982.88
R2277 VSS.t1022 VSS.n44 1982.88
R2278 VSS.n87 VSS.t1026 1982.88
R2279 VSS.t1822 VSS.n85 1982.88
R2280 VSS.t1800 VSS.n108 1982.88
R2281 VSS.n84 VSS.t1006 1982.88
R2282 VSS.t633 VSS.n82 1982.88
R2283 VSS.n39 VSS.t1726 1982.88
R2284 VSS.n81 VSS.t1633 1982.88
R2285 VSS.t1626 VSS.n79 1982.88
R2286 VSS.t759 VSS.n77 1982.88
R2287 VSS.t805 VSS.n33 1982.88
R2288 VSS.n76 VSS.t319 1982.88
R2289 VSS.t1449 VSS.n74 1982.88
R2290 VSS.t802 VSS.n112 1982.88
R2291 VSS.t1511 VSS.n71 1982.88
R2292 VSS.t1718 VSS.n66 1982.88
R2293 VSS.t1183 VSS.t387 1982.88
R2294 VSS.t860 VSS.t1408 1957.19
R2295 VSS.t843 VSS.t582 1957.19
R2296 VSS.t696 VSS.n95 1941.78
R2297 VSS.n50 VSS.t291 1941.78
R2298 VSS.t1397 VSS.n47 1941.78
R2299 VSS.t1059 VSS.n110 1941.78
R2300 VSS.t1318 VSS.n36 1941.78
R2301 VSS.t1698 VSS.n114 1941.78
R2302 VSS.t1029 VSS.n62 1941.78
R2303 VSS.t1239 VSS.t1402 1931.51
R2304 VSS.t976 VSS.t71 1926.37
R2305 VSS.t1793 VSS.t1283 1888.89
R2306 VSS.t503 VSS.t1547 1888.89
R2307 VSS.t1650 VSS.t1338 1888.89
R2308 VSS.t1346 VSS.t1374 1888.89
R2309 VSS.t1649 VSS.t913 1888.89
R2310 VSS.t1486 VSS.t910 1888.89
R2311 VSS.t883 VSS.t1306 1888.89
R2312 VSS.t232 VSS.t1481 1888.89
R2313 VSS.t722 VSS.t1438 1888.89
R2314 VSS.t54 VSS.t438 1849.32
R2315 VSS.t473 VSS.t1848 1849.32
R2316 VSS.t560 VSS.t1067 1849.32
R2317 VSS.t639 VSS.t521 1849.32
R2318 VSS.t920 VSS.t1533 1849.32
R2319 VSS.t498 VSS.t930 1849.32
R2320 VSS.t732 VSS.t1203 1818.49
R2321 VSS.t946 VSS.t313 1797.95
R2322 VSS.t1540 VSS.t1742 1797.95
R2323 VSS.t1361 VSS.t424 1797.95
R2324 VSS.t221 VSS.t1772 1797.95
R2325 VSS.t1045 VSS.t1780 1797.95
R2326 VSS.t849 VSS.t213 1797.95
R2327 VSS.t718 VSS.t191 1797.95
R2328 VSS.t1040 VSS.t1832 1797.95
R2329 VSS.t1310 VSS.t689 1797.95
R2330 VSS.t669 VSS.t1073 1797.95
R2331 VSS.t1079 VSS.t373 1797.95
R2332 VSS.t467 VSS.t1820 1797.95
R2333 VSS.t276 VSS.t32 1797.95
R2334 VSS.t1053 VSS.t369 1797.95
R2335 VSS.t130 VSS.t1013 1797.95
R2336 VSS.t512 VSS.t1703 1797.95
R2337 VSS.t1733 VSS.t763 1797.95
R2338 VSS.t829 VSS.t1455 1797.95
R2339 VSS.t1516 VSS.t1493 1797.95
R2340 VSS.t939 VSS.t1579 1797.95
R2341 VSS.t1663 VSS.t1101 1797.95
R2342 VSS.t1355 VSS.t242 1797.95
R2343 VSS.t988 VSS.t589 1797.95
R2344 VSS.t1798 VSS.t1658 1797.95
R2345 VSS.t1506 VSS.t1619 1797.95
R2346 VSS.t1192 VSS.t609 1797.95
R2347 VSS.t1840 VSS.t225 1726.03
R2348 VSS.t1841 VSS.t226 1726.03
R2349 VSS.t1575 VSS.t1674 1726.03
R2350 VSS.t1576 VSS.t1676 1726.03
R2351 VSS.t114 VSS.t899 1726.03
R2352 VSS.t116 VSS.t900 1726.03
R2353 VSS.t945 VSS.t311 1669.52
R2354 VSS.t1542 VSS.t1741 1669.52
R2355 VSS.t1359 VSS.t422 1669.52
R2356 VSS.t220 VSS.t1774 1669.52
R2357 VSS.t1043 VSS.t1779 1669.52
R2358 VSS.t848 VSS.t211 1669.52
R2359 VSS.t721 VSS.t189 1669.52
R2360 VSS.t1039 VSS.t1831 1669.52
R2361 VSS.t1313 VSS.t688 1669.52
R2362 VSS.t667 VSS.t1075 1669.52
R2363 VSS.t1078 VSS.t372 1669.52
R2364 VSS.t465 VSS.t1819 1669.52
R2365 VSS.t275 VSS.t30 1669.52
R2366 VSS.t1055 VSS.t368 1669.52
R2367 VSS.t128 VSS.t1012 1669.52
R2368 VSS.t511 VSS.t1702 1669.52
R2369 VSS.t1732 VSS.t767 1669.52
R2370 VSS.t828 VSS.t1454 1669.52
R2371 VSS.t1515 VSS.t1492 1669.52
R2372 VSS.t938 VSS.t1578 1669.52
R2373 VSS.t1662 VSS.t1099 1669.52
R2374 VSS.t1356 VSS.t240 1669.52
R2375 VSS.t987 VSS.t587 1669.52
R2376 VSS.t1797 VSS.t1657 1669.52
R2377 VSS.t1505 VSS.t1618 1669.52
R2378 VSS.t1190 VSS.t613 1669.52
R2379 VSS.t1664 VSS.n63 1648.97
R2380 VSS.t227 VSS.t1841 1597.6
R2381 VSS.t1677 VSS.t1576 1597.6
R2382 VSS.t900 VSS.t118 1597.6
R2383 VSS.t225 VSS.t1839 1592.47
R2384 VSS.t1674 VSS.t1574 1592.47
R2385 VSS.t898 VSS.t114 1592.47
R2386 VSS.t1538 VSS.n25 1551.37
R2387 VSS.t1691 VSS.n106 1551.37
R2388 VSS.n103 VSS.t982 1551.37
R2389 VSS.t1418 VSS.t250 1551.37
R2390 VSS.t215 VSS.n94 1551.37
R2391 VSS.t1326 VSS.n91 1551.37
R2392 VSS.t979 VSS.n89 1551.37
R2393 VSS.t304 VSS.t306 1551.37
R2394 VSS.n51 VSS.t1764 1551.37
R2395 VSS.n53 VSS.t413 1551.37
R2396 VSS.n55 VSS.t482 1551.37
R2397 VSS.t49 VSS.t1769 1551.37
R2398 VSS.t1035 VSS.n46 1551.37
R2399 VSS.t180 VSS.n43 1551.37
R2400 VSS.t713 VSS.n86 1551.37
R2401 VSS.t98 VSS.t96 1551.37
R2402 VSS.t539 VSS.n109 1551.37
R2403 VSS.n42 VSS.t358 1551.37
R2404 VSS.t280 VSS.n83 1551.37
R2405 VSS.t1063 VSS.t351 1551.37
R2406 VSS.n40 VSS.t1639 1551.37
R2407 VSS.t1395 VSS.n80 1551.37
R2408 VSS.t820 VSS.n78 1551.37
R2409 VSS.t21 VSS.t19 1551.37
R2410 VSS.t1519 VSS.n35 1551.37
R2411 VSS.t1365 VSS.n32 1551.37
R2412 VSS.t1287 VSS.n75 1551.37
R2413 VSS.t513 VSS.t66 1551.37
R2414 VSS.t1523 VSS.n113 1551.37
R2415 VSS.n31 VSS.t975 1551.37
R2416 VSS.t339 VSS.n72 1551.37
R2417 VSS.t1555 VSS.t798 1551.37
R2418 VSS.n29 VSS.t1604 1551.37
R2419 VSS.t247 VSS.n67 1551.37
R2420 VSS.t947 VSS.t443 1551.37
R2421 VSS.t313 VSS.t945 1525.68
R2422 VSS.t1741 VSS.t1540 1525.68
R2423 VSS.t424 VSS.t1359 1525.68
R2424 VSS.t1774 VSS.t221 1525.68
R2425 VSS.t1779 VSS.t1045 1525.68
R2426 VSS.t211 VSS.t849 1525.68
R2427 VSS.t191 VSS.t721 1525.68
R2428 VSS.t1832 VSS.t1039 1525.68
R2429 VSS.t689 VSS.t1313 1525.68
R2430 VSS.t1075 VSS.t669 1525.68
R2431 VSS.t373 VSS.t1078 1525.68
R2432 VSS.t1819 VSS.t467 1525.68
R2433 VSS.t30 VSS.t276 1525.68
R2434 VSS.t369 VSS.t1055 1525.68
R2435 VSS.t1012 VSS.t130 1525.68
R2436 VSS.t1703 VSS.t511 1525.68
R2437 VSS.t767 VSS.t1733 1525.68
R2438 VSS.t1454 VSS.t829 1525.68
R2439 VSS.t1492 VSS.t1516 1525.68
R2440 VSS.t1579 VSS.t938 1525.68
R2441 VSS.t1099 VSS.t1663 1525.68
R2442 VSS.t240 VSS.t1355 1525.68
R2443 VSS.t587 VSS.t988 1525.68
R2444 VSS.t1658 VSS.t1797 1525.68
R2445 VSS.t1618 VSS.t1506 1525.68
R2446 VSS.t613 VSS.t1192 1525.68
R2447 VSS.t1378 VSS.t1376 1469.18
R2448 VSS.t750 VSS.t751 1469.18
R2449 VSS.t335 VSS.t334 1469.18
R2450 VSS.t418 VSS.t420 1469.18
R2451 VSS.t768 VSS.t770 1469.18
R2452 VSS.t255 VSS.t253 1469.18
R2453 VSS.t494 VSS.t495 1469.18
R2454 VSS.t994 VSS.t995 1469.18
R2455 VSS.t438 VSS.t52 1469.18
R2456 VSS.t690 VSS.t691 1469.18
R2457 VSS.t1041 VSS.t1042 1469.18
R2458 VSS.t1775 VSS.t1776 1469.18
R2459 VSS.t941 VSS.t942 1469.18
R2460 VSS.t744 VSS.t745 1469.18
R2461 VSS.t299 VSS.t300 1469.18
R2462 VSS.t692 VSS.t693 1469.18
R2463 VSS.t1848 VSS.t476 1469.18
R2464 VSS.t1830 VSS.t1829 1469.18
R2465 VSS.t731 VSS.t730 1469.18
R2466 VSS.t1752 VSS.t1751 1469.18
R2467 VSS.t788 VSS.t786 1469.18
R2468 VSS.t1300 VSS.t1299 1469.18
R2469 VSS.t298 VSS.t296 1469.18
R2470 VSS.t1340 VSS.t1339 1469.18
R2471 VSS.t1067 VSS.t557 1469.18
R2472 VSS.t169 VSS.t171 1469.18
R2473 VSS.t563 VSS.t565 1469.18
R2474 VSS.t547 VSS.t548 1469.18
R2475 VSS.t847 VSS.t846 1469.18
R2476 VSS.t549 VSS.t551 1469.18
R2477 VSS.t678 VSS.t679 1469.18
R2478 VSS.t173 VSS.t174 1469.18
R2479 VSS.t521 VSS.t519 1469.18
R2480 VSS.t23 VSS.t25 1469.18
R2481 VSS.t119 VSS.t120 1469.18
R2482 VSS.t529 VSS.t528 1469.18
R2483 VSS.t1808 VSS.t1807 1469.18
R2484 VSS.t531 VSS.t532 1469.18
R2485 VSS.t1061 VSS.t1060 1469.18
R2486 VSS.t1056 VSS.t1057 1469.18
R2487 VSS.t1105 VSS.t1104 1469.18
R2488 VSS.t1504 VSS.t1502 1469.18
R2489 VSS.t8 VSS.t6 1469.18
R2490 VSS.t1518 VSS.t1517 1469.18
R2491 VSS.t839 VSS.t840 1469.18
R2492 VSS.t1509 VSS.t1508 1469.18
R2493 VSS.t841 VSS.t842 1469.18
R2494 VSS.t1534 VSS.t1535 1469.18
R2495 VSS.t1533 VSS.t923 1469.18
R2496 VSS.t363 VSS.t364 1469.18
R2497 VSS.t797 VSS.t794 1469.18
R2498 VSS.t1563 VSS.t1562 1469.18
R2499 VSS.t892 VSS.t891 1469.18
R2500 VSS.t1700 VSS.t1701 1469.18
R2501 VSS.t1560 VSS.t1561 1469.18
R2502 VSS.t826 VSS.t827 1469.18
R2503 VSS.t930 VSS.t496 1469.18
R2504 VSS.t1496 VSS.t1497 1469.18
R2505 VSS.t1323 VSS.t1324 1469.18
R2506 VSS.t1584 VSS.t1585 1469.18
R2507 VSS.t71 VSS.t69 1469.18
R2508 VSS.t753 VSS.t754 1469.18
R2509 VSS.t1720 VSS.t1721 1469.18
R2510 VSS.t1269 VSS.t1267 1469.18
R2511 VSS.t1205 VSS.t1204 1469.18
R2512 VSS.t1787 VSS.t1786 1469.18
R2513 VSS.t1102 VSS.t1103 1469.18
R2514 VSS.t1220 VSS.t1219 1469.18
R2515 VSS.t1271 VSS.t1272 1469.18
R2516 VSS.t1157 VSS.t385 1469.18
R2517 VSS.t627 VSS.t625 1469.18
R2518 VSS.t751 VSS.t1538 1417.81
R2519 VSS.t420 VSS.t1691 1417.81
R2520 VSS.t982 VSS.t255 1417.81
R2521 VSS.t995 VSS.t1418 1417.81
R2522 VSS.t691 VSS.t215 1417.81
R2523 VSS.t1776 VSS.t1326 1417.81
R2524 VSS.t745 VSS.t979 1417.81
R2525 VSS.t693 VSS.t304 1417.81
R2526 VSS.t1764 VSS.t1830 1417.81
R2527 VSS.t413 VSS.t1752 1417.81
R2528 VSS.t482 VSS.t1300 1417.81
R2529 VSS.t1769 VSS.t1340 1417.81
R2530 VSS.t171 VSS.t1035 1417.81
R2531 VSS.t548 VSS.t180 1417.81
R2532 VSS.t551 VSS.t713 1417.81
R2533 VSS.t174 VSS.t98 1417.81
R2534 VSS.t25 VSS.t539 1417.81
R2535 VSS.t358 VSS.t529 1417.81
R2536 VSS.t532 VSS.t280 1417.81
R2537 VSS.t1057 VSS.t1063 1417.81
R2538 VSS.t1639 VSS.t1504 1417.81
R2539 VSS.t1517 VSS.t1395 1417.81
R2540 VSS.t1508 VSS.t820 1417.81
R2541 VSS.t1535 VSS.t21 1417.81
R2542 VSS.t364 VSS.t1519 1417.81
R2543 VSS.t1562 VSS.t1365 1417.81
R2544 VSS.t1701 VSS.t1287 1417.81
R2545 VSS.t827 VSS.t513 1417.81
R2546 VSS.t1497 VSS.t1523 1417.81
R2547 VSS.t975 VSS.t1584 1417.81
R2548 VSS.t1721 VSS.t1555 1417.81
R2549 VSS.t1430 VSS.n69 1417.81
R2550 VSS.t1103 VSS.t947 1417.81
R2551 VSS.t1263 VSS.t1125 1407.53
R2552 VSS.t1261 VSS.t1798 1386.99
R2553 VSS.t1125 VSS.t1430 1386.99
R2554 VSS.t1408 VSS.t862 1366.44
R2555 VSS.t584 VSS.t843 1366.44
R2556 VSS.t1257 VSS.t75 1304.79
R2557 VSS.t1439 VSS.t1378 1294.52
R2558 VSS.t1104 VSS.t1724 1294.52
R2559 VSS.t1197 VSS.t294 1294.52
R2560 VSS.n20 VSS.t1164 1285.36
R2561 VSS.t1750 VSS.t1221 1258.56
R2562 VSS.t1092 VSS.t309 1253.42
R2563 VSS.t971 VSS.t1636 1253.42
R2564 VSS.t884 VSS.t1413 1243.15
R2565 VSS.t1236 VSS.n117 1243.15
R2566 VSS.t1407 VSS.t860 1238.01
R2567 VSS.t582 VSS.t845 1238.01
R2568 VSS.t887 VSS.t1409 1238.01
R2569 VSS.t56 VSS.t195 1217.47
R2570 VSS.t682 VSS.t477 1217.47
R2571 VSS.t562 VSS.t1811 1217.47
R2572 VSS.t640 VSS.t525 1217.47
R2573 VSS.t924 VSS.t1642 1217.47
R2574 VSS.t500 VSS.t1735 1217.47
R2575 VSS.n65 VSS.t1140 1217.47
R2576 VSS.t1228 VSS.t1029 1202.05
R2577 VSS.n127 VSS.t856 1171.23
R2578 VSS.n26 VSS.t1498 1171.23
R2579 VSS.t943 VSS.n25 1171.23
R2580 VSS.n107 VSS.t960 1171.23
R2581 VSS.n106 VSS.t1740 1171.23
R2582 VSS.n105 VSS.t1678 1171.23
R2583 VSS.t1358 VSS.n103 1171.23
R2584 VSS.n104 VSS.t773 1171.23
R2585 VSS.n96 VSS.t194 1171.23
R2586 VSS.n95 VSS.t59 1171.23
R2587 VSS.n94 VSS.t1771 1171.23
R2588 VSS.n92 VSS.t1319 1171.23
R2589 VSS.n91 VSS.t1777 1171.23
R2590 VSS.n90 VSS.t1379 1171.23
R2591 VSS.n89 VSS.t210 1171.23
R2592 VSS.n88 VSS.t850 1171.23
R2593 VSS.t680 VSS.n49 1171.23
R2594 VSS.t184 VSS.n50 1171.23
R2595 VSS.t716 VSS.n51 1171.23
R2596 VSS.t427 VSS.n52 1171.23
R2597 VSS.t1037 VSS.n53 1171.23
R2598 VSS.t734 VSS.n54 1171.23
R2599 VSS.t1309 VSS.n55 1171.23
R2600 VSS.t452 VSS.n56 1171.23
R2601 VSS.n48 VSS.t1809 1171.23
R2602 VSS.n47 VSS.t1084 1171.23
R2603 VSS.n46 VSS.t1072 1171.23
R2604 VSS.n44 VSS.t571 1171.23
R2605 VSS.t1076 VSS.n43 1171.23
R2606 VSS.n87 VSS.t673 1171.23
R2607 VSS.n86 VSS.t1817 1171.23
R2608 VSS.n85 VSS.t40 1171.23
R2609 VSS.n111 VSS.t522 1171.23
R2610 VSS.n110 VSS.t641 1171.23
R2611 VSS.n109 VSS.t27 1171.23
R2612 VSS.n108 VSS.t122 1171.23
R2613 VSS.t1052 VSS.n42 1171.23
R2614 VSS.n84 VSS.t541 1171.23
R2615 VSS.n83 VSS.t1010 1171.23
R2616 VSS.n82 VSS.t33 1171.23
R2617 VSS.t578 VSS.n38 1171.23
R2618 VSS.t1686 VSS.n39 1171.23
R2619 VSS.t510 VSS.n40 1171.23
R2620 VSS.n81 VSS.t1421 1171.23
R2621 VSS.n80 VSS.t761 1171.23
R2622 VSS.n79 VSS.t810 1171.23
R2623 VSS.n78 VSS.t1452 1171.23
R2624 VSS.n77 VSS.t265 1171.23
R2625 VSS.n37 VSS.t1641 1171.23
R2626 VSS.n36 VSS.t347 1171.23
R2627 VSS.n35 VSS.t1489 1171.23
R2628 VSS.n33 VSS.t1565 1171.23
R2629 VSS.t937 VSS.n32 1171.23
R2630 VSS.n76 VSS.t1403 1171.23
R2631 VSS.n75 VSS.t1095 1171.23
R2632 VSS.n74 VSS.t707 1171.23
R2633 VSS.n115 VSS.t1736 1171.23
R2634 VSS.n114 VSS.t1528 1171.23
R2635 VSS.n113 VSS.t239 1171.23
R2636 VSS.n112 VSS.t697 1171.23
R2637 VSS.t69 VSS.n31 1171.23
R2638 VSS.n73 VSS.t887 1171.23
R2639 VSS.n72 VSS.t585 1171.23
R2640 VSS.n71 VSS.t1550 1171.23
R2641 VSS.t594 VSS.n27 1171.23
R2642 VSS.t1795 VSS.n29 1171.23
R2643 VSS.n67 VSS.t1617 1171.23
R2644 VSS.n66 VSS.t873 1171.23
R2645 VSS.t1116 VSS.t1217 1171.23
R2646 VSS.n60 VSS.t403 1171.23
R2647 VSS.n59 VSS.t898 1171.23
R2648 VSS.t408 VSS.t1239 1166.1
R2649 VSS.t403 VSS.t1241 1160.96
R2650 VSS.t1722 VSS.t1206 1155.82
R2651 VSS.t1839 VSS.t902 1150.68
R2652 VSS.t1574 VSS.t1572 1150.68
R2653 VSS.t459 VSS.t361 1150.68
R2654 VSS.t1431 VSS.t394 1150.68
R2655 VSS.t1167 VSS.t1225 1150.68
R2656 VSS.t1196 VSS.t1119 1150.68
R2657 VSS.t1398 VSS.t1209 1150.68
R2658 VSS.n127 VSS.t1092 1119.86
R2659 VSS.n38 VSS.t971 1119.86
R2660 VSS.t1229 VSS.t1271 1119.86
R2661 VSS.t1001 VSS.t84 1109.59
R2662 VSS.t460 VSS.t1058 1109.59
R2663 VSS.t1193 VSS.t400 1109.59
R2664 VSS.t1256 VSS.t1756 1109.59
R2665 VSS.t1500 VSS.t230 1094.18
R2666 VSS.t962 VSS.t442 1094.18
R2667 VSS.t1292 VSS.t1681 1094.18
R2668 VSS.t779 VSS.t1459 1094.18
R2669 VSS.t65 VSS.t488 1094.18
R2670 VSS.t1321 VSS.t201 1094.18
R2671 VSS.t1381 VSS.t205 1094.18
R2672 VSS.t853 VSS.t491 1094.18
R2673 VSS.t142 VSS.t187 1094.18
R2674 VSS.t685 VSS.t432 1094.18
R2675 VSS.t1298 VSS.t738 1094.18
R2676 VSS.t1331 VSS.t456 1094.18
R2677 VSS.t1085 VSS.t1071 1094.18
R2678 VSS.t574 VSS.t648 1094.18
R2679 VSS.t676 VSS.t652 1094.18
R2680 VSS.t44 VSS.t1081 1094.18
R2681 VSS.t643 VSS.t272 1094.18
R2682 VSS.t629 VSS.t127 1094.18
R2683 VSS.t545 VSS.t631 1094.18
R2684 VSS.t39 VSS.t534 1094.18
R2685 VSS.t1836 VSS.t1689 1094.18
R2686 VSS.t1424 VSS.t1762 1094.18
R2687 VSS.t816 VSS.t1487 1094.18
R2688 VSS.t269 VSS.t1704 1094.18
R2689 VSS.t348 VSS.t1613 1094.18
R2690 VSS.t1566 VSS.t1462 1094.18
R2691 VSS.t1406 VSS.t997 1094.18
R2692 VSS.t708 VSS.t1729 1094.18
R2693 VSS.t1527 VSS.t1383 1094.18
R2694 VSS.t1495 VSS.t703 1094.18
R2695 VSS.t1548 VSS.t1571 1094.18
R2696 VSS.t596 VSS.t908 1094.18
R2697 VSS.t871 VSS.t1127 1094.18
R2698 VSS.t1253 VSS.t1190 1094.18
R2699 VSS.t1219 VSS.t1149 1094.18
R2700 VSS.t1710 VSS.t1207 1089.04
R2701 VSS.t555 VSS.t567 1089.04
R2702 VSS.t1129 VSS.t518 1078.77
R2703 VSS.t1410 VSS.t261 1078.77
R2704 VSS.t1154 VSS.t1179 1078.77
R2705 VSS.t600 VSS.t1202 1078.77
R2706 VSS.t1267 VSS.t371 1068.49
R2707 VSS.t1614 VSS.t396 1068.49
R2708 VSS.t1166 VSS.t607 1068.49
R2709 VSS.t1391 VSS.t1228 1068.49
R2710 VSS.t1262 VSS.t1238 1068.49
R2711 VSS.t1469 VSS.t155 1068.49
R2712 VSS.t625 VSS.t1750 1063.36
R2713 VSS.t854 VSS.t227 1047.95
R2714 VSS.t1094 VSS.t1407 1047.95
R2715 VSS.t862 VSS.t1439 1047.95
R2716 VSS.t1442 VSS.t228 1047.95
R2717 VSS.t1501 VSS.t1537 1047.95
R2718 VSS.t311 VSS.t1539 1047.95
R2719 VSS.t864 VSS.t946 1047.95
R2720 VSS.t867 VSS.t440 1047.95
R2721 VSS.t963 VSS.t1692 1047.95
R2722 VSS.t1694 VSS.t1542 1047.95
R2723 VSS.t1742 VSS.t830 1047.95
R2724 VSS.t1291 VSS.t831 1047.95
R2725 VSS.t984 VSS.t1679 1047.95
R2726 VSS.t422 VSS.t986 1047.95
R2727 VSS.t1347 VSS.t1361 1047.95
R2728 VSS.t1350 VSS.t1458 1047.95
R2729 VSS.t775 VSS.t1417 1047.95
R2730 VSS.t52 VSS.t436 1047.95
R2731 VSS.t58 VSS.t1781 1047.95
R2732 VSS.t741 VSS.t487 1047.95
R2733 VSS.t61 VSS.t214 1047.95
R2734 VSS.t219 VSS.t220 1047.95
R2735 VSS.t1772 VSS.t322 1047.95
R2736 VSS.t323 VSS.t199 1047.95
R2737 VSS.t1322 VSS.t1325 1047.95
R2738 VSS.t1329 VSS.t1043 1047.95
R2739 VSS.t1780 VSS.t327 1047.95
R2740 VSS.t332 VSS.t203 1047.95
R2741 VSS.t1382 VSS.t978 1047.95
R2742 VSS.t981 VSS.t848 1047.95
R2743 VSS.t213 VSS.t746 1047.95
R2744 VSS.t749 VSS.t489 1047.95
R2745 VSS.t851 VSS.t302 1047.95
R2746 VSS.t476 VSS.t727 1047.95
R2747 VSS.t686 VSS.t479 1047.95
R2748 VSS.t140 VSS.t287 1047.95
R2749 VSS.t1763 VSS.t188 1047.95
R2750 VSS.t189 VSS.t1766 1047.95
R2751 VSS.t469 VSS.t718 1047.95
R2752 VSS.t684 VSS.t472 1047.95
R2753 VSS.t409 VSS.t429 1047.95
R2754 VSS.t1831 VSS.t411 1047.95
R2755 VSS.t1293 VSS.t1040 1047.95
R2756 VSS.t1297 VSS.t1296 1047.95
R2757 VSS.t480 VSS.t739 1047.95
R2758 VSS.t688 VSS.t486 1047.95
R2759 VSS.t1087 VSS.t1310 1047.95
R2760 VSS.t1330 VSS.t1090 1047.95
R2761 VSS.t1767 VSS.t458 1047.95
R2762 VSS.t557 VSS.t168 1047.95
R2763 VSS.t558 VSS.t1827 1047.95
R2764 VSS.t1816 VSS.t1069 1047.95
R2765 VSS.t1086 VSS.t1033 1047.95
R2766 VSS.t1034 VSS.t667 1047.95
R2767 VSS.t1073 VSS.t1021 1047.95
R2768 VSS.t1024 VSS.t649 1047.95
R2769 VSS.t575 VSS.t176 1047.95
R2770 VSS.t372 VSS.t178 1047.95
R2771 VSS.t1025 VSS.t1079 1047.95
R2772 VSS.t1028 VSS.t650 1047.95
R2773 VSS.t677 VSS.t712 1047.95
R2774 VSS.t715 VSS.t465 1047.95
R2775 VSS.t1820 VSS.t1821 1047.95
R2776 VSS.t1824 VSS.t1080 1047.95
R2777 VSS.t46 VSS.t95 1047.95
R2778 VSS.t519 VSS.t624 1047.95
R2779 VSS.t638 VSS.t535 1047.95
R2780 VSS.t92 VSS.t271 1047.95
R2781 VSS.t644 VSS.t537 1047.95
R2782 VSS.t538 VSS.t275 1047.95
R2783 VSS.t32 VSS.t1799 1047.95
R2784 VSS.t628 VSS.t1802 1047.95
R2785 VSS.t357 VSS.t123 1047.95
R2786 VSS.t368 VSS.t359 1047.95
R2787 VSS.t1005 VSS.t1053 1047.95
R2788 VSS.t1008 VSS.t630 1047.95
R2789 VSS.t546 VSS.t277 1047.95
R2790 VSS.t279 VSS.t128 1047.95
R2791 VSS.t1013 VSS.t632 1047.95
R2792 VSS.t635 VSS.t533 1047.95
R2793 VSS.t35 VSS.t1062 1047.95
R2794 VSS.t1707 VSS.t1677 1047.95
R2795 VSS.t845 VSS.t973 1047.95
R2796 VSS.t1724 VSS.t584 1047.95
R2797 VSS.t1837 VSS.t1725 1047.95
R2798 VSS.t1637 VSS.t1690 1047.95
R2799 VSS.t1702 VSS.t1638 1047.95
R2800 VSS.t1632 VSS.t512 1047.95
R2801 VSS.t1635 VSS.t1761 1047.95
R2802 VSS.t1425 VSS.t1392 1047.95
R2803 VSS.t1394 VSS.t1732 1047.95
R2804 VSS.t763 VSS.t1624 1047.95
R2805 VSS.t1625 VSS.t1488 1047.95
R2806 VSS.t812 VSS.t817 1047.95
R2807 VSS.t818 VSS.t828 1047.95
R2808 VSS.t1455 VSS.t756 1047.95
R2809 VSS.t758 VSS.t1705 1047.95
R2810 VSS.t270 VSS.t17 1047.95
R2811 VSS.t923 VSS.t1315 1047.95
R2812 VSS.t926 VSS.t1303 1047.95
R2813 VSS.t1583 VSS.t1612 1047.95
R2814 VSS.t350 VSS.t1520 1047.95
R2815 VSS.t1522 VSS.t1515 1047.95
R2816 VSS.t1493 VSS.t806 1047.95
R2817 VSS.t809 VSS.t1463 1047.95
R2818 VSS.t1567 VSS.t1363 1047.95
R2819 VSS.t1578 VSS.t1367 1047.95
R2820 VSS.t315 VSS.t939 1047.95
R2821 VSS.t317 VSS.t996 1047.95
R2822 VSS.t1404 VSS.t1288 1047.95
R2823 VSS.t1290 VSS.t1662 1047.95
R2824 VSS.t1101 VSS.t1447 1047.95
R2825 VSS.t1448 VSS.t1728 1047.95
R2826 VSS.t709 VSS.t516 1047.95
R2827 VSS.t496 VSS.t838 1047.95
R2828 VSS.t502 VSS.t1695 1047.95
R2829 VSS.t957 VSS.t1385 1047.95
R2830 VSS.t1530 VSS.t1524 1047.95
R2831 VSS.t1526 VSS.t1356 1047.95
R2832 VSS.t242 VSS.t801 1047.95
R2833 VSS.t1494 VSS.t804 1047.95
R2834 VSS.t974 VSS.t699 1047.95
R2835 VSS.t1413 VSS.t1834 1047.95
R2836 VSS.t890 VSS.t337 1047.95
R2837 VSS.t343 VSS.t987 1047.95
R2838 VSS.t589 VSS.t1510 1047.95
R2839 VSS.t1514 VSS.t1570 1047.95
R2840 VSS.t1552 VSS.t1553 1047.95
R2841 VSS.t991 VSS.t909 1047.95
R2842 VSS.t1216 VSS.t1609 1047.95
R2843 VSS.t1657 VSS.t1602 1047.95
R2844 VSS.t245 VSS.t1505 1047.95
R2845 VSS.t1619 VSS.t1716 1047.95
R2846 VSS.t1717 VSS.t1126 1047.95
R2847 VSS.t874 VSS.t948 1047.95
R2848 VSS.t462 VSS.t1235 1047.95
R2849 VSS.t118 VSS.t384 1047.95
R2850 VSS.t901 VSS.t1157 1047.95
R2851 VSS.t740 VSS.t1784 1037.67
R2852 VSS.t289 VSS.t283 1037.67
R2853 VSS.t1813 VSS.t784 1037.67
R2854 VSS.t86 VSS.t1805 1037.67
R2855 VSS.t1580 VSS.t1387 1037.67
R2856 VSS.t951 VSS.t1671 1037.67
R2857 VSS.t605 VSS.t1186 1037.67
R2858 VSS.t1203 VSS.t1197 1027.4
R2859 VSS.t865 VSS.t335 986.302
R2860 VSS.t770 VSS.t833 986.302
R2861 VSS.t1348 VSS.t494 986.302
R2862 VSS.t1042 VSS.t324 986.302
R2863 VSS.t942 VSS.t329 986.302
R2864 VSS.t300 VSS.t747 986.302
R2865 VSS.t470 VSS.t731 986.302
R2866 VSS.t1294 VSS.t788 986.302
R2867 VSS.t1088 VSS.t298 986.302
R2868 VSS.t565 VSS.t1022 986.302
R2869 VSS.t1026 VSS.t847 986.302
R2870 VSS.t679 VSS.t1822 986.302
R2871 VSS.t120 VSS.t1800 986.302
R2872 VSS.t1006 VSS.t1808 986.302
R2873 VSS.t1060 VSS.t633 986.302
R2874 VSS.t1633 VSS.t8 986.302
R2875 VSS.t840 VSS.t1626 986.302
R2876 VSS.t842 VSS.t759 986.302
R2877 VSS.t794 VSS.t805 986.302
R2878 VSS.t319 VSS.t892 986.302
R2879 VSS.t1561 VSS.t1449 986.302
R2880 VSS.t1324 VSS.t802 986.302
R2881 VSS.t754 VSS.t1511 986.302
R2882 VSS.t1786 VSS.t1718 986.302
R2883 VSS.t1238 VSS.n60 986.302
R2884 VSS.t1032 VSS.t659 976.028
R2885 VSS.t161 VSS.t1249 965.754
R2886 VSS.t903 VSS.t1667 955.48
R2887 VSS.n20 VSS.t79 951.452
R2888 VSS.t80 VSS.t1714 919.521
R2889 VSS.t1601 VSS.t1468 919.521
R2890 VSS.t0 VSS.t148 914.385
R2891 VSS.t1604 VSS.t1465 914.385
R2892 VSS.t607 VSS.t1168 909.247
R2893 VSS.t334 VSS.t864 863.014
R2894 VSS.t830 VSS.t768 863.014
R2895 VSS.t495 VSS.t1347 863.014
R2896 VSS.t322 VSS.t1041 863.014
R2897 VSS.t327 VSS.t941 863.014
R2898 VSS.t746 VSS.t299 863.014
R2899 VSS.t730 VSS.t469 863.014
R2900 VSS.t786 VSS.t1293 863.014
R2901 VSS.t296 VSS.t1087 863.014
R2902 VSS.t1021 VSS.t563 863.014
R2903 VSS.t846 VSS.t1025 863.014
R2904 VSS.t1821 VSS.t678 863.014
R2905 VSS.t1799 VSS.t119 863.014
R2906 VSS.t1807 VSS.t1005 863.014
R2907 VSS.t632 VSS.t1061 863.014
R2908 VSS.t6 VSS.t1632 863.014
R2909 VSS.t1624 VSS.t839 863.014
R2910 VSS.t756 VSS.t841 863.014
R2911 VSS.t806 VSS.t797 863.014
R2912 VSS.t891 VSS.t315 863.014
R2913 VSS.t1447 VSS.t1560 863.014
R2914 VSS.t801 VSS.t1323 863.014
R2915 VSS.t1510 VSS.t753 863.014
R2916 VSS.t1588 VSS.t1682 863.014
R2917 VSS.t1589 VSS.t1684 863.014
R2918 VSS.t1591 VSS.t1685 863.014
R2919 VSS.t1592 VSS.t1683 863.014
R2920 VSS.t919 VSS.t243 863.014
R2921 VSS.t1716 VSS.t1787 863.014
R2922 VSS.n61 VSS.t1106 842.466
R2923 VSS.t940 VSS.t339 821.918
R2924 VSS.t135 VSS.t1244 821.918
R2925 VSS.t1155 VSS.t556 816.782
R2926 VSS.t855 VSS.t1842 791.096
R2927 VSS.t1706 VSS.t1577 791.096
R2928 VSS.t1235 VSS.t1184 770.548
R2929 VSS.t258 VSS.t1280 760.274
R2930 VSS.t447 VSS.n68 760.274
R2931 VSS.n117 VSS.t658 760.274
R2932 VSS.t77 VSS.t992 750
R2933 VSS.t1461 VSS.t1412 739.726
R2934 VSS.t1659 VSS.t619 739.726
R2935 VSS.n58 VSS.t1187 739.726
R2936 VSS.t223 VSS.n126 734.59
R2937 VSS.n125 VSS.t433 734.59
R2938 VSS.n124 VSS.t726 734.59
R2939 VSS.n123 VSS.t164 734.59
R2940 VSS.n122 VSS.t621 734.59
R2941 VSS.n121 VSS.t1675 734.59
R2942 VSS.n120 VSS.t1314 734.59
R2943 VSS.n119 VSS.t835 734.59
R2944 VSS.n118 VSS.t1150 734.59
R2945 VSS.t1412 VSS.t1460 729.452
R2946 VSS.t591 VSS.t1712 719.178
R2947 VSS.t1237 VSS.t112 719.178
R2948 VSS.t1184 VSS.t1236 698.63
R2949 VSS.t1842 VSS.t854 678.082
R2950 VSS.t1577 VSS.t1707 678.082
R2951 VSS.n70 VSS.t360 678.082
R2952 VSS.t1180 VSS.t1214 678.082
R2953 VSS.t598 VSS.t618 678.082
R2954 VSS.t384 VSS.t901 678.082
R2955 VSS.t670 VSS.t1068 667.808
R2956 VSS.t1835 VSS.t888 631.85
R2957 VSS.t198 VSS.t1783 616.438
R2958 VSS.t288 VSS.t681 616.438
R2959 VSS.t1810 VSS.t782 616.438
R2960 VSS.t524 VSS.t1804 616.438
R2961 VSS.t1644 VSS.t1386 616.438
R2962 VSS.t1738 VSS.t1673 616.438
R2963 VSS.t569 VSS.t977 616.438
R2964 VSS.t1794 VSS.t149 616.438
R2965 VSS.t1153 VSS.t1730 616.438
R2966 VSS.t897 VSS.t1341 616.438
R2967 VSS.t1233 VSS.t1247 616.438
R2968 VSS.t15 VSS.t461 616.438
R2969 VSS.t243 VSS.t917 606.164
R2970 VSS.t1446 VSS.t976 590.754
R2971 VSS.t1843 VSS.t615 575.342
R2972 VSS.t1128 VSS.t263 565.068
R2973 VSS.t1201 VSS.t1188 565.068
R2974 VSS.t902 VSS.t1457 554.794
R2975 VSS.t1376 VSS.t1440 554.794
R2976 VSS.t1572 VSS.t1611 554.794
R2977 VSS.t1726 VSS.t1105 554.794
R2978 VSS.t1207 VSS.t1446 554.794
R2979 VSS.t967 VSS.t1710 554.794
R2980 VSS.t518 VSS.t672 554.794
R2981 VSS.t606 VSS.t144 554.794
R2982 VSS.t906 VSS.t1269 554.794
R2983 VSS.t75 VSS.t1266 554.794
R2984 VSS.t361 VSS.t1181 554.794
R2985 VSS.t377 VSS.t459 554.794
R2986 VSS.t617 VSS.t258 554.794
R2987 VSS.t1598 VSS.t1263 554.794
R2988 VSS.t1206 VSS.t447 554.794
R2989 VSS.t659 VSS.t1167 554.794
R2990 VSS.t1117 VSS.t1213 554.794
R2991 VSS.t1164 VSS.t1166 554.794
R2992 VSS.t1223 VSS.t1208 554.794
R2993 VSS.t13 VSS.t1110 554.794
R2994 VSS.t1068 VSS.t603 554.794
R2995 VSS.t1209 VSS.t1470 554.794
R2996 VSS.t112 VSS.n59 554.794
R2997 VSS.t977 VSS.t967 534.247
R2998 VSS.t1109 VSS.t1843 534.247
R2999 VSS.t461 VSS.t1227 534.247
R3000 VSS.t672 VSS.t391 523.973
R3001 VSS.t389 VSS.t1129 523.973
R3002 VSS.t1210 VSS.t1608 523.973
R3003 VSS.t590 VSS.t1210 523.973
R3004 VSS.t144 VSS.t80 523.973
R3005 VSS.t82 VSS.t606 523.973
R3006 VSS.t83 VSS.t1257 523.973
R3007 VSS.t1276 VSS.t77 523.973
R3008 VSS.t1609 VSS.t1276 523.973
R3009 VSS.t1258 VSS.t1216 523.973
R3010 VSS.t1058 VSS.t108 523.973
R3011 VSS.t150 VSS.t85 523.973
R3012 VSS.t402 VSS.t111 523.973
R3013 VSS.t148 VSS.t1794 523.973
R3014 VSS.t1204 VSS.t1261 523.973
R3015 VSS.t378 VSS.t375 523.973
R3016 VSS.t376 VSS.t379 523.973
R3017 VSS.t259 VSS.t1594 523.973
R3018 VSS.t1179 VSS.t390 523.973
R3019 VSS.t390 VSS.t135 523.973
R3020 VSS.t394 VSS.t1596 523.973
R3021 VSS.t1596 VSS.t600 523.973
R3022 VSS.t1111 VSS.t1734 523.973
R3023 VSS.t397 VSS.t601 523.973
R3024 VSS.t1660 VSS.t710 523.973
R3025 VSS.t932 VSS.t1211 523.973
R3026 VSS.t1754 VSS.t1112 523.973
R3027 VSS.t1113 VSS.t1755 523.973
R3028 VSS.t1232 VSS.t416 523.973
R3029 VSS.t1844 VSS.t1232 523.973
R3030 VSS.t1168 VSS.t1169 523.973
R3031 VSS.t1169 VSS.t1170 523.973
R3032 VSS.t1170 VSS.t1171 523.973
R3033 VSS.t1171 VSS.t1172 523.973
R3034 VSS.t1173 VSS.t1174 523.973
R3035 VSS.t1174 VSS.t1175 523.973
R3036 VSS.t1175 VSS.t1176 523.973
R3037 VSS.t1176 VSS.t1251 523.973
R3038 VSS.t1251 VSS.t1252 523.973
R3039 VSS.t1252 VSS.t1253 523.973
R3040 VSS.t1141 VSS.t1666 523.973
R3041 VSS.t1143 VSS.t1142 523.973
R3042 VSS.t1144 VSS.t1143 523.973
R3043 VSS.t1145 VSS.t1144 523.973
R3044 VSS.t1146 VSS.t1145 523.973
R3045 VSS.t1147 VSS.t1146 523.973
R3046 VSS.t1149 VSS.t1148 523.973
R3047 VSS.t1254 VSS.t1250 523.973
R3048 VSS.t1255 VSS.t1254 523.973
R3049 VSS.t1132 VSS.t1131 523.973
R3050 VSS.t1134 VSS.t1133 523.973
R3051 VSS.t1135 VSS.t1134 523.973
R3052 VSS.t1136 VSS.t1135 523.973
R3053 VSS.t1139 VSS.t1138 523.973
R3054 VSS.t1222 VSS.t388 523.973
R3055 VSS.t1607 VSS.t159 523.973
R3056 VSS.t159 VSS.t1009 523.973
R3057 VSS.t392 VSS.t570 523.973
R3058 VSS.t1281 VSS.t134 523.973
R3059 VSS.t134 VSS.t599 523.973
R3060 VSS.t1277 VSS.t598 523.973
R3061 VSS.t1759 VSS.t1230 523.973
R3062 VSS.t1231 VSS.t1760 523.973
R3063 VSS.t733 VSS.t1260 513.699
R3064 VSS.t858 VSS.t1093 508.562
R3065 VSS.t972 VSS.t580 508.562
R3066 VSS.t1131 VSS.t662 508.562
R3067 VSS.t382 VSS.t462 503.425
R3068 VSS.t1249 VSS.t162 503.425
R3069 VSS.t1212 VSS.t670 503.425
R3070 VSS.t1214 VSS.t1195 493.151
R3071 VSS.t263 VSS.t1708 488.014
R3072 VSS.t1444 VSS.t389 482.877
R3073 VSS.t1245 VSS.t1123 482.877
R3074 VSS.t657 VSS.t1226 482.877
R3075 VSS.t614 VSS.t1471 482.877
R3076 VSS.t132 VSS.t671 477.74
R3077 VSS.t1833 VSS.t54 472.603
R3078 VSS.t47 VSS.t473 472.603
R3079 VSS.t646 VSS.t560 472.603
R3080 VSS.t450 VSS.t639 472.603
R3081 VSS.t875 VSS.t920 472.603
R3082 VSS.t1474 VSS.t498 472.603
R3083 VSS.t1712 VSS.t146 472.603
R3084 VSS.t1665 VSS.t1224 467.466
R3085 VSS.t666 VSS.t1472 467.466
R3086 VSS.t1597 VSS.t397 462.329
R3087 VSS.t1266 VSS.t991 452.055
R3088 VSS.t151 VSS.t903 452.055
R3089 VSS.t966 VSS.t989 452.055
R3090 VSS.t927 VSS.t990 452.055
R3091 VSS.t1279 VSS.t555 452.055
R3092 VSS.t106 VSS.t1398 452.055
R3093 VSS.t1152 VSS.n57 452.055
R3094 VSS.t1666 VSS.t1274 436.644
R3095 VSS.t618 VSS.t399 436.644
R3096 VSS.t1758 VSS.t1201 436.644
R3097 VSS.t1537 VSS.t750 431.507
R3098 VSS.t1692 VSS.t418 431.507
R3099 VSS.t253 VSS.t984 431.507
R3100 VSS.t1417 VSS.t994 431.507
R3101 VSS.t1783 VSS.t740 431.507
R3102 VSS.t214 VSS.t690 431.507
R3103 VSS.t1325 VSS.t1775 431.507
R3104 VSS.t978 VSS.t744 431.507
R3105 VSS.t302 VSS.t692 431.507
R3106 VSS.t283 VSS.t288 431.507
R3107 VSS.t1829 VSS.t1763 431.507
R3108 VSS.t1751 VSS.t409 431.507
R3109 VSS.t1299 VSS.t480 431.507
R3110 VSS.t1339 VSS.t1767 431.507
R3111 VSS.t782 VSS.t1813 431.507
R3112 VSS.t1033 VSS.t169 431.507
R3113 VSS.t176 VSS.t547 431.507
R3114 VSS.t712 VSS.t549 431.507
R3115 VSS.t95 VSS.t173 431.507
R3116 VSS.t1804 VSS.t86 431.507
R3117 VSS.t537 VSS.t23 431.507
R3118 VSS.t528 VSS.t357 431.507
R3119 VSS.t277 VSS.t531 431.507
R3120 VSS.t1062 VSS.t1056 431.507
R3121 VSS.t1502 VSS.t1637 431.507
R3122 VSS.t1392 VSS.t1518 431.507
R3123 VSS.t817 VSS.t1509 431.507
R3124 VSS.t17 VSS.t1534 431.507
R3125 VSS.t1386 VSS.t1580 431.507
R3126 VSS.t1520 VSS.t363 431.507
R3127 VSS.t1363 VSS.t1563 431.507
R3128 VSS.t1288 VSS.t1700 431.507
R3129 VSS.t516 VSS.t826 431.507
R3130 VSS.t1673 VSS.t951 431.507
R3131 VSS.t1524 VSS.t1496 431.507
R3132 VSS.t1585 VSS.t974 431.507
R3133 VSS.t1443 VSS.t569 431.507
R3134 VSS.t1553 VSS.t1720 431.507
R3135 VSS.n70 VSS.t377 431.507
R3136 VSS.t948 VSS.t1102 431.507
R3137 VSS.t388 VSS.t553 431.507
R3138 VSS.t567 VSS.t1273 431.507
R3139 VSS.t1031 VSS.t1155 431.507
R3140 VSS.t1009 VSS.t597 431.507
R3141 VSS.t1106 VSS.t863 431.507
R3142 VSS.t1401 VSS.t1262 431.507
R3143 VSS.t1187 VSS.t605 431.507
R3144 VSS.t1186 VSS.t604 431.507
R3145 VSS.t111 VSS.t4 421.233
R3146 VSS.t616 VSS.t102 421.233
R3147 VSS.t396 VSS.t1128 416.096
R3148 VSS.t1142 VSS.t660 416.096
R3149 VSS.t292 VSS.t658 410.959
R3150 VSS.t1234 VSS.t1180 410.959
R3151 VSS.t1122 VSS.t1107 410.959
R3152 VSS.t1282 VSS.t1615 400.685
R3153 VSS.t136 VSS.t1111 400.685
R3154 VSS.t1049 VSS.t247 390.411
R3155 VSS.t1247 VSS.t1120 380.137
R3156 VSS.t619 VSS.t1185 369.863
R3157 VSS.t992 VSS.t83 359.589
R3158 VSS.t1451 VSS.t1595 359.589
R3159 VSS.t398 VSS.t260 359.589
R3160 VSS.t1244 VSS.t1598 359.589
R3161 VSS.t1593 VSS.t825 359.589
R3162 VSS.t1441 VSS.t1499 354.452
R3163 VSS.t866 VSS.t961 354.452
R3164 VSS.t1680 VSS.t834 354.452
R3165 VSS.t1349 VSS.t777 354.452
R3166 VSS.t743 VSS.t63 354.452
R3167 VSS.t326 VSS.t1320 354.452
R3168 VSS.t331 VSS.t1380 354.452
R3169 VSS.t748 VSS.t852 354.452
R3170 VSS.t186 VSS.t286 354.452
R3171 VSS.t430 VSS.t471 354.452
R3172 VSS.t736 VSS.t1295 354.452
R3173 VSS.t454 VSS.t1089 354.452
R3174 VSS.t1815 VSS.t1082 354.452
R3175 VSS.t1023 VSS.t572 354.452
R3176 VSS.t1027 VSS.t675 354.452
R3177 VSS.t1823 VSS.t42 354.452
R3178 VSS.t90 VSS.t642 354.452
R3179 VSS.t125 VSS.t1801 354.452
R3180 VSS.t1007 VSS.t543 354.452
R3181 VSS.t634 VSS.t37 354.452
R3182 VSS.t1687 VSS.t1727 354.452
R3183 VSS.t1634 VSS.t1422 354.452
R3184 VSS.t1627 VSS.t814 354.452
R3185 VSS.t760 VSS.t267 354.452
R3186 VSS.t1582 VSS.t344 354.452
R3187 VSS.t807 VSS.t1564 354.452
R3188 VSS.t321 VSS.t1405 354.452
R3189 VSS.t1450 VSS.t704 354.452
R3190 VSS.t955 VSS.t1529 354.452
R3191 VSS.t701 VSS.t803 354.452
R3192 VSS.t1512 VSS.t1551 354.452
R3193 VSS.t1719 VSS.t868 354.452
R3194 VSS.t1156 VSS.t1132 354.452
R3195 VSS.t108 VSS.t1586 349.315
R3196 VSS.t147 VSS.t1426 349.315
R3197 VSS.t104 VSS.t1199 349.315
R3198 VSS.t1280 VSS.t100 349.315
R3199 VSS.t1723 VSS.t1614 349.315
R3200 VSS.t597 VSS.t1223 349.315
R3201 VSS.t1587 VSS.t1258 339.041
R3202 VSS.t73 VSS.t460 339.041
R3203 VSS.t556 VSS.t1607 333.904
R3204 VSS.t146 VSS.t82 328.767
R3205 VSS.t907 VSS.t591 328.767
R3206 VSS.t1189 VSS.t1248 328.767
R3207 VSS.t999 VSS.t257 328.767
R3208 VSS.t1470 VSS.n61 328.767
R3209 VSS.t405 VSS.t1237 328.767
R3210 VSS.t1138 VSS.n64 323.63
R3211 VSS.t1182 VSS.t1139 323.63
R3212 VSS.t401 VSS.t1193 318.493
R3213 VSS.t85 VSS.t110 318.493
R3214 VSS.t149 VSS.t402 318.493
R3215 VSS.t360 VSS.t378 318.493
R3216 VSS.t379 VSS.t905 318.493
R3217 VSS.t1594 VSS.t1731 318.493
R3218 VSS.t710 VSS.t1670 318.493
R3219 VSS.t1838 VSS.t824 318.493
R3220 VSS.t1211 VSS.t1697 318.493
R3221 VSS.t1226 VSS.t1754 318.493
R3222 VSS.t1177 VSS.t1113 318.493
R3223 VSS.t1213 VSS.t732 318.493
R3224 VSS.t615 VSS.t1108 318.493
R3225 VSS.t1427 VSS.t15 318.493
R3226 VSS.t1757 VSS.t426 318.493
R3227 VSS.t1230 VSS.t1130 318.493
R3228 VSS.t1760 VSS.t1400 318.493
R3229 VSS.t1731 VSS.t1456 313.356
R3230 VSS.t145 VSS.t1427 313.356
R3231 VSS.t1172 VSS.t611 313.356
R3232 VSS.t601 VSS.t620 308.219
R3233 VSS.t1302 VSS.t1659 308.219
R3234 VSS.t895 VSS.t932 308.219
R3235 VSS.n68 VSS.t1588 308.219
R3236 VSS.t380 VSS.t1256 308.219
R3237 VSS.t417 VSS.t1198 308.219
R3238 VSS.t1208 VSS.t13 308.219
R3239 VSS.t153 VSS.t1018 308.219
R3240 VSS.t1748 VSS.t10 308.219
R3241 VSS.n28 VSS.t401 297.945
R3242 VSS.t1265 VSS.t1177 297.945
R3243 VSS.t568 VSS.t1278 297.945
R3244 VSS.t1246 VSS.t1222 297.945
R3245 VSS.t1130 VSS.t1000 297.945
R3246 VSS.t1215 VSS.t93 282.534
R3247 VSS.t1429 VSS.t16 282.534
R3248 VSS.t664 VSS.t1147 282.534
R3249 VSS.t1181 VSS.t1205 277.397
R3250 VSS.t1730 VSS.t1243 277.397
R3251 VSS.t1375 VSS.t1661 277.397
R3252 VSS.t1341 VSS.t1200 277.397
R3253 VSS.t1108 VSS.t1218 277.397
R3254 VSS.t79 VSS.t1428 272.26
R3255 VSS.t1091 VSS.t855 256.849
R3256 VSS.t969 VSS.t1706 256.849
R3257 VSS.t1278 VSS.t1246 256.849
R3258 VSS.t1428 VSS.t1429 251.713
R3259 VSS.t1788 VSS.t890 246.576
R3260 VSS.t1243 VSS.t1154 246.576
R3261 VSS.t620 VSS.t1302 246.576
R3262 VSS.t711 VSS.t1375 246.576
R3263 VSS.t1661 VSS.t1559 246.576
R3264 VSS.t1200 VSS.t895 246.576
R3265 VSS.t1218 VSS.t417 246.576
R3266 VSS.t93 VSS.t145 241.439
R3267 VSS.t16 VSS.t1215 241.439
R3268 VSS.t1148 VSS.t664 241.439
R3269 VSS.t426 VSS.t1116 236.302
R3270 VSS.t196 VSS.t1782 231.165
R3271 VSS.t687 VSS.t683 231.165
R3272 VSS.t1812 VSS.t1828 231.165
R3273 VSS.t527 VSS.t536 231.165
R3274 VSS.t1643 VSS.t1304 231.165
R3275 VSS.t1737 VSS.t1696 231.165
R3276 VSS.t371 VSS.t907 226.028
R3277 VSS.t110 VSS.n28 226.028
R3278 VSS.t1248 VSS.t1265 226.028
R3279 VSS.t1000 VSS.t999 226.028
R3280 VSS.t1402 VSS.t405 226.028
R3281 VSS.t400 VSS.t73 215.754
R3282 VSS.n63 VSS.t1178 215.754
R3283 VSS.t1456 VSS.t1715 210.617
R3284 VSS.t611 VSS.t1173 210.617
R3285 VSS.t100 VSS.t1124 205.48
R3286 VSS.t1697 VSS.t1723 205.48
R3287 VSS.t1110 VSS.t161 205.48
R3288 VSS.n64 VSS.t1136 200.343
R3289 VSS.t1140 VSS.t1182 200.343
R3290 VSS.t1112 VSS.t1189 195.206
R3291 VSS.t257 VSS.t1231 195.206
R3292 VSS.t1714 VSS.t590 190.069
R3293 VSS.t84 VSS.t1587 184.933
R3294 VSS.t1185 VSS.t823 184.933
R3295 VSS.t1683 VSS.t919 184.933
R3296 VSS.t337 VSS.t1789 174.659
R3297 VSS.t1586 VSS.t1001 174.659
R3298 VSS.t1432 VSS.t147 174.659
R3299 VSS.t1426 VSS.t104 174.659
R3300 VSS.t1199 VSS.t376 174.659
R3301 VSS.t294 VSS.t1196 174.659
R3302 VSS.t1259 VSS.t1233 174.659
R3303 VSS.t1133 VSS.t1156 169.522
R3304 VSS.t1715 VSS.t1451 164.385
R3305 VSS.t1595 VSS.t398 164.385
R3306 VSS.t260 VSS.t138 164.385
R3307 VSS.t990 VSS.t1593 164.385
R3308 VSS.t825 VSS.t928 164.385
R3309 VSS.t138 VSS.t1153 154.111
R3310 VSS.t1202 VSS.t1282 154.111
R3311 VSS.t928 VSS.t897 154.111
R3312 VSS.t375 VSS.t1432 143.837
R3313 VSS.t1119 VSS.t292 143.837
R3314 VSS.t1120 VSS.t1234 143.837
R3315 VSS.t1107 VSS.t1259 143.837
R3316 VSS.t1464 VSS.t0 133.562
R3317 VSS.t905 VSS.t1245 133.562
R3318 VSS.t823 VSS.t1660 133.562
R3319 VSS.t1670 VSS.t1838 133.562
R3320 VSS.t102 VSS.t657 133.562
R3321 VSS.t1400 VSS.t614 133.562
R3322 VSS.t1468 VSS.t5 128.425
R3323 VSS.t1713 VSS.t1151 123.288
R3324 VSS.t1615 VSS.t136 123.288
R3325 VSS.t1734 VSS.t1597 123.288
R3326 VSS.t1273 VSS.t1031 123.288
R3327 VSS.t863 VSS.t1401 123.288
R3328 VSS.t157 VSS.t1749 123.288
R3329 VSS.t399 VSS.t1758 118.151
R3330 VSS.t1124 VSS.t259 113.014
R3331 VSS.t416 VSS.t1122 113.014
R3332 VSS.t660 VSS.t1141 107.877
R3333 VSS.t1188 VSS.t153 107.877
R3334 VSS.t4 VSS.t150 102.74
R3335 VSS.t1225 VSS.t616 102.74
R3336 VSS.t553 VSS.t1279 102.74
R3337 VSS.n57 VSS.t1469 102.74
R3338 VSS.t1667 VSS.t617 92.4663
R3339 VSS.t1274 VSS.t1665 87.3293
R3340 VSS.t1536 VSS.t944 77.0553
R3341 VSS.t1739 VSS.t1693 77.0553
R3342 VSS.t985 VSS.t1357 77.0553
R3343 VSS.t1773 VSS.t217 77.0553
R3344 VSS.t1778 VSS.t1328 77.0553
R3345 VSS.t207 VSS.t980 77.0553
R3346 VSS.t1765 VSS.t720 77.0553
R3347 VSS.t415 VSS.t1038 77.0553
R3348 VSS.t484 VSS.t1312 77.0553
R3349 VSS.t1074 VSS.t1036 77.0553
R3350 VSS.t182 VSS.t1077 77.0553
R3351 VSS.t1818 VSS.t714 77.0553
R3352 VSS.t28 VSS.t540 77.0553
R3353 VSS.t354 VSS.t1054 77.0553
R3354 VSS.t1011 VSS.t282 77.0553
R3355 VSS.t1640 VSS.t507 77.0553
R3356 VSS.t765 VSS.t1396 77.0553
R3357 VSS.t1453 VSS.t822 77.0553
R3358 VSS.t1490 VSS.t1521 77.0553
R3359 VSS.t1366 VSS.t934 77.0553
R3360 VSS.t1097 VSS.t1289 77.0553
R3361 VSS.t236 VSS.t1525 77.0553
R3362 VSS.t586 VSS.t341 77.0553
R3363 VSS.t1606 VSS.t1796 77.0553
R3364 VSS.t1616 VSS.t249 77.0553
R3365 VSS.t1123 VSS.t151 71.9183
R3366 VSS.t824 VSS.t966 71.9183
R3367 VSS.t989 VSS.t711 71.9183
R3368 VSS.t1559 VSS.t927 71.9183
R3369 VSS.t1471 VSS.t106 71.9183
R3370 VSS.t1708 VSS.t1722 66.7813
R3371 VSS.t1224 VSS.t1664 56.5073
R3372 VSS.t603 VSS.t1281 56.5073
R3373 VSS.n69 VSS.t1431 51.3704
R3374 VSS.t1756 VSS.t382 51.3704
R3375 VSS.n65 VSS.t1183 51.3704
R3376 VSS.t162 VSS.t1391 51.3704
R3377 VSS.n62 VSS.t1229 51.3704
R3378 VSS.t599 VSS.t132 46.2334
R3379 VSS.t671 VSS.t1277 46.2334
R3380 VSS.t742 VSS.t696 41.0964
R3381 VSS.t291 VSS.t285 41.0964
R3382 VSS.t1814 VSS.t1397 41.0964
R3383 VSS.t88 VSS.t1059 41.0964
R3384 VSS.t1581 VSS.t1318 41.0964
R3385 VSS.t953 VSS.t1698 41.0964
R3386 VSS.t261 VSS.t1444 41.0964
R3387 VSS.t1195 VSS.t733 41.0964
R3388 VSS.t391 VSS.t1443 30.8224
R3389 VSS.t1457 VSS.t223 20.5484
R3390 VSS.t1611 VSS.t1675 20.5484
R3391 VSS.t1227 VSS.t1109 20.5484
R3392 VSS.t387 VSS.t568 20.5484
R3393 VSS.t570 VSS.t1212 20.5484
R3394 VSS.t662 VSS.t1255 15.4115
R3395 VSS.t381 VSS.n5 14.0919
R3396 VSS.n10 VSS.t661 14.0919
R3397 VSS.t107 VSS.n15 14.0919
R3398 VSS.n98 VSS.n0 14.0919
R3399 VSS.n11 VSS.t878 14.0919
R3400 VSS.t1371 VSS.n128 14.0919
R3401 VSS.n19 VSS.t158 14.0919
R3402 VSS.n5 VSS.t81 13.5005
R3403 VSS.t497 VSS.n5 13.5005
R3404 VSS.t922 VSS.n6 13.5005
R3405 VSS.n6 VSS.t1573 13.5005
R3406 VSS.t520 VSS.n4 13.5005
R3407 VSS.t165 VSS.n4 13.5005
R3408 VSS.n3 VSS.t475 13.5005
R3409 VSS.t53 VSS.n3 13.5005
R3410 VSS.t224 VSS 13.5005
R3411 VSS VSS.t1284 13.5005
R3412 VSS.t778 VSS.n0 13.5005
R3413 VSS.n11 VSS.t769 13.5005
R3414 VSS.n128 VSS.n24 13.5005
R3415 VSS.n116 VSS.n10 13.5005
R3416 VSS.n10 VSS.n30 13.5005
R3417 VSS.n34 VSS.n9 13.5005
R3418 VSS.n2 VSS.n9 13.5005
R3419 VSS.n7 VSS.n41 13.5005
R3420 VSS.n45 VSS.n7 13.5005
R3421 VSS.n1 VSS.n8 13.5005
R3422 VSS.n93 VSS.n8 13.5005
R3423 VSS.n17 VSS.t490 13.5005
R3424 VSS.t328 VSS.n12 13.5005
R3425 VSS.t264 VSS.n15 13.5005
R3426 VSS.t1411 VSS.n15 13.5005
R3427 VSS.n13 VSS.t316 13.5005
R3428 VSS.t764 VSS.n13 13.5005
R3429 VSS.t370 VSS.n14 13.5005
R3430 VSS.n14 VSS.t374 13.5005
R3431 VSS.t787 VSS.n12 13.5005
R3432 VSS.t455 VSS.n17 13.5005
R3433 VSS.n16 VSS.t43 13.5005
R3434 VSS.n16 VSS.t38 13.5005
R3435 VSS.n18 VSS.t268 13.5005
R3436 VSS.n18 VSS.t705 13.5005
R3437 VSS.n19 VSS.t1513 13.5005
R3438 VSS.n19 VSS.t869 13.5005
R3439 VSS.t301 VSS.n88 11.5884
R3440 VSS.t330 VSS.n90 11.5884
R3441 VSS.t325 VSS.n92 11.5884
R3442 VSS.t60 VSS.n95 11.5884
R3443 VSS.t453 VSS.n56 11.5884
R3444 VSS.t735 VSS.n54 11.5884
R3445 VSS.t428 VSS.n52 11.5884
R3446 VSS.t185 VSS.n50 11.5884
R3447 VSS.t41 VSS.n85 11.5884
R3448 VSS.t674 VSS.n87 11.5884
R3449 VSS.t566 VSS.n44 11.5884
R3450 VSS.t1083 VSS.n47 11.5884
R3451 VSS.t34 VSS.n82 11.5884
R3452 VSS.t542 VSS.n84 11.5884
R3453 VSS.n108 VSS.t121 11.5884
R3454 VSS.t89 VSS.n110 11.5884
R3455 VSS.t266 VSS.n77 11.5884
R3456 VSS.t811 VSS.n79 11.5884
R3457 VSS.t9 VSS.n81 11.5884
R3458 VSS.t844 VSS.n39 11.5884
R3459 VSS.t706 VSS.n74 11.5884
R3460 VSS.t320 VSS.n76 11.5884
R3461 VSS.t795 VSS.n33 11.5884
R3462 VSS.t346 VSS.n36 11.5884
R3463 VSS.t755 VSS.n71 11.5884
R3464 VSS.t886 VSS.n73 11.5884
R3465 VSS.n112 VSS.t698 11.5884
R3466 VSS.t954 VSS.n114 11.5884
R3467 VSS.t870 VSS.n66 11.5884
R3468 VSS.t448 VSS.n68 11.5884
R3469 VSS.t105 VSS.n70 11.5884
R3470 VSS.t74 VSS.n28 11.5884
R3471 VSS.t156 VSS.n57 11.5884
R3472 VSS.t404 VSS.n60 11.5884
R3473 VSS.t1137 VSS.n65 11.5884
R3474 VSS.t1165 VSS.n20 0.102897
R3475 VSS.t774 VSS.n104 11.5884
R3476 VSS.n105 VSS.t771 11.5884
R3477 VSS.t336 VSS.n107 11.5884
R3478 VSS.t1377 VSS.n26 11.5884
R3479 VSS.t894 VSS.n21 11.5876
R3480 VSS.t1333 VSS.n22 11.5876
R3481 VSS.t1370 VSS.n23 11.5876
R3482 VSS.t1345 VSS.n102 11.5876
R3483 VSS.t916 VSS.n101 11.5876
R3484 VSS.n100 VSS.t878 11.5876
R3485 VSS.n99 VSS.t1308 11.5876
R3486 VSS.t1434 VSS.n97 11.5876
R3487 VSS.t725 VSS.t1046 11.5876
R3488 VSS.t857 VSS.n127 11.5876
R3489 VSS.t752 VSS.n25 11.5876
R3490 VSS.t421 VSS.n106 11.5876
R3491 VSS.t983 VSS.n103 11.5876
R3492 VSS.t250 VSS.t251 11.5876
R3493 VSS.t55 VSS.n96 11.5876
R3494 VSS.t216 VSS.n94 11.5876
R3495 VSS.t1327 VSS.n91 11.5876
R3496 VSS.t208 VSS.n89 11.5876
R3497 VSS.t306 VSS.t305 11.5876
R3498 VSS.t474 VSS.n49 11.5876
R3499 VSS.t717 VSS.n51 11.5876
R3500 VSS.t414 VSS.n53 11.5876
R3501 VSS.t483 VSS.n55 11.5876
R3502 VSS.t50 VSS.t49 11.5876
R3503 VSS.t561 VSS.n48 11.5876
R3504 VSS.t172 VSS.n46 11.5876
R3505 VSS.t181 VSS.n43 11.5876
R3506 VSS.t552 VSS.n86 11.5876
R3507 VSS.t96 VSS.t97 11.5876
R3508 VSS.t523 VSS.n111 11.5876
R3509 VSS.t26 VSS.n109 11.5876
R3510 VSS.t356 VSS.n42 11.5876
R3511 VSS.t281 VSS.n83 11.5876
R3512 VSS.t351 VSS.t352 11.5876
R3513 VSS.t579 VSS.n38 11.5876
R3514 VSS.t508 VSS.n40 11.5876
R3515 VSS.t762 VSS.n80 11.5876
R3516 VSS.t821 VSS.n78 11.5876
R3517 VSS.t19 VSS.t20 11.5876
R3518 VSS.t921 VSS.n37 11.5876
R3519 VSS.t365 VSS.n35 11.5876
R3520 VSS.t935 VSS.n32 11.5876
R3521 VSS.t1096 VSS.n75 11.5876
R3522 VSS.t66 VSS.t67 11.5876
R3523 VSS.t499 VSS.n115 11.5876
R3524 VSS.t237 VSS.n113 11.5876
R3525 VSS.t70 VSS.n31 11.5876
R3526 VSS.t340 VSS.n72 11.5876
R3527 VSS.t798 VSS.t799 11.5876
R3528 VSS.t595 VSS.n27 11.5876
R3529 VSS.t1605 VSS.n29 11.5876
R3530 VSS.t395 VSS.n69 11.5876
R3531 VSS.t248 VSS.n67 11.5876
R3532 VSS.t443 VSS.t444 11.5876
R3533 VSS.n117 VSS.t293 11.5876
R3534 VSS.n63 VSS.t610 11.5876
R3535 VSS.n64 VSS.t1137 11.5876
R3536 VSS.t1030 VSS.n62 11.5876
R3537 VSS.t107 VSS.n61 11.5876
R3538 VSS.t113 VSS.n59 11.5876
R3539 VSS.t386 VSS.n58 11.5876
R3540 VSS.t10 VSS.t11 11.5876
R3541 VSS.t1755 VSS.t380 10.2745
R3542 VSS.t1260 VSS.t1117 10.2745
R3543 VSS.t1198 VSS.t1844 10.2745
R3544 VSS.t1217 VSS.t392 10.2745
R3545 VSS.t1018 VSS.t1759 10.2745
R3546 VSS.t152 VSS.t904 8.49682
R3547 VSS.t107 VSS.t1399 8.49682
R3548 VSS.t381 VSS.t103 8.49682
R3549 VSS.t771 VSS.t769 2.69206
R3550 VSS.t330 VSS.t328 2.69206
R3551 VSS.t674 VSS.t374 2.69206
R3552 VSS.t542 VSS.t370 2.69206
R3553 VSS.t811 VSS.t764 2.69206
R3554 VSS.t320 VSS.t316 2.69206
R3555 VSS.t870 VSS.t1507 2.69206
R3556 VSS.t755 VSS.t588 2.69206
R3557 VSS.t706 VSS.t1100 2.69206
R3558 VSS.t266 VSS.t757 2.69206
R3559 VSS.t34 VSS.t131 2.69206
R3560 VSS.t41 VSS.t468 2.69206
R3561 VSS.t301 VSS.t212 2.69206
R3562 VSS.t583 VSS.t844 2.69206
R3563 VSS.t1377 VSS.t861 2.69206
R3564 VSS.t1096 VSS.t998 2.57347
R3565 VSS.t762 VSS.t1393 2.57347
R3566 VSS.t821 VSS.t813 2.57347
R3567 VSS.t281 VSS.t278 2.57347
R3568 VSS.t552 VSS.t550 2.57347
R3569 VSS.t1327 VSS.t202 2.57347
R3570 VSS.t421 VSS.t419 2.57347
R3571 VSS.t208 VSS.t206 2.57347
R3572 VSS.t181 VSS.t177 2.57347
R3573 VSS.t935 VSS.t1364 2.57347
R3574 VSS.t889 VSS.t885 2.48581
R3575 VSS.t453 VSS.t455 2.45488
R3576 VSS.t869 VSS.t870 2.45488
R3577 VSS.t1513 VSS.t755 2.45488
R3578 VSS.t705 VSS.t706 2.45488
R3579 VSS.t268 VSS.t266 2.45488
R3580 VSS.t38 VSS.t34 2.45488
R3581 VSS.t43 VSS.t41 2.45488
R3582 VSS.t490 VSS.t301 2.45488
R3583 VSS.t778 VSS.t774 2.45488
R3584 VSS.t610 VSS.t1191 2.40847
R3585 VSS.t1308 VSS.t882 2.40331
R3586 VSS.t916 VSS.t914 2.40331
R3587 VSS.t1345 VSS.t1344 2.40331
R3588 VSS.t878 VSS.t911 2.40331
R3589 VSS.t7 VSS.t509 2.3105
R3590 VSS.t222 VSS.t218 2.3105
R3591 VSS.t314 VSS.t312 2.3105
R3592 VSS.t564 VSS.t668 2.3105
R3593 VSS.t31 VSS.t29 2.3105
R3594 VSS.t796 VSS.t1491 2.3105
R3595 VSS.t241 VSS.t238 2.3105
R3596 VSS.t105 VSS.t362 2.21253
R3597 VSS.t998 VSS.t318 2.16613
R3598 VSS.t1393 VSS.t1423 2.16613
R3599 VSS.t813 VSS.t815 2.16613
R3600 VSS.t278 VSS.t544 2.16613
R3601 VSS.t550 VSS.t651 2.16613
R3602 VSS.t57 VSS.t55 2.16613
R3603 VSS.t62 VSS.t64 2.16613
R3604 VSS.t202 VSS.t200 2.16613
R3605 VSS.t832 VSS.t254 2.16613
R3606 VSS.t419 VSS.t441 2.16613
R3607 VSS.t206 VSS.t204 2.16613
R3608 VSS.t737 VSS.t481 2.16613
R3609 VSS.t431 VSS.t410 2.16613
R3610 VSS.t141 VSS.t143 2.16613
R3611 VSS.t474 VSS.t478 2.16613
R3612 VSS.t559 VSS.t561 2.16613
R3613 VSS.t170 VSS.t1070 2.16613
R3614 VSS.t177 VSS.t573 2.16613
R3615 VSS.t126 VSS.t124 2.16613
R3616 VSS.t526 VSS.t523 2.16613
R3617 VSS.t24 VSS.t91 2.16613
R3618 VSS.t1688 VSS.t1503 2.16613
R3619 VSS.t925 VSS.t921 2.16613
R3620 VSS.t349 VSS.t345 2.16613
R3621 VSS.t1364 VSS.t808 2.16613
R3622 VSS.t702 VSS.t700 2.16613
R3623 VSS.t501 VSS.t499 2.16613
R3624 VSS.t1384 VSS.t956 2.16613
R3625 VSS.t231 VSS.t229 2.16613
R3626 VSS.t158 VSS.t156 2.10769
R3627 VSS.t457 VSS.t50 2.06816
R3628 VSS.t444 VSS.t872 2.06816
R3629 VSS.t799 VSS.t1549 2.06816
R3630 VSS.t67 VSS.t514 2.06816
R3631 VSS.t20 VSS.t18 2.06816
R3632 VSS.t352 VSS.t36 2.06816
R3633 VSS.t97 VSS.t45 2.06816
R3634 VSS.t305 VSS.t303 2.06816
R3635 VSS.t216 VSS.t62 2.06816
R3636 VSS.t251 VSS.t776 2.06816
R3637 VSS.t172 VSS.t170 2.06816
R3638 VSS.t26 VSS.t24 2.06816
R3639 VSS.t365 VSS.t349 2.06816
R3640 VSS.t237 VSS.t1384 2.06816
R3641 VSS.t752 VSS.t231 2.06816
R3642 VSS.t894 VSS.t1544 2.04753
R3643 VSS.t1544 VSS.t504 2.04753
R3644 VSS.t1333 VSS.t1335 2.04753
R3645 VSS.t1335 VSS.t1337 2.04753
R3646 VSS.t1344 VSS.t1371 2.04753
R3647 VSS.t1647 VSS.t1345 2.04753
R3648 VSS.t914 VSS.t1647 2.04753
R3649 VSS.t1483 VSS.t916 2.04753
R3650 VSS.t911 VSS.t1483 2.04753
R3651 VSS.t880 VSS.t878 2.04753
R3652 VSS.t882 VSS.t880 2.04753
R3653 VSS.t1308 VSS.t1478 2.04753
R3654 VSS.t1478 VSS.t233 2.04753
R3655 VSS.t1434 VSS.t1436 2.04753
R3656 VSS.t244 VSS.t1590 2.04753
R3657 VSS.t1507 VSS.t246 2.04753
R3658 VSS.t588 VSS.t342 2.04753
R3659 VSS.t1100 VSS.t1098 2.04753
R3660 VSS.t764 VSS.t766 2.04753
R3661 VSS.t757 VSS.t819 2.04753
R3662 VSS.t131 VSS.t129 2.04753
R3663 VSS.t468 VSS.t466 2.04753
R3664 VSS.t328 VSS.t1044 2.04753
R3665 VSS.t423 VSS.t1360 2.04753
R3666 VSS.t769 VSS.t1541 2.04753
R3667 VSS.t212 VSS.t209 2.04753
R3668 VSS.t485 VSS.t1311 2.04753
R3669 VSS.t412 VSS.t787 2.04753
R3670 VSS.t374 VSS.t179 2.04753
R3671 VSS.t355 VSS.t370 2.04753
R3672 VSS.t316 VSS.t936 2.04753
R3673 VSS.t117 VSS.t115 2.04753
R3674 VSS.t1370 VSS.t1371 2.04753
R3675 VSS.t581 VSS.t583 2.04753
R3676 VSS.t861 VSS.t859 2.04753
R3677 VSS.t1240 VSS.t407 2.04753
R3678 VSS.t1 VSS.t1467 2.04753
R3679 VSS.t610 VSS.t661 2.04237
R3680 VSS.t1541 VSS.t421 2.02175
R3681 VSS.t983 VSS.t423 2.02175
R3682 VSS.t1044 VSS.t1327 2.02175
R3683 VSS.t209 VSS.t208 2.02175
R3684 VSS.t414 VSS.t412 2.02175
R3685 VSS.t483 VSS.t485 2.02175
R3686 VSS.t179 VSS.t181 2.02175
R3687 VSS.t466 VSS.t552 2.02175
R3688 VSS.t356 VSS.t355 2.02175
R3689 VSS.t129 VSS.t281 2.02175
R3690 VSS.t766 VSS.t762 2.02175
R3691 VSS.t819 VSS.t821 2.02175
R3692 VSS.t936 VSS.t935 2.02175
R3693 VSS.t1098 VSS.t1096 2.02175
R3694 VSS.t342 VSS.t340 2.02175
R3695 VSS.t246 VSS.t248 2.02175
R3696 VSS.t107 VSS.t154 2.00964
R3697 VSS.t508 VSS.n2 1.96503
R3698 VSS.t717 VSS.n1 1.96503
R3699 VSS.t229 VSS.t1377 1.92894
R3700 VSS.t441 VSS.t336 1.92894
R3701 VSS.t771 VSS.t832 1.92894
R3702 VSS.t197 VSS.t57 1.92894
R3703 VSS.t64 VSS.t60 1.92894
R3704 VSS.t200 VSS.t325 1.92894
R3705 VSS.t204 VSS.t330 1.92894
R3706 VSS.t478 VSS.t284 1.92894
R3707 VSS.t185 VSS.t141 1.92894
R3708 VSS.t428 VSS.t431 1.92894
R3709 VSS.t735 VSS.t737 1.92894
R3710 VSS.t783 VSS.t559 1.92894
R3711 VSS.t1070 VSS.t1083 1.92894
R3712 VSS.t573 VSS.t566 1.92894
R3713 VSS.t651 VSS.t674 1.92894
R3714 VSS.t87 VSS.t526 1.92894
R3715 VSS.t91 VSS.t89 1.92894
R3716 VSS.t121 VSS.t126 1.92894
R3717 VSS.t544 VSS.t542 1.92894
R3718 VSS.t844 VSS.t1688 1.92894
R3719 VSS.t1423 VSS.t9 1.92894
R3720 VSS.t815 VSS.t811 1.92894
R3721 VSS.t1305 VSS.t925 1.92894
R3722 VSS.t345 VSS.t346 1.92894
R3723 VSS.t808 VSS.t795 1.92894
R3724 VSS.t318 VSS.t320 1.92894
R3725 VSS.t952 VSS.t501 1.92894
R3726 VSS.t956 VSS.t954 1.92894
R3727 VSS.t698 VSS.t702 1.92894
R3728 VSS.t383 VSS.t381 1.92041
R3729 VSS.t859 VSS.t857 1.87738
R3730 VSS.t579 VSS.t581 1.87738
R3731 VSS.t9 VSS.t7 1.87738
R3732 VSS.t325 VSS.t222 1.87738
R3733 VSS.t336 VSS.t314 1.87738
R3734 VSS.t566 VSS.t564 1.87738
R3735 VSS.t121 VSS.t31 1.87738
R3736 VSS.t795 VSS.t796 1.87738
R3737 VSS.t698 VSS.t241 1.87738
R3738 VSS.t70 VSS.t72 1.87738
R3739 VSS.t885 VSS.t886 1.83097
R3740 VSS.t113 VSS.t1240 1.82581
R3741 VSS.t970 VSS.t579 1.82066
R3742 VSS.t857 VSS.t310 1.82066
R3743 VSS.t1165 VSS.t94 1.78972
R3744 VSS.t404 VSS.t107 1.77941
R3745 VSS.n4 VSS.n3 1.77458
R3746 VSS.t1590 VSS.t448 1.75878
R3747 VSS.t554 VSS.t1137 1.75191
R3748 VSS.t156 VSS.t386 1.733
R3749 VSS.t448 VSS.t264 1.733
R3750 VSS.n116 VSS.t1603 1.70722
R3751 VSS.n2 VSS.t509 1.70722
R3752 VSS.t218 VSS.n93 1.70722
R3753 VSS.n24 VSS.t312 1.70722
R3754 VSS.n1 VSS.t190 1.70722
R3755 VSS.t668 VSS.n45 1.70722
R3756 VSS.n41 VSS.t29 1.70722
R3757 VSS.t1491 VSS.n34 1.70722
R3758 VSS.n30 VSS.t238 1.70722
R3759 VSS.t340 VSS.t338 1.67628
R3760 VSS.t81 VSS.t1268 1.65222
R3761 VSS.t55 VSS.t439 1.6505
R3762 VSS.t48 VSS.t474 1.6505
R3763 VSS.t561 VSS.t647 1.6505
R3764 VSS.t523 VSS.t451 1.6505
R3765 VSS.t921 VSS.t876 1.6505
R3766 VSS.t499 VSS.t931 1.6505
R3767 VSS.t776 VSS.t778 1.64019
R3768 VSS.t303 VSS.t490 1.64019
R3769 VSS.t455 VSS.t457 1.64019
R3770 VSS.t45 VSS.t43 1.64019
R3771 VSS.t36 VSS.t38 1.64019
R3772 VSS.t18 VSS.t268 1.64019
R3773 VSS.t514 VSS.t705 1.64019
R3774 VSS.t1549 VSS.t1513 1.64019
R3775 VSS.t872 VSS.t869 1.64019
R3776 VSS.t595 VSS.t76 1.64019
R3777 VSS.t719 VSS.t192 1.61956
R3778 VSS.t1311 VSS.t297 1.61956
R3779 VSS.t1360 VSS.t425 1.61956
R3780 VSS.t787 VSS.t789 1.61956
R3781 VSS.t264 VSS.t896 1.61941
R3782 VSS.t262 VSS.t1411 1.57831
R3783 VSS.t3 VSS.t1605 1.54222
R3784 VSS.t248 VSS.t918 1.53191
R3785 VSS.t60 VSS.t1785 1.50613
R3786 VSS.t290 VSS.t185 1.50613
R3787 VSS.t1083 VSS.t785 1.50613
R3788 VSS.t89 VSS.t1806 1.50613
R3789 VSS.t346 VSS.t1388 1.50613
R3790 VSS.t954 VSS.t1672 1.50613
R3791 VSS.t1030 VSS.t163 1.50613
R3792 VSS.t1286 VSS.t894 1.50613
R3793 VSS.t395 VSS.t1264 1.50269
R3794 VSS.t190 VSS.t719 1.49581
R3795 VSS.t362 VSS.t1603 1.49581
R3796 VSS.t626 VSS.t158 1.48722
R3797 VSS.t76 VSS.t78 1.47519
R3798 VSS.t700 VSS.t70 1.47519
R3799 VSS.t1503 VSS.t508 1.47519
R3800 VSS.t124 VSS.t530 1.47519
R3801 VSS.t143 VSS.t717 1.47519
R3802 VSS.t410 VSS.t1753 1.47519
R3803 VSS.t481 VSS.t1301 1.47519
R3804 VSS.t254 VSS.t256 1.47519
R3805 VSS.t160 VSS.t554 1.47347
R3806 VSS.t74 VSS.t1 1.47339
R3807 VSS.t115 VSS.t113 1.47003
R3808 VSS.t968 VSS.t262 1.44253
R3809 VSS.t1467 VSS.t3 1.41847
R3810 VSS.t723 VSS.t725 1.39784
R3811 VSS.t886 VSS.t1411 1.39784
R3812 VSS.t386 VSS.t1158 1.39784
R3813 VSS.t393 VSS.t1030 1.37722
R3814 VSS.n24 VSS.t752 1.37206
R3815 VSS.t1605 VSS.n116 1.37206
R3816 VSS.n30 VSS.t237 1.37206
R3817 VSS.n34 VSS.t365 1.37206
R3818 VSS.n41 VSS.t26 1.37206
R3819 VSS.n45 VSS.t172 1.37206
R3820 VSS.n93 VSS.t216 1.37206
R3821 VSS.t896 VSS.t602 1.36862
R3822 VSS.t608 VSS.t1165 1.36175
R3823 VSS.t133 VSS.t393 1.33597
R3824 VSS.t504 VSS.t506 1.33081
R3825 VSS.t1337 VSS.t1652 1.33081
R3826 VSS.t233 VSS.t235 1.33081
R3827 VSS.t918 VSS.t244 1.33081
R3828 VSS.t94 VSS.t1121 1.32909
R3829 VSS.t407 VSS.t404 1.32566
R3830 VSS.t1436 VSS.n98 1.31363
R3831 VSS.t152 VSS.t105 1.31142
R3832 VSS.t295 VSS.t293 1.28441
R3833 VSS.t139 VSS.t101 1.26933
R3834 VSS.n98 VSS.t723 1.26034
R3835 VSS.t1191 VSS.t612 1.24316
R3836 VSS.t1284 VSS.t1286 1.21909
R3837 VSS.t310 VSS.t224 1.21909
R3838 VSS.t931 VSS.t497 1.21909
R3839 VSS.t876 VSS.t922 1.21909
R3840 VSS.t1573 VSS.t970 1.21909
R3841 VSS.t451 VSS.t520 1.21909
R3842 VSS.t647 VSS.t165 1.21909
R3843 VSS.t475 VSS.t48 1.21909
R3844 VSS.t439 VSS.t53 1.21909
R3845 VSS.t1268 VSS.t595 1.21737
R3846 VSS.t137 VSS.t395 1.21222
R3847 VSS.t665 VSS.t661 1.20706
R3848 VSS.t1264 VSS.t139 1.19503
R3849 VSS.t14 VSS.t160 1.19331
R3850 VSS.t1118 VSS.t295 1.18988
R3851 VSS.t284 VSS.t290 1.18644
R3852 VSS.t1672 VSS.t952 1.18644
R3853 VSS.t1388 VSS.t1305 1.18644
R3854 VSS.t1806 VSS.t87 1.18644
R3855 VSS.t785 VSS.t783 1.18644
R3856 VSS.t1785 VSS.t197 1.18644
R3857 VSS.n3 VSS 1.18322
R3858 VSS.n18 VSS.n19 1.18322
R3859 VSS.n16 VSS.n18 1.18322
R3860 VSS.n17 VSS.n16 1.18322
R3861 VSS.n17 VSS.n0 1.18322
R3862 VSS.n15 VSS.n13 1.18322
R3863 VSS.n14 VSS.n13 1.18322
R3864 VSS.n14 VSS.n12 1.18322
R3865 VSS.n12 VSS.n11 1.18322
R3866 VSS.n10 VSS.n9 1.18322
R3867 VSS.n9 VSS.n7 1.18322
R3868 VSS.n8 VSS.n7 1.18322
R3869 VSS.n128 VSS.n8 1.18322
R3870 VSS.n6 VSS.n5 1.18322
R3871 VSS.n6 VSS.n4 1.18322
R3872 VSS.t1121 VSS.t1118 1.17777
R3873 VSS.t11 VSS.t626 1.17097
R3874 VSS.t993 VSS.t109 1.1555
R3875 VSS.t338 VSS.t889 1.1555
R3876 VSS.t663 VSS.t1473 1.1555
R3877 VSS.t154 VSS.t133 1.13487
R3878 VSS.t1158 VSS.t117 1.10394
R3879 VSS.t256 VSS.t983 1.09878
R3880 VSS.t1301 VSS.t483 1.09878
R3881 VSS.t1753 VSS.t414 1.09878
R3882 VSS.t530 VSS.t356 1.09878
R3883 VSS.t72 VSS.t968 1.08503
R3884 VSS.t425 VSS.t774 1.073
R3885 VSS.t297 VSS.t453 1.073
R3886 VSS.t789 VSS.t735 1.073
R3887 VSS.t192 VSS.t428 1.073
R3888 VSS.t235 VSS.t1434 1.073
R3889 VSS.t1652 VSS.t1370 1.073
R3890 VSS.t506 VSS.t1333 1.073
R3891 VSS.t1473 VSS.t665 1.06269
R3892 VSS.t163 VSS.t14 1.05409
R3893 VSS.t612 VSS.t608 1.05237
R3894 VSS.t101 VSS.t152 1.04075
R3895 VSS.t1137 VSS.t663 1.03175
R3896 VSS.t293 VSS.t383 1.02659
R3897 VSS.t109 VSS.t74 1.02659
R3898 VSS.t78 VSS.t993 1.01113
R3899 VSS.t602 VSS.t137 1.01113
R3900 BUFX3_1.Y BUFX3_1.Y.n6 40.1183
R3901 BUFX3_1.Y.n6 BUFX3_1.Y.n5 29.5458
R3902 BUFX3_1.Y.n4 BUFX3_1.Y.n3 21.0677
R3903 BUFX3_1.Y.n0 BUFX3_1.Y 20.7255
R3904 BUFX3_1.Y.n3 BUFX3_1.Y 20.3907
R3905 BUFX3_1.Y.n0 BUFX3_1.Y 20.3281
R3906 BUFX3_1.Y.n2 BUFX3_1.Y 19.6526
R3907 BUFX3_1.Y.n1 BUFX3_1.Y 18.3833
R3908 BUFX3_1.Y.n4 BUFX3_1.Y 18.2821
R3909 BUFX3_1.Y BUFX3_1.Y.t7 15.123
R3910 BUFX3_1.Y BUFX3_1.Y.t4 15.0793
R3911 BUFX3_1.Y BUFX3_1.Y.t5 15.0005
R3912 BUFX3_1.Y BUFX3_1.Y.t1 15.0005
R3913 BUFX3_1.Y BUFX3_1.Y.t6 15.0005
R3914 BUFX3_1.Y BUFX3_1.Y.t2 15.0005
R3915 BUFX3_1.Y BUFX3_1.Y.t3 15.0005
R3916 BUFX3_1.Y.n5 BUFX3_1.Y.n4 9.9245
R3917 BUFX3_1.Y.n5 BUFX3_1.Y 9.26109
R3918 BUFX3_1.Y.n6 BUFX3_1.Y 9.0005
R3919 BUFX3_1.Y.n2 BUFX3_1.Y.n1 6.5653
R3920 BUFX3_1.Y BUFX3_1.Y.t0 6.24387
R3921 BUFX3_1.Y.n1 BUFX3_1.Y.n0 2.5877
R3922 BUFX3_1.Y.n3 BUFX3_1.Y.n2 1.8485
C0 a_2877_16380# a_3049_16146# 0.01682f
C1 a_4392_4100# a_4460_4064# 0.15111f
C2 a_35973_5628# VDD 0.25052f
C3 VDD a_15813_10522# 0.6927f
C4 a_37905_14554# a_38580_14588# 0.01169f
C5 BUFX3_2.A a_20937_14144# 0.01465f
C6 BUFX3_1.Y a_9161_14480# 0.01956f
C7 a_38580_7868# a_38913_7424# 0.01772f
C8 BUFX3_1.Y AND2X1_0.Y 0.03676f
C9 AND2X1_3.Y a_1097_14480# 0.01054f
C10 a_22197_15624# a_23171_15532# 0.05938f
C11 a_22399_15524# a_22665_15572# 0.06817f
C12 VDD a_3297_16380# 0.12103f
C13 a_19593_13210# a_19661_11792# 0.01868f
C14 a_31269_5430# a_31337_5394# 1.99572f
C15 a_5145_6774# VDD 3.05823f
C16 VDD a_28161_12348# 0.25052f
C17 a_15981_15036# AND2X1_0.Y 0.06086f
C18 VDD a_8757_14144# 0.15604f
C19 a_27489_8118# a_28161_8316# 0.01448f
C20 a_24717_3802# VDD 3.11067f
C21 a_23693_3728# a_23625_3802# 0.43806f
C22 a_16905_3802# a_19593_3802# 0.15401f
C23 DFFQX1_4.Q BUFX3_16.A 0.19047f
C24 VDD BUFX3_2.A 1.21404f
C25 a_27896_13472# a_27473_13136# 0.01952f
C26 a_6473_13136# a_6405_13210# 0.94424f
C27 a_14469_6490# a_15813_6490# 0.01349f
C28 a_3717_14554# a_4392_13508# 0.03593f
C29 a_4305_15898# a_3969_14838# 0.02669f
C30 a_16973_9104# VDD 0.51278f
C31 VDD a_7833_13494# 3.12745f
C32 VDD a_16905_10522# 3.05265f
C33 clock_i DFFQX1_1.D 0.0218f
C34 a_22281_7834# a_20769_6774# 0.25266f
C35 a_1029_6774# a_1097_6738# 1.99572f
C36 a_31589_2706# a_34277_2706# 0.01208f
C37 a_23457_12150# a_23525_12114# 1.99572f
C38 a_1097_12114# a_1097_11792# 0.58526f
C39 BUFX3_2.A BUFX3_2.Y 0.05656f
C40 a_34025_5394# a_35369_5394# 0.01425f
C41 a_11933_6738# VDD 0.2189f
C42 a_11849_14480# a_11781_14554# 1.99572f
C43 VDD a_34025_12114# 0.32194f
C44 a_8492_14502# a_8757_14144# 0.02298f
C45 a_14537_10448# a_15813_10522# 0.06964f
C46 a_9093_10522# a_11781_10522# 0.15401f
C47 a_1365_3802# a_1029_2742# 0.46845f
C48 a_3023_15792# XOR2X1_0.A 0.02027f
C49 a_7901_8082# a_7817_7760# 0.08769f
C50 a_37973_3728# VDD 0.25876f
C51 a_27405_9178# a_27473_7760# 0.01868f
C52 NOR3X1_0.A DFFQX1_5.D 0.02026f
C53 VDD a_22197_15624# 0.62572f
C54 OR3X1_1.Y a_22635_14192# 0.01816f
C55 OAI21X1_0.Y a_19341_15898# 0.1834f
C56 OA21X2_1.Y BUFX3_23.A 0.14458f
C57 a_28649_13458# a_30161_13136# 0.22482f
C58 a_22281_9178# VDD 1.53423f
C59 a_4305_15898# a_4641_15036# 0.02737f
C60 OR3X1_1.C a_22029_14280# 0.01345f
C61 OA21X2_0.B NOR3X1_0.Y 0.10787f
C62 a_6473_5072# VDD 0.31873f
C63 a_11865_4086# a_10589_4050# 0.06964f
C64 a_5213_4050# a_7901_4050# 0.01208f
C65 a_11849_9104# a_11781_9178# 1.99572f
C66 VDD a_30161_10448# 0.32552f
C67 a_35301_9462# a_34025_9426# 0.06964f
C68 a_28649_9426# a_31337_9426# 0.01208f
C69 a_3717_13494# a_3785_13458# 0.43806f
C70 a_4460_16160# a_4373_15824# 0.01893f
C71 a_4392_6788# a_4460_6752# 0.15111f
C72 VDD NAND4X2_0.C 0.596f
C73 a_26213_12114# a_27557_12114# 0.01425f
C74 a_15713_5394# a_15881_5072# 0.11187f
C75 a_13025_6738# VDD 0.53088f
C76 a_14469_14554# a_15813_14554# 0.01349f
C77 VDD a_37805_12114# 0.25732f
C78 a_30161_3728# a_31505_3728# 0.01425f
C79 a_31269_8118# a_31337_8082# 1.99572f
C80 a_24785_3728# a_24717_3802# 1.99572f
C81 a_32109_3392# VDD 0.25358f
C82 BUFX3_2.A BUFX3_17.A 0.01823f
C83 VDD a_18589_16146# 0.27255f
C84 a_9093_14554# a_7833_13494# 0.27719f
C85 a_22349_6416# a_22281_6490# 0.94424f
C86 a_16485_8768# VDD 0.25052f
C87 DFFQX1_3.CK a_8001_14852# 0.02926f
C88 VDD a_15713_13458# 0.52435f
C89 NAND3X1_0.B a_6153_15938# 0.10589f
C90 DFFQX1_5.Q NOR3X1_0.C 0.0148f
C91 DFFQX1_6.D BUFX3_23.A 0.0272f
C92 a_11933_4050# a_12537_4284# 0.04852f
C93 a_8424_5180# VDD 0.26381f
C94 a_32529_5146# a_31269_4086# 0.27719f
C95 a_14469_9178# a_15813_9178# 0.01349f
C96 VDD a_15057_15488# 0.19188f
C97 a_4460_13472# a_4725_13692# 0.03941f
C98 a_35369_9426# a_35973_9660# 0.04852f
C99 OR3X1_1.A a_22197_13608# 0.23949f
C100 a_38057_2706# a_38664_2756# 0.04779f
C101 VDD DFFQX1_7.Q 0.55464f
C102 a_37805_5394# a_38412_5444# 0.04779f
C103 a_18401_5394# a_16973_5072# 0.24595f
C104 a_23457_6774# VDD 3.12574f
C105 OAI21X1_0.A a_18989_14480# 0.01088f
C106 a_16973_10448# a_16905_10522# 1.99572f
C107 a_22349_10448# a_23693_10448# 0.01425f
C108 OR3X1_1.Y BUFX3_28.A 0.12236f
C109 a_34025_8082# a_35369_8082# 0.01425f
C110 a_4392_2756# VDD 0.26383f
C111 a_35973_13692# a_35285_13136# 0.01014f
C112 OR3BX1_0.B DFFQX1_5.CK 0.38169f
C113 OR3X1_1.A OR3X1_1.Y 0.06611f
C114 BUFX3_3.A a_17497_14130# 0.20293f
C115 a_1029_6490# a_1029_5430# 0.58425f
C116 a_35285_9104# VDD 0.52643f
C117 VDD a_21441_13692# 0.13512f
C118 a_4392_10820# a_4725_11004# 0.01772f
C119 BUFX3_0.Y a_1433_10448# 0.08804f
C120 a_15645_4086# a_18333_4086# 0.15401f
C121 a_11781_5146# VDD 3.18026f
C122 DFFQX1_0.Q a_6417_15938# 0.04585f
C123 VDD a_37905_10522# 0.72638f
C124 a_5145_13494# a_5213_13458# 1.99572f
C125 a_27405_14554# a_27153_13494# 0.04782f
C126 a_37737_9462# a_36461_9426# 0.06964f
C127 DFFQX1_0.Q DFFQX1_3.CK 0.18585f
C128 a_5213_6738# a_7901_6738# 0.01208f
C129 a_11865_6774# a_10589_6738# 0.06964f
C130 a_19661_9104# a_19593_10522# 0.01868f
C131 a_7901_12114# a_9161_11792# 0.27946f
C132 BUFX3_0.Y a_1029_14554# 0.10127f
C133 BUFX24_2.A a_15225_15488# 0.03139f
C134 VDD a_6405_11866# 1.46323f
C135 BUFX3_27.A a_23121_13494# 0.09764f
C136 a_15813_10522# a_16485_10112# 0.01448f
C137 a_15713_8082# a_15881_7760# 0.11187f
C138 AOI21BX1_0.Y a_18837_16182# 0.09848f
C139 a_1029_9178# BUFX3_0.Y 0.09952f
C140 a_18589_16146# BUFX3_17.A 0.21598f
C141 a_3717_6490# a_4725_5628# 0.02812f
C142 a_27473_6416# a_30161_6416# 0.01208f
C143 a_38580_9212# VDD 0.27751f
C144 VDD a_25809_13494# 1.48198f
C145 VDD a_3131_15770# 0.24027f
C146 counter_value_o[3] a_17497_16146# 0.01004f
C147 BUFX3_0.Y a_8673_15488# 0.02785f
C148 VDD AOI21BX2_1.A 0.2935f
C149 NAND2X1_0.Y a_5213_14802# 0.03764f
C150 OR3X1_1.Y DFFQX1_5.D 0.08484f
C151 a_7833_10806# a_10521_10806# 0.15401f
C152 BUFX3_27.Y a_19661_13136# 0.01032f
C153 a_19677_4086# a_19745_4050# 0.43806f
C154 a_23693_5072# VDD 0.20824f
C155 a_22349_9104# a_22281_9178# 0.94424f
C156 BUFX3_1.Y a_22245_15244# 0.01023f
C157 VDD a_3717_9462# 0.72864f
C158 BUFX3_1.Y a_1029_11866# 0.10484f
C159 a_15732_16196# a_15800_16160# 0.15111f
C160 a_7901_13458# a_10589_13458# 0.01208f
C161 a_32529_7834# a_31269_6774# 0.27719f
C162 a_11933_6738# a_12537_6972# 0.04852f
C163 a_2373_15488# a_2373_15036# 0.02526f
C164 a_31337_6738# VDD 0.59593f
C165 VDD a_14537_11792# 0.3248f
C166 BUFX3_27.A a_23189_13458# 0.03419f
C167 a_1365_10522# a_3717_9462# 0.04136f
C168 a_35285_3728# a_35217_3802# 1.99572f
C169 a_12201_2940# VDD 0.25387f
C170 a_11781_3802# a_12201_2940# 0.02812f
C171 a_18401_8082# a_16973_7760# 0.24595f
C172 a_37805_8082# a_38412_8132# 0.04779f
C173 a_31337_4050# a_31521_2742# 0.01636f
C174 a_19661_13136# a_22349_13136# 0.01208f
C175 a_6661_16182# NAND3X1_0.B 0.09688f
C176 a_30161_6416# a_31437_6490# 0.06964f
C177 a_3785_8082# VDD 0.25345f
C178 VDD a_25877_13458# 0.31873f
C179 VDD a_4305_15898# 0.7322f
C180 OR3X1_1.B a_19661_13136# 0.03002f
C181 a_11865_10806# a_11933_10770# 0.43806f
C182 a_31437_11866# a_31269_10806# 0.11121f
C183 a_24785_5072# VDD 0.51278f
C184 a_1029_9178# a_1029_8118# 0.58425f
C185 VDD a_7833_9462# 3.13177f
C186 NAND3X1_0.B NAND2X1_0.Y 0.20881f
C187 a_31437_14554# a_31269_13494# 0.11121f
C188 a_21979_14852# a_22029_14280# 0.0104f
C189 a_21777_14920# OR3X1_0.Y 0.0615f
C190 a_15645_6774# a_18333_6774# 0.15401f
C191 BUFX3_23.A a_18803_15170# 0.14486f
C192 DFFQX1_0.Q a_6803_15792# 0.15401f
C193 a_17073_15938# a_16905_15488# 0.02487f
C194 XOR2X1_0.A a_3309_15244# 0.02921f
C195 a_36393_12150# a_37737_12150# 0.01349f
C196 a_3785_5072# a_3717_5146# 1.99572f
C197 a_36461_6738# VDD 0.3193f
C198 VDD a_16973_11792# 0.51278f
C199 a_23693_10448# a_24297_10112# 0.04852f
C200 a_4053_10522# a_5145_9462# 0.27827f
C201 DFFQX1_4.Q OR3X1_1.B 0.06843f
C202 a_16401_2742# VDD 3.11603f
C203 a_19341_15898# a_19932_14852# 0.03593f
C204 a_22349_13136# a_23625_13210# 0.06964f
C205 DFFQX1_3.CK a_15716_14816# 0.01181f
C206 a_11865_8118# VDD 0.70179f
C207 VDD a_33957_13494# 1.45226f
C208 a_32529_11866# a_33957_10806# 0.26941f
C209 a_20769_4086# a_20837_4050# 1.99572f
C210 a_30093_5146# VDD 1.46587f
C211 a_27473_9104# a_30161_9104# 0.01208f
C212 a_3717_9178# a_4725_8316# 0.02812f
C213 a_18333_13494# a_19677_13494# 0.01349f
C214 a_19677_6774# a_19745_6738# 0.43806f
C215 DFFQX1_3.CK BUFX24_2.A 0.0108f
C216 DFFQX1_5.CK DFFQX1_2.D 0.07539f
C217 a_37805_12114# a_38480_12128# 0.01184f
C218 a_6405_5146# a_7749_5146# 0.01349f
C219 AND2X1_1.B a_6473_14480# 0.01677f
C220 VDD a_22281_11866# 1.53423f
C221 a_32597_16146# a_33941_16146# 0.01425f
C222 a_27405_10522# a_30093_10522# 0.15401f
C223 a_22869_2742# VDD 0.74486f
C224 OAI21X1_2.Y NAND2X1_1.Y 0.01622f
C225 a_37469_16146# a_37973_15824# 0.11187f
C226 a_32597_6416# a_32529_6490# 1.99572f
C227 a_11781_6490# a_12537_5628# 0.02812f
C228 a_12957_8118# VDD 3.1114f
C229 a_24297_16182# DFFQX1_7.Q 0.14395f
C230 a_1097_5072# BUFX3_0.Y 0.10479f
C231 VDD a_35973_13692# 0.25052f
C232 a_12957_10806# a_13025_10770# 1.99572f
C233 a_4460_4064# a_4121_3728# 0.01952f
C234 a_23525_4050# a_26213_4050# 0.01208f
C235 a_32529_5146# VDD 3.11738f
C236 a_30161_9104# a_31437_9178# 0.06964f
C237 VDD a_15713_9426# 0.52435f
C238 BUFX3_23.A a_24213_15488# 0.02247f
C239 a_32109_14144# a_31269_13494# 0.02812f
C240 a_19677_13494# a_20349_13692# 0.01448f
C241 BUFX3_23.A a_20000_14816# 0.01784f
C242 a_9161_9104# a_7901_9426# 0.27946f
C243 a_38745_12348# a_38913_12348# 0.09255f
C244 BUFX3_3.A a_15645_13494# 0.0106f
C245 a_3717_6490# VDD 3.0976f
C246 NAND3X1_0.B XOR2X1_0.A 0.45551f
C247 VDD a_16485_11456# 0.25052f
C248 a_24029_2706# VDD 0.50703f
C249 a_3785_7760# a_3717_7834# 1.99572f
C250 VDD a_23457_16380# 0.19888f
C251 a_3717_13210# a_5145_12150# 0.27326f
C252 a_35217_6490# a_37905_6490# 0.15401f
C253 a_19745_8082# VDD 0.20824f
C254 a_15713_10770# a_18401_10770# 0.01208f
C255 BUFX3_26.Y NAND3X1_0.B 0.31723f
C256 a_5213_4050# a_6809_3728# 0.20369f
C257 AOI21BX2_1.A a_21195_16000# 0.03042f
C258 a_27405_5146# a_27473_3728# 0.01868f
C259 a_38913_4736# VDD 0.11104f
C260 VDD a_1029_16182# 1.47885f
C261 VDD a_26145_9462# 1.45223f
C262 DFFQX1_4.Q a_17829_14920# 0.14952f
C263 DFFQX1_3.CK a_10521_13494# 0.01452f
C264 a_37905_14554# a_37737_13494# 0.06895f
C265 a_6237_16380# a_6325_16182# 0.01102f
C266 a_20769_6774# a_20837_6738# 1.99572f
C267 OAI21X1_0.A AOI21BX1_0.A 0.09323f
C268 AND2X1_1.Y BUFX3_1.Y 0.03803f
C269 a_22350_16146# a_22484_16182# 0.10269f
C270 VDD a_38913_16380# 0.0868f
C271 a_14537_5072# a_15881_5072# 0.01425f
C272 a_35369_5394# a_35285_5072# 0.10882f
C273 a_11849_6416# VDD 0.59389f
C274 VDD a_35285_11792# 0.52643f
C275 a_35369_16146# a_36648_16196# 0.04849f
C276 a_1097_2706# BUFX3_0.Y 0.02935f
C277 a_17073_15938# BUFX3_3.A 0.04068f
C278 OR3X1_1.B a_18031_14852# 0.03228f
C279 a_31437_10522# a_32109_10112# 0.01448f
C280 DFFQX1_3.Q a_13041_16182# 0.10122f
C281 a_4392_2756# a_4725_2940# 0.01772f
C282 a_6405_7834# a_7749_7834# 0.01349f
C283 a_30497_2706# VDD 0.2084f
C284 counter_value_o[1] a_7333_16182# 0.11006f
C285 a_24717_13210# a_27405_13210# 0.15401f
C286 a_23625_13210# a_24297_12800# 0.01448f
C287 a_31505_13136# a_31437_13210# 0.43806f
C288 a_38648_6438# a_38913_6080# 0.02298f
C289 a_19593_6490# a_19677_5430# 0.11121f
C290 a_20837_8082# VDD 0.57859f
C291 VDD a_6473_13136# 0.31873f
C292 a_12356_15846# a_12288_15932# 0.15111f
C293 a_19593_11866# a_19661_10448# 0.01868f
C294 a_33957_4086# a_35301_4086# 0.01349f
C295 a_4725_4284# VDD 0.24966f
C296 a_32597_9104# a_32529_9178# 1.99572f
C297 VDD BUFX3_12.A 0.63103f
C298 a_11781_9178# a_12537_8316# 0.02812f
C299 VDD a_28161_9660# 0.25052f
C300 a_23525_6738# a_26213_6738# 0.01208f
C301 a_4725_6972# a_3785_6416# 0.01014f
C302 AOI21BX2_0.A DFFQX1_5.Q 0.49863f
C303 a_22383_15045# a_22245_15244# 0.21799f
C304 VDD a_2629_15510# 0.2214f
C305 a_27557_12114# a_27473_11792# 0.10882f
C306 BUFX3_0.Y a_1029_11866# 0.08752f
C307 VDD a_19409_15824# 0.26192f
C308 a_15713_5394# a_15645_4086# 0.0208f
C309 a_37805_5394# a_37973_5072# 0.06961f
C310 VDD a_38580_11900# 0.27751f
C311 NAND3X1_0.Y XOR2X1_0.A 0.01966f
C312 OR3X1_1.B a_18989_14480# 0.10003f
C313 BUFX3_1.Y a_1097_13136# 0.09664f
C314 a_37905_10522# a_38580_10556# 0.01169f
C315 VDD a_9429_16182# 3.0679f
C316 OA21X2_1.Y a_22665_15572# 0.04542f
C317 a_11781_13210# a_11865_12150# 0.11121f
C318 NAND3X1_0.Y a_8265_16258# 0.05361f
C319 a_1029_5430# a_3717_5430# 0.15401f
C320 a_31269_8118# VDD 3.20096f
C321 a_19593_6490# a_20769_5430# 0.27765f
C322 VDD a_8424_13244# 0.26381f
C323 a_26145_10806# a_27489_10806# 0.01349f
C324 OR3X1_1.B a_9765_14838# 0.05894f
C325 a_35301_4086# a_35973_4284# 0.01448f
C326 a_10589_4050# VDD 0.32629f
C327 a_35217_9178# a_37905_9178# 0.15401f
C328 VDD a_34025_9426# 0.32194f
C329 a_16687_14852# a_17321_15244# 0.14171f
C330 a_3313_15779# a_3131_15770# 0.01951f
C331 a_7901_12114# a_7833_10806# 0.02042f
C332 a_28649_12114# a_27473_11792# 0.30073f
C333 counter_value_o[3] DFFQX1_4.Q 0.02481f
C334 a_16973_5072# a_19661_5072# 0.01208f
C335 a_19593_6490# VDD 3.13748f
C336 VDD a_3785_10770# 0.25916f
C337 VDD a_12285_16380# 0.13116f
C338 a_14537_7760# a_15881_7760# 0.01425f
C339 a_35369_8082# a_35285_7760# 0.10882f
C340 a_38732_2720# VDD 0.09293f
C341 BUFX3_27.Y NAND2X1_1.Y 0.60973f
C342 clock_i a_6661_16182# 0.01026f
C343 a_11781_13210# a_12957_12150# 0.27765f
C344 XOR2X1_0.A AND2X1_3.B 0.21134f
C345 BUFX3_27.Y BUFX3_27.A 0.02927f
C346 a_3785_5394# a_4460_5408# 0.01184f
C347 BUFX3_31.A BUFX3_27.Y 0.0139f
C348 DFFQX1_6.D a_22665_15572# 0.0795f
C349 OR3BX1_0.B NOR3X1_0.C 0.07773f
C350 a_24617_14802# a_27305_14802# 0.01208f
C351 a_14792_15846# a_14724_15932# 0.15111f
C352 VDD a_11781_13210# 3.18026f
C353 a_4725_11004# a_4121_10448# 0.01014f
C354 a_9497_16146# BUFX24_2.A 0.05847f
C355 a_27489_10806# a_28161_11004# 0.01448f
C356 a_15713_4050# a_15881_3728# 0.11187f
C357 a_19593_9178# a_19677_8118# 0.11121f
C358 a_38648_9126# a_38913_8768# 0.02298f
C359 a_19677_4086# VDD 0.6927f
C360 a_17829_14920# a_18031_14852# 0.25198f
C361 VDD a_37805_9426# 0.25732f
C362 a_3313_15779# a_4305_15898# 0.11642f
C363 a_33941_16146# a_32597_15824# 0.11187f
C364 OA21X2_1.Y DFFQX1_5.Q 0.01364f
C365 a_33957_6774# a_35301_6774# 0.01349f
C366 a_18905_16146# OAI21X1_0.Y 0.01549f
C367 a_15881_5072# a_16485_4736# 0.04852f
C368 NOR3X1_0.Y a_22751_15170# 0.03254f
C369 a_31505_6416# VDD 0.21456f
C370 VDD a_11865_10806# 0.70179f
C371 BUFX3_27.A a_22349_13136# 0.02784f
C372 a_23625_10522# a_23457_9462# 0.11121f
C373 a_3717_9462# a_3785_9426# 0.43806f
C374 OR3X1_1.B NAND2X1_1.Y 0.52608f
C375 a_13109_16146# a_12957_14838# 0.01833f
C376 a_8909_2706# a_11597_2706# 0.01208f
C377 a_3785_16146# a_4392_16196# 0.04779f
C378 a_37805_8082# a_37973_7760# 0.06961f
C379 a_15713_8082# a_15645_6774# 0.0208f
C380 DFFQX1_3.CK a_9181_15474# 0.04458f
C381 OR3X1_1.B BUFX3_27.A 0.21328f
C382 BUFX3_31.A OR3X1_1.B 0.01428f
C383 BUFX3_41.A a_28649_14802# 0.04912f
C384 BUFX3_27.Y a_22350_16146# 0.02955f
C385 a_7093_15779# a_7297_15682# 0.08137f
C386 a_38480_8096# VDD 0.10776f
C387 a_5145_5430# a_7833_5430# 0.15401f
C388 counter_value_o[1] AND2X1_1.Y 0.16953f
C389 VDD a_23693_13136# 0.20824f
C390 NOR3X1_0.Y a_23121_13494# 0.01474f
C391 a_22873_16146# a_22399_15524# 0.01111f
C392 BUFX3_41.A a_24301_14802# 0.21456f
C393 a_32281_16146# a_32529_16182# 0.05055f
C394 a_7901_10770# a_6809_10448# 0.01127f
C395 a_5381_15824# a_6153_15938# 0.02526f
C396 a_21193_16182# OAI21X1_1.Y 0.02515f
C397 BUFX3_31.A a_21529_16182# 0.01007f
C398 a_20856_16196# a_20924_16160# 0.15111f
C399 a_18401_4050# a_16973_3728# 0.24595f
C400 a_20769_4086# VDD 3.1423f
C401 a_1029_8118# a_3717_8118# 0.15401f
C402 a_19593_9178# a_20769_8118# 0.27765f
C403 OR3X1_1.B AOI21BX1_0.B 0.01081f
C404 clock_i a_2444_16160# 0.01326f
C405 a_18031_14852# a_18435_15045# 0.15054f
C406 VDD OR3X1_0.Y 0.21142f
C407 a_4373_15824# a_4981_15510# 0.07431f
C408 a_27153_13494# a_27221_13458# 0.43806f
C409 a_5213_13458# a_3785_13136# 0.24646f
C410 a_27405_14554# a_27473_13136# 0.02113f
C411 a_35369_16146# a_35285_15824# 0.27194f
C412 BUFX3_41.A a_24717_15898# 0.17427f
C413 a_35301_6774# a_35973_6972# 0.01448f
C414 a_12537_6972# a_11849_6416# 0.01014f
C415 BUFX3_25.Y a_16687_14852# 0.12246f
C416 a_16485_14920# a_17091_15045# 0.0867f
C417 VDD a_20924_16160# 0.09549f
C418 OR3BX1_0.Y a_18031_14852# 0.01132f
C419 a_11849_11792# a_11781_11866# 1.99572f
C420 clock_i a_1097_15824# 0.02863f
C421 a_22281_5146# a_23625_5146# 0.01349f
C422 a_32597_6416# VDD 0.56295f
C423 a_21979_14852# a_22751_15170# 0.0313f
C424 BUFX3_29.Y a_22245_15244# 0.08259f
C425 VDD a_12957_10806# 3.1114f
C426 DFFQX1_5.CK a_18803_15170# 0.01254f
C427 a_4460_9440# a_4725_9660# 0.03941f
C428 a_24717_10522# a_23457_9462# 0.27719f
C429 a_17833_15510# DFFQX1_2.D 0.21766f
C430 a_18757_15474# OR3BX1_0.Y 0.20482f
C431 VDD OAI21X1_0.Y 0.35377f
C432 a_16973_7760# a_19661_7760# 0.01208f
C433 AND2X1_2.B XOR2X1_0.A 0.11341f
C434 a_38580_13244# a_38913_12800# 0.01772f
C435 VDD a_34548_16196# 0.26678f
C436 a_10521_5430# a_10589_5394# 0.94424f
C437 a_30093_6490# a_28581_5430# 0.25266f
C438 a_3785_7760# VDD 0.525f
C439 a_33957_14838# a_35301_14838# 0.01349f
C440 VDD a_24785_13136# 0.51765f
C441 BUFX3_29.Y a_22197_13608# 0.1716f
C442 a_31269_10806# a_31337_10770# 1.99572f
C443 a_7901_10770# a_9161_10448# 0.27946f
C444 a_8841_16380# a_9009_16380# 0.09255f
C445 BUFX3_41.A a_30161_14480# 0.01352f
C446 a_3785_8082# a_4460_8096# 0.01184f
C447 a_27557_4050# VDD 0.20824f
C448 AOI21BX2_0.A a_22399_15524# 0.01082f
C449 DFFQX1_4.Q BUFX3_1.Y 0.02281f
C450 a_24049_16146# DFFQX1_7.Q 0.03269f
C451 a_27473_9104# a_27557_9426# 0.10882f
C452 a_14469_11866# a_15813_11866# 0.01349f
C453 a_27405_15898# a_28581_14838# 0.27765f
C454 VDD NAND2X1_0.A 0.59141f
C455 a_38648_6438# VDD 0.10108f
C456 BUFX3_38.Y DFFQX1_7.Q 0.02434f
C457 VDD a_19745_10770# 0.20824f
C458 VDD enable_i 0.15797f
C459 AND2X1_1.Y BUFX3_0.Y 0.06414f
C460 a_5145_9462# a_5213_9426# 1.99572f
C461 a_5736_16196# a_5804_16160# 0.15111f
C462 a_15881_7760# a_16485_7424# 0.04852f
C463 a_1029_12150# a_1097_12114# 1.99572f
C464 a_22281_13210# a_20769_12150# 0.25266f
C465 VDD a_36716_16160# 0.0985f
C466 a_8492_7782# VDD 0.12771f
C467 a_30161_15824# a_31505_15824# 0.01425f
C468 a_35301_14838# a_35973_15036# 0.01448f
C469 VDD a_30093_13210# 1.46587f
C470 a_34025_10770# a_35369_10770# 0.01425f
C471 a_12288_15932# a_12453_15036# 0.01103f
C472 clock_i BUFX3_26.Y 0.03759f
C473 a_8623_14852# a_8889_15244# 0.06817f
C474 a_18989_14480# a_20333_14480# 0.01425f
C475 BUFX3_41.A a_32597_14480# 0.02445f
C476 a_19681_14802# a_18989_14480# 0.0116f
C477 a_5145_8118# a_7833_8118# 0.15401f
C478 a_28649_4050# VDD 0.51275f
C479 AOI21BX2_0.A NOR3X1_0.C 0.02977f
C480 a_11933_13458# a_11849_13136# 0.10882f
C481 a_15713_6738# a_16973_6416# 0.27946f
C482 a_7833_8118# a_7901_9426# 0.02042f
C483 a_27473_9104# a_28649_9426# 0.30073f
C484 a_8424_5180# a_7833_4086# 0.03593f
C485 a_30161_5072# a_30093_5146# 0.94424f
C486 a_1097_5394# VDD 0.57652f
C487 DFFQX1_5.CK a_22029_14280# 0.14426f
C488 DFFQX1_0.Q NAND3X1_0.B 0.19415f
C489 VDD a_20837_10770# 0.57859f
C490 DFFQX1_5.CK a_20000_14816# 0.01382f
C491 a_7901_9426# a_10589_9426# 0.01208f
C492 a_6069_16380# DFFQX1_0.Q 0.01265f
C493 a_16401_2742# a_16469_2706# 1.99572f
C494 counter_value_o[7] a_37401_16182# 0.0178f
C495 a_22281_7834# a_23625_7834# 0.01349f
C496 a_17077_16182# a_17497_16146# 0.01895f
C497 a_4392_12164# a_4460_12128# 0.15111f
C498 AND2X1_1.Y a_7093_15779# 0.01031f
C499 BUFX3_0.Y a_1097_13136# 0.07809f
C500 a_9093_7834# VDD 3.05733f
C501 VDD a_32529_13210# 3.11738f
C502 VDD a_27912_14852# 0.26381f
C503 a_4121_3728# a_6809_3728# 0.01208f
C504 VDD a_6493_14838# 0.2164f
C505 a_37737_4086# VDD 0.72674f
C506 BUFX3_41.A a_32529_14554# 0.01891f
C507 a_30093_9178# a_28581_8118# 0.25266f
C508 a_10521_8118# a_10589_8082# 0.94424f
C509 OA21X2_1.Y a_22399_15524# 0.02063f
C510 a_31269_13494# a_31337_13458# 1.99572f
C511 BUFX3_1.Y a_17459_15170# 0.02517f
C512 a_13025_13458# a_11849_13136# 0.30073f
C513 BUFX3_31.A OAI21X1_1.Y 0.03137f
C514 NAND3X1_0.Y a_8001_14852# 0.08071f
C515 OR3X1_1.B AOI21BX1_0.A 0.02799f
C516 BUFX3_12.A a_3313_15779# 0.01073f
C517 VDD a_22497_14228# 0.19792f
C518 BUFX24_2.A a_12714_15510# 1.18329f
C519 VDD a_4460_16160# 0.12774f
C520 a_22349_11792# a_22281_11866# 0.94424f
C521 a_23323_15175# BUFX3_28.A 0.13928f
C522 a_10521_5430# VDD 1.45582f
C523 a_9093_5146# a_10521_4086# 0.26941f
C524 VDD a_31269_10806# 3.20096f
C525 DFFQX1_5.Q a_23003_14188# 0.14307f
C526 a_24785_14480# a_27473_14480# 0.01208f
C527 VDD a_18297_15244# 0.19458f
C528 a_1029_15898# a_2373_15488# 0.01445f
C529 a_23209_16146# a_23457_16380# 0.02089f
C530 AOI21BX1_0.A a_19093_15474# 0.21667f
C531 AOI21BX1_0.B OR3BX1_0.Y 0.01503f
C532 a_22349_7760# VDD 0.38109f
C533 BUFX3_27.A a_23709_14838# 0.06031f
C534 a_13025_5394# a_15713_5394# 0.01208f
C535 a_19677_5430# a_18401_5394# 0.06964f
C536 a_32597_15824# a_35285_15824# 0.01208f
C537 VDD a_38913_12800# 0.11104f
C538 BUFX3_27.Y OR3X1_1.C 0.39196f
C539 a_15318_15510# a_15648_14852# 0.01556f
C540 a_37805_10770# a_38412_10820# 0.04779f
C541 DFFQX1_0.D XOR2X1_0.A 0.02103f
C542 VDD a_28649_14802# 0.51327f
C543 a_8153_3728# a_8085_3802# 0.43806f
C544 VDD a_9181_16146# 0.2715f
C545 OAI21X1_0.A BUFX3_23.A 0.17943f
C546 a_38913_4284# VDD 0.0867f
C547 NAND2X1_1.Y a_20333_14480# 0.02031f
C548 OA21X2_1.Y NOR3X1_0.C 0.68997f
C549 a_2625_14852# a_1097_14480# 0.01127f
C550 a_34025_13458# a_35369_13458# 0.01425f
C551 BUFX3_1.Y a_18031_14852# 0.01263f
C552 AOI21BX2_1.A a_21391_15175# 0.05625f
C553 VDD a_24301_14802# 0.27497f
C554 a_15713_6738# a_16485_6080# 0.01014f
C555 a_35369_14802# a_35285_14480# 0.10882f
C556 a_22803_15536# a_23033_15572# 0.05497f
C557 DFFQX1_6.D a_22399_15524# 0.09952f
C558 a_8673_15488# a_8421_14920# 0.02812f
C559 a_1029_11866# a_1029_10806# 0.58425f
C560 a_19512_16196# a_19580_16160# 0.15111f
C561 a_12537_5628# VDD 0.25529f
C562 a_35285_5072# a_37973_5072# 0.01208f
C563 counter_value_o[0] a_2877_16380# 0.03202f
C564 VDD a_24717_15898# 3.07652f
C565 VDD a_17748_14588# 0.26566f
C566 a_6661_16182# AND2X1_1.B 0.2104f
C567 a_18333_9462# a_19677_9462# 0.01349f
C568 a_35217_10522# a_35973_9660# 0.02812f
C569 a_3325_15532# a_3131_15770# 0.14171f
C570 a_30161_14480# a_30093_14554# 0.94424f
C571 a_22869_2742# a_22937_2706# 0.43806f
C572 DFFQX1_5.Q a_27405_15898# 0.04963f
C573 a_8424_7868# a_7833_6774# 0.03593f
C574 a_30161_7760# a_30093_7834# 0.94424f
C575 AND2X1_3.Y a_3309_15244# 0.01574f
C576 VDD reset_n_i 0.1938f
C577 a_5213_12114# a_7901_12114# 0.01208f
C578 a_11865_12150# a_10589_12114# 0.06964f
C579 OR3X1_1.C OR3X1_1.B 0.60243f
C580 VDD a_16153_14838# 0.21601f
C581 AND2X1_1.B NAND2X1_0.Y 0.0617f
C582 BUFX3_27.A BUFX3_28.A 0.03603f
C583 a_38580_6524# a_38745_5628# 0.01103f
C584 a_19745_5394# a_20349_5628# 0.04852f
C585 a_31437_15898# a_32109_15488# 0.01448f
C586 VDD a_4725_12348# 0.24966f
C587 OR3X1_1.A BUFX3_27.A 0.05226f
C588 VDD a_37737_14838# 0.72674f
C589 a_8153_3728# VDD 0.21775f
C590 NAND2X1_1.Y a_21525_14180# 0.17821f
C591 a_20000_14816# a_20265_15036# 0.03941f
C592 a_20349_13692# a_19661_13136# 0.01014f
C593 reset_n_i a_1365_10522# 0.01847f
C594 a_6473_6416# a_7817_6416# 0.01425f
C595 a_26213_6738# a_24785_6416# 0.24595f
C596 a_37805_14802# a_37973_14480# 0.06961f
C597 a_23965_15474# BUFX3_27.A 0.226f
C598 a_5313_15898# NAND2X1_0.Y 0.01125f
C599 VDD a_30161_14480# 0.32552f
C600 a_27473_11792# a_30161_11792# 0.01208f
C601 a_3717_11866# a_4725_11004# 0.02812f
C602 DFFQX1_3.Q BUFX24_2.A 0.01357f
C603 BUFX3_4.A a_8265_16258# 0.09634f
C604 a_18401_5394# VDD 0.32194f
C605 a_37973_5072# a_38580_5180# 0.04779f
C606 VDD a_37973_15824# 0.25335f
C607 OR3X1_1.B a_17073_15938# 0.28984f
C608 VDD a_38480_10784# 0.10776f
C609 a_19677_9462# a_20349_9660# 0.01448f
C610 VDD a_19932_14852# 0.26132f
C611 XOR2X1_0.A a_5381_15824# 0.01324f
C612 BUFX3_2.A a_17321_15244# 0.02471f
C613 BUFX3_1.Y a_9765_14838# 0.15365f
C614 a_9093_7834# a_10521_6774# 0.26941f
C615 AND2X1_3.B a_3721_14802# 0.21106f
C616 a_6997_16182# AND2X1_1.Y 0.02825f
C617 a_32529_13210# a_31269_12150# 0.27719f
C618 a_11933_12114# a_12537_12348# 0.04852f
C619 a_23457_5430# a_26145_5430# 0.15401f
C620 a_27405_7834# VDD 3.12537f
C621 a_9497_16146# DFFQX1_3.CK 0.0172f
C622 VDD a_10589_12114# 0.32678f
C623 a_21777_14920# a_22245_15244# 0.08137f
C624 a_9395_15170# a_9161_14480# 0.01853f
C625 VDD a_38913_15036# 0.0867f
C626 a_22350_16146# OR3X1_1.A 0.05784f
C627 a_35369_4050# a_35285_3728# 0.10882f
C628 a_11849_3728# a_11781_3802# 1.99572f
C629 a_11849_3728# VDD 0.59389f
C630 a_19677_8118# a_18401_8082# 0.06964f
C631 a_13025_8082# a_15713_8082# 0.01208f
C632 a_37805_13458# a_38412_13508# 0.04779f
C633 BUFX3_27.A DFFQX1_5.D 0.01165f
C634 DFFQX1_5.CK a_16905_15488# 0.01221f
C635 BUFX3_23.A OAI21X1_2.Y 0.03325f
C636 VDD a_31101_16380# 0.25294f
C637 a_7817_6416# a_8424_6524# 0.04779f
C638 AOI21BX2_0.A OR3BX1_0.B 0.16202f
C639 VDD a_32597_14480# 0.56295f
C640 BUFX3_41.A NOR3X1_0.A 0.01897f
C641 a_30161_11792# a_31437_11866# 0.06964f
C642 a_31521_16182# DFFQX1_5.Q 0.01276f
C643 AND2X1_2.B a_8001_14852# 0.24236f
C644 a_27489_5430# VDD 0.6927f
C645 VDD a_38580_15932# 0.27765f
C646 VDD a_1433_10448# 0.58038f
C647 NOR3X1_0.A a_23803_14838# 0.01162f
C648 a_26649_2742# a_27321_2940# 0.01448f
C649 a_35285_7760# a_37973_7760# 0.01208f
C650 VDD a_16485_14144# 0.24611f
C651 a_15645_12150# a_18333_12150# 0.15401f
C652 a_27489_5430# a_27557_5394# 0.43806f
C653 a_24297_7424# VDD 0.25056f
C654 a_4460_5408# a_3785_5072# 0.01952f
C655 a_6473_14480# a_7817_14480# 0.01425f
C656 VDD a_19677_12150# 0.6927f
C657 AND2X1_3.Y a_2625_14852# 0.09169f
C658 a_27557_10770# a_27473_10448# 0.10882f
C659 a_1433_10448# a_1365_10522# 1.99572f
C660 VDD a_1029_14554# 3.08106f
C661 a_12453_15036# a_12621_15036# 0.09255f
C662 a_14469_3802# a_15813_3802# 0.01349f
C663 AOI21BX1_0.A OR3BX1_0.Y 0.4382f
C664 a_37401_16182# a_38745_16380# 0.01445f
C665 a_37805_4050# a_37973_3728# 0.06961f
C666 VDD a_12957_14838# 3.30466f
C667 a_38580_9212# a_38745_8316# 0.01103f
C668 a_19745_8082# a_20349_8316# 0.04852f
C669 AND2X1_1.B XOR2X1_0.A 0.0181f
C670 a_1029_9178# VDD 3.08533f
C671 VDD a_32529_14554# 3.11738f
C672 BUFX3_1.Y a_17497_14130# 0.05629f
C673 BUFX3_31.A BUFX3_1.Y 0.09303f
C674 AND2X1_3.B a_1097_14480# 0.01554f
C675 clock_i a_5061_16182# 0.035f
C676 a_16485_4736# a_15645_4086# 0.02812f
C677 VDD a_8673_15488# 0.26578f
C678 a_1029_16182# a_2376_16196# 0.01103f
C679 a_28581_5430# VDD 3.06479f
C680 a_19593_5146# a_20349_4284# 0.02812f
C681 VDD a_2541_15036# 0.10275f
C682 VDD a_8085_10522# 0.69267f
C683 a_1097_9426# a_1097_9104# 0.58526f
C684 a_23457_9462# a_23525_9426# 1.99572f
C685 BUFX3_2.A a_18921_14554# 0.04689f
C686 a_37973_14480# a_37905_14554# 0.43806f
C687 BUFX3_1.Y a_6473_14480# 0.01233f
C688 a_27741_2742# a_30429_2742# 0.15401f
C689 a_37973_7760# a_38580_7868# 0.04779f
C690 XOR2X1_0.A a_5313_15898# 0.03303f
C691 BUFX3_17.A a_18333_16149# 0.02403f
C692 BUFX3_26.Y AND2X1_1.B 0.54996f
C693 a_19677_12150# a_19745_12114# 0.43806f
C694 a_1097_14802# a_2373_15036# 0.04852f
C695 a_5213_5394# a_6473_5072# 0.27274f
C696 OR3BX1_0.Y a_18343_15660# 0.01737f
C697 VDD a_20769_12150# 3.14281f
C698 a_7817_14480# a_8424_14588# 0.04779f
C699 a_28649_10770# a_27473_10448# 0.30073f
C700 a_4053_10522# a_6741_10522# 0.15401f
C701 a_7901_10770# a_7833_9462# 0.02154f
C702 VDD a_9161_14480# 0.51875f
C703 a_15713_4050# a_16401_2742# 0.01316f
C704 NOR3X1_0.Y OR3X1_1.B 0.34677f
C705 a_19593_3802# VDD 3.12751f
C706 VDD AND2X1_0.Y 0.26013f
C707 BUFX3_1.Y a_1097_14802# 0.02975f
C708 a_23457_8118# a_26145_8118# 0.15401f
C709 BUFX3_27.Y a_21979_14852# 0.03509f
C710 a_9161_9104# VDD 0.51524f
C711 a_9161_6416# a_9093_6490# 1.99572f
C712 AOI21BX2_0.A a_22873_16146# 0.01664f
C713 OAI21X1_1.Y OR3X1_1.C 0.01344f
C714 a_22350_16146# BUFX3_1.Y 0.2194f
C715 VDD a_38913_14144# 0.11104f
C716 a_1029_5430# BUFX3_0.Y 0.09952f
C717 a_32597_11792# a_32529_11866# 1.99572f
C718 a_11781_11866# a_12537_11004# 0.02812f
C719 a_15318_15510# a_15057_15488# 0.01108f
C720 clock_i DFFQX1_0.Q 0.09446f
C721 a_3785_4050# a_4392_4100# 0.04779f
C722 a_2709_16380# a_2877_16380# 0.09255f
C723 a_35369_5394# VDD 0.20824f
C724 a_7817_9104# a_8424_9212# 0.04779f
C725 VDD a_11781_10522# 3.18026f
C726 a_26213_9426# a_27557_9426# 0.01425f
C727 a_30497_2706# a_31101_2940# 0.04852f
C728 a_22197_15624# a_22803_15536# 0.0867f
C729 a_4460_6752# VDD 0.12134f
C730 a_7901_5394# a_8492_5094# 0.03648f
C731 a_28581_5430# a_28649_5394# 1.99572f
C732 VDD a_27557_12114# 0.20824f
C733 VDD a_15813_14554# 0.69297f
C734 a_22349_3728# a_22281_3802# 0.94424f
C735 a_31505_3728# VDD 0.21456f
C736 a_27489_8118# a_27557_8082# 0.43806f
C737 a_26985_16380# a_24785_15824# 0.01014f
C738 a_4460_8096# a_3785_7760# 0.01952f
C739 counter_value_o[7] a_37153_16146# 0.21916f
C740 DFFQX1_4.Q a_17077_16182# 0.21734f
C741 VDD a_17749_16182# 0.21366f
C742 a_27221_13458# a_27473_13136# 0.04899f
C743 a_3785_13136# a_3717_13210# 1.99572f
C744 a_15813_9178# VDD 0.6927f
C745 a_8424_6524# a_8757_6080# 0.01772f
C746 a_31337_6738# a_32109_6080# 0.01014f
C747 a_11781_6490# a_14469_6490# 0.15401f
C748 VDD a_4725_13692# 0.24966f
C749 a_35217_11866# a_37905_11866# 0.15401f
C750 DFFQX1_5.CK BUFX3_3.A 0.10709f
C751 a_27405_5146# a_27489_4086# 0.11121f
C752 a_38412_5444# VDD 0.28533f
C753 VDD a_23693_10448# 0.20824f
C754 NAND2X1_0.A BUFX3_26.A 0.02447f
C755 DFFQX1_6.D OR3BX1_0.B 0.02352f
C756 counter_value_o[4] NOR3X1_0.Y 0.01698f
C757 a_38580_14588# a_38913_14144# 0.01772f
C758 clock_i a_3385_16182# 0.01286f
C759 a_19593_7834# a_20349_6972# 0.02812f
C760 a_16485_7424# a_15645_6774# 0.02812f
C761 BUFX3_12.A a_3325_15532# 0.01088f
C762 a_22197_15624# a_23033_15572# 0.01951f
C763 a_20769_12150# a_20837_12114# 1.99572f
C764 BUFX3_2.A a_17816_14502# 0.08161f
C765 a_31337_5394# a_34025_5394# 0.01208f
C766 a_7901_6738# VDD 0.5247f
C767 a_9161_14480# a_9093_14554# 1.99572f
C768 VDD a_28649_12114# 0.51327f
C769 a_8153_10448# a_8757_10112# 0.03035f
C770 a_32597_3728# VDD 0.56295f
C771 a_5213_8082# a_6473_7760# 0.27274f
C772 OR3X1_1.C OR3X1_1.A 0.66219f
C773 a_6405_13210# a_7749_13210# 0.01349f
C774 AND2X1_3.Y AND2X1_3.B 0.12979f
C775 BUFX3_27.Y BUFX3_23.A 0.01771f
C776 a_16905_9178# VDD 3.05265f
C777 OA21X2_1.Y a_22873_16146# 0.02427f
C778 VDD a_10589_13458# 0.32678f
C779 a_38648_11814# a_38913_11456# 0.02298f
C780 a_19593_11866# a_19677_10806# 0.11121f
C781 a_27405_5146# a_28581_4086# 0.27765f
C782 a_1097_5072# VDD 0.57652f
C783 a_9161_9104# a_9093_9178# 1.99572f
C784 VDD a_24785_10448# 0.51278f
C785 NOR3X1_0.C a_22029_14280# 0.01006f
C786 BUFX3_1.Y BUFX3_3.Y 0.30538f
C787 a_1029_13494# a_1097_13458# 1.99572f
C788 VDD NOR3X1_0.A 0.57747f
C789 a_3785_6738# a_4392_6788# 0.04779f
C790 a_23525_12114# a_26213_12114# 0.01208f
C791 a_4725_12348# a_3785_11792# 0.01014f
C792 a_35217_6490# a_35285_5072# 0.02403f
C793 a_13025_5394# a_14537_5072# 0.22482f
C794 a_18333_6774# VDD 1.45223f
C795 BUFX3_1.Y AOI21BX1_0.A 0.09901f
C796 VDD a_37737_12150# 0.72674f
C797 a_11781_14554# a_14469_14554# 0.15401f
C798 AND2X1_0.Y a_17069_14144# 0.08408f
C799 DFFQX1_3.D a_8673_15488# 0.01782f
C800 a_27473_3728# a_30161_3728# 0.01208f
C801 a_38648_3750# VDD 0.10108f
C802 a_4053_3802# a_4392_2756# 0.03593f
C803 a_28581_8118# a_28649_8082# 1.99572f
C804 a_7901_8082# a_8492_7782# 0.03648f
C805 BUFX3_23.A OR3X1_1.B 0.07945f
C806 BUFX3_26.A a_6493_14838# 0.20922f
C807 a_30161_9104# VDD 0.32552f
C808 a_19661_6416# a_19593_6490# 1.99572f
C809 OR3X1_1.C DFFQX1_5.D 0.03598f
C810 DFFQX1_7.Q a_23033_15572# 0.04202f
C811 NOR3X1_0.Y a_22635_14192# 0.03674f
C812 VDD a_19677_13494# 0.71192f
C813 a_1029_10806# a_3717_10806# 0.15401f
C814 a_19593_11866# a_20769_10806# 0.27765f
C815 BUFX3_27.Y BUFX3_29.A 0.19291f
C816 a_11781_9178# a_14469_9178# 0.15401f
C817 a_7749_5146# VDD 0.71162f
C818 a_8424_9212# a_8757_8768# 0.01772f
C819 clock_i BUFX24_2.A 0.16154f
C820 VDD a_30093_10522# 1.46587f
C821 AOI21BX2_0.A OA21X2_1.Y 0.03657f
C822 a_4392_13508# a_4460_13472# 0.15111f
C823 a_23709_14554# a_23121_13494# 0.11121f
C824 a_37989_2742# a_38664_2756# 0.01169f
C825 a_35369_2706# a_38057_2706# 0.01208f
C826 a_27405_7834# a_27489_6774# 0.11121f
C827 BUFX3_1.Y a_18343_15660# 0.01306f
C828 a_20937_14144# a_20769_13494# 0.02812f
C829 a_20349_6972# VDD 0.25052f
C830 a_36461_5394# a_37805_5394# 0.01425f
C831 a_37737_5430# a_38412_5444# 0.01169f
C832 VDD a_38913_12348# 0.0867f
C833 BUFX3_1.Y a_15645_13494# 0.02487f
C834 VDD a_5985_15488# 0.23103f
C835 a_19661_10448# a_22349_10448# 0.01208f
C836 a_30161_3728# a_31437_3802# 0.06964f
C837 a_1097_2706# VDD 0.57296f
C838 a_31337_8082# a_34025_8082# 0.01208f
C839 a_14537_13136# a_15881_13136# 0.01425f
C840 a_35369_13458# a_35285_13136# 0.10882f
C841 a_23525_6738# a_23457_5430# 0.0208f
C842 DFFQX1_3.CK a_8623_14852# 0.01878f
C843 NAND3X1_0.B a_6417_15938# 0.04825f
C844 OR3X1_1.B BUFX3_29.A 0.17931f
C845 NOR3X1_0.Y a_22865_14228# 0.01603f
C846 DFFQX1_3.Q DFFQX1_3.CK 0.21418f
C847 VDD a_20769_13494# 0.74638f
C848 OR3X1_0.Y a_21391_15175# 0.05207f
C849 a_3785_10770# a_4460_10784# 0.01184f
C850 a_21189_14906# BUFX3_29.A 0.01449f
C851 BUFX3_1.Y OR3X1_1.C 0.52234f
C852 a_32109_4736# a_31269_4086# 0.02812f
C853 a_12957_4086# a_15645_4086# 0.15401f
C854 a_15881_5072# VDD 0.20824f
C855 NAND3X1_0.B DFFQX1_3.CK 0.12112f
C856 VDD a_32529_10522# 3.11738f
C857 a_36393_9462# a_37737_9462# 0.01349f
C858 a_24717_14554# a_25809_13494# 0.24023f
C859 a_27405_7834# a_28581_6774# 0.27765f
C860 DFFQX1_6.D AOI21BX2_0.A 0.09401f
C861 a_33957_12150# a_35301_12150# 0.01349f
C862 BUFX3_0.Y a_6473_14480# 0.06225f
C863 a_26213_6738# VDD 0.32194f
C864 a_38480_5408# a_38745_5628# 0.03941f
C865 VDD a_22245_15244# 0.19678f
C866 VDD a_1029_11866# 3.08405f
C867 a_22349_10448# a_23625_10522# 0.06964f
C868 a_13025_8082# a_14537_7760# 0.22482f
C869 a_35217_9178# a_35285_7760# 0.02403f
C870 DFFQX1_3.CK a_16485_14920# 0.15649f
C871 a_5129_2706# VDD 0.50703f
C872 a_37805_13458# a_37973_13136# 0.06961f
C873 a_37905_9178# VDD 0.72638f
C874 a_24785_6416# a_27473_6416# 0.01208f
C875 a_3717_6490# a_4392_5444# 0.03593f
C876 VDD a_2373_15488# 0.19993f
C877 NAND2X1_0.Y a_5145_14838# 0.0832f
C878 VDD a_22197_13608# 0.18281f
C879 a_5145_10806# a_7833_10806# 0.15401f
C880 NOR3X1_0.Y OR3X1_1.A 0.1236f
C881 a_18333_4086# a_18401_4050# 0.94424f
C882 a_19661_5072# VDD 0.53123f
C883 a_37905_5146# a_37737_4086# 0.06895f
C884 a_19661_9104# a_19593_9178# 1.99572f
C885 VDD a_38913_10112# 0.11104f
C886 OA21X2_0.B a_22873_16146# 0.09164f
C887 a_37805_9426# a_38480_9440# 0.01184f
C888 a_11865_13494# a_10589_13458# 0.06964f
C889 a_5213_13458# a_7901_13458# 0.01208f
C890 a_12537_12348# a_11849_11792# 0.01014f
C891 a_35301_12150# a_35973_12348# 0.01448f
C892 a_23525_5394# a_23693_5072# 0.11187f
C893 VDD a_7333_16182# 0.21028f
C894 a_35301_6774# VDD 0.6927f
C895 VDD OR3X1_1.Y 0.31604f
C896 VDD a_9161_11792# 0.51524f
C897 a_13041_16182# OR3X1_1.B 0.01377f
C898 a_11597_2706# VDD 0.21542f
C899 a_19341_15898# a_18989_14480# 0.01394f
C900 a_37737_8118# a_38412_8132# 0.01169f
C901 a_36461_8082# a_37805_8082# 0.01425f
C902 a_32597_3728# a_32529_3802# 1.99572f
C903 VDD a_7297_15682# 0.19458f
C904 a_16973_13136# a_19661_13136# 0.01208f
C905 DFFQX1_0.Q AND2X1_1.B 0.45185f
C906 a_3717_8118# VDD 0.69675f
C907 DFFQX1_3.CK a_9833_14802# 0.17053f
C908 VDD a_4981_15510# 0.21709f
C909 VDD a_22903_13948# 0.01202f
C910 a_30093_11866# a_28581_10806# 0.25266f
C911 BUFX3_2.A a_15713_13458# 0.01187f
C912 a_10521_10806# a_10589_10770# 0.94424f
C913 OR3X1_1.A a_21979_14852# 0.05844f
C914 a_23625_5146# VDD 0.69298f
C915 VDD a_4725_9660# 0.24966f
C916 NAND3X1_0.B a_6803_15792# 0.04386f
C917 NAND3X1_0.Y DFFQX1_3.CK 0.11118f
C918 NOR3X1_0.Y DFFQX1_5.D 0.02225f
C919 a_15800_16160# a_16065_16380# 0.02298f
C920 a_38745_9660# a_38913_9660# 0.09255f
C921 a_11933_13458# a_12537_13692# 0.04852f
C922 a_30093_14554# a_28581_13494# 0.25266f
C923 a_12957_6774# a_15645_6774# 0.15401f
C924 a_32109_7424# a_31269_6774# 0.02812f
C925 OAI21X1_2.Y a_20775_14852# 0.04152f
C926 AOI21BX2_0.A OA21X2_0.B 0.042f
C927 DFFQX1_6.D OA21X2_1.Y 0.18596f
C928 OR3BX1_0.B a_20000_14816# 0.01123f
C929 a_1097_5072# a_1029_5146# 1.99572f
C930 a_23525_5394# a_24785_5072# 0.27946f
C931 a_36393_6774# VDD 1.48411f
C932 VDD a_15813_11866# 0.6927f
C933 a_35217_3802# a_37905_3802# 0.15401f
C934 a_38480_8096# a_38745_8316# 0.03941f
C935 a_15881_13136# a_16485_12800# 0.04852f
C936 a_30093_6490# a_31437_6490# 0.01349f
C937 DFFQX1_3.CK a_13025_14802# 0.14465f
C938 a_7833_8118# VDD 3.12641f
C939 a_9093_6490# a_7833_5430# 0.27719f
C940 OR3X1_1.B a_19593_13210# 0.01979f
C941 VDD a_28581_13494# 3.06515f
C942 a_24785_9104# a_27473_9104# 0.01208f
C943 a_24717_5146# VDD 3.05265f
C944 a_3717_9178# a_4392_8132# 0.03593f
C945 VDD a_10589_9426# 0.32678f
C946 VDD a_17497_16146# 0.21235f
C947 a_16401_16182# DFFQX1_4.Q 0.01446f
C948 a_15645_13494# a_18333_13494# 0.15401f
C949 BUFX3_23.A a_19681_14802# 0.21703f
C950 DFFQX1_3.CK a_9429_15898# 0.015f
C951 a_37905_7834# a_37737_6774# 0.06895f
C952 BUFX3_1.Y NOR3X1_0.Y 0.02563f
C953 a_18333_6774# a_18401_6738# 0.94424f
C954 XOR2X1_0.A a_5145_14838# 0.01495f
C955 BUFX3_27.A BUFX3_29.Y 0.03172f
C956 a_15713_12114# a_16973_11792# 0.27946f
C957 a_3717_5146# a_6405_5146# 0.15401f
C958 a_7817_5072# a_8492_5094# 0.01184f
C959 a_38745_6972# VDD 0.2023f
C960 VDD a_16905_11866# 3.05265f
C961 a_33873_16182# a_33941_16146# 0.43806f
C962 a_24717_10522# a_27405_10522# 0.15401f
C963 a_31505_10448# a_31437_10522# 0.43806f
C964 a_23625_10522# a_24297_10112# 0.01448f
C965 a_38648_3750# a_38913_3392# 0.02298f
C966 a_23525_8082# a_23693_7760# 0.11187f
C967 a_19761_2940# VDD 0.25052f
C968 BUFX3_0.Y a_5213_13458# 0.02347f
C969 a_22281_13210# a_23625_13210# 0.01349f
C970 DFFQX1_3.CK a_11849_14480# 0.07204f
C971 a_31505_6416# a_32109_6080# 0.04852f
C972 VDD a_35369_13458# 0.20824f
C973 OAI21X1_0.A a_18837_16182# 0.02907f
C974 OR3X1_1.B a_10941_15898# 0.06696f
C975 a_37973_5072# VDD 0.25876f
C976 a_20837_4050# a_23525_4050# 0.01208f
C977 a_27489_4086# a_26213_4050# 0.06964f
C978 a_3785_4050# a_4121_3728# 0.02786f
C979 OR3X1_1.A BUFX3_23.A 0.49931f
C980 VDD a_19677_9462# 0.6927f
C981 a_35217_14554# a_35301_13494# 0.11121f
C982 a_19677_13494# a_19745_13458# 0.43806f
C983 counter_value_o[6] DFFQX1_5.Q 0.01439f
C984 OA21X2_0.B OA21X2_1.Y 0.09543f
C985 BUFX3_23.A a_23965_15474# 0.02289f
C986 a_7817_6416# VDD 0.25487f
C987 VDD a_30161_11792# 0.32552f
C988 a_34548_16196# a_34616_16160# 0.15111f
C989 a_13109_16146# a_14792_15846# 0.03648f
C990 a_11781_10522# a_11865_9462# 0.11121f
C991 DFFQX1_3.Q a_9497_16146# 0.11424f
C992 a_23961_2742# VDD 3.14338f
C993 a_1097_7760# a_1029_7834# 1.99572f
C994 a_23525_8082# a_24785_7760# 0.27946f
C995 a_1029_2742# a_3717_2742# 0.15401f
C996 VDD AND2X1_1.Y 0.31289f
C997 a_32529_6490# a_35217_6490# 0.15401f
C998 a_15713_8082# VDD 0.52435f
C999 a_37973_6416# a_38648_6438# 0.01184f
C1000 a_3717_5146# BUFX3_0.Y 0.0125f
C1001 VDD a_38412_13508# 0.28533f
C1002 a_13025_10770# a_15713_10770# 0.01208f
C1003 a_19677_10806# a_18401_10770# 0.06964f
C1004 OR3X1_1.B a_14049_15898# 0.02641f
C1005 a_27557_4050# a_28161_4284# 0.04852f
C1006 a_9093_9178# a_7833_8118# 0.27719f
C1007 a_30093_9178# a_31437_9178# 0.01349f
C1008 a_32109_4736# VDD 0.25358f
C1009 BUFX3_27.Y DFFQX1_5.CK 0.30269f
C1010 VDD a_20769_9462# 3.1423f
C1011 a_35217_14554# a_36393_13494# 0.25048f
C1012 OR3X1_1.A BUFX3_29.A 0.11103f
C1013 OR3X1_1.C a_22383_15045# 0.02581f
C1014 a_11849_9104# a_12537_9660# 0.01014f
C1015 AND2X1_2.B DFFQX1_3.CK 0.10278f
C1016 a_15713_12114# a_16485_11456# 0.01014f
C1017 BUFX3_29.A a_21525_14180# 0.04462f
C1018 a_11849_5072# a_14537_5072# 0.01208f
C1019 a_34025_5394# a_32597_5072# 0.24595f
C1020 a_1029_2742# BUFX3_0.Y 0.04675f
C1021 a_32597_16146# BUFX3_41.A 0.02507f
C1022 a_35301_16182# a_35369_16146# 0.94424f
C1023 NOR3X1_0.C a_22751_15170# 0.01129f
C1024 a_3049_16146# a_3385_16182# 0.04731f
C1025 a_11781_10522# a_12957_9462# 0.27765f
C1026 BUFX3_1.Y NAND2X1_0.Y 0.03973f
C1027 a_3717_7834# a_6405_7834# 0.15401f
C1028 a_30429_2742# VDD 0.69301f
C1029 a_3785_2706# a_4460_2720# 0.01184f
C1030 a_7817_7760# a_8492_7782# 0.01184f
C1031 a_8424_13244# a_7833_12150# 0.03593f
C1032 a_30161_13136# a_30093_13210# 0.94424f
C1033 a_16905_6490# a_18333_5430# 0.26941f
C1034 a_26145_8118# VDD 1.45223f
C1035 a_10941_15898# a_12288_15932# 0.01103f
C1036 clock_i DFFQX1_3.CK 0.29986f
C1037 VDD a_1097_13136# 0.57546f
C1038 a_38580_11900# a_38745_11004# 0.01103f
C1039 OR3X1_1.B DFFQX1_5.CK 0.98426f
C1040 a_19745_10770# a_20349_11004# 0.04852f
C1041 a_31269_4086# a_33957_4086# 0.15401f
C1042 a_4392_4100# VDD 0.26358f
C1043 a_31505_9104# a_32109_8768# 0.04852f
C1044 VDD a_2877_16380# 0.10769f
C1045 VDD a_27557_9426# 0.20824f
C1046 a_27489_6774# a_26213_6738# 0.06964f
C1047 a_20837_6738# a_23525_6738# 0.01208f
C1048 BUFX3_27.Y a_20775_14852# 0.01864f
C1049 BUFX3_1.Y BUFX3_23.A 0.95094f
C1050 a_26213_12114# a_24785_11792# 0.24595f
C1051 a_6473_11792# a_7817_11792# 0.01425f
C1052 a_36461_5394# a_35285_5072# 0.27676f
C1053 a_14469_6490# VDD 1.46572f
C1054 a_15881_5072# a_15813_5146# 0.43806f
C1055 a_8492_5094# a_8757_4736# 0.02298f
C1056 VDD a_37905_11866# 0.72638f
C1057 a_36716_16160# a_36981_16380# 0.02298f
C1058 a_35369_16146# BUFX3_41.A 0.03559f
C1059 a_31589_2706# VDD 0.57265f
C1060 a_5061_2742# a_7749_2742# 0.15401f
C1061 a_9093_13210# a_10521_12150# 0.26941f
C1062 a_28161_8316# VDD 0.25052f
C1063 a_12356_15846# a_12621_15488# 0.02298f
C1064 VDD a_7749_13210# 0.71162f
C1065 a_23457_10806# a_26145_10806# 0.15401f
C1066 a_37973_9104# a_38648_9126# 0.01184f
C1067 a_35301_4086# a_35369_4050# 0.43806f
C1068 a_32529_9178# a_35217_9178# 0.15401f
C1069 a_5213_4050# VDD 0.51275f
C1070 VDD a_28649_9426# 0.51327f
C1071 OAI21X1_0.A AOI21BX1_0.Y 0.06635f
C1072 DFFQX1_3.CK a_13025_13458# 0.01733f
C1073 a_3517_15682# a_3441_15952# 0.21799f
C1074 OR3X1_1.B a_20775_14852# 0.06191f
C1075 a_27557_6738# a_28161_6972# 0.04852f
C1076 a_5213_6738# a_3785_6416# 0.24646f
C1077 a_16973_9104# a_15713_9426# 0.27946f
C1078 a_7817_11792# a_8424_11900# 0.04779f
C1079 NAND2X1_0.A a_7241_14816# 0.02562f
C1080 a_8757_6080# VDD 0.15604f
C1081 OR3X1_1.B a_20265_14554# 0.06132f
C1082 VDD a_3717_10806# 0.69675f
C1083 a_38580_10556# a_38913_10112# 0.01772f
C1084 a_34025_8082# a_32597_7760# 0.24595f
C1085 a_11849_7760# a_14537_7760# 0.01208f
C1086 a_7817_2706# a_8421_2940# 0.04852f
C1087 a_38057_2706# VDD 0.25336f
C1088 BUFX3_41.A a_24617_14802# 0.06312f
C1089 a_35285_13136# a_37973_13136# 0.01208f
C1090 a_34025_8082# VDD 0.32194f
C1091 a_14049_15898# a_14724_15932# 0.01169f
C1092 VDD a_15881_13136# 0.20824f
C1093 a_27489_10806# a_27557_10770# 0.43806f
C1094 a_4641_15036# a_4809_15036# 0.09255f
C1095 BUFX3_1.Y XOR2X1_0.A 0.32572f
C1096 a_13025_4050# a_14537_3728# 0.22482f
C1097 a_35217_5146# a_35285_3728# 0.02403f
C1098 a_15645_4086# VDD 3.1238f
C1099 a_16905_9178# a_18333_8118# 0.26941f
C1100 VDD a_37737_9462# 0.72674f
C1101 a_31269_6774# a_33957_6774# 0.15401f
C1102 a_22613_15244# OR3X1_1.Y 0.01507f
C1103 a_27473_6416# VDD 0.52258f
C1104 OR3X1_1.C BUFX3_29.Y 0.57208f
C1105 DFFQX1_5.CK a_17829_14920# 0.18386f
C1106 BUFX3_26.Y BUFX3_1.Y 0.02043f
C1107 VDD a_7833_10806# 3.12641f
C1108 a_22281_10522# a_20769_9462# 0.25266f
C1109 a_1029_9462# a_1097_9426# 1.99572f
C1110 DFFQX1_0.D DFFQX1_3.CK 0.04048f
C1111 VDD a_15732_16196# 0.2675f
C1112 a_36461_8082# a_35285_7760# 0.27676f
C1113 a_8492_7782# a_8757_7424# 0.02298f
C1114 a_15881_7760# a_15813_7834# 0.43806f
C1115 a_30093_3802# a_30429_2742# 0.11121f
C1116 BUFX3_41.A a_33957_14838# 0.03934f
C1117 a_37973_13136# a_38580_13244# 0.04779f
C1118 BUFX3_12.A a_3297_16380# 0.05452f
C1119 a_37805_8082# VDD 0.25732f
C1120 a_27912_14852# a_28245_15036# 0.01772f
C1121 VDD a_19661_13136# 0.55052f
C1122 a_5213_10770# a_4121_10448# 0.30526f
C1123 a_37737_4086# a_37805_4050# 0.43806f
C1124 clock_i a_1097_16146# 0.05603f
C1125 VDD a_38913_9660# 0.0867f
C1126 OAI21X1_0.Y a_19179_14852# 0.04156f
C1127 a_24717_14554# a_24785_13136# 0.01237f
C1128 a_25809_13494# a_25877_13458# 0.94424f
C1129 BUFX3_41.A a_30161_15824# 0.01893f
C1130 DFFQX1_5.Q OR3X1_1.B 0.12679f
C1131 a_11933_6738# a_11849_6416# 0.10882f
C1132 a_35301_6774# a_35369_6738# 0.43806f
C1133 a_16485_8768# a_15713_9426# 0.01014f
C1134 a_9161_11792# a_9093_11866# 1.99572f
C1135 a_31437_6490# VDD 0.69838f
C1136 a_19593_5146# a_22281_5146# 0.15401f
C1137 a_21979_14852# a_22383_15045# 0.15054f
C1138 BUFX3_27.A a_22281_13210# 0.02063f
C1139 counter_value_o[2] a_13041_16182# 0.01533f
C1140 a_4392_9476# a_4460_9440# 0.15111f
C1141 VDD DFFQX1_4.Q 0.40772f
C1142 a_4460_16160# a_4725_16380# 0.02298f
C1143 DFFQX1_5.CK OR3BX1_0.Y 0.04258f
C1144 VDD a_32597_16146# 0.36586f
C1145 a_6803_15792# a_6911_15770# 0.21538f
C1146 a_27405_6490# a_28161_5628# 0.02812f
C1147 a_7833_5430# a_7901_5394# 1.99572f
C1148 a_31269_14838# a_33957_14838# 0.15401f
C1149 VDD a_23625_13210# 0.69298f
C1150 a_28581_10806# a_28649_10770# 1.99572f
C1151 a_23525_4050# VDD 0.52396f
C1152 BUFX3_41.A a_24785_14480# 0.02779f
C1153 a_18031_14852# a_18573_14575# 0.01103f
C1154 a_38412_4100# a_38745_4284# 0.01772f
C1155 a_18031_14852# a_18665_15244# 0.14171f
C1156 a_27237_14838# a_27912_14852# 0.01169f
C1157 BUFX3_28.A a_23425_14838# 0.01704f
C1158 a_5381_15824# DFFQX1_3.CK 0.03085f
C1159 a_37153_16146# a_35285_15824# 0.0116f
C1160 BUFX3_41.A a_32597_15824# 0.11131f
C1161 a_13025_6738# a_11849_6416# 0.30073f
C1162 a_24785_9104# a_26213_9426# 0.24595f
C1163 a_7817_9104# a_6473_9104# 0.01425f
C1164 a_11781_11866# a_14469_11866# 0.15401f
C1165 a_8424_11900# a_8757_11456# 0.01772f
C1166 a_31337_12114# a_32109_11456# 0.01014f
C1167 BUFX3_41.A a_23629_15474# 0.01243f
C1168 OR3X1_1.B BUFX24_2.A 0.95365f
C1169 a_23709_14838# a_23777_14480# 0.01188f
C1170 a_35217_6490# VDD 3.14104f
C1171 VDD a_15713_10770# 0.52435f
C1172 clock_i a_9497_16146# 0.14998f
C1173 a_12689_2706# a_15377_2706# 0.01208f
C1174 a_5129_16146# a_5736_16196# 0.04779f
C1175 a_16485_12800# a_15645_12150# 0.02812f
C1176 VDD a_35369_16146# 0.31197f
C1177 a_19593_13210# a_20349_12348# 0.02812f
C1178 a_10589_5394# a_11933_5394# 0.01425f
C1179 NAND2X1_0.Y BUFX3_0.Y 0.19511f
C1180 a_6405_7834# VDD 1.46323f
C1181 a_27473_15824# a_30161_15824# 0.01208f
C1182 VDD a_24717_13210# 3.05265f
C1183 a_35301_14838# a_35369_14802# 0.43806f
C1184 VDD a_12356_15846# 0.10676f
C1185 a_31337_10770# a_34025_10770# 0.01208f
C1186 a_12537_11004# a_11849_10448# 0.01014f
C1187 a_23525_4050# a_23693_3728# 0.11187f
C1188 a_33957_4086# VDD 1.45226f
C1189 a_27896_13472# a_28161_13692# 0.03941f
C1190 a_10589_13458# a_9161_13136# 0.24595f
C1191 a_37737_6774# a_37805_6738# 0.43806f
C1192 OR3X1_1.A DFFQX1_5.CK 0.36955f
C1193 BUFX3_41.A BUFX3_27.A 0.05048f
C1194 BUFX3_28.A a_23777_14480# 0.01679f
C1195 a_1029_5430# VDD 3.08535f
C1196 a_27473_5072# a_27405_5146# 1.99572f
C1197 a_7749_5146# a_7833_4086# 0.09008f
C1198 DFFQX1_5.CK a_21525_14180# 0.03085f
C1199 VDD a_26145_10806# 1.45223f
C1200 DFFQX1_4.Q BUFX3_17.A 0.14524f
C1201 a_5213_9426# a_7901_9426# 0.01208f
C1202 VDD a_17459_15170# 0.24138f
C1203 a_11865_9462# a_10589_9426# 0.06964f
C1204 BUFX3_1.Y a_10941_15898# 0.01583f
C1205 BUFX3_27.A a_23803_14838# 0.01548f
C1206 a_37905_3802# a_37989_2742# 0.08639f
C1207 a_19593_7834# a_22281_7834# 0.15401f
C1208 a_5804_16160# DFFQX1_0.Q 0.01523f
C1209 a_3785_12114# a_4392_12164# 0.04779f
C1210 a_22029_14280# a_23003_14188# 0.05938f
C1211 AND2X1_1.B DFFQX1_3.CK 0.01361f
C1212 a_7333_16182# a_7105_15532# 0.0116f
C1213 a_22231_14180# a_22497_14228# 0.06817f
C1214 a_11781_6490# a_11849_5072# 0.01868f
C1215 a_31505_15824# a_31437_15898# 0.43806f
C1216 a_3717_16182# a_3785_16146# 0.43806f
C1217 a_14537_7760# VDD 0.3248f
C1218 VDD a_37973_13136# 0.25876f
C1219 a_1097_4050# BUFX3_0.Y 0.15586f
C1220 VDD a_24617_14802# 0.51026f
C1221 a_8623_14852# a_9257_15244# 0.14171f
C1222 a_9395_15170# a_9765_14838# 0.01613f
C1223 VDD a_14792_15846# 0.10248f
C1224 VDD a_4809_15036# 0.13664f
C1225 a_20333_14480# a_20265_14554# 0.43806f
C1226 a_1433_3728# a_4121_3728# 0.01208f
C1227 a_7833_8118# a_7901_8082# 1.99572f
C1228 a_23525_4050# a_24785_3728# 0.27946f
C1229 a_35973_4284# VDD 0.25052f
C1230 a_27405_9178# a_28161_8316# 0.02812f
C1231 a_7105_15532# a_7297_15682# 0.06817f
C1232 a_28581_13494# a_28649_13458# 1.99572f
C1233 BUFX3_2.A OR3X1_0.Y 0.04337f
C1234 BUFX3_1.Y a_17091_15045# 0.01567f
C1235 a_31337_14802# a_31505_14480# 0.11187f
C1236 a_38412_6788# a_38745_6972# 0.01772f
C1237 a_20349_6972# a_19661_6416# 0.01014f
C1238 DFFQX1_3.CK a_5313_15898# 0.01443f
C1239 NAND3X1_0.Y a_8001_16258# 0.26687f
C1240 OR3X1_1.B a_17833_15510# 0.01247f
C1241 VDD a_3785_16146# 0.25724f
C1242 BUFX24_2.A a_12288_15932# 0.01368f
C1243 a_19661_11792# a_19593_11866# 1.99572f
C1244 AND2X1_3.B a_3309_15244# 0.02335f
C1245 a_5145_5430# VDD 3.05823f
C1246 BUFX3_28.A a_23709_14554# 0.09189f
C1247 a_31337_5394# a_31269_4086# 0.0208f
C1248 VDD a_21193_16182# 0.20955f
C1249 a_16153_14838# BUFX3_25.Y 0.2187f
C1250 VDD a_28161_11004# 0.25052f
C1251 a_11933_9426# a_12537_9660# 0.04852f
C1252 a_32529_10522# a_31269_9462# 0.27719f
C1253 VDD a_18031_14852# 0.34566f
C1254 BUFX3_1.Y a_4037_14802# 0.02166f
C1255 a_27809_16146# a_30161_15824# 0.02019f
C1256 a_21979_14852# BUFX3_29.Y 0.09455f
C1257 BUFX3_0.Y a_3717_13210# 0.01291f
C1258 a_27405_13210# a_27489_12150# 0.11121f
C1259 VDD a_18757_15474# 0.21681f
C1260 a_16973_7760# VDD 0.51278f
C1261 a_37737_14838# a_37805_14802# 0.43806f
C1262 VDD a_32109_12800# 0.25358f
C1263 a_8001_14852# a_7817_14480# 0.01127f
C1264 VDD a_33957_14838# 1.4526f
C1265 a_15713_10770# a_16973_10448# 0.27946f
C1266 a_37737_10806# a_38412_10820# 0.01169f
C1267 a_36461_10770# a_37805_10770# 0.01425f
C1268 a_10589_8082# a_11933_8082# 0.01425f
C1269 VDD a_8841_16380# 0.22824f
C1270 a_6809_3728# a_6741_3802# 0.94424f
C1271 a_31337_13458# a_34025_13458# 0.01208f
C1272 a_34025_14802# a_32597_14480# 0.24595f
C1273 XOR2X1_0.A BUFX3_0.Y 0.23873f
C1274 BUFX3_27.Y NOR3X1_0.C 0.13377f
C1275 a_18031_14852# BUFX3_2.Y 0.01281f
C1276 a_23171_15532# a_23629_15474# 0.0206f
C1277 BUFX3_12.A a_3131_15770# 0.03666f
C1278 VDD a_5736_16196# 0.26648f
C1279 BUFX24_2.A a_14724_15932# 0.01459f
C1280 a_35217_15898# a_35973_15036# 0.02812f
C1281 a_23525_12114# a_23457_10806# 0.0208f
C1282 NAND3X1_0.B NAND3X1_0.Y 0.08876f
C1283 a_32597_5072# a_35285_5072# 0.01208f
C1284 a_18905_16146# a_19512_16196# 0.04779f
C1285 a_11933_5394# VDD 0.2189f
C1286 VDD a_30161_15824# 0.33127f
C1287 counter_value_o[0] a_2444_16160# 0.03633f
C1288 VDD a_34025_10770# 0.32194f
C1289 VDD a_18989_14480# 0.33825f
C1290 a_23777_14480# a_24381_14144# 0.03035f
C1291 a_27473_14480# a_27405_14554# 1.99572f
C1292 a_15645_9462# a_18333_9462# 0.15401f
C1293 BUFX3_1.Y DFFQX1_5.CK 0.61796f
C1294 BUFX3_1.Y a_8001_14852# 0.1099f
C1295 DFFQX1_5.Q a_31505_15824# 0.03962f
C1296 a_7749_7834# a_7833_6774# 0.09008f
C1297 a_27473_7760# a_27405_7834# 1.99572f
C1298 a_20181_2742# a_20249_2706# 1.99572f
C1299 a_27405_13210# a_28581_12150# 0.27765f
C1300 a_22281_7834# VDD 1.53423f
C1301 AND2X1_1.B a_6803_15792# 0.03514f
C1302 VDD a_4392_12164# 0.26358f
C1303 a_38412_14852# a_38745_15036# 0.01772f
C1304 a_38480_10784# a_38745_11004# 0.03941f
C1305 VDD a_35973_15036# 0.25052f
C1306 NOR3X1_0.C a_22349_13136# 0.01237f
C1307 VDD a_9765_14838# 3.20031f
C1308 a_11781_9178# a_11849_7760# 0.01868f
C1309 a_4121_3728# VDD 0.52638f
C1310 NAND2X1_1.Y a_20937_14554# 0.01739f
C1311 OR3X1_1.B NOR3X1_0.C 0.26922f
C1312 a_19745_13458# a_19661_13136# 0.10882f
C1313 VDD a_23323_15175# 0.2467f
C1314 AOI21BX1_0.Y OR3X1_1.B 0.03128f
C1315 a_17816_14502# a_17748_14588# 0.15111f
C1316 a_36461_14802# a_35285_14480# 0.27676f
C1317 a_3785_6416# a_6473_6416# 0.01208f
C1318 a_32109_8768# a_31337_9426# 0.01014f
C1319 VDD a_24785_14480# 0.51122f
C1320 OR3X1_1.B a_18401_13458# 0.02593f
C1321 BUFX3_12.A a_4305_15898# 0.03837f
C1322 DFFQX1_5.Q BUFX3_28.A 0.09294f
C1323 a_24785_11792# a_27473_11792# 0.01208f
C1324 a_3717_11866# a_4392_10820# 0.03593f
C1325 BUFX3_27.Y a_21613_13458# 0.22079f
C1326 a_27809_16146# a_30497_16146# 0.01208f
C1327 a_13025_5394# VDD 0.53088f
C1328 XOR2X1_0.A a_7093_15779# 0.03852f
C1329 a_37973_5072# a_37905_5146# 0.43806f
C1330 VDD a_32597_15824# 0.5656f
C1331 a_15813_5146# a_15645_4086# 0.11121f
C1332 VDD a_37805_10770# 0.25732f
C1333 BUFX3_1.Y a_1097_12114# 0.09665f
C1334 a_19677_9462# a_19745_9426# 0.43806f
C1335 a_30093_14554# a_31437_14554# 0.01349f
C1336 a_23709_14554# a_24381_14144# 0.01448f
C1337 a_31337_8082# a_31269_6774# 0.0208f
C1338 BUFX3_1.Y a_8889_15244# 0.01006f
C1339 AND2X1_3.B a_2625_14852# 0.21847f
C1340 VDD a_23629_15474# 0.2152f
C1341 VDD a_19512_16196# 0.26684f
C1342 a_20769_5430# a_23457_5430# 0.15401f
C1343 a_35217_15898# a_37905_15898# 0.15401f
C1344 a_16485_7424# VDD 0.25052f
C1345 DFFQX1_5.Q a_23965_15474# 0.02903f
C1346 VDD a_5213_12114# 0.51428f
C1347 a_15713_10770# a_16485_10112# 0.01014f
C1348 a_9765_14838# a_12453_14805# 0.01223f
C1349 AND2X1_1.Y a_7105_15532# 0.03448f
C1350 a_20937_14144# a_21105_14144# 0.09255f
C1351 clock_i a_12714_15510# 0.51818f
C1352 NAND2X1_1.Y a_20937_14144# 0.01517f
C1353 a_3717_16182# DFFQX1_1.D 0.15999f
C1354 a_9161_3728# a_9093_3802# 1.99572f
C1355 a_34025_4050# a_32597_3728# 0.24595f
C1356 a_36461_13458# a_37805_13458# 0.01425f
C1357 a_21865_13494# a_19661_13136# 0.0116f
C1358 a_37737_13494# a_38412_13508# 0.01169f
C1359 a_7817_6416# a_7749_6490# 0.43806f
C1360 VDD a_30497_16146# 0.2085f
C1361 BUFX3_23.A a_19341_15898# 0.07483f
C1362 VDD a_31437_14554# 0.69838f
C1363 a_16905_5146# a_15645_4086# 0.27719f
C1364 a_38648_5094# a_38580_5180# 0.15111f
C1365 VDD a_37905_15898# 0.72638f
C1366 a_23457_5430# VDD 3.12574f
C1367 AND2X1_2.B a_8001_16258# 0.13054f
C1368 a_20856_16196# BUFX3_31.A 0.01731f
C1369 VDD a_21105_14144# 0.10553f
C1370 VDD NAND2X1_1.Y 0.32974f
C1371 VDD DFFQX1_1.D 0.27874f
C1372 a_32597_7760# a_35285_7760# 0.01208f
C1373 a_26649_2742# a_26717_2706# 0.43806f
C1374 VDD BUFX3_27.A 0.55176f
C1375 DFFQX1_5.Q DFFQX1_5.D 0.19412f
C1376 a_12957_12150# a_15645_12150# 0.15401f
C1377 a_32109_12800# a_31269_12150# 0.02812f
C1378 VDD a_17497_14130# 0.26809f
C1379 AND2X1_0.Y BUFX3_25.Y 0.0141f
C1380 VDD BUFX3_31.A 0.33622f
C1381 a_3785_5394# a_3785_5072# 0.10935f
C1382 a_26145_5430# a_26213_5394# 0.94424f
C1383 a_38648_15846# a_38913_15488# 0.02298f
C1384 a_35285_7760# VDD 0.52643f
C1385 VDD a_15645_12150# 3.1238f
C1386 a_3785_14480# a_6473_14480# 0.01208f
C1387 a_26213_10770# a_24785_10448# 0.24595f
C1388 VDD a_6473_14480# 0.33895f
C1389 VDD a_12453_15036# 0.23458f
C1390 VDD AOI21BX1_0.B 0.1575f
C1391 a_8085_3802# a_8757_3392# 0.01448f
C1392 a_36461_4050# a_35285_3728# 0.27676f
C1393 a_14469_3802# VDD 1.47771f
C1394 a_11781_3802# a_14469_3802# 0.15401f
C1395 a_37401_16182# a_37469_16146# 0.94424f
C1396 a_38480_13472# a_38745_13692# 0.03941f
C1397 a_31337_6738# a_31505_6416# 0.11187f
C1398 a_8492_6438# a_8424_6524# 0.15111f
C1399 a_23525_6738# a_24297_6080# 0.01014f
C1400 a_9093_11866# a_7833_10806# 0.27719f
C1401 a_30093_11866# a_31437_11866# 0.01349f
C1402 AOI21BX2_1.A OR3X1_0.Y 0.06244f
C1403 VDD a_1097_14802# 0.26605f
C1404 VDD a_4053_10522# 3.16234f
C1405 a_35285_14480# a_35217_14554# 1.99572f
C1406 a_20769_9462# a_20837_9426# 1.99572f
C1407 BUFX3_1.Y a_1097_14480# 0.11352f
C1408 BUFX3_2.A a_17748_14588# 0.03618f
C1409 NAND3X1_0.B AND2X1_2.B 0.06864f
C1410 a_15813_7834# a_15645_6774# 0.11121f
C1411 a_37973_7760# a_37905_7834# 0.43806f
C1412 VDD a_22350_16146# 0.24787f
C1413 a_1029_7834# BUFX3_0.Y 0.09952f
C1414 a_18333_12150# a_18401_12114# 0.94424f
C1415 a_37905_13210# a_37737_12150# 0.06895f
C1416 a_1029_14838# a_1097_14802# 0.94424f
C1417 a_38580_7868# VDD 0.27751f
C1418 BUFX3_1.Y DFFQX1_5.Q 0.18253f
C1419 a_7817_14480# a_7749_14554# 0.43806f
C1420 a_9833_14802# a_11849_14480# 0.09855f
C1421 a_6809_10448# a_8085_10522# 0.06964f
C1422 a_12957_14838# a_15648_14852# 0.11802f
C1423 VDD a_8424_14588# 0.26408f
C1424 a_1365_10522# a_4053_10522# 0.15401f
C1425 a_16905_15488# a_16485_14920# 0.02812f
C1426 a_20769_8118# a_23457_8118# 0.15401f
C1427 a_8757_3392# VDD 0.16198f
C1428 clock_i DFFQX1_3.Q 0.82124f
C1429 clock_i NAND3X1_0.B 0.03249f
C1430 a_31337_6738# a_32597_6416# 0.27946f
C1431 a_8424_9212# VDD 0.26381f
C1432 DFFQX1_3.CK OR3X1_1.B 0.39382f
C1433 VDD a_32109_14144# 0.25358f
C1434 a_23457_8118# a_23525_9426# 0.0208f
C1435 a_31505_11792# a_32109_11456# 0.04852f
C1436 OR3BX1_0.B BUFX3_27.Y 0.62904f
C1437 clock_i a_6069_16380# 0.01132f
C1438 NOR3X1_0.C a_22635_14192# 0.01964f
C1439 a_2444_16160# a_2709_16380# 0.03941f
C1440 a_1097_4050# a_3785_4050# 0.01208f
C1441 a_3717_4086# a_4392_4100# 0.01169f
C1442 a_31337_5394# VDD 0.59593f
C1443 a_7817_9104# a_7749_9178# 0.43806f
C1444 VDD a_15881_10448# 0.20824f
C1445 a_23525_9426# a_26213_9426# 0.01208f
C1446 a_4725_9660# a_3785_9104# 0.01014f
C1447 NAND4X2_0.C a_9181_16146# 0.22181f
C1448 a_16905_7834# a_15645_6774# 0.27719f
C1449 a_30429_2742# a_31101_2940# 0.01448f
C1450 a_38648_7782# a_38580_7868# 0.15111f
C1451 a_3785_6738# VDD 0.25345f
C1452 a_8492_14502# a_8424_14588# 0.15111f
C1453 VDD a_23525_12114# 0.52435f
C1454 BUFX3_0.Y a_4037_14802# 0.02946f
C1455 a_13025_14802# a_11849_14480# 0.30073f
C1456 VDD a_11781_14554# 3.17922f
C1457 a_15716_14816# a_15981_15036# 0.03941f
C1458 AOI21BX1_0.Y OR3BX1_0.Y 0.16016f
C1459 a_1097_15824# a_1029_15898# 0.94424f
C1460 a_3785_8082# a_3785_7760# 0.10935f
C1461 a_26145_8118# a_26213_8082# 0.94424f
C1462 a_19661_3728# a_19593_3802# 1.99572f
C1463 a_27473_3728# VDD 0.52258f
C1464 a_1097_13136# a_1029_13210# 1.99572f
C1465 a_21777_14920# a_21979_14852# 0.25198f
C1466 a_25877_13458# a_24785_13136# 0.26805f
C1467 a_14537_6416# a_15813_6490# 0.06964f
C1468 a_9093_6490# a_11781_6490# 0.15401f
C1469 a_11781_9178# VDD 3.18026f
C1470 OR3BX1_0.B OR3X1_1.B 0.70872f
C1471 NOR3X1_0.C a_23709_14838# 0.14763f
C1472 VDD a_4392_13508# 0.26358f
C1473 a_37973_11792# a_38648_11814# 0.01184f
C1474 a_32529_11866# a_35217_11866# 0.15401f
C1475 a_24717_5146# a_26145_4086# 0.26941f
C1476 a_8492_9126# a_8424_9212# 0.15111f
C1477 a_36461_5394# VDD 0.3193f
C1478 OR3X1_1.A a_22399_15524# 0.01932f
C1479 VDD a_19661_10448# 0.53123f
C1480 a_21529_16182# OR3BX1_0.B 0.08183f
C1481 counter_value_o[1] DFFQX1_0.Q 0.05296f
C1482 a_3785_16146# a_3313_15779# 0.01094f
C1483 a_31521_2742# a_34209_2742# 0.15401f
C1484 AND2X1_2.B NAND3X1_0.Y 0.57097f
C1485 BUFX3_12.A a_2629_15510# 0.21706f
C1486 a_18921_14554# a_19677_13494# 0.08639f
C1487 a_35301_5430# a_34025_5394# 0.06964f
C1488 a_28649_5394# a_31337_5394# 0.01208f
C1489 a_11865_6774# VDD 0.70179f
C1490 NOR3X1_0.A a_24717_14554# 0.0103f
C1491 BUFX3_0.Y a_8001_14852# 0.01683f
C1492 VDD a_33957_12150# 1.45226f
C1493 AND2X1_0.Y a_14537_14480# 0.01216f
C1494 BUFX3_1.Y a_1097_13458# 0.0971f
C1495 VDD BUFX3_3.Y 0.26227f
C1496 a_14537_10448# a_15881_10448# 0.01425f
C1497 a_31437_3802# VDD 0.71359f
C1498 a_3717_13210# a_6405_13210# 0.15401f
C1499 a_7817_13136# a_8492_13158# 0.01184f
C1500 a_23693_9104# VDD 0.20824f
C1501 a_3717_14554# a_5145_13494# 0.27326f
C1502 VDD AOI21BX1_0.A 0.15739f
C1503 NOR3X1_0.C BUFX3_28.A 0.01f
C1504 clock_i NAND3X1_0.Y 0.03328f
C1505 VDD a_5213_13458# 0.51428f
C1506 a_16905_11866# a_18333_10806# 0.26941f
C1507 AND2X1_3.Y BUFX3_1.Y 0.0625f
C1508 a_10521_4086# a_11865_4086# 0.01349f
C1509 a_24297_4736# a_23457_4086# 0.02812f
C1510 OR3X1_1.A NOR3X1_0.C 0.53304f
C1511 VDD a_23625_10522# 0.69298f
C1512 a_33957_9462# a_35301_9462# 0.01349f
C1513 a_1097_6738# a_3785_6738# 0.01208f
C1514 a_34277_2706# a_34881_2940# 0.04852f
C1515 a_3717_6774# a_4392_6788# 0.01169f
C1516 a_27489_12150# a_26213_12114# 0.06964f
C1517 a_20837_12114# a_23525_12114# 0.01208f
C1518 BUFX3_0.Y a_1097_12114# 0.07651f
C1519 a_20265_14554# a_20349_13692# 0.02812f
C1520 BUFX3_4.A a_8001_16258# 0.08153f
C1521 a_7669_16182# NAND3X1_0.Y 0.01427f
C1522 a_35369_5394# a_35973_5628# 0.04852f
C1523 NAND3X1_0.B DFFQX1_0.D 0.01799f
C1524 a_12957_6774# VDD 3.1114f
C1525 a_26985_16380# a_27157_16182# 0.02089f
C1526 a_14537_14480# a_15813_14554# 0.06964f
C1527 VDD a_35973_12348# 0.25052f
C1528 BUFX3_1.Y a_17833_15510# 0.02411f
C1529 a_9093_14554# a_11781_14554# 0.15401f
C1530 a_1033_3414# BUFX3_0.Y 0.21667f
C1531 a_31337_10770# a_32109_10112# 0.01014f
C1532 a_24785_3728# a_27473_3728# 0.01208f
C1533 a_35217_3802# VDD 3.0407f
C1534 VDD a_18343_15660# 0.10195f
C1535 a_24785_9104# VDD 0.51278f
C1536 a_22349_6416# a_23693_6416# 0.01425f
C1537 a_16973_6416# a_16905_6490# 1.99572f
C1538 VDD a_15645_13494# 3.24024f
C1539 a_11865_4086# a_12537_4284# 0.01448f
C1540 a_3717_5146# VDD 3.0976f
C1541 a_14537_9104# a_15813_9178# 0.06964f
C1542 a_9093_9178# a_11781_9178# 0.15401f
C1543 VDD a_24717_10522# 3.05265f
C1544 a_35301_9462# a_35973_9660# 0.01448f
C1545 a_3785_13458# a_4392_13508# 0.04779f
C1546 AOI21BX2_0.A BUFX3_27.Y 0.03135f
C1547 NOR3X1_0.C DFFQX1_5.D 0.02601f
C1548 a_3717_7834# a_3785_6416# 0.01931f
C1549 a_24717_7834# a_26145_6774# 0.26941f
C1550 VDD a_24365_16146# 0.51813f
C1551 a_5213_12114# a_3785_11792# 0.24646f
C1552 a_27557_12114# a_28161_12348# 0.04852f
C1553 BUFX3_1.Y a_22399_15524# 0.06281f
C1554 VDD OR3X1_1.C 0.53692f
C1555 a_37737_5430# a_36461_5394# 0.06964f
C1556 a_19745_6738# VDD 0.20824f
C1557 OAI21X1_0.A a_18803_15170# 0.05432f
C1558 a_16973_10448# a_19661_10448# 0.01208f
C1559 a_6741_3802# a_7749_2742# 0.02669f
C1560 a_28649_8082# a_31337_8082# 0.01208f
C1561 a_1029_2742# VDD 3.15891f
C1562 a_35301_8118# a_34025_8082# 0.06964f
C1563 a_34025_13458# a_32597_13136# 0.24595f
C1564 a_11849_13136# a_14537_13136# 0.01208f
C1565 a_30093_9178# VDD 1.46587f
C1566 a_11781_14554# a_11865_13494# 0.11121f
C1567 a_15813_6490# a_16485_6080# 0.01448f
C1568 a_21777_14920# BUFX3_29.A 0.01081f
C1569 a_11781_5146# a_11849_3728# 0.01868f
C1570 a_35217_5146# a_35301_4086# 0.11121f
C1571 a_15057_15488# a_12957_14838# 0.02812f
C1572 a_11849_5072# VDD 0.59389f
C1573 VDD a_17073_15938# 0.23179f
C1574 VDD a_37973_10448# 0.25876f
C1575 a_9429_16182# a_12117_16149# 0.01223f
C1576 a_24297_7424# a_23457_6774# 0.02812f
C1577 a_10521_6774# a_11865_6774# 0.01349f
C1578 a_21529_16182# AOI21BX2_0.A 0.21836f
C1579 OAI21X1_1.Y OR3BX1_0.B 0.37909f
C1580 BUFX3_1.Y NOR3X1_0.C 0.29939f
C1581 a_31269_12150# a_33957_12150# 0.15401f
C1582 OR3X1_1.B DFFQX1_2.D 0.03919f
C1583 AOI21BX1_0.Y BUFX3_1.Y 0.01565f
C1584 DFFQX1_1.D a_3313_15779# 0.12439f
C1585 BUFX3_0.Y a_1097_14480# 0.11598f
C1586 a_20837_6738# VDD 0.57859f
C1587 DFFQX1_0.D NAND3X1_0.Y 0.01578f
C1588 a_17069_14144# BUFX3_3.Y 0.33746f
C1589 VDD a_6473_11792# 0.31873f
C1590 BUFX3_27.A a_21865_13494# 0.0132f
C1591 a_9497_16146# OR3X1_1.B 0.0176f
C1592 a_15881_10448# a_16485_10112# 0.04852f
C1593 a_30093_3802# a_31437_3802# 0.01349f
C1594 DFFQX1_5.CK BUFX3_29.Y 0.48246f
C1595 a_5061_2742# VDD 3.08548f
C1596 OR3BX1_0.B OR3BX1_0.Y 0.01681f
C1597 a_35369_8082# a_35973_8316# 0.04852f
C1598 a_8492_13158# a_8757_12800# 0.02298f
C1599 a_36461_13458# a_35285_13136# 0.27676f
C1600 a_15881_13136# a_15813_13210# 0.43806f
C1601 a_32529_9178# VDD 3.11738f
C1602 a_11781_14554# a_12957_13494# 0.27765f
C1603 a_31337_14802# a_31269_13494# 0.0208f
C1604 AND2X1_0.Y a_15713_13458# 0.01477f
C1605 VDD a_3517_15682# 0.19458f
C1606 OAI21X1_0.Y a_19409_15824# 0.02616f
C1607 a_3717_11866# a_4121_10448# 0.01968f
C1608 a_15645_4086# a_15713_4050# 1.99572f
C1609 a_35217_5146# a_36393_4086# 0.25048f
C1610 a_22349_9104# a_23693_9104# 0.01425f
C1611 a_16973_9104# a_16905_9178# 1.99572f
C1612 BUFX3_41.A a_37401_16182# 0.09848f
C1613 a_18165_15510# AOI21BX1_0.A 0.07688f
C1614 VDD a_32109_10112# 0.25358f
C1615 a_13041_16182# a_13109_16146# 1.99572f
C1616 BUFX3_1.Y a_1097_11792# 0.10817f
C1617 clock_i AND2X1_2.B 0.04576f
C1618 a_11865_6774# a_12537_6972# 0.01448f
C1619 a_11933_12114# a_11849_11792# 0.10882f
C1620 a_35301_12150# a_35369_12114# 0.43806f
C1621 OR3BX1_0.B a_20333_14480# 0.0269f
C1622 BUFX3_12.A NAND2X1_0.A 0.02599f
C1623 OR3BX1_0.B a_19681_14802# 0.24245f
C1624 a_20837_5394# a_22349_5072# 0.22482f
C1625 BUFX3_23.A BUFX3_41.A 0.24223f
C1626 a_31269_6774# VDD 3.20096f
C1627 BUFX3_0.Y a_7749_14554# 0.01792f
C1628 VDD a_8424_11900# 0.26381f
C1629 a_23525_10770# a_23457_9462# 0.0208f
C1630 a_22281_10522# a_23625_10522# 0.01349f
C1631 a_31505_3728# a_32109_3392# 0.04852f
C1632 a_11781_3802# a_11529_2742# 0.04782f
C1633 BUFX3_4.A NAND3X1_0.Y 0.12543f
C1634 DFFQX1_5.Q a_23121_14906# 0.02695f
C1635 AND2X1_1.Y a_7241_14816# 0.08804f
C1636 NAND3X1_0.B AND2X1_1.B 0.02311f
C1637 a_7669_16182# AND2X1_2.B 0.22028f
C1638 a_11529_2742# VDD 0.73184f
C1639 a_37737_8118# a_36461_8082# 0.06964f
C1640 VDD a_6153_15938# 0.21909f
C1641 a_38913_8768# VDD 0.11104f
C1642 a_23693_6416# a_24297_6080# 0.04852f
C1643 a_7833_10806# a_7901_10770# 1.99572f
C1644 a_27405_11866# a_28161_11004# 0.02812f
C1645 a_18401_4050# a_19745_4050# 0.01425f
C1646 a_19593_5146# VDD 3.13748f
C1647 a_15813_9178# a_16485_8768# 0.01448f
C1648 VDD a_4392_9476# 0.26358f
C1649 OR3BX1_0.B OR3X1_1.A 0.10322f
C1650 a_27405_14554# a_28161_13692# 0.02812f
C1651 a_35217_7834# a_35301_6774# 0.11121f
C1652 clock_i a_7669_16182# 0.0105f
C1653 XOR2X1_0.A a_3969_14838# 0.02356f
C1654 a_13025_12114# a_11849_11792# 0.30073f
C1655 OR3BX1_0.B a_21525_14180# 0.0406f
C1656 DFFQX1_6.D BUFX3_27.Y 0.03464f
C1657 VDD a_11781_11866# 3.18026f
C1658 a_37973_3728# a_38648_3750# 0.01184f
C1659 a_14469_3802# a_15309_2742# 0.06895f
C1660 a_32529_3802# a_35217_3802# 0.15401f
C1661 VDD NOR3X1_0.Y 0.62557f
C1662 a_12689_2706# VDD 0.54997f
C1663 BUFX3_1.Y a_1097_9426# 0.02395f
C1664 BUFX3_0.Y a_1097_13458# 0.08066f
C1665 a_27405_6490# a_30093_6490# 0.15401f
C1666 a_4725_8316# VDD 0.24966f
C1667 VDD a_27896_13472# 0.12134f
C1668 DFFQX1_2.D a_17829_14920# 0.12081f
C1669 DFFQX1_0.Q a_6997_16182# 0.23106f
C1670 a_10589_10770# a_11933_10770# 0.01425f
C1671 BUFX3_2.A a_20769_13494# 0.0108f
C1672 a_31505_5072# VDD 0.21456f
C1673 VDD a_5213_9426# 0.51428f
C1674 BUFX3_2.A a_17337_15938# 0.05021f
C1675 a_12957_13494# a_15645_13494# 0.15401f
C1676 a_15645_6774# a_15713_6738# 1.99572f
C1677 a_35217_7834# a_36393_6774# 0.25048f
C1678 AND2X1_3.Y BUFX3_0.Y 0.08417f
C1679 DFFQX1_6.D OR3X1_1.B 0.01932f
C1680 a_37737_12150# a_37805_12114# 0.43806f
C1681 a_28161_5628# a_27473_5072# 0.01014f
C1682 a_38480_6752# VDD 0.10776f
C1683 a_1029_5146# a_3717_5146# 0.15401f
C1684 a_6473_5072# a_7749_5146# 0.06964f
C1685 OR3X1_1.C a_21195_16000# 0.04774f
C1686 VDD a_23693_11792# 0.20824f
C1687 BUFX3_1.Y DFFQX1_3.CK 1.56117f
C1688 a_32529_16182# a_32597_16146# 0.94424f
C1689 a_8085_10522# a_7833_9462# 0.11121f
C1690 a_30161_10448# a_30093_10522# 0.94424f
C1691 a_21529_16182# DFFQX1_6.D 0.09097f
C1692 a_3785_16146# a_3325_15532# 0.04102f
C1693 AND2X1_3.Y a_3441_15952# 0.02387f
C1694 a_19157_2706# VDD 0.2084f
C1695 a_20837_8082# a_22349_7760# 0.22482f
C1696 a_19341_15898# a_20265_15036# 0.02812f
C1697 VDD a_21979_14852# 0.33879f
C1698 DFFQX1_0.D AND2X1_2.B 0.0346f
C1699 a_23189_13458# a_23457_12150# 0.02115f
C1700 a_19593_13210# a_22281_13210# 0.15401f
C1701 a_10589_8082# VDD 0.32678f
C1702 a_24297_16182# a_24365_16146# 1.99572f
C1703 VDD a_31337_13458# 0.59593f
C1704 a_1097_4050# a_1433_3728# 0.49543f
C1705 a_23693_9104# a_24297_8768# 0.04852f
C1706 a_32597_5072# VDD 0.56295f
C1707 VDD a_15645_9462# 3.1238f
C1708 a_32529_14554# a_33957_13494# 0.26941f
C1709 a_18333_13494# a_18401_13458# 0.94424f
C1710 a_22873_16146# OR3X1_1.A 0.21043f
C1711 VDD a_17661_15488# 0.23954f
C1712 a_18401_6738# a_19745_6738# 0.01425f
C1713 counter_value_o[6] a_31521_16182# 0.03042f
C1714 clock_i DFFQX1_0.D 0.02653f
C1715 a_20349_12348# a_19661_11792# 0.01014f
C1716 a_38412_12164# a_38745_12348# 0.01772f
C1717 a_3785_6416# VDD 0.525f
C1718 a_7749_5146# a_8424_5180# 0.01169f
C1719 OR3BX1_0.B BUFX3_1.Y 0.0652f
C1720 BUFX3_38.Y a_23629_15474# 0.21785f
C1721 VDD a_24785_11792# 0.51278f
C1722 a_9093_10522# a_10521_9462# 0.26941f
C1723 a_9181_16146# a_9429_16182# 0.0525f
C1724 a_16905_3802# a_19089_2742# 0.08361f
C1725 VDD a_6661_16182# 0.21028f
C1726 a_31437_6490# a_32109_6080# 0.01448f
C1727 a_19677_8118# VDD 0.6927f
C1728 DFFQX1_3.CK a_14469_14554# 0.02708f
C1729 a_7669_16182# DFFQX1_0.D 0.09422f
C1730 BUFX3_4.A AND2X1_2.B 0.04739f
C1731 VDD a_36461_13458# 0.3193f
C1732 OR3X1_1.B a_12714_15510# 0.03871f
C1733 VDD NAND2X1_0.Y 0.36801f
C1734 a_38648_5094# VDD 0.10108f
C1735 a_27405_9178# a_30093_9178# 0.15401f
C1736 BUFX3_29.A a_21493_14838# 0.01701f
C1737 AOI21BX2_0.A BUFX3_28.A 0.11936f
C1738 a_11849_9104# a_11933_9426# 0.10882f
C1739 VDD a_37401_16182# 1.46768f
C1740 AOI21BX2_0.A OR3X1_1.A 0.20884f
C1741 a_9161_5072# a_11849_5072# 0.01208f
C1742 a_8492_6438# VDD 0.12771f
C1743 VDD a_30093_11866# 1.46587f
C1744 clock_i BUFX3_4.A 0.04705f
C1745 XOR2X1_0.A XOR2X1_0.Y 0.23684f
C1746 NOR3X1_0.C a_22383_15045# 0.01117f
C1747 a_35285_10448# a_37973_10448# 0.01208f
C1748 a_22281_3802# a_20181_2742# 0.10475f
C1749 a_6473_7760# a_7749_7834# 0.06964f
C1750 a_27321_2940# VDD 0.27147f
C1751 a_28161_8316# a_27473_7760# 0.01014f
C1752 a_1029_7834# a_3717_7834# 0.15401f
C1753 OR3X1_1.C a_21865_13494# 0.01506f
C1754 VDD BUFX3_23.A 0.85731f
C1755 a_7749_13210# a_7833_12150# 0.09008f
C1756 a_27473_13136# a_27405_13210# 1.99572f
C1757 a_37905_6490# a_38580_6524# 0.01169f
C1758 a_20769_8118# VDD 3.1423f
C1759 a_11009_15824# a_12356_15846# 0.01184f
C1760 BUFX3_4.A a_7669_16182# 0.22987f
C1761 a_28581_4086# a_31269_4086# 0.15401f
C1762 a_1097_4050# VDD 0.58028f
C1763 DFFQX1_5.CK a_21777_14920# 0.16069f
C1764 VDD a_2444_16160# 0.11204f
C1765 BUFX3_17.A a_17661_15488# 0.05983f
C1766 VDD a_23525_9426# 0.52435f
C1767 a_20769_13494# a_21441_13692# 0.01448f
C1768 a_17497_16146# BUFX3_2.A 0.22652f
C1769 OA21X2_1.Y a_23709_14838# 0.07211f
C1770 OR3X1_1.B a_23003_14188# 0.04617f
C1771 a_11849_9104# a_13025_9426# 0.30073f
C1772 VDD a_1097_15824# 0.26023f
C1773 a_3785_11792# a_6473_11792# 0.01208f
C1774 BUFX3_0.Y a_1097_11792# 0.07651f
C1775 a_14537_5072# a_14469_5146# 0.94424f
C1776 a_9093_6490# VDD 3.05733f
C1777 VDD a_32529_11866# 3.11738f
C1778 counter_value_o[5] a_27157_16182# 0.22249f
C1779 a_37973_10448# a_38580_10556# 0.04779f
C1780 OR3X1_1.B a_18803_15170# 0.01638f
C1781 a_23625_3802# a_23961_2742# 0.02669f
C1782 a_31521_2742# VDD 3.2071f
C1783 a_7749_7834# a_8424_7868# 0.01169f
C1784 OAI21X1_1.Y DFFQX1_6.D 0.36982f
C1785 a_31337_13458# a_31269_12150# 0.0208f
C1786 a_3717_14554# a_3785_13136# 0.01931f
C1787 DFFQX1_1.D a_3325_15532# 0.11198f
C1788 a_27557_8082# VDD 0.20824f
C1789 VDD BUFX3_29.A 0.25409f
C1790 VDD a_3717_13210# 3.0976f
C1791 a_20769_10806# a_23457_10806# 0.15401f
C1792 a_3969_14838# a_4037_14802# 0.43806f
C1793 DFFQX1_3.Q OR3X1_1.B 0.03095f
C1794 a_33957_4086# a_34025_4050# 0.94424f
C1795 a_10521_4086# VDD 1.45582f
C1796 a_31437_9178# a_32109_8768# 0.01448f
C1797 a_16687_14852# a_17459_15170# 0.0313f
C1798 VDD a_33957_9462# 1.45226f
C1799 a_17091_15045# a_16953_15244# 0.21799f
C1800 a_3313_15779# a_3517_15682# 0.08137f
C1801 OAI21X1_0.A a_18333_16380# 0.03619f
C1802 NAND3X1_0.B OR3X1_1.B 0.08224f
C1803 NAND2X1_0.A a_6493_14838# 0.01985f
C1804 a_7817_11792# a_7749_11866# 0.43806f
C1805 VDD XOR2X1_0.A 0.93926f
C1806 OA21X2_1.Y OR3X1_1.A 0.25524f
C1807 a_22349_6416# VDD 0.38109f
C1808 VDD a_38913_11456# 0.11104f
C1809 a_37153_16146# BUFX3_41.A 0.21379f
C1810 clock_i AND2X1_1.B 0.02312f
C1811 a_24717_3802# a_23961_2742# 0.36279f
C1812 a_7749_2742# a_8421_2940# 0.01448f
C1813 a_7221_15952# a_6911_15770# 0.05497f
C1814 a_9161_7760# a_11849_7760# 0.01208f
C1815 a_37989_2742# VDD 0.71532f
C1816 AOI21BX2_0.A BUFX3_1.Y 0.04759f
C1817 a_32597_13136# a_35285_13136# 0.01208f
C1818 a_3717_5430# a_3785_5394# 0.43806f
C1819 a_23625_6490# a_23457_5430# 0.11121f
C1820 a_28649_8082# VDD 0.51327f
C1821 VDD BUFX3_26.Y 0.31278f
C1822 a_14117_15824# a_14792_15846# 0.01184f
C1823 VDD a_11849_13136# 0.59389f
C1824 a_26145_10806# a_26213_10770# 0.94424f
C1825 a_3785_10770# a_1433_10448# 0.02019f
C1826 BUFX3_0.Y a_1097_9426# 0.09052f
C1827 a_4037_14802# a_4641_15036# 0.04852f
C1828 BUFX3_1.Y DFFQX1_2.D 0.21018f
C1829 a_12537_4284# VDD 0.25529f
C1830 a_37905_9178# a_38580_9212# 0.01169f
C1831 a_17459_15170# a_17321_15244# 0.21538f
C1832 VDD a_35973_9660# 0.25052f
C1833 BUFX3_4.A DFFQX1_0.D 0.16247f
C1834 a_28581_6774# a_31269_6774# 0.15401f
C1835 BUFX3_16.A a_18333_16380# 0.04129f
C1836 a_19661_9104# a_20349_9660# 0.01014f
C1837 a_31337_12114# a_31505_11792# 0.11187f
C1838 a_23525_12114# a_24297_11456# 0.01014f
C1839 a_8492_11814# a_8424_11900# 0.15111f
C1840 VDD a_4725_11004# 0.24966f
C1841 a_16485_10112# a_15645_9462# 0.02812f
C1842 a_19593_10522# a_20349_9660# 0.02812f
C1843 OR3X1_1.B a_22029_14280# 0.02134f
C1844 VDD a_13041_16182# 3.0848f
C1845 OR3X1_1.B a_20000_14816# 0.01333f
C1846 a_27405_3802# a_27741_2742# 0.46845f
C1847 DFFQX1_6.D OR3X1_1.A 0.22639f
C1848 a_8841_2742# a_11529_2742# 0.15401f
C1849 a_14537_7760# a_14469_7834# 0.94424f
C1850 BUFX3_41.A a_28581_14838# 0.08231f
C1851 a_37973_13136# a_37905_13210# 0.43806f
C1852 DFFQX1_3.CK BUFX3_0.Y 0.40276f
C1853 a_15813_13210# a_15645_12150# 0.11121f
C1854 NOR3X1_0.C BUFX3_29.Y 0.05094f
C1855 a_24717_6490# a_23457_5430# 0.27719f
C1856 a_4460_5408# a_4725_5628# 0.03941f
C1857 a_37737_8118# VDD 0.72674f
C1858 a_14792_15846# a_15318_15510# 0.02024f
C1859 a_27305_14802# a_27980_14816# 0.01184f
C1860 a_5145_14838# a_5213_14802# 0.94424f
C1861 a_36393_4086# a_36461_4050# 0.94424f
C1862 a_18401_4050# VDD 0.32159f
C1863 a_17829_14920# a_18803_15170# 0.05938f
C1864 a_23121_13494# a_23189_13458# 1.99572f
C1865 a_34616_16160# a_32597_15824# 0.01952f
C1866 BUFX3_41.A a_24785_15824# 0.03182f
C1867 a_3721_14802# a_3969_14838# 0.0499f
C1868 a_10589_6738# a_9161_6416# 0.24595f
C1869 a_33957_6774# a_34025_6738# 0.94424f
C1870 a_31337_12114# a_32597_11792# 0.27946f
C1871 AND2X1_1.B a_6911_15770# 0.02731f
C1872 a_27405_6490# VDD 3.12537f
C1873 a_16905_5146# a_19593_5146# 0.15401f
C1874 NOR3X1_0.Y a_22613_15244# 0.02586f
C1875 a_23693_5072# a_23625_5146# 0.43806f
C1876 VDD a_10589_10770# 0.32678f
C1877 a_3785_9426# a_4392_9476# 0.04779f
C1878 VDD a_16065_16380# 0.1567f
C1879 counter_value_o[2] a_12621_16380# 0.03f
C1880 a_11597_2706# a_12201_2940# 0.04852f
C1881 BUFX3_1.Y OA21X2_1.Y 0.38403f
C1882 BUFX3_41.A a_35369_14802# 0.01136f
C1883 a_16905_13210# a_15645_12150# 0.27719f
C1884 a_38648_13158# a_38580_13244# 0.15111f
C1885 VDD a_33873_16182# 0.70625f
C1886 a_38913_8316# VDD 0.0867f
C1887 a_5145_5430# a_5213_5394# 1.99572f
C1888 a_6153_15938# BUFX3_26.A 0.03987f
C1889 VDD a_19593_13210# 3.13748f
C1890 a_28581_14838# a_31269_14838# 0.15401f
C1891 DFFQX1_5.Q a_31589_16146# 0.02643f
C1892 a_13109_16146# BUFX24_2.A 0.0922f
C1893 DFFQX1_3.CK a_7093_15779# 0.15579f
C1894 a_27489_4086# VDD 0.6927f
C1895 a_38412_4100# a_38480_4064# 0.15111f
C1896 a_3717_8118# a_3785_8082# 0.43806f
C1897 a_23625_9178# a_23457_8118# 0.11121f
C1898 clock_i a_3049_16146# 0.01286f
C1899 VDD a_6473_9104# 0.31873f
C1900 a_4373_15824# DFFQX1_3.CK 0.04232f
C1901 NAND3X1_0.B a_5145_14838# 0.01023f
C1902 BUFX3_41.A a_31437_15898# 0.03026f
C1903 a_7901_13458# a_7817_13136# 0.08769f
C1904 XOR2X1_0.Y a_4037_14802# 0.02743f
C1905 BUFX3_23.A a_24297_16182# 0.09848f
C1906 a_9093_11866# a_11781_11866# 0.15401f
C1907 a_14537_11792# a_15813_11866# 0.06964f
C1908 a_3717_5146# a_3717_4086# 0.1104f
C1909 a_24297_6080# VDD 0.25056f
C1910 VDD a_19677_10806# 0.6927f
C1911 a_21979_14852# a_22613_15244# 0.14171f
C1912 a_4053_10522# a_3785_9104# 0.02105f
C1913 a_27405_10522# a_27489_9462# 0.11121f
C1914 a_23003_14188# a_22865_14228# 0.21538f
C1915 OA21X2_0.B OR3X1_1.A 0.16994f
C1916 a_23209_16146# NOR3X1_0.Y 0.22567f
C1917 a_5061_16182# a_5129_16146# 0.43806f
C1918 a_32529_3802# a_31521_2742# 0.2994f
C1919 BUFX3_1.Y a_1097_9104# 0.01374f
C1920 VDD a_34881_16380# 0.25227f
C1921 a_7901_5394# a_10589_5394# 0.01208f
C1922 a_1029_7834# VDD 3.08533f
C1923 a_24785_15824# a_27473_15824# 0.01208f
C1924 VDD a_31505_13136# 0.21456f
C1925 DFFQX1_6.D BUFX3_1.Y 0.02102f
C1926 a_33957_14838# a_34025_14802# 0.94424f
C1927 a_11933_10770# a_11849_10448# 0.10882f
C1928 a_35301_10806# a_34025_10770# 0.06964f
C1929 a_28649_10770# a_31337_10770# 0.01208f
C1930 VDD a_10941_15898# 1.47962f
C1931 a_8421_14920# a_8889_15244# 0.08137f
C1932 a_20837_4050# a_22349_3728# 0.22482f
C1933 a_28581_4086# VDD 3.06479f
C1934 a_24717_9178# a_23457_8118# 0.27719f
C1935 BUFX3_41.A a_27405_14554# 0.02138f
C1936 a_4460_8096# a_4725_8316# 0.03941f
C1937 a_27828_13508# a_27896_13472# 0.15111f
C1938 BUFX3_41.A a_32529_15898# 0.15909f
C1939 a_36393_6774# a_36461_6738# 0.94424f
C1940 a_27980_14816# a_27473_14480# 0.01952f
C1941 a_31437_15898# a_31269_14838# 0.11121f
C1942 OAI21X1_2.Y a_20857_15510# 0.23128f
C1943 a_24785_5072# a_24717_5146# 1.99572f
C1944 a_30161_5072# a_31505_5072# 0.01425f
C1945 a_6405_5146# a_5145_4086# 0.26082f
C1946 VDD a_20769_10806# 3.1423f
C1947 BUFX3_16.A OAI21X1_0.A 0.15373f
C1948 a_27405_10522# a_28581_9462# 0.27765f
C1949 VDD a_17091_15045# 0.1152f
C1950 a_35217_3802# a_35301_2742# 0.54857f
C1951 a_5804_16160# a_6069_16380# 0.03941f
C1952 a_16905_7834# a_19593_7834# 0.15401f
C1953 a_23693_7760# a_23625_7834# 0.43806f
C1954 VDD a_37153_16146# 0.27144f
C1955 a_3717_12150# a_4392_12164# 0.01169f
C1956 a_1097_12114# a_3785_12114# 0.01208f
C1957 a_22029_14280# a_22635_14192# 0.0867f
C1958 a_9161_7760# VDD 0.51524f
C1959 a_30161_15824# a_30093_15898# 0.94424f
C1960 a_1029_4086# BUFX3_0.Y 0.13855f
C1961 VDD a_32597_13136# 0.56295f
C1962 a_13025_10770# a_11849_10448# 0.30073f
C1963 a_35369_10770# a_35973_11004# 0.04852f
C1964 DFFQX1_5.Q BUFX3_41.A 1.88316f
C1965 a_4037_14802# a_3785_14480# 0.11187f
C1966 VDD a_14049_15898# 0.73482f
C1967 a_1033_3414# a_1433_3728# 0.0112f
C1968 a_18989_14480# a_18921_14554# 0.94424f
C1969 VDD a_4037_14802# 0.2058f
C1970 a_35369_4050# VDD 0.20824f
C1971 a_5145_8118# a_5213_8082# 1.99572f
C1972 a_6803_15792# a_7093_15779# 0.05938f
C1973 a_16469_16146# OR3X1_1.B 0.0123f
C1974 a_5381_15824# a_5313_15898# 0.43806f
C1975 OR3X1_1.B a_16905_15488# 0.05008f
C1976 a_28649_14802# a_30161_14480# 0.22482f
C1977 a_19745_6738# a_19661_6416# 0.10882f
C1978 a_38412_6788# a_38480_6752# 0.15111f
C1979 a_24297_8768# a_23525_9426# 0.01014f
C1980 a_31505_9104# a_31337_9426# 0.11187f
C1981 a_16973_11792# a_16905_11866# 1.99572f
C1982 a_22349_11792# a_23693_11792# 0.01425f
C1983 a_32529_15898# a_31269_14838# 0.27719f
C1984 a_3721_14802# XOR2X1_0.Y 0.20898f
C1985 a_4460_5408# VDD 0.12134f
C1986 AND2X1_2.B OR3X1_1.B 0.01147f
C1987 VDD a_27557_10770# 0.20824f
C1988 a_16469_2706# a_19157_2706# 0.01208f
C1989 a_38580_3836# a_38664_2756# 0.01556f
C1990 DFFQX1_4.Q BUFX3_2.A 0.20424f
C1991 a_3717_7834# a_3717_6774# 0.1104f
C1992 a_27405_15898# a_27473_14480# 0.02113f
C1993 a_24717_13210# a_26145_12150# 0.26941f
C1994 a_3717_13210# a_3785_11792# 0.01931f
C1995 DFFQX1_5.D a_23003_14188# 0.01954f
C1996 DFFQX1_4.Q a_17661_15898# 0.01197f
C1997 a_22029_14280# a_22865_14228# 0.01951f
C1998 a_18333_5430# a_19677_5430# 0.01349f
C1999 a_15813_7834# VDD 0.6927f
C2000 a_35217_6490# a_35973_5628# 0.02812f
C2001 BUFX3_1.Y OA21X2_0.B 0.08057f
C2002 a_36393_14838# a_36461_14802# 0.94424f
C2003 VDD a_38648_13158# 0.10108f
C2004 a_7241_14816# a_6473_14480# 0.01127f
C2005 a_37737_10806# a_36461_10770# 0.06964f
C2006 VDD DFFQX1_5.CK 1.76369f
C2007 VDD a_28581_14838# 3.06534f
C2008 a_38412_4100# VDD 0.28535f
C2009 VDD a_8001_14852# 0.19624f
C2010 a_4121_3728# a_4053_3802# 1.99572f
C2011 a_28161_4284# a_27473_3728# 0.01014f
C2012 a_7901_8082# a_10589_8082# 0.01208f
C2013 NAND2X1_0.Y BUFX3_26.A 0.19151f
C2014 clock_i OR3X1_1.B 0.05466f
C2015 a_15713_13458# a_15881_13136# 0.11187f
C2016 a_28649_13458# a_31337_13458# 0.01208f
C2017 BUFX3_29.A a_21865_13494# 0.20539f
C2018 a_35301_13494# a_34025_13458# 0.06964f
C2019 a_20837_6738# a_19661_6416# 0.30073f
C2020 BUFX3_12.A a_2373_15488# 0.0118f
C2021 a_32597_9104# a_31337_9426# 0.27946f
C2022 VDD a_5061_16182# 0.7198f
C2023 VDD a_23777_14480# 0.22684f
C2024 OR3BX1_0.B a_19341_15898# 0.01561f
C2025 a_15813_11866# a_16485_11456# 0.01448f
C2026 a_7901_5394# VDD 0.5247f
C2027 VDD a_24785_15824# 0.51395f
C2028 VDD a_28649_10770# 0.51327f
C2029 a_12957_9462# a_15645_9462# 0.15401f
C2030 a_32109_10112# a_31269_9462# 0.02812f
C2031 a_24785_14480# a_24717_14554# 1.99572f
C2032 a_3325_15532# a_3517_15682# 0.06817f
C2033 XOR2X1_0.A a_3313_15779# 0.04703f
C2034 DFFQX1_5.Q a_27473_15824# 0.14423f
C2035 NAND4X2_0.C a_8422_15932# 0.01155f
C2036 a_6405_7834# a_5145_6774# 0.26082f
C2037 a_30161_7760# a_31505_7760# 0.01425f
C2038 a_24785_7760# a_24717_7834# 1.99572f
C2039 a_24297_12800# a_23457_12150# 0.02812f
C2040 a_10521_12150# a_11865_12150# 0.01349f
C2041 a_19677_5430# a_20349_5628# 0.01448f
C2042 BUFX3_38.Y NOR3X1_0.Y 0.06408f
C2043 OR3X1_1.A a_22029_14280# 0.04617f
C2044 a_31505_15824# a_32109_15488# 0.04852f
C2045 a_16905_7834# VDD 3.05265f
C2046 AOI21BX2_0.A a_23121_14906# 0.07468f
C2047 a_38412_14852# a_38480_14816# 0.15111f
C2048 VDD a_1097_12114# 0.57546f
C2049 a_20349_11004# a_19661_10448# 0.01014f
C2050 VDD a_35369_14802# 0.20824f
C2051 a_20265_14554# a_20937_14144# 0.01448f
C2052 VDD a_8889_15244# 0.19458f
C2053 a_6741_3802# a_8085_3802# 0.01349f
C2054 a_1033_3414# VDD 0.21275f
C2055 a_23965_15474# a_24213_15488# 0.02089f
C2056 a_18401_13458# a_16973_13136# 0.24595f
C2057 a_35369_13458# a_35973_13692# 0.04852f
C2058 VDD a_3721_14802# 0.27427f
C2059 a_1097_6416# a_3785_6416# 0.01208f
C2060 BUFX3_12.A a_4981_15510# 0.19931f
C2061 VDD DFFQX1_0.Q 0.45988f
C2062 VDD a_23709_14554# 0.69334f
C2063 BUFX3_27.Y a_20837_13458# 0.08392f
C2064 a_14469_5146# a_12957_4086# 0.25266f
C2065 a_19580_16160# a_19845_16380# 0.02298f
C2066 a_18333_5430# VDD 1.45223f
C2067 a_35285_5072# a_35217_5146# 1.99572f
C2068 VDD a_31437_15898# 0.69768f
C2069 a_16687_14852# BUFX3_3.Y 0.01149f
C2070 BUFX3_1.Y a_1029_12150# 0.08901f
C2071 VDD a_37737_10806# 0.72674f
C2072 VDD a_20265_14554# 0.74406f
C2073 a_37905_10522# a_37737_9462# 0.06895f
C2074 a_18333_9462# a_18401_9426# 0.94424f
C2075 a_27405_14554# a_30093_14554# 0.15401f
C2076 BUFX3_2.A a_17459_15170# 0.039f
C2077 BUFX3_1.Y a_8623_14852# 0.01643f
C2078 DFFQX1_3.Q BUFX3_1.Y 0.03638f
C2079 VDD a_22665_15572# 0.20137f
C2080 a_11865_12150# a_12537_12348# 0.01448f
C2081 NAND3X1_0.B BUFX3_1.Y 0.57147f
C2082 a_19593_6490# a_19661_5072# 0.01868f
C2083 a_32529_15898# a_35217_15898# 0.15401f
C2084 a_37973_15824# a_38580_15932# 0.04779f
C2085 DFFQX1_5.Q a_23171_15532# 0.02911f
C2086 BUFX3_1.Y a_2625_14852# 0.12751f
C2087 a_30161_7760# VDD 0.32552f
C2088 BUFX3_17.A DFFQX1_5.CK 0.01193f
C2089 VDD a_10521_12150# 1.45582f
C2090 VDD a_38412_14852# 0.28533f
C2091 counter_value_o[2] DFFQX1_3.Q 0.05991f
C2092 a_22029_14280# DFFQX1_5.D 0.11969f
C2093 a_6741_3802# VDD 1.47771f
C2094 a_20265_15036# a_20433_15036# 0.09255f
C2095 a_18333_8118# a_19677_8118# 0.01349f
C2096 a_35217_9178# a_35973_8316# 0.02812f
C2097 a_37737_13494# a_36461_13458# 0.06964f
C2098 VDD a_30429_16182# 0.70262f
C2099 a_6473_6416# a_6405_6490# 0.94424f
C2100 OR3X1_1.B a_20837_13458# 0.01166f
C2101 VDD a_27405_14554# 3.14222f
C2102 a_23693_11792# a_24297_11456# 0.04852f
C2103 a_9674_15474# a_9765_14838# 0.08354f
C2104 a_27809_16146# DFFQX1_5.Q 0.07614f
C2105 BUFX3_1.Y a_16485_14920# 0.01395f
C2106 XOR2X1_0.A BUFX3_26.A 0.01168f
C2107 VDD a_32529_15898# 3.10777f
C2108 a_20349_5628# VDD 0.25052f
C2109 a_20249_16146# a_20856_16196# 0.04779f
C2110 OR3X1_1.B BUFX3_3.A 0.09584f
C2111 VDD a_38913_11004# 0.0867f
C2112 VDD a_3385_16182# 0.21832f
C2113 VDD a_20265_15036# 0.19744f
C2114 BUFX3_2.A a_18031_14852# 0.01411f
C2115 a_23961_2742# a_24029_2706# 1.99572f
C2116 AND2X1_0.Y a_16153_14838# 0.21296f
C2117 VDD a_20249_16146# 0.25836f
C2118 a_35217_13210# a_35301_12150# 0.11121f
C2119 a_16687_14852# a_15645_13494# 0.01174f
C2120 a_23457_5430# a_23525_5394# 1.99572f
C2121 a_1097_5394# a_1097_5072# 0.58526f
C2122 a_1097_14480# a_3785_14480# 0.01208f
C2123 VDD a_12537_12348# 0.25529f
C2124 VDD a_1097_14480# 0.59192f
C2125 BUFX3_0.Y a_1097_9104# 0.09052f
C2126 BUFX3_26.Y BUFX3_26.A 0.0643f
C2127 a_9093_3802# VDD 3.0854f
C2128 a_9093_3802# a_11781_3802# 0.15401f
C2129 a_14537_3728# a_15813_3802# 0.06964f
C2130 a_19677_8118# a_20349_8316# 0.01448f
C2131 VDD DFFQX1_5.Q 0.56875f
C2132 a_28649_6738# a_30161_6416# 0.22482f
C2133 OR3X1_1.B a_23121_13494# 0.08961f
C2134 OR3X1_1.B a_20857_15510# 0.06836f
C2135 clock_i a_4392_16196# 0.01273f
C2136 a_27405_11866# a_30093_11866# 0.15401f
C2137 VDD a_38913_15488# 0.11104f
C2138 a_26213_5394# VDD 0.32194f
C2139 VDD a_8153_10448# 0.21775f
C2140 a_32597_14480# a_32529_14554# 1.99572f
C2141 BUFX3_2.A a_18989_14480# 0.04945f
C2142 BUFX3_1.Y a_9833_14802# 0.03506f
C2143 a_35285_7760# a_35217_7834# 1.99572f
C2144 a_14469_7834# a_12957_6774# 0.25266f
C2145 a_18837_16182# a_18905_16146# 0.43806f
C2146 a_24049_16146# BUFX3_23.A 0.20295f
C2147 VDD a_18085_14166# 0.21696f
C2148 a_15645_12150# a_15713_12114# 1.99572f
C2149 a_35217_13210# a_36393_12150# 0.25048f
C2150 a_37905_7834# VDD 0.72638f
C2151 a_26213_5394# a_27557_5394# 0.01425f
C2152 NAND3X1_0.Y BUFX3_1.Y 0.08168f
C2153 a_6473_14480# a_6405_14554# 0.94424f
C2154 VDD a_18401_12114# 0.32194f
C2155 VDD a_7749_14554# 0.71162f
C2156 VDD a_15716_14816# 0.10527f
C2157 a_19593_9178# a_19661_7760# 0.01868f
C2158 a_22349_3728# VDD 0.38109f
C2159 a_23189_13458# a_22349_13136# 0.07012f
C2160 a_7749_9178# VDD 0.71162f
C2161 OR3X1_1.B a_23189_13458# 0.03477f
C2162 VDD a_38648_14502# 0.10108f
C2163 clock_i a_5804_16160# 0.01609f
C2164 VDD BUFX24_2.A 1.9159f
C2165 a_14792_15846# a_15057_15488# 0.03941f
C2166 OAI21X1_0.A OR3X1_1.B 0.2027f
C2167 a_35301_5430# VDD 0.6927f
C2168 a_2376_16196# a_2444_16160# 0.15111f
C2169 a_18085_14166# BUFX3_2.Y 0.23503f
C2170 VDD a_11849_10448# 0.59389f
C2171 a_20837_9426# a_23525_9426# 0.01208f
C2172 a_27489_9462# a_26213_9426# 0.06964f
C2173 DFFQX1_3.D a_8889_15244# 0.0891f
C2174 a_30429_2742# a_30497_2706# 0.43806f
C2175 BUFX3_1.Y a_13025_14802# 0.03158f
C2176 NAND4X2_0.C a_8841_16380# 0.05383f
C2177 XOR2X1_0.A a_7105_15532# 0.01191f
C2178 a_18401_12114# a_19745_12114# 0.01425f
C2179 a_9181_15474# a_9429_15488# 0.02089f
C2180 NOR3X1_0.A a_24301_14802# 0.21783f
C2181 a_3717_6774# VDD 0.69675f
C2182 BUFX3_0.Y a_3309_15244# 0.02351f
C2183 VDD a_27489_12150# 0.6927f
C2184 a_31337_10770# a_31505_10448# 0.11187f
C2185 OAI21X1_0.A a_19093_15474# 0.06734f
C2186 a_23525_10770# a_24297_10112# 0.01014f
C2187 VDD a_18837_16182# 0.70669f
C2188 VDD a_15881_14480# 0.21507f
C2189 a_22349_3728# a_23693_3728# 0.01425f
C2190 a_16973_3728# a_16905_3802# 1.99572f
C2191 a_23457_8118# a_23525_8082# 1.99572f
C2192 a_1097_8082# a_1097_7760# 0.58526f
C2193 counter_value_o[7] a_36648_16196# 0.01528f
C2194 BUFX3_1.Y AND2X1_3.B 0.60158f
C2195 a_35973_6972# a_35285_6416# 0.01014f
C2196 a_15881_9104# VDD 0.20824f
C2197 VDD a_1097_13458# 0.57546f
C2198 a_31437_11866# a_32109_11456# 0.01448f
C2199 a_4392_4100# a_4725_4284# 0.01772f
C2200 a_36393_5430# VDD 1.48411f
C2201 a_5213_9426# a_3785_9104# 0.24646f
C2202 a_27557_9426# a_28161_9660# 0.04852f
C2203 BUFX3_2.A a_21105_14144# 0.05118f
C2204 a_38648_14502# a_38580_14588# 0.15111f
C2205 BUFX3_2.A NAND2X1_1.Y 0.4231f
C2206 BUFX3_27.Y OAI21X1_2.Y 0.12814f
C2207 a_4981_15510# NAND2X1_0.A 0.22202f
C2208 a_15813_14554# a_16485_14144# 0.01448f
C2209 a_22399_15524# a_23171_15532# 0.0313f
C2210 VDD AND2X1_3.Y 0.44519f
C2211 BUFX3_2.A a_17497_14130# 0.0331f
C2212 a_7901_5394# a_9161_5072# 0.27946f
C2213 a_7833_6774# VDD 3.12641f
C2214 BUFX3_0.Y a_5213_14802# 0.06826f
C2215 VDD a_28581_12150# 3.06479f
C2216 BUFX3_1.Y a_1029_13494# 0.09141f
C2217 a_11849_10448# a_14537_10448# 0.01208f
C2218 a_31337_10770# a_32597_10448# 0.27946f
C2219 a_26213_8082# a_27557_8082# 0.01425f
C2220 a_27405_3802# VDD 3.09403f
C2221 a_15813_3802# a_16485_3392# 0.01448f
C2222 a_21391_15175# BUFX3_29.A 0.13897f
C2223 a_1029_13210# a_3717_13210# 0.15401f
C2224 a_28161_13692# a_27473_13136# 0.01014f
C2225 a_6473_13136# a_7749_13210# 0.06964f
C2226 DFFQX1_3.CK a_9429_15488# 0.03811f
C2227 a_19661_9104# VDD 0.53123f
C2228 VDD a_17833_15510# 0.22548f
C2229 BUFX3_3.A OR3BX1_0.Y 0.01583f
C2230 VDD a_10521_13494# 1.45582f
C2231 a_37905_11866# a_38580_11900# 0.01169f
C2232 AND2X1_2.B a_7817_14480# 0.01376f
C2233 a_7833_4086# a_10521_4086# 0.15401f
C2234 a_38745_5628# VDD 0.2023f
C2235 VDD a_19593_10522# 3.13748f
C2236 a_31269_9462# a_33957_9462# 0.15401f
C2237 OR3X1_1.B OAI21X1_2.Y 0.15815f
C2238 OAI21X1_2.Y a_21189_14906# 0.1565f
C2239 a_34209_2742# a_34881_2940# 0.01448f
C2240 BUFX3_0.Y a_1029_12150# 0.08752f
C2241 AND2X1_2.Y a_8001_14852# 0.08497f
C2242 BUFX3_0.Y a_8623_14852# 0.04428f
C2243 a_8424_14588# a_8757_14144# 0.01772f
C2244 AOI21BX1_0.Y a_18905_16146# 0.02603f
C2245 AND2X1_0.Y a_15813_14554# 0.0136f
C2246 VDD a_35369_12114# 0.20824f
C2247 a_15881_10448# a_15813_10522# 0.43806f
C2248 a_1365_3802# a_3717_2742# 0.04136f
C2249 a_3325_15532# XOR2X1_0.A 0.02286f
C2250 a_24297_3392# VDD 0.25056f
C2251 NAND3X1_0.B BUFX3_0.Y 0.01958f
C2252 OR3X1_1.Y a_22497_14228# 0.04052f
C2253 BUFX3_0.Y a_2625_14852# 0.04025f
C2254 VDD a_22399_15524# 0.35863f
C2255 AND2X1_2.B BUFX3_1.Y 0.11983f
C2256 a_7749_13210# a_8424_13244# 0.01169f
C2257 a_23625_9178# VDD 0.69298f
C2258 a_19661_6416# a_22349_6416# 0.01208f
C2259 a_8424_14588# a_7833_13494# 0.03593f
C2260 OR3X1_1.C a_22231_14180# 0.06169f
C2261 VDD a_12537_13692# 0.25529f
C2262 a_31437_5146# a_31269_4086# 0.11121f
C2263 a_7817_5072# VDD 0.25487f
C2264 a_11865_4086# a_11933_4050# 0.43806f
C2265 a_3313_15779# a_3721_14802# 0.01099f
C2266 VDD a_31505_10448# 0.21456f
C2267 a_35301_9462# a_35369_9426# 0.43806f
C2268 a_1097_13458# a_3785_13458# 0.01208f
C2269 a_3717_13494# a_4392_13508# 0.01169f
C2270 a_4392_6788# a_4725_6972# 0.01772f
C2271 a_35301_2742# a_37989_2742# 0.15401f
C2272 a_36393_5430# a_37737_5430# 0.01349f
C2273 a_15713_6738# VDD 0.52435f
C2274 a_1365_3802# BUFX3_0.Y 0.21805f
C2275 VDD a_38412_12164# 0.28533f
C2276 a_7901_8082# a_9161_7760# 0.27946f
C2277 a_4053_3802# a_5061_2742# 0.2994f
C2278 a_23693_3728# a_24297_3392# 0.04852f
C2279 counter_value_o[2] clock_i 0.03422f
C2280 VDD NOR3X1_0.C 0.8637f
C2281 a_6325_16182# BUFX3_26.Y 0.02466f
C2282 a_9161_13136# a_11849_13136# 0.01208f
C2283 VDD AOI21BX1_0.Y 0.16279f
C2284 OAI21X1_0.A OR3BX1_0.Y 0.01903f
C2285 a_15713_13458# a_15645_12150# 0.0208f
C2286 BUFX3_17.A a_17833_15510# 0.22734f
C2287 a_9093_14554# a_10521_13494# 0.26941f
C2288 a_24717_9178# VDD 3.05265f
C2289 a_22349_6416# a_23625_6490# 0.06964f
C2290 DFFQX1_3.CK a_8421_14920# 0.17869f
C2291 DFFQX1_7.Q BUFX3_27.A 0.04781f
C2292 NAND3X1_0.B a_7093_15779# 0.01913f
C2293 VDD a_18401_13458# 0.32194f
C2294 a_23625_11866# a_23457_10806# 0.11121f
C2295 a_3717_10806# a_3785_10770# 0.43806f
C2296 AND2X1_1.Y NAND2X1_0.A 0.0223f
C2297 a_32529_5146# a_33957_4086# 0.26941f
C2298 BUFX3_28.A a_23121_13494# 0.01533f
C2299 VDD a_15225_15488# 0.09844f
C2300 VDD a_32597_10448# 0.56295f
C2301 a_5129_16146# DFFQX1_3.CK 0.01469f
C2302 a_5804_16160# a_5381_15824# 0.01675f
C2303 a_7833_6774# a_10521_6774# 0.15401f
C2304 a_38057_2706# a_38732_2720# 0.01184f
C2305 a_28581_12150# a_31269_12150# 0.15401f
C2306 a_26145_6774# VDD 1.45223f
C2307 a_37805_5394# a_38480_5408# 0.01184f
C2308 VDD a_1097_11792# 0.57546f
C2309 a_4460_2720# VDD 0.12771f
C2310 a_27405_3802# a_30093_3802# 0.15401f
C2311 a_8085_3802# a_8421_2940# 0.02737f
C2312 NAND3X1_0.Y BUFX3_0.Y 0.16075f
C2313 a_14537_13136# a_14469_13210# 0.94424f
C2314 a_37973_9104# VDD 0.25876f
C2315 VDD a_21613_13458# 0.21352f
C2316 a_5313_15898# a_5145_14838# 0.11121f
C2317 a_24717_11866# a_23457_10806# 0.27719f
C2318 a_4460_10784# a_4725_11004# 0.03941f
C2319 DFFQX1_0.Q BUFX3_26.A 0.02914f
C2320 a_19661_9104# a_22349_9104# 0.01208f
C2321 a_14469_5146# VDD 1.46572f
C2322 a_12957_4086# a_13025_4050# 1.99572f
C2323 VDD a_38648_10470# 0.10108f
C2324 a_12793_16146# a_13041_16182# 0.0525f
C2325 a_37737_9462# a_37805_9426# 0.43806f
C2326 a_10521_13494# a_11865_13494# 0.01349f
C2327 a_11865_6774# a_11933_6738# 0.43806f
C2328 a_31437_7834# a_31269_6774# 0.11121f
C2329 NOR3X1_0.Y a_22803_15536# 0.039f
C2330 OR3BX1_0.B a_18573_14575# 0.17462f
C2331 a_10589_12114# a_9161_11792# 0.24595f
C2332 a_33957_12150# a_34025_12114# 0.94424f
C2333 BUFX3_0.Y a_3717_14554# 0.08722f
C2334 VDD a_9181_15474# 0.21568f
C2335 a_38745_5628# a_38913_5628# 0.09255f
C2336 a_28161_6972# VDD 0.25052f
C2337 VDD a_7749_11866# 0.71162f
C2338 a_19593_10522# a_22281_10522# 0.15401f
C2339 a_8421_2940# VDD 0.25112f
C2340 a_9093_3802# a_8841_2742# 0.49362f
C2341 a_36393_8118# a_37737_8118# 0.01349f
C2342 BUFX3_1.Y BUFX3_3.A 0.0919f
C2343 AOI21BX1_0.Y BUFX3_17.A 0.04872f
C2344 a_3717_9178# BUFX3_0.Y 0.0125f
C2345 a_3717_6490# a_5145_5430# 0.27326f
C2346 a_32109_8768# VDD 0.25358f
C2347 counter_value_o[3] BUFX3_16.A 0.01658f
C2348 VDD a_27153_13494# 0.7284f
C2349 BUFX3_0.Y AND2X1_3.B 0.06766f
C2350 BUFX3_2.A a_15645_13494# 0.03529f
C2351 a_5145_10806# a_5213_10770# 1.99572f
C2352 NAND3X1_0.Y a_7093_15779# 0.04926f
C2353 a_15713_4050# a_18401_4050# 0.01208f
C2354 a_8757_4736# VDD 0.15604f
C2355 a_22349_9104# a_23625_9178# 0.06964f
C2356 BUFX3_1.Y a_22751_15170# 0.03927f
C2357 NOR3X1_0.Y a_22231_14180# 0.01611f
C2358 VDD a_1097_9426# 0.57652f
C2359 BUFX3_27.Y OR3X1_1.B 0.29483f
C2360 a_38412_9476# a_38745_9660# 0.01772f
C2361 a_11865_13494# a_12537_13692# 0.01448f
C2362 a_27405_14554# a_27828_13508# 0.03593f
C2363 BUFX3_27.Y a_21189_14906# 0.01697f
C2364 a_32529_7834# a_33957_6774# 0.26941f
C2365 a_34025_6738# VDD 0.32194f
C2366 BUFX3_2.A OR3X1_1.C 0.07944f
C2367 VDD a_15881_11792# 0.20824f
C2368 a_4053_10522# a_3717_9462# 0.02669f
C2369 a_31437_3802# a_32109_3392# 0.01448f
C2370 a_37805_8082# a_38480_8096# 0.01184f
C2371 a_12621_2742# VDD 3.14428f
C2372 a_11781_3802# a_12621_2742# 0.34166f
C2373 BUFX3_1.Y a_1029_9462# 0.03715f
C2374 BUFX3_0.Y a_1029_13494# 0.09508f
C2375 AOI21BX2_0.A BUFX3_41.A 0.10415f
C2376 a_31505_6416# a_31437_6490# 0.43806f
C2377 a_23625_6490# a_24297_6080# 0.01448f
C2378 a_4392_8132# VDD 0.26358f
C2379 a_24717_6490# a_27405_6490# 0.15401f
C2380 VDD DFFQX1_3.CK 1.8663f
C2381 VDD a_27221_13458# 0.25949f
C2382 OR3X1_1.B a_22349_13136# 0.02976f
C2383 counter_value_o[1] clock_i 0.07964f
C2384 a_7901_10770# a_10589_10770# 0.01208f
C2385 AOI21BX1_0.Y a_18165_15510# 0.02252f
C2386 a_27473_5072# VDD 0.52258f
C2387 a_19593_5146# a_19661_3728# 0.01868f
C2388 VDD a_10521_9462# 1.45582f
C2389 a_21979_14852# a_22231_14180# 0.08702f
C2390 BUFX3_2.A a_17073_15938# 0.11118f
C2391 BUFX3_29.Y a_22029_14280# 0.02646f
C2392 a_12957_6774# a_13025_6738# 1.99572f
C2393 a_36393_12150# a_36461_12114# 0.94424f
C2394 counter_value_o[1] a_7669_16182# 0.01124f
C2395 a_27557_5394# a_27473_5072# 0.10882f
C2396 a_37805_6738# VDD 0.25732f
C2397 OR3X1_1.C a_22197_15624# 0.04262f
C2398 VDD a_19661_11792# 0.53123f
C2399 a_32529_16182# a_33873_16182# 0.01349f
C2400 a_6741_10522# a_5145_9462# 0.23154f
C2401 a_27473_10448# a_27405_10522# 1.99572f
C2402 a_15813_3802# a_15981_2940# 0.02812f
C2403 OAI21X1_0.A BUFX3_1.Y 0.02993f
C2404 a_38745_8316# a_38913_8316# 0.09255f
C2405 a_19089_2742# VDD 0.71328f
C2406 a_37905_3802# a_38580_3836# 0.01169f
C2407 a_16905_13210# a_19593_13210# 0.15401f
C2408 BUFX3_0.Y a_5145_13494# 0.0392f
C2409 a_23693_13136# a_23625_13210# 0.43806f
C2410 a_5213_8082# VDD 0.51428f
C2411 VDD OR3BX1_0.B 0.80936f
C2412 a_11781_6490# a_11865_5430# 0.11121f
C2413 VDD a_35301_13494# 0.6927f
C2414 a_26145_4086# a_27489_4086# 0.01349f
C2415 a_31437_5146# VDD 0.69838f
C2416 a_3717_9178# a_5145_8118# 0.27326f
C2417 OR3X1_1.A a_22484_16182# 0.01603f
C2418 VDD a_12537_9660# 0.25529f
C2419 a_15645_13494# a_15713_13458# 1.99572f
C2420 a_3785_9104# a_6473_9104# 0.01208f
C2421 a_15713_6738# a_18401_6738# 0.01208f
C2422 a_38412_12164# a_38480_12128# 0.15111f
C2423 a_19745_12114# a_19661_11792# 0.10882f
C2424 a_28649_5394# a_27473_5072# 0.30073f
C2425 a_7901_5394# a_7833_4086# 0.02042f
C2426 VDD a_23625_11866# 0.69298f
C2427 a_13109_16146# a_12714_15510# 0.09464f
C2428 a_20249_2706# VDD 0.52885f
C2429 a_3717_13210# a_3717_12150# 0.1104f
C2430 a_11781_6490# a_12957_5430# 0.27765f
C2431 DFFQX1_3.CK a_9093_14554# 0.0361f
C2432 a_15645_8118# VDD 3.1238f
C2433 VDD a_36393_13494# 1.48411f
C2434 a_24365_16146# DFFQX1_7.Q 0.16188f
C2435 a_18333_10806# a_19677_10806# 0.01349f
C2436 VDD a_6803_15792# 0.24588f
C2437 a_35217_11866# a_35973_11004# 0.02812f
C2438 a_31505_9104# a_31437_9178# 0.43806f
C2439 a_27489_4086# a_28161_4284# 0.01448f
C2440 a_23625_9178# a_24297_8768# 0.01448f
C2441 a_35217_5146# VDD 3.14104f
C2442 a_24717_9178# a_27405_9178# 0.15401f
C2443 a_4725_4284# a_4121_3728# 0.01014f
C2444 a_9181_15474# DFFQX1_3.D 0.21593f
C2445 VDD a_18401_9426# 0.32194f
C2446 a_18401_13458# a_19745_13458# 0.01425f
C2447 AND2X1_1.B BUFX3_1.Y 0.13281f
C2448 BUFX3_23.A a_19179_14852# 0.04062f
C2449 a_9161_9104# a_10589_9426# 0.24595f
C2450 a_20837_12114# a_19661_11792# 0.30073f
C2451 a_6405_6490# VDD 1.46323f
C2452 counter_value_o[1] DFFQX1_0.D 0.0116f
C2453 XOR2X1_0.A a_3045_15244# 0.11372f
C2454 VDD a_24717_11866# 3.05265f
C2455 a_34616_16160# a_34881_16380# 0.03941f
C2456 a_32597_10448# a_35285_10448# 0.01208f
C2457 BUFX3_1.Y a_5313_15898# 0.01083f
C2458 a_3717_2742# a_3785_2706# 0.43806f
C2459 a_19593_3802# a_19761_2940# 0.02812f
C2460 a_27557_8082# a_27473_7760# 0.10882f
C2461 a_26717_2706# VDD 0.2084f
C2462 AOI21BX2_0.A a_23171_15532# 0.05767f
C2463 VDD a_23625_16380# 0.13132f
C2464 a_6405_13210# a_5145_12150# 0.26082f
C2465 a_30161_13136# a_31505_13136# 0.01425f
C2466 a_24785_13136# a_24717_13210# 1.99572f
C2467 BUFX3_1.Y OAI21X1_2.Y 0.06988f
C2468 VDD a_22873_16146# 0.2292f
C2469 a_11009_15824# a_10941_15898# 0.94424f
C2470 VDD a_38745_13692# 0.2023f
C2471 a_19677_10806# a_20349_11004# 0.01448f
C2472 a_20857_15510# a_20685_15488# 0.02089f
C2473 a_7901_4050# a_6809_3728# 0.01127f
C2474 a_1029_4086# VDD 3.08334f
C2475 VDD a_1097_16146# 0.324f
C2476 BUFX3_38.Y DFFQX1_5.Q 0.04129f
C2477 a_11781_9178# a_11865_8118# 0.11121f
C2478 counter_value_o[0] clock_i 0.05068f
C2479 VDD a_27489_9462# 0.6927f
C2480 DFFQX1_0.Q a_6325_16182# 0.22496f
C2481 a_17497_16146# a_17749_16182# 0.09753f
C2482 a_26145_6774# a_27489_6774# 0.01349f
C2483 a_17077_16182# a_16469_16146# 0.07358f
C2484 BUFX3_1.Y a_22484_16182# 0.01575f
C2485 a_1097_11792# a_3785_11792# 0.01208f
C2486 a_14537_6416# VDD 0.3248f
C2487 a_11849_5072# a_11781_5146# 1.99572f
C2488 DFFQX1_3.CK DFFQX1_3.D 0.04116f
C2489 VDD a_37973_11792# 0.25876f
C2490 NOR3X1_0.C a_22613_15244# 0.03125f
C2491 a_35369_16146# a_36716_16160# 0.01184f
C2492 BUFX3_12.A DFFQX1_1.D 0.02898f
C2493 OR3X1_1.B a_18435_15045# 0.01995f
C2494 a_37973_10448# a_37905_10522# 0.43806f
C2495 a_15813_10522# a_15645_9462# 0.11121f
C2496 DFFQX1_3.Q a_13109_16146# 0.02379f
C2497 a_4460_2720# a_4725_2940# 0.02298f
C2498 a_7901_8082# a_7833_6774# 0.02042f
C2499 counter_value_o[1] BUFX3_4.A 0.02634f
C2500 a_28649_8082# a_27473_7760# 0.30073f
C2501 OR3X1_1.C AOI21BX2_1.A 0.02838f
C2502 OAI21X1_1.Y a_21529_16182# 0.19769f
C2503 a_21193_16182# a_20924_16160# 0.06425f
C2504 a_38580_6524# a_38913_6080# 0.01772f
C2505 OR3X1_1.B OR3BX1_0.Y 0.41463f
C2506 a_3385_16182# a_3325_15532# 0.01111f
C2507 a_23525_8082# VDD 0.52435f
C2508 VDD a_7817_13136# 0.25487f
C2509 a_7901_4050# a_9161_3728# 0.27946f
C2510 a_31269_4086# a_31337_4050# 1.99572f
C2511 a_5145_4086# VDD 3.05823f
C2512 a_11781_9178# a_12957_8118# 0.27765f
C2513 VDD AOI21BX2_0.A 0.35f
C2514 a_16687_14852# a_17091_15045# 0.15054f
C2515 VDD a_28581_9462# 3.06479f
C2516 DFFQX1_3.CK a_12957_13494# 0.02729f
C2517 a_21613_13458# a_21865_13494# 0.09753f
C2518 a_38580_14588# a_38745_13692# 0.01103f
C2519 OR3X1_1.B a_23709_14838# 0.12709f
C2520 a_27489_6774# a_28161_6972# 0.01448f
C2521 BUFX3_2.A a_17661_15488# 0.06936f
C2522 OR3X1_1.B a_22865_14228# 0.03579f
C2523 VDD a_3023_15792# 0.26255f
C2524 VDD DFFQX1_2.D 0.28712f
C2525 BUFX3_0.Y a_3717_11866# 0.0125f
C2526 OR3BX1_0.Y a_19093_15474# 0.02592f
C2527 a_6473_11792# a_6405_11866# 0.94424f
C2528 a_14469_5146# a_15813_5146# 0.01349f
C2529 a_16973_6416# VDD 0.51278f
C2530 VDD a_32109_11456# 0.25358f
C2531 BUFX3_27.Y OR3X1_1.A 0.69741f
C2532 a_36981_16380# a_37153_16146# 0.01682f
C2533 OR3X1_1.B a_20333_14480# 0.07742f
C2534 a_16905_10522# a_15645_9462# 0.27719f
C2535 a_38648_10470# a_38580_10556# 0.15111f
C2536 VDD a_9497_16146# 0.52091f
C2537 a_7749_2742# a_7817_2706# 0.43806f
C2538 a_7093_15779# a_6911_15770# 0.01951f
C2539 a_34881_2940# VDD 0.25052f
C2540 BUFX3_27.Y a_21525_14180# 0.22932f
C2541 a_22281_6490# a_20769_5430# 0.25266f
C2542 a_1029_5430# a_1097_5394# 1.99572f
C2543 a_33957_8118# VDD 1.45226f
C2544 a_12714_15510# a_12621_15488# 0.01371f
C2545 a_14117_15824# a_14049_15898# 0.43806f
C2546 a_23457_10806# a_23525_10770# 1.99572f
C2547 BUFX3_0.Y a_1029_9462# 0.09952f
C2548 a_11933_4050# VDD 0.2189f
C2549 a_34025_4050# a_35369_4050# 0.01425f
C2550 a_17091_15045# a_17321_15244# 0.05497f
C2551 VDD a_35369_9426# 0.20824f
C2552 OR3X1_1.B BUFX3_28.A 0.031f
C2553 a_7901_6738# a_7817_6416# 0.08769f
C2554 a_27405_7834# a_27473_6416# 0.01868f
C2555 OR3X1_1.A a_22349_13136# 0.0126f
C2556 a_9181_15474# AND2X1_2.Y 0.21102f
C2557 NOR3X1_0.Y DFFQX1_7.Q 0.07365f
C2558 a_19661_9104# a_19745_9426# 0.10882f
C2559 a_28649_12114# a_30161_11792# 0.22482f
C2560 OR3X1_1.A OR3X1_1.B 0.24281f
C2561 DFFQX1_0.D a_7093_15779# 0.12236f
C2562 a_22281_6490# VDD 1.53423f
C2563 VDD a_4392_10820# 0.26358f
C2564 OR3X1_1.B a_21525_14180# 0.05868f
C2565 VDD a_12621_16380# 0.15241f
C2566 a_11849_7760# a_11781_7834# 1.99572f
C2567 OR3X1_1.Y a_22197_13608# 0.11669f
C2568 a_1097_8082# BUFX3_0.Y 0.09052f
C2569 clock_i a_6997_16182# 0.01164f
C2570 a_35285_13136# a_35217_13210# 1.99572f
C2571 a_14469_13210# a_12957_12150# 0.25266f
C2572 BUFX3_2.A BUFX3_23.A 0.02136f
C2573 a_4392_5444# a_4460_5408# 0.15111f
C2574 a_35973_8316# VDD 0.25052f
C2575 VDD a_14469_13210# 1.46572f
C2576 DFFQX1_3.Q a_9429_15488# 0.01467f
C2577 a_26213_10770# a_27557_10770# 0.01425f
C2578 a_13025_4050# VDD 0.53036f
C2579 a_38580_9212# a_38913_8768# 0.01772f
C2580 a_17829_14920# a_18435_15045# 0.0867f
C2581 VDD OA21X2_1.Y 0.41578f
C2582 VDD a_38412_9476# 0.28533f
C2583 BUFX3_1.Y a_1097_10770# 0.14615f
C2584 a_4460_13472# a_3785_13136# 0.01952f
C2585 a_3313_15779# DFFQX1_3.CK 0.15875f
C2586 a_31269_6774# a_31337_6738# 1.99572f
C2587 OAI21X1_2.Y a_20685_15488# 0.05991f
C2588 a_19661_9104# a_20837_9426# 0.30073f
C2589 BUFX3_17.A DFFQX1_2.D 0.04191f
C2590 a_22349_5072# a_22281_5146# 0.94424f
C2591 a_16485_6080# VDD 0.25052f
C2592 VDD a_5213_10770# 0.51275f
C2593 OR3X1_1.B DFFQX1_5.D 0.24559f
C2594 a_1097_9426# a_3785_9426# 0.01208f
C2595 a_3717_9462# a_4392_9476# 0.01169f
C2596 a_3785_16146# a_4460_16160# 0.01184f
C2597 a_14469_7834# a_15813_7834# 0.01349f
C2598 a_11529_2742# a_12201_2940# 0.01448f
C2599 DFFQX1_3.CK AND2X1_2.Y 0.16886f
C2600 BUFX3_41.A a_31337_14802# 0.04631f
C2601 BUFX3_27.Y BUFX3_1.Y 0.06325f
C2602 a_7093_15779# a_7221_15952# 0.0867f
C2603 a_15318_15510# DFFQX1_5.CK 1.12462f
C2604 VDD a_8757_12800# 0.15604f
C2605 BUFX3_41.A a_24549_14838# 0.20403f
C2606 BUFX3_38.Y a_22399_15524# 0.01007f
C2607 a_31521_16182# a_31589_16146# 0.43806f
C2608 BUFX3_2.A BUFX3_29.A 0.03289f
C2609 a_7901_10770# a_8153_10448# 0.11187f
C2610 DFFQX1_5.Q a_32529_16182# 0.09848f
C2611 BUFX3_31.A a_20924_16160# 0.07155f
C2612 a_23457_4086# VDD 3.12574f
C2613 a_1029_8118# a_1097_8082# 1.99572f
C2614 a_37805_4050# a_38412_4100# 0.04779f
C2615 a_22281_9178# a_20769_8118# 0.25266f
C2616 a_18031_14852# a_18297_15244# 0.06817f
C2617 AND2X1_3.Y a_3325_15532# 0.03847f
C2618 VDD a_1097_9104# 0.57652f
C2619 a_27153_13494# a_27828_13508# 0.01169f
C2620 a_5213_13458# a_6473_13136# 0.27274f
C2621 BUFX3_41.A a_27405_15898# 0.15357f
C2622 XOR2X1_0.Y a_3309_15244# 0.06148f
C2623 a_34025_6738# a_35369_6738# 0.01425f
C2624 a_16485_14920# a_16953_15244# 0.08137f
C2625 VDD DFFQX1_6.D 0.21922f
C2626 OR3BX1_0.Y a_18435_15045# 0.03589f
C2627 a_35973_12348# a_35285_11792# 0.01014f
C2628 clock_i a_1029_15898# 0.02063f
C2629 AND2X1_1.B BUFX3_0.Y 0.04606f
C2630 a_1029_5146# a_1029_4086# 0.58425f
C2631 a_35285_6416# VDD 0.52643f
C2632 VDD a_15645_10806# 3.1238f
C2633 a_22635_14192# a_22865_14228# 0.05497f
C2634 a_24717_10522# a_26145_9462# 0.26941f
C2635 a_18165_15510# DFFQX1_2.D 0.20529f
C2636 a_12621_2742# a_15309_2742# 0.15401f
C2637 BUFX3_1.Y OR3X1_1.B 0.71339f
C2638 BUFX3_41.A a_36461_14802# 0.01749f
C2639 BUFX3_1.Y a_21189_14906# 0.18653f
C2640 a_11865_5430# a_10589_5394# 0.06964f
C2641 a_5213_5394# a_7901_5394# 0.01208f
C2642 a_6473_7760# VDD 0.31873f
C2643 a_6417_15938# BUFX3_26.A 0.09449f
C2644 VDD a_27473_13136# 0.52519f
C2645 a_31269_14838# a_31337_14802# 1.99572f
C2646 a_8421_14920# a_8623_14852# 0.25198f
C2647 a_10589_10770# a_9161_10448# 0.24595f
C2648 a_4392_8132# a_4460_8096# 0.15111f
C2649 a_18803_15170# a_18665_15244# 0.21538f
C2650 a_7901_13458# a_8492_13158# 0.03648f
C2651 a_27221_13458# a_27828_13508# 0.04779f
C2652 BUFX3_41.A a_24213_15488# 0.01122f
C2653 a_15713_6738# a_15881_6416# 0.11187f
C2654 a_27305_14802# a_27473_14480# 0.07012f
C2655 a_1029_6490# BUFX3_0.Y 0.09952f
C2656 a_6405_9178# a_6473_9104# 0.94424f
C2657 BUFX3_23.A DFFQX1_7.Q 0.49126f
C2658 NAND2X1_0.A a_6473_14480# 0.01361f
C2659 a_30093_15898# a_28581_14838# 0.25266f
C2660 a_3717_5146# a_4725_4284# 0.02812f
C2661 a_27473_5072# a_30161_5072# 0.01208f
C2662 a_38580_6524# VDD 0.27751f
C2663 a_24297_10112# a_23457_9462# 0.02812f
C2664 a_23461_14130# a_23709_14554# 0.0499f
C2665 a_10521_9462# a_11865_9462# 0.01349f
C2666 AND2X1_1.B a_7093_15779# 0.01163f
C2667 a_15377_2706# a_15981_2940# 0.04852f
C2668 a_32109_3392# a_31521_2742# 0.02812f
C2669 a_32529_3802# a_34881_2940# 0.02812f
C2670 a_22349_7760# a_22281_7834# 0.94424f
C2671 a_32529_6490# a_31269_5430# 0.27719f
C2672 a_11933_5394# a_12537_5628# 0.04852f
C2673 a_8424_7868# VDD 0.26381f
C2674 a_27473_15824# a_27405_15898# 1.99572f
C2675 OAI21X1_1.Y OR3X1_1.A 0.11539f
C2676 VDD a_31437_13210# 0.69838f
C2677 a_34025_14802# a_35369_14802# 0.01425f
C2678 a_9027_15045# a_8889_15244# 0.21799f
C2679 VDD a_12714_15510# 1.02124f
C2680 a_8623_14852# a_9395_15170# 0.0313f
C2681 a_8421_14920# a_9257_15244# 0.01951f
C2682 VDD a_3309_15244# 0.14869f
C2683 DFFQX1_3.Q a_9395_15170# 0.15906f
C2684 a_31337_4050# VDD 0.5963f
C2685 BUFX3_41.A a_35285_14480# 0.02404f
C2686 NAND4X2_0.C a_8265_16258# 0.0582f
C2687 a_37805_6738# a_38412_6788# 0.04779f
C2688 a_18401_6738# a_16973_6416# 0.24595f
C2689 VDD OA21X2_0.B 0.34502f
C2690 a_30161_9104# a_28649_9426# 0.22482f
C2691 BUFX24_2.A a_11009_15824# 0.07512f
C2692 a_9674_15474# a_10941_15898# 0.08339f
C2693 a_19661_11792# a_22349_11792# 0.01208f
C2694 a_30161_5072# a_31437_5146# 0.06964f
C2695 a_3785_5394# VDD 0.25345f
C2696 AND2X1_1.Y a_7333_16182# 0.20727f
C2697 DFFQX1_5.CK a_22231_14180# 0.02122f
C2698 VDD a_23525_10770# 0.52435f
C2699 OAI21X1_0.A a_19341_15898# 0.01525f
C2700 a_11865_9462# a_12537_9660# 0.01448f
C2701 a_6237_16380# DFFQX1_0.Q 0.05676f
C2702 DFFQX1_4.Q a_17749_16182# 0.21154f
C2703 clock_i a_13109_16146# 0.01787f
C2704 a_16401_16182# a_16469_16146# 0.43806f
C2705 a_1029_7834# a_1029_6774# 0.58425f
C2706 a_4392_12164# a_4725_12348# 0.01772f
C2707 AND2X1_1.Y a_7297_15682# 0.03159f
C2708 BUFX3_0.Y a_3785_13136# 0.01793f
C2709 a_15645_5430# a_18333_5430# 0.15401f
C2710 a_11781_7834# VDD 3.18026f
C2711 a_30093_15898# a_31437_15898# 0.01349f
C2712 VDD a_35217_13210# 3.14104f
C2713 a_6493_14838# a_6473_14480# 0.01055f
C2714 a_5213_14802# a_3785_14480# 0.24595f
C2715 a_36393_10806# a_37737_10806# 0.01349f
C2716 a_9395_15170# a_9257_15244# 0.21538f
C2717 VDD a_27980_14816# 0.12771f
C2718 a_18921_14554# a_20265_14554# 0.01349f
C2719 VDD a_5213_14802# 0.24645f
C2720 BUFX3_23.A AOI21BX2_1.A 0.04664f
C2721 a_11865_8118# a_10589_8082# 0.06964f
C2722 VDD a_8001_16258# 0.21762f
C2723 a_27557_4050# a_27473_3728# 0.10882f
C2724 BUFX3_41.A a_35217_14554# 0.01727f
C2725 a_5213_8082# a_7901_8082# 0.01208f
C2726 a_1433_3728# a_1365_3802# 1.99572f
C2727 a_36461_4050# VDD 0.3193f
C2728 a_13025_13458# a_14537_13136# 0.22482f
C2729 a_35217_14554# a_35285_13136# 0.02403f
C2730 BUFX3_1.Y a_17829_14920# 0.02946f
C2731 DFFQX1_3.CK a_7105_15532# 0.0338f
C2732 VDD a_23003_14188# 0.2572f
C2733 a_22803_15536# a_22665_15572# 0.21799f
C2734 BUFX24_2.A a_14117_15824# 0.03085f
C2735 a_22349_11792# a_23625_11866# 0.06964f
C2736 a_32109_15488# a_31269_14838# 0.02812f
C2737 a_11865_5430# VDD 0.70179f
C2738 VDD a_33957_10806# 1.45226f
C2739 VDD a_18803_15170# 0.24883f
C2740 a_35217_10522# a_35301_9462# 0.11121f
C2741 a_3023_15792# a_3313_15779# 0.05938f
C2742 a_31101_16380# a_30161_15824# 0.01014f
C2743 a_3717_7834# a_4725_6972# 0.02812f
C2744 a_27473_7760# a_30161_7760# 0.01208f
C2745 BUFX3_1.Y a_5145_14838# 0.05666f
C2746 DFFQX1_5.CK a_17816_14502# 0.01105f
C2747 NOR3X1_0.Y a_23457_16380# 0.06798f
C2748 a_7833_12150# a_10521_12150# 0.15401f
C2749 a_19677_5430# a_19745_5394# 0.43806f
C2750 a_23693_7760# VDD 0.20824f
C2751 a_37805_14802# a_38412_14852# 0.04779f
C2752 VDD a_1029_12150# 3.08407f
C2753 a_9395_15170# a_9833_14802# 0.01229f
C2754 a_19745_10770# a_19661_10448# 0.10882f
C2755 a_37805_10770# a_38480_10784# 0.01184f
C2756 VDD a_31337_14802# 0.59593f
C2757 a_4053_3802# a_6741_3802# 0.15401f
C2758 a_28649_4050# a_27473_3728# 0.30073f
C2759 VDD a_8623_14852# 0.34886f
C2760 VDD DFFQX1_3.Q 0.74839f
C2761 a_32529_9178# a_31269_8118# 0.27719f
C2762 a_11933_8082# a_12537_8316# 0.04852f
C2763 OR3X1_1.B a_20685_15488# 0.02189f
C2764 a_3045_15244# a_1097_14480# 0.01407f
C2765 AOI21BX2_1.A BUFX3_29.A 0.11367f
C2766 VDD NAND3X1_0.B 0.85831f
C2767 VDD a_24549_14838# 3.06028f
C2768 a_17497_14130# a_17748_14588# 0.03962f
C2769 VDD a_2625_14852# 0.20719f
C2770 OR3X1_1.B a_18333_13494# 0.04839f
C2771 a_35285_9104# a_35973_9660# 0.01014f
C2772 BUFX24_2.A a_15318_15510# 0.50731f
C2773 VDD a_6069_16380# 0.19562f
C2774 a_37905_15898# a_37737_14838# 0.06895f
C2775 BUFX3_0.Y a_1097_10770# 0.07651f
C2776 DFFQX1_6.D a_21195_16000# 0.01543f
C2777 a_27741_16182# a_30429_16182# 0.15401f
C2778 a_32597_5072# a_32529_5146# 1.99572f
C2779 a_11781_5146# a_12537_4284# 0.02812f
C2780 BUFX3_1.Y OR3BX1_0.Y 0.1699f
C2781 a_12957_5430# VDD 3.1114f
C2782 counter_value_o[0] a_3049_16146# 0.2172f
C2783 VDD a_27405_15898# 3.14033f
C2784 VDD a_35973_11004# 0.25052f
C2785 a_6997_16182# AND2X1_1.B 0.0867f
C2786 a_30161_14480# a_31437_14554# 0.06964f
C2787 a_35217_10522# a_36393_9462# 0.25048f
C2788 a_15645_9462# a_15713_9426# 1.99572f
C2789 a_24717_14554# a_27405_14554# 0.15401f
C2790 a_30161_7760# a_31437_7834# 0.06964f
C2791 DFFQX1_5.Q a_30093_15898# 0.0241f
C2792 a_20249_2706# a_22937_2706# 0.01208f
C2793 BUFX3_28.A DFFQX1_5.D 0.01887f
C2794 a_31437_13210# a_31269_12150# 0.11121f
C2795 a_11865_12150# a_11933_12114# 0.43806f
C2796 VDD a_16485_14920# 0.63171f
C2797 a_24785_7760# VDD 0.51278f
C2798 a_37973_15824# a_37905_15898# 0.43806f
C2799 VDD a_5145_12150# 3.05823f
C2800 a_38745_11004# a_38913_11004# 0.09255f
C2801 a_20837_10770# a_19661_10448# 0.30073f
C2802 VDD a_36461_14802# 0.3193f
C2803 VDD a_9257_15244# 0.23527f
C2804 a_15645_8118# a_18333_8118# 0.15401f
C2805 a_1365_3802# VDD 3.14666f
C2806 a_36393_13494# a_37737_13494# 0.01349f
C2807 VDD a_27157_16182# 0.23582f
C2808 a_3785_6416# a_3717_6490# 1.99572f
C2809 a_6803_15792# a_7105_15532# 0.0313f
C2810 VDD a_31505_14480# 0.21456f
C2811 a_3717_11866# a_5145_10806# 0.27326f
C2812 a_20181_16182# a_20249_16146# 0.43806f
C2813 a_27741_16182# DFFQX1_5.Q 0.05643f
C2814 a_30497_16146# a_31101_16380# 0.04852f
C2815 a_35217_5146# a_37905_5146# 0.15401f
C2816 VDD a_24213_15488# 0.20779f
C2817 a_19745_5394# VDD 0.20824f
C2818 VDD a_22029_14280# 0.64205f
C2819 VDD a_20000_14816# 0.1214f
C2820 a_18401_9426# a_19745_9426# 0.01425f
C2821 XOR2X1_0.A a_4305_15898# 0.03202f
C2822 a_3325_15532# DFFQX1_3.CK 0.02276f
C2823 AND2X1_3.B XOR2X1_0.Y 0.12276f
C2824 a_35217_15898# a_35285_14480# 0.02403f
C2825 VDD a_19845_16380# 0.15668f
C2826 a_32529_13210# a_33957_12150# 0.26941f
C2827 a_20769_5430# a_20837_5394# 1.99572f
C2828 a_30093_7834# VDD 1.46587f
C2829 a_37905_15898# a_38580_15932# 0.01169f
C2830 DFFQX1_5.Q a_23033_15572# 0.02046f
C2831 VDD a_11933_12114# 0.2189f
C2832 OA21X2_1.Y a_22613_15244# 0.01594f
C2833 BUFX3_0.Y OR3X1_1.B 0.28966f
C2834 a_21777_14920# a_22751_15170# 0.05938f
C2835 BUFX3_1.Y OR3X1_1.A 0.75528f
C2836 clock_i a_12621_15488# 0.02908f
C2837 VDD a_9833_14802# 0.52283f
C2838 a_8153_3728# a_8757_3392# 0.03035f
C2839 BUFX3_2.A DFFQX1_5.CK 0.35202f
C2840 a_14537_3728# VDD 0.3248f
C2841 a_19677_8118# a_19745_8082# 0.43806f
C2842 OR3BX1_0.B a_21391_15175# 0.02279f
C2843 a_37805_13458# a_38480_13472# 0.01184f
C2844 VDD a_31521_16182# 0.72467f
C2845 a_6405_6490# a_7749_6490# 0.01349f
C2846 VDD NAND3X1_0.Y 0.50028f
C2847 VDD a_35285_14480# 0.52643f
C2848 a_24717_11866# a_27405_11866# 0.15401f
C2849 a_23625_11866# a_24297_11456# 0.01448f
C2850 a_31505_11792# a_31437_11866# 0.43806f
C2851 a_32281_16146# DFFQX1_5.Q 0.2153f
C2852 a_38648_5094# a_38913_4736# 0.02298f
C2853 a_19593_5146# a_19677_4086# 0.11121f
C2854 VDD a_32109_15488# 0.25478f
C2855 a_20837_5394# VDD 0.57859f
C2856 a_1029_2742# enable_i 0.01059f
C2857 VDD a_4121_10448# 0.52638f
C2858 NOR3X1_0.A a_24617_14802# 0.01296f
C2859 a_11781_7834# a_12537_6972# 0.02812f
C2860 a_32597_7760# a_32529_7834# 1.99572f
C2861 a_1097_7760# BUFX3_0.Y 0.09052f
C2862 VDD a_16905_14144# 0.15187f
C2863 a_12957_12150# a_13025_12114# 1.99572f
C2864 a_23525_5394# a_26213_5394# 0.01208f
C2865 a_4725_5628# a_3785_5072# 0.01014f
C2866 OR3X1_1.B a_23121_14906# 0.01406f
C2867 a_32529_7834# VDD 3.11738f
C2868 a_3785_14480# a_3717_14554# 1.99572f
C2869 VDD a_13025_12114# 0.53088f
C2870 VDD a_3717_14554# 3.0976f
C2871 a_6809_10448# a_8153_10448# 0.01425f
C2872 AND2X1_3.Y a_3045_15244# 0.22708f
C2873 VDD a_13025_14802# 0.52749f
C2874 DFFQX1_5.CK a_22197_15624# 0.16504f
C2875 a_22873_16146# BUFX3_38.Y 0.20317f
C2876 a_16973_3728# VDD 0.51278f
C2877 a_37469_16146# a_38745_16380# 0.04852f
C2878 BUFX3_1.Y a_1033_10134# 0.21691f
C2879 a_38745_13692# a_38913_13692# 0.09255f
C2880 a_3717_9178# VDD 3.0976f
C2881 VDD a_35217_14554# 3.14104f
C2882 a_11781_11866# a_11865_10806# 0.11121f
C2883 clock_i a_5129_16146# 0.0301f
C2884 a_1029_4086# a_3717_4086# 0.15401f
C2885 a_1097_16146# a_2376_16196# 0.04849f
C2886 a_19593_5146# a_20769_4086# 0.27765f
C2887 VDD AND2X1_3.B 0.32933f
C2888 a_31269_5430# VDD 3.20096f
C2889 a_17816_14502# a_18085_14166# 0.06425f
C2890 BUFX3_27.A a_20769_12150# 0.01337f
C2891 a_37973_14480# a_38648_14502# 0.01184f
C2892 BUFX3_2.A a_20265_14554# 0.02274f
C2893 DFFQX1_3.D a_8623_14852# 0.10018f
C2894 BUFX3_1.Y a_7817_14480# 0.01256f
C2895 a_35217_7834# a_37905_7834# 0.15401f
C2896 a_27741_2742# a_27809_2706# 1.99572f
C2897 a_15713_12114# a_18401_12114# 0.01208f
C2898 a_38913_7424# VDD 0.11104f
C2899 VDD a_23457_12150# 3.12574f
C2900 a_6405_14554# a_7749_14554# 0.01349f
C2901 a_28649_10770# a_30161_10448# 0.22482f
C2902 VDD a_11849_14480# 0.59299f
C2903 a_15648_14852# a_15716_14816# 0.15111f
C2904 a_19661_3728# a_22349_3728# 0.01208f
C2905 counter_value_o[7] a_35301_16182# 0.01417f
C2906 a_22281_3802# VDD 1.56531f
C2907 a_20769_8118# a_20837_8082# 1.99572f
C2908 BUFX3_1.Y a_2373_15036# 0.01254f
C2909 a_14537_6416# a_15881_6416# 0.01425f
C2910 a_11849_9104# VDD 0.59389f
C2911 a_35369_6738# a_35285_6416# 0.10882f
C2912 AOI21BX2_0.A BUFX3_38.Y 0.46758f
C2913 a_3297_16380# a_3385_16182# 0.01102f
C2914 VDD a_1029_13494# 3.08407f
C2915 a_11781_11866# a_12957_10806# 0.27765f
C2916 a_3785_4050# a_4460_4064# 0.01184f
C2917 a_15318_15510# a_15225_15488# 0.01371f
C2918 BUFX3_23.A a_19409_15824# 0.03434f
C2919 a_6405_9178# a_7749_9178# 0.01349f
C2920 VDD a_14469_10522# 1.46572f
C2921 a_38648_7782# a_38913_7424# 0.02298f
C2922 a_19593_7834# a_19677_6774# 0.11121f
C2923 BUFX3_12.A a_1097_15824# 0.02068f
C2924 a_22399_15524# a_22803_15536# 0.15054f
C2925 a_22197_15624# a_22665_15572# 0.08137f
C2926 a_17748_14588# a_15645_13494# 0.03593f
C2927 a_9674_15474# BUFX24_2.A 0.50723f
C2928 a_4725_6972# VDD 0.24966f
C2929 a_33957_5430# a_35301_5430# 0.01349f
C2930 BUFX3_0.Y a_5145_14838# 0.01784f
C2931 a_9161_10448# a_11849_10448# 0.01208f
C2932 a_22349_3728# a_23625_3802# 0.06964f
C2933 a_1097_15824# a_2629_15510# 0.01631f
C2934 a_16485_3392# VDD 0.25052f
C2935 a_4725_8316# a_3785_7760# 0.01014f
C2936 counter_value_o[7] BUFX3_41.A 0.01288f
C2937 a_23525_8082# a_26213_8082# 0.01208f
C2938 DFFQX1_7.Q a_24785_15824# 0.06265f
C2939 OR3X1_1.B BUFX3_29.Y 0.02737f
C2940 DFFQX1_4.Q a_17497_16146# 0.02667f
C2941 VDD a_16469_16146# 0.19659f
C2942 a_37805_6738# a_37973_6416# 0.06961f
C2943 a_15713_6738# a_15645_5430# 0.0208f
C2944 VDD a_16905_15488# 0.26208f
C2945 VDD a_5145_13494# 3.05874f
C2946 a_5145_4086# a_7833_4086# 0.15401f
C2947 a_38480_5408# VDD 0.10776f
C2948 VDD a_8757_10112# 0.15641f
C2949 VDD AND2X1_2.B 0.34398f
C2950 OR3X1_1.B a_19341_15898# 0.03052f
C2951 a_28581_9462# a_31269_9462# 0.15401f
C2952 clock_i a_3717_16182# 0.03251f
C2953 a_34209_2742# a_34277_2706# 0.43806f
C2954 a_19593_7834# a_20769_6774# 0.27765f
C2955 a_1029_6774# a_3717_6774# 0.15401f
C2956 a_17069_14144# a_16905_14144# 0.04122f
C2957 BUFX3_12.A XOR2X1_0.A 1.53114f
C2958 a_22399_15524# a_23033_15572# 0.14171f
C2959 a_26145_12150# a_27489_12150# 0.01349f
C2960 a_35301_5430# a_35973_5628# 0.01448f
C2961 a_12537_5628# a_11849_5072# 0.01014f
C2962 a_10589_6738# VDD 0.32678f
C2963 BUFX3_2.A a_18085_14166# 0.21178f
C2964 DFFQX1_3.CK a_16687_14852# 0.0244f
C2965 a_24297_16182# a_27157_16182# 0.01627f
C2966 a_14537_14480# a_15881_14480# 0.01425f
C2967 VDD a_31337_12114# 0.59593f
C2968 a_35973_11004# a_35285_10448# 0.01014f
C2969 a_14537_10448# a_14469_10522# 0.94424f
C2970 a_3023_15792# a_3325_15532# 0.0313f
C2971 a_2629_15510# XOR2X1_0.A 0.21932f
C2972 a_35285_3728# VDD 0.52643f
C2973 VDD clock_i 0.73585f
C2974 a_19093_15474# a_19341_15898# 0.05247f
C2975 a_28649_13458# a_27473_13136# 0.30073f
C2976 a_19593_9178# VDD 3.13748f
C2977 a_7749_14554# a_7833_13494# 0.09008f
C2978 a_16973_6416# a_19661_6416# 0.01208f
C2979 OA21X2_0.B a_23209_16146# 0.21648f
C2980 counter_value_o[6] a_31589_16146# 0.15473f
C2981 BUFX3_27.A NOR3X1_0.A 0.83505f
C2982 VDD a_11933_13458# 0.2189f
C2983 a_38580_11900# a_38913_11456# 0.01772f
C2984 a_10521_4086# a_10589_4050# 0.94424f
C2985 a_30093_5146# a_28581_4086# 0.25266f
C2986 a_3785_5072# VDD 0.525f
C2987 a_14537_9104# a_15881_9104# 0.01425f
C2988 VDD a_27473_10448# 0.52258f
C2989 clock_i a_1029_14838# 0.01154f
C2990 a_33957_9462# a_34025_9426# 0.94424f
C2991 VDD a_7669_16182# 0.2126f
C2992 a_3785_6738# a_4460_6752# 0.01184f
C2993 a_27489_12150# a_28161_12348# 0.01448f
C2994 DFFQX1_3.Q AND2X1_2.Y 0.08986f
C2995 a_19677_6774# VDD 0.6927f
C2996 AND2X1_2.Y a_8623_14852# 0.01154f
C2997 VDD a_36461_12114# 0.3193f
C2998 AND2X1_0.Y BUFX3_3.Y 0.13805f
C2999 a_23525_4050# a_23961_2742# 0.01636f
C3000 a_16485_14144# a_15645_13494# 0.02812f
C3001 a_33957_8118# a_35301_8118# 0.01349f
C3002 a_38580_3836# VDD 0.27762f
C3003 BUFX3_26.A a_5213_14802# 0.09136f
C3004 VDD a_18333_16380# 0.22274f
C3005 a_31505_9104# VDD 0.21456f
C3006 a_15881_6416# a_16485_6080# 0.04852f
C3007 VDD a_13025_13458# 0.53088f
C3008 a_22281_11866# a_20769_10806# 0.25266f
C3009 a_1029_10806# a_1097_10770# 1.99572f
C3010 a_8492_5094# VDD 0.12771f
C3011 a_3297_16380# AND2X1_3.Y 0.05452f
C3012 VDD a_31437_10522# 0.69838f
C3013 a_5129_16146# a_5381_15824# 0.04848f
C3014 a_4392_13508# a_4725_13692# 0.01772f
C3015 BUFX3_23.A OAI21X1_0.Y 0.07504f
C3016 a_5145_6774# a_7833_6774# 0.15401f
C3017 VDD a_26985_16380# 0.23807f
C3018 NAND2X1_0.A NAND2X1_0.Y 0.5259f
C3019 a_27405_13210# a_27473_11792# 0.01868f
C3020 a_7901_12114# a_7817_11792# 0.08769f
C3021 a_15713_5394# a_16973_5072# 0.27946f
C3022 AND2X1_2.Y a_9257_15244# 0.02f
C3023 DFFQX1_7.Q DFFQX1_5.Q 0.86715f
C3024 a_20769_6774# VDD 3.1423f
C3025 VDD a_6911_15770# 0.23765f
C3026 OR3X1_1.Y a_23323_15175# 0.04985f
C3027 a_31505_3728# a_31437_3802# 0.43806f
C3028 a_24717_3802# a_27405_3802# 0.15401f
C3029 a_23625_3802# a_24297_3392# 0.01448f
C3030 a_23121_14906# BUFX3_28.A 0.01309f
C3031 a_12537_8316# a_11849_7760# 0.01014f
C3032 a_35301_8118# a_35973_8316# 0.01448f
C3033 a_3785_2706# VDD 0.25345f
C3034 a_11849_13136# a_11781_13210# 1.99572f
C3035 a_32597_9104# VDD 0.56295f
C3036 a_22281_6490# a_23625_6490# 0.01349f
C3037 AND2X1_0.Y a_15645_13494# 0.02163f
C3038 NAND3X1_0.B BUFX3_26.A 0.16265f
C3039 VDD a_20837_13458# 0.18935f
C3040 a_4392_10820# a_4460_10784# 0.15111f
C3041 OR3X1_0.Y BUFX3_29.A 0.11813f
C3042 a_9093_5146# VDD 3.05733f
C3043 a_16973_9104# a_19661_9104# 0.01208f
C3044 VDD BUFX3_3.A 0.32641f
C3045 VDD a_35217_10522# 3.14104f
C3046 a_36393_9462# a_36461_9426# 0.94424f
C3047 a_12621_16380# a_12793_16146# 0.01682f
C3048 a_7833_13494# a_10521_13494# 0.15401f
C3049 a_24717_14554# a_27153_13494# 0.02023f
C3050 a_10521_6774# a_10589_6738# 0.94424f
C3051 a_30093_7834# a_28581_6774# 0.25266f
C3052 VDD DFFQX1_0.D 0.21685f
C3053 a_31269_12150# a_31337_12114# 1.99572f
C3054 a_27557_6738# VDD 0.20824f
C3055 BUFX24_2.A a_15057_15488# 0.01442f
C3056 BUFX3_0.Y a_7817_14480# 0.02627f
C3057 VDD a_22751_15170# 0.2578f
C3058 VDD a_3717_11866# 3.0976f
C3059 a_23693_10448# a_23625_10522# 0.43806f
C3060 BUFX3_27.A a_22197_13608# 0.01173f
C3061 a_16905_10522# a_19593_10522# 0.15401f
C3062 a_7817_2706# VDD 0.2084f
C3063 DFFQX1_3.CK BUFX3_25.Y 0.03732f
C3064 a_18589_16146# a_18837_16182# 0.0499f
C3065 OAI21X1_0.A a_18905_16146# 0.06429f
C3066 a_18333_16380# BUFX3_17.A 0.04889f
C3067 a_14469_13210# a_15813_13210# 0.01349f
C3068 a_15813_14554# a_15645_13494# 0.11121f
C3069 a_38648_9126# VDD 0.10108f
C3070 VDD counter_value_o[7] 0.1828f
C3071 VDD a_23121_13494# 3.16306f
C3072 counter_value_o[3] a_17077_16182# 0.22232f
C3073 VDD a_2541_15488# 0.10108f
C3074 NAND2X1_0.Y a_6493_14838# 0.01674f
C3075 VDD a_20857_15510# 0.21498f
C3076 a_19677_4086# a_18401_4050# 0.06964f
C3077 a_22349_5072# VDD 0.38109f
C3078 a_13025_4050# a_15713_4050# 0.01208f
C3079 a_15881_9104# a_16485_8768# 0.04852f
C3080 VDD a_1029_9462# 3.16059f
C3081 OA21X2_0.B BUFX3_38.Y 0.14887f
C3082 BUFX3_27.A OR3X1_1.Y 0.02749f
C3083 BUFX3_1.Y BUFX3_0.Y 0.60779f
C3084 a_38412_9476# a_38480_9440# 0.15111f
C3085 a_11865_13494# a_11933_13458# 0.43806f
C3086 BUFX3_27.Y a_21777_14920# 0.03168f
C3087 a_34025_12114# a_35369_12114# 0.01425f
C3088 OR3BX1_0.B a_18921_14554# 0.03244f
C3089 VDD BUFX3_4.A 0.27259f
C3090 a_28649_6738# VDD 0.51327f
C3091 a_15713_5394# a_16485_4736# 0.01014f
C3092 VDD a_11849_11792# 0.59389f
C3093 a_9497_16146# a_11009_15824# 0.22482f
C3094 a_1365_10522# a_1029_9462# 0.46845f
C3095 a_13109_16146# OR3X1_1.B 0.01596f
C3096 a_15713_8082# a_16973_7760# 0.27946f
C3097 XOR2X1_0.A NAND2X1_0.A 0.04101f
C3098 a_19341_15898# a_19681_14802# 0.01099f
C3099 VDD a_7221_15952# 0.1152f
C3100 BUFX3_2.A NOR3X1_0.C 0.04106f
C3101 a_22197_15624# a_22399_15524# 0.25198f
C3102 a_8424_6524# a_7833_5430# 0.03593f
C3103 a_30161_6416# a_30093_6490# 0.94424f
C3104 a_1097_8082# VDD 0.57652f
C3105 OR3X1_1.B a_16973_13136# 0.01111f
C3106 VDD a_5381_15824# 0.20155f
C3107 VDD a_23189_13458# 0.53282f
C3108 a_5213_10770# a_7901_10770# 0.01208f
C3109 a_11865_10806# a_10589_10770# 0.06964f
C3110 OR3X1_1.A BUFX3_29.Y 0.28936f
C3111 a_38580_5180# a_38745_4284# 0.01103f
C3112 VDD OAI21X1_0.A 0.34476f
C3113 a_19745_4050# a_20349_4284# 0.04852f
C3114 a_22281_9178# a_23625_9178# 0.01349f
C3115 BUFX3_1.Y a_23121_14906# 0.17677f
C3116 VDD a_5145_9462# 3.08527f
C3117 BUFX3_26.Y NAND2X1_0.A 0.12838f
C3118 a_15713_12114# a_15881_11792# 0.11187f
C3119 BUFX3_1.Y a_7093_15779# 0.01299f
C3120 OR3BX1_0.B a_19179_14852# 0.01518f
C3121 a_6473_5072# a_7817_5072# 0.01425f
C3122 a_37737_6774# VDD 0.72674f
C3123 a_26213_5394# a_24785_5072# 0.24595f
C3124 a_30161_10448# a_31505_10448# 0.01425f
C3125 a_24785_10448# a_24717_10522# 1.99572f
C3126 a_4053_10522# a_4725_9660# 0.02812f
C3127 a_15981_2940# VDD 0.25052f
C3128 a_22349_13136# a_22281_13210# 0.94424f
C3129 a_22197_15624# NOR3X1_0.C 0.1467f
C3130 a_10521_8118# VDD 1.45582f
C3131 a_9093_6490# a_10521_5430# 0.26941f
C3132 VDD a_31269_13494# 3.20096f
C3133 a_32529_11866# a_31269_10806# 0.27719f
C3134 a_11933_10770# a_12537_11004# 0.04852f
C3135 a_23457_4086# a_26145_4086# 0.15401f
C3136 a_27405_5146# VDD 3.12537f
C3137 VDD a_11933_9426# 0.2189f
C3138 a_1097_9104# a_3785_9104# 0.01208f
C3139 VDD BUFX3_16.A 0.41412f
C3140 a_12957_13494# a_13025_13458# 1.99572f
C3141 DFFQX1_3.CK a_9674_15474# 1.14533f
C3142 a_19677_6774# a_18401_6738# 0.06964f
C3143 a_13025_6738# a_15713_6738# 0.01208f
C3144 a_7817_9104# a_7901_9426# 0.08769f
C3145 a_27473_9104# a_27405_10522# 0.01868f
C3146 DFFQX1_7.Q a_22399_15524# 0.01257f
C3147 a_37805_12114# a_38412_12164# 0.04779f
C3148 a_18401_12114# a_16973_11792# 0.24595f
C3149 a_38913_6972# VDD 0.0867f
C3150 a_7817_5072# a_8424_5180# 0.04779f
C3151 VDD a_19593_11866# 3.13748f
C3152 a_33873_16182# a_34548_16196# 0.01169f
C3153 VDD AND2X1_1.B 0.33649f
C3154 AND2X1_3.Y a_3131_15770# 0.04069f
C3155 a_38580_3836# a_38913_3392# 0.01772f
C3156 a_20181_2742# VDD 3.1113f
C3157 a_15713_8082# a_16485_7424# 0.01014f
C3158 a_37469_16146# a_35285_15824# 0.05578f
C3159 a_1029_13210# a_1029_12150# 0.58425f
C3160 DFFQX1_3.CK a_14537_14480# 0.03706f
C3161 a_35285_6416# a_37973_6416# 0.01208f
C3162 BUFX3_26.Y a_6493_14838# 0.22051f
C3163 a_12537_8316# VDD 0.25529f
C3164 AND2X1_2.B AND2X1_2.Y 0.08791f
C3165 a_24297_16182# a_26985_16380# 0.03051f
C3166 OAI21X1_0.A BUFX3_17.A 0.17542f
C3167 a_18589_16146# AOI21BX1_0.Y 0.21054f
C3168 a_15645_10806# a_18333_10806# 0.15401f
C3169 VDD a_5313_15898# 0.69338f
C3170 a_27489_4086# a_27557_4050# 0.43806f
C3171 a_24297_4736# VDD 0.25056f
C3172 a_8424_9212# a_7833_8118# 0.03593f
C3173 a_30161_9104# a_30093_9178# 0.94424f
C3174 VDD a_13025_9426# 0.53088f
C3175 VDD counter_value_o[6] 0.18952f
C3176 NAND3X1_0.Y a_7105_15532# 0.01569f
C3177 VDD OAI21X1_2.Y 0.3477f
C3178 a_15713_13458# a_18401_13458# 0.01208f
C3179 BUFX3_23.A a_19932_14852# 0.083f
C3180 a_19745_6738# a_20349_6972# 0.04852f
C3181 a_38580_7868# a_38745_6972# 0.01103f
C3182 DFFQX1_7.Q NOR3X1_0.C 0.02017f
C3183 a_1029_6490# VDD 3.08533f
C3184 VDD a_31505_11792# 0.21456f
C3185 a_15057_15488# a_15225_15488# 0.09255f
C3186 a_34548_16196# a_34881_16380# 0.01772f
C3187 a_1029_2742# a_1097_2706# 1.99572f
C3188 a_6473_7760# a_7817_7760# 0.01425f
C3189 a_26649_2742# VDD 0.69301f
C3190 a_26213_8082# a_24785_7760# 0.24595f
C3191 AOI21BX2_0.A a_22803_15536# 0.01337f
C3192 a_27473_13136# a_30161_13136# 0.01208f
C3193 BUFX3_1.Y a_19341_15898# 0.01973f
C3194 a_3717_13210# a_4725_12348# 0.02812f
C3195 a_18401_8082# VDD 0.32194f
C3196 a_37973_6416# a_38580_6524# 0.04779f
C3197 VDD a_38480_13472# 0.10776f
C3198 a_19677_10806# a_19745_10770# 0.43806f
C3199 a_5213_4050# a_4121_3728# 0.30526f
C3200 a_6325_16182# NAND3X1_0.B 0.2209f
C3201 BUFX3_16.A BUFX3_17.A 0.03431f
C3202 a_9093_9178# a_10521_8118# 0.26941f
C3203 VDD a_23457_9462# 3.12574f
C3204 DFFQX1_4.Q a_17459_15170# 0.1414f
C3205 OR3X1_1.C a_22245_15244# 0.04333f
C3206 a_23457_6774# a_26145_6774# 0.15401f
C3207 VDD a_38745_16380# 0.19516f
C3208 a_9161_6416# VDD 0.51524f
C3209 a_9161_5072# a_9093_5146# 1.99572f
C3210 a_35301_16182# a_36648_16196# 0.01103f
C3211 VDD a_32597_11792# 0.56295f
C3212 a_33941_16146# BUFX3_41.A 0.01201f
C3213 a_14469_10522# a_12957_9462# 0.25266f
C3214 a_35285_10448# a_35217_10522# 1.99572f
C3215 DFFQX1_3.Q a_12793_16146# 0.20722f
C3216 a_4392_2756# a_4460_2720# 0.15111f
C3217 a_7817_7760# a_8424_7868# 0.04779f
C3218 a_27809_2706# VDD 0.50703f
C3219 OR3X1_1.C a_22197_13608# 0.12557f
C3220 AOI21BX2_0.A a_23033_15572# 0.0158f
C3221 a_30161_13136# a_31437_13210# 0.06964f
C3222 a_27489_8118# VDD 0.6927f
C3223 VDD a_3785_13136# 0.525f
C3224 BUFX3_2.A OR3BX1_0.B 1.16618f
C3225 DFFQX1_5.CK OR3X1_0.Y 0.15677f
C3226 VDD a_3049_16146# 0.22808f
C3227 a_28581_4086# a_28649_4050# 1.99572f
C3228 a_4460_4064# VDD 0.12134f
C3229 a_35285_9104# a_37973_9104# 0.01208f
C3230 a_20249_16146# a_19409_15824# 0.06961f
C3231 a_21441_13692# a_21613_13458# 0.01682f
C3232 OR3X1_1.C OR3X1_1.Y 0.07443f
C3233 NOR3X1_0.Y NOR3X1_0.A 0.06194f
C3234 a_4460_6752# a_3785_6416# 0.01952f
C3235 a_27489_6774# a_27557_6738# 0.43806f
C3236 a_15881_9104# a_15713_9426# 0.11187f
C3237 a_3785_11792# a_3717_11866# 1.99572f
C3238 a_8424_5180# a_8757_4736# 0.01772f
C3239 a_15813_6490# VDD 0.6927f
C3240 a_31337_5394# a_32109_4736# 0.01014f
C3241 a_11781_5146# a_14469_5146# 0.15401f
C3242 NAND4X2_0.C DFFQX1_3.CK 0.0373f
C3243 VDD a_38648_11814# 0.10108f
C3244 OR3X1_1.B a_18573_14575# 0.17697f
C3245 OR3X1_1.B a_18665_15244# 0.03969f
C3246 a_34277_2706# VDD 0.2084f
C3247 a_5061_2742# a_5129_2706# 1.99572f
C3248 a_6153_15938# a_5985_15488# 0.02487f
C3249 a_28581_8118# VDD 3.06479f
C3250 a_16485_6080# a_15645_5430# 0.02812f
C3251 a_19593_6490# a_20349_5628# 0.02812f
C3252 a_12288_15932# a_12621_15488# 0.01772f
C3253 a_12714_15510# a_14117_15824# 0.01169f
C3254 VDD a_8492_13158# 0.12771f
C3255 a_20769_10806# a_20837_10770# 1.99572f
C3256 a_31337_4050# a_34025_4050# 0.01208f
C3257 a_7901_4050# VDD 0.52655f
C3258 a_12537_4284# a_11849_3728# 0.01014f
C3259 a_37973_9104# a_38580_9212# 0.04779f
C3260 VDD a_31337_9426# 0.59593f
C3261 a_31589_16146# a_31505_15824# 0.08719f
C3262 a_5213_6738# a_6473_6416# 0.27274f
C3263 a_16973_9104# a_18401_9426# 0.24595f
C3264 a_22751_15170# a_22613_15244# 0.21538f
C3265 a_6405_11866# a_7749_11866# 0.01349f
C3266 counter_value_o[3] a_16401_16182# 0.01164f
C3267 VDD counter_value_o[5] 0.22843f
C3268 OR3X1_1.A a_21777_14920# 0.01276f
C3269 a_16905_6490# VDD 3.05265f
C3270 VDD a_1097_10770# 0.58208f
C3271 VDD a_12117_16380# 0.2262f
C3272 a_38664_2756# VDD 0.27709f
C3273 a_9161_7760# a_9093_7834# 1.99572f
C3274 BUFX3_41.A a_27305_14802# 0.01136f
C3275 a_1029_8118# BUFX3_0.Y 0.09952f
C3276 a_11781_13210# a_12537_12348# 0.02812f
C3277 a_32597_13136# a_32529_13210# 1.99572f
C3278 a_35369_8082# VDD 0.20824f
C3279 a_3785_5394# a_4392_5444# 0.04779f
C3280 VDD a_9093_13210# 3.05733f
C3281 a_23525_10770# a_26213_10770# 0.01208f
C3282 a_9497_16146# a_9674_15474# 0.10995f
C3283 a_4460_10784# a_4121_10448# 0.01952f
C3284 a_18333_4086# VDD 1.45223f
C3285 VDD a_36461_9426# 0.3193f
C3286 VDD BUFX3_27.Y 0.68777f
C3287 BUFX3_1.Y a_1029_10806# 0.11692f
C3288 a_32597_16146# a_32597_15824# 0.27826f
C3289 a_25809_13494# a_27153_13494# 0.01349f
C3290 a_3785_13458# a_3785_13136# 0.10935f
C3291 a_19341_15898# a_20685_15488# 0.01445f
C3292 a_28581_6774# a_28649_6738# 1.99572f
C3293 a_7901_6738# a_8492_6438# 0.03648f
C3294 a_18905_16146# a_19093_15474# 0.0116f
C3295 a_30161_6416# VDD 0.32552f
C3296 a_19661_5072# a_19593_5146# 1.99572f
C3297 a_1033_3414# enable_i 0.21407f
C3298 VDD a_10521_10806# 1.45582f
C3299 OR3X1_1.B a_20937_14144# 0.01466f
C3300 BUFX3_27.A a_19661_13136# 0.02038f
C3301 OR3X1_1.B a_20433_15036# 0.0236f
C3302 VDD a_15800_16160# 0.12803f
C3303 a_11529_2742# a_11597_2706# 0.43806f
C3304 a_8424_7868# a_8757_7424# 0.01772f
C3305 a_31337_8082# a_32109_7424# 0.01014f
C3306 a_11781_7834# a_14469_7834# 0.15401f
C3307 BUFX3_41.A a_35301_14838# 0.01633f
C3308 BUFX3_12.A AND2X1_3.Y 0.2105f
C3309 a_35217_13210# a_37905_13210# 0.15401f
C3310 a_27405_6490# a_27489_5430# 0.11121f
C3311 a_38412_8132# VDD 0.28533f
C3312 counter_value_o[1] a_6997_16182# 0.22563f
C3313 a_27980_14816# a_28245_15036# 0.02298f
C3314 VDD a_22349_13136# 0.38477f
C3315 a_27405_11866# a_27473_10448# 0.01868f
C3316 a_5213_10770# a_6809_10448# 0.20369f
C3317 a_20249_16146# a_20924_16160# 0.01184f
C3318 a_19593_9178# a_20349_8316# 0.02812f
C3319 a_37737_4086# a_38412_4100# 0.01169f
C3320 a_15713_4050# a_16973_3728# 0.27946f
C3321 a_36461_4050# a_37805_4050# 0.01425f
C3322 a_16485_8768# a_15645_8118# 0.02812f
C3323 VDD OR3X1_1.B 3.08626f
C3324 a_20349_4284# VDD 0.25052f
C3325 a_17829_14920# a_18665_15244# 0.01951f
C3326 clock_i a_2376_16196# 0.01273f
C3327 a_23709_14838# a_23803_14838# 0.10269f
C3328 BUFX3_2.A AOI21BX2_0.A 0.07026f
C3329 VDD a_21189_14906# 0.17486f
C3330 BUFX3_41.A a_31505_15824# 0.01412f
C3331 a_27153_13494# a_25877_13458# 0.06964f
C3332 a_31337_6738# a_34025_6738# 0.01208f
C3333 VDD a_21529_16182# 0.21329f
C3334 a_16485_14920# a_16687_14852# 0.25198f
C3335 a_14537_11792# a_15881_11792# 0.01425f
C3336 a_35369_12114# a_35285_11792# 0.10882f
C3337 NOR3X1_0.Y OR3X1_1.Y 0.27464f
C3338 a_23525_5394# a_23457_4086# 0.0208f
C3339 DFFQX1_5.CK a_18297_15244# 0.01028f
C3340 a_21979_14852# a_22245_15244# 0.06817f
C3341 VDD a_12537_11004# 0.25529f
C3342 a_4392_9476# a_4725_9660# 0.01772f
C3343 a_23003_14188# a_23461_14130# 0.0206f
C3344 VDD a_19093_15474# 0.27617f
C3345 BUFX3_41.A a_36393_14838# 0.0348f
C3346 OR3X1_1.B BUFX3_2.Y 0.02067f
C3347 VDD a_33941_16146# 0.25318f
C3348 a_38648_13158# a_38913_12800# 0.02298f
C3349 a_19593_13210# a_19677_12150# 0.11121f
C3350 a_7105_15532# a_6911_15770# 0.14171f
C3351 NAND2X1_0.Y a_5985_15488# 0.04965f
C3352 a_27405_6490# a_28581_5430# 0.27765f
C3353 a_1097_7760# VDD 0.57652f
C3354 a_28581_14838# a_28649_14802# 1.99572f
C3355 a_33957_10806# a_35301_10806# 0.01349f
C3356 a_38480_4064# a_38745_4284# 0.03941f
C3357 BUFX3_41.A a_27473_14480# 0.02781f
C3358 a_3785_8082# a_4392_8132# 0.04779f
C3359 a_26213_4050# VDD 0.32169f
C3360 a_18435_15045# a_18665_15244# 0.05497f
C3361 OR3BX1_0.B AOI21BX2_1.A 0.29661f
C3362 a_4305_15898# DFFQX1_3.CK 0.0233f
C3363 NAND3X1_0.B a_7241_14816# 0.01921f
C3364 a_25877_13458# a_27221_13458# 0.01425f
C3365 BUFX3_41.A a_35285_15824# 0.19582f
C3366 a_24617_14802# a_24785_14480# 0.53769f
C3367 a_35217_7834# a_35285_6416# 0.02403f
C3368 a_13025_6738# a_14537_6416# 0.22482f
C3369 a_3717_9178# a_3785_9104# 1.99572f
C3370 OR3BX1_0.Y a_18573_14575# 0.08361f
C3371 a_16485_14920# a_17321_15244# 0.01951f
C3372 a_15713_12114# a_15645_10806# 0.0208f
C3373 a_37805_12114# a_37973_11792# 0.06961f
C3374 BUFX3_41.A a_23965_15474# 0.01003f
C3375 a_37905_6490# VDD 0.72638f
C3376 a_3717_5146# a_4392_4100# 0.03593f
C3377 a_24785_5072# a_27473_5072# 0.01208f
C3378 a_21979_14852# OR3X1_1.Y 0.01641f
C3379 VDD a_18401_10770# 0.32194f
C3380 a_7833_9462# a_10521_9462# 0.15401f
C3381 VDD counter_value_o[4] 0.23023f
C3382 a_5129_16146# a_5804_16160# 0.01184f
C3383 DFFQX1_0.D a_7105_15532# 0.11013f
C3384 a_15309_2742# a_15981_2940# 0.01448f
C3385 a_19661_7760# a_19593_7834# 1.99572f
C3386 a_1029_12150# a_3717_12150# 0.15401f
C3387 VDD a_36648_16196# 0.26687f
C3388 a_19593_13210# a_20769_12150# 0.27765f
C3389 a_24785_15824# a_24717_15898# 1.99572f
C3390 a_7749_7834# VDD 0.71162f
C3391 clock_i a_6325_16182# 0.01599f
C3392 VDD a_27405_13210# 3.12537f
C3393 a_31337_14802# a_34025_14802# 0.01208f
C3394 a_35301_10806# a_35973_11004# 0.01448f
C3395 a_8623_14852# a_9027_15045# 0.15054f
C3396 VDD a_12288_15932# 0.28482f
C3397 BUFX3_17.A OR3X1_1.B 0.0143f
C3398 a_27405_9178# a_27489_8118# 0.11121f
C3399 a_15713_4050# a_16485_3392# 0.01014f
C3400 a_35301_4086# VDD 0.6927f
C3401 a_36461_6738# a_37805_6738# 0.01425f
C3402 a_37737_6774# a_38412_6788# 0.01169f
C3403 a_24549_14838# a_27237_14838# 0.15401f
C3404 a_16973_11792# a_19661_11792# 0.01208f
C3405 a_3717_5430# VDD 0.69675f
C3406 VDD a_27489_10806# 0.6927f
C3407 VDD a_17829_14920# 0.64728f
C3408 a_31437_10522# a_31269_9462# 0.11121f
C3409 a_11865_9462# a_11933_9426# 0.43806f
C3410 a_27405_15898# a_27237_14838# 0.06895f
C3411 BUFX3_1.Y a_3969_14838# 0.03114f
C3412 a_16401_2742# a_19089_2742# 0.15401f
C3413 a_6069_16380# a_6237_16380# 0.09255f
C3414 clock_i a_12793_16146# 0.013f
C3415 a_23525_8082# a_23457_6774# 0.0208f
C3416 AOI21BX2_0.A DFFQX1_7.Q 0.029f
C3417 BUFX3_4.A a_7105_15532# 0.01196f
C3418 a_3785_12114# a_4460_12128# 0.01184f
C3419 a_22231_14180# a_23003_14188# 0.0313f
C3420 a_3717_16182# a_4392_16196# 0.01169f
C3421 DFFQX1_1.D a_3785_16146# 0.03582f
C3422 a_27405_15898# a_30093_15898# 0.15401f
C3423 a_12957_5430# a_15645_5430# 0.15401f
C3424 a_32109_6080# a_31269_5430# 0.02812f
C3425 a_15881_7760# VDD 0.20824f
C3426 VDD a_24297_12800# 0.25056f
C3427 a_14049_15898# a_12957_14838# 0.07119f
C3428 a_15713_10770# a_15881_10448# 0.11187f
C3429 VDD a_14724_15932# 0.26322f
C3430 a_9027_15045# a_9257_15244# 0.05497f
C3431 counter_value_o[5] a_24297_16182# 0.01437f
C3432 VDD a_27305_14802# 0.25748f
C3433 VDD a_5145_14838# 1.54417f
C3434 a_26213_4050# a_24785_3728# 0.24595f
C3435 a_27405_9178# a_28581_8118# 0.27765f
C3436 a_36393_4086# VDD 1.48411f
C3437 a_7105_15532# a_7221_15952# 0.15054f
C3438 BUFX3_1.Y a_16953_15244# 0.0165f
C3439 a_33957_13494# a_35301_13494# 0.01349f
C3440 BUFX3_31.A a_21193_16182# 0.20578f
C3441 NAND3X1_0.Y a_7241_14816# 0.01325f
C3442 a_38480_6752# a_38745_6972# 0.03941f
C3443 VDD a_4392_16196# 0.26686f
C3444 VDD a_22635_14192# 0.11682f
C3445 a_35217_15898# a_35301_14838# 0.11121f
C3446 BUFX3_2.A DFFQX1_6.D 0.03536f
C3447 a_15881_11792# a_16485_11456# 0.04852f
C3448 a_9093_5146# a_7833_4086# 0.27719f
C3449 a_30093_5146# a_31437_5146# 0.01349f
C3450 a_7833_5430# VDD 3.12641f
C3451 VDD a_28581_10806# 3.06479f
C3452 VDD OAI21X1_1.Y 0.28706f
C3453 a_16485_14920# BUFX3_25.Y 0.2748f
C3454 VDD a_18435_15045# 0.1152f
C3455 a_32529_10522# a_33957_9462# 0.26941f
C3456 a_1097_15824# a_2373_15488# 0.04852f
C3457 a_30497_16146# a_30161_15824# 0.11187f
C3458 a_19157_2706# a_19761_2940# 0.04852f
C3459 OR3X1_1.B DFFQX1_3.D 0.07646f
C3460 a_24785_7760# a_27473_7760# 0.01208f
C3461 a_3717_7834# a_4392_6788# 0.03593f
C3462 a_5145_12150# a_7833_12150# 0.15401f
C3463 VDD OR3BX1_0.Y 0.33154f
C3464 AOI21BX1_0.B a_18757_15474# 0.22611f
C3465 a_37905_6490# a_37737_5430# 0.06895f
C3466 a_18333_5430# a_18401_5394# 0.94424f
C3467 a_19661_7760# VDD 0.53123f
C3468 a_36461_14802# a_37805_14802# 0.01425f
C3469 a_37737_14838# a_38412_14852# 0.01169f
C3470 a_18401_10770# a_16973_10448# 0.24595f
C3471 VDD a_35301_14838# 0.6927f
C3472 a_20333_14480# a_20937_14144# 0.04852f
C3473 a_1365_3802# a_4053_3802# 0.15401f
C3474 a_38745_4284# VDD 0.2023f
C3475 VDD a_9009_16380# 0.10645f
C3476 a_6809_3728# a_8085_3802# 0.06964f
C3477 OR3X1_1.B a_21195_16000# 0.06318f
C3478 VDD a_23709_14838# 0.24355f
C3479 a_35301_13494# a_35973_13692# 0.01448f
C3480 a_23525_6738# a_23693_6416# 0.11187f
C3481 a_35285_9104# a_35369_9426# 0.10882f
C3482 VDD a_5804_16160# 0.10584f
C3483 VDD a_22865_14228# 0.2578f
C3484 DFFQX1_6.D a_22197_15624# 0.12163f
C3485 a_35217_15898# a_36393_14838# 0.25048f
C3486 a_22281_11866# a_23625_11866# 0.01349f
C3487 BUFX3_0.Y a_1029_10806# 0.08752f
C3488 a_18905_16146# a_19580_16160# 0.01184f
C3489 a_31505_5072# a_32109_4736# 0.04852f
C3490 VDD a_31505_15824# 0.21518f
C3491 counter_value_o[0] a_2709_16380# 0.03357f
C3492 OR3BX1_0.Y BUFX3_2.Y 0.18456f
C3493 VDD a_35369_10770# 0.20824f
C3494 a_12957_9462# a_13025_9426# 1.99572f
C3495 VDD a_20333_14480# 0.20766f
C3496 VDD a_19681_14802# 0.26924f
C3497 a_3023_15792# a_3131_15770# 0.21538f
C3498 DFFQX1_5.Q a_24717_15898# 0.05128f
C3499 OA21X2_1.Y DFFQX1_7.Q 0.02538f
C3500 a_10521_12150# a_10589_12114# 0.94424f
C3501 a_30093_13210# a_28581_12150# 0.25266f
C3502 VDD counter_value_o[3] 0.18405f
C3503 a_35285_15824# a_35217_15898# 1.99572f
C3504 a_24213_15488# a_24381_15488# 0.09255f
C3505 a_23625_7834# VDD 0.69298f
C3506 a_38480_14816# a_38745_15036# 0.03941f
C3507 VDD a_4460_12128# 0.12134f
C3508 VDD a_36393_14838# 1.48411f
C3509 a_9765_14838# a_12453_15036# 0.03051f
C3510 a_6809_3728# VDD 0.32533f
C3511 clock_i a_11009_15824# 0.04872f
C3512 a_22029_14280# a_22231_14180# 0.25198f
C3513 a_12957_8118# a_15645_8118# 0.15401f
C3514 a_32109_8768# a_31269_8118# 0.02812f
C3515 a_19932_14852# a_20265_15036# 0.01772f
C3516 VDD BUFX3_28.A 0.14878f
C3517 a_1097_6416# a_1029_6490# 1.99572f
C3518 a_23525_6738# a_24785_6416# 0.27946f
C3519 BUFX3_12.A DFFQX1_3.CK 0.54542f
C3520 a_37973_9104# a_37805_9426# 0.06961f
C3521 a_23629_15474# BUFX3_27.A 0.10095f
C3522 OR3X1_1.B a_19745_13458# 0.01317f
C3523 a_15645_8118# a_15713_9426# 0.0208f
C3524 VDD a_27473_14480# 0.52519f
C3525 VDD OR3X1_1.A 0.67067f
C3526 a_30429_16182# a_31101_16380# 0.01448f
C3527 DFFQX1_3.Q a_9674_15474# 0.02071f
C3528 a_15713_5394# VDD 0.52435f
C3529 a_32529_5146# a_35217_5146# 0.15401f
C3530 VDD a_35285_15824# 0.525f
C3531 a_37973_5072# a_38648_5094# 0.01184f
C3532 VDD a_38412_10820# 0.28533f
C3533 VDD a_21525_14180# 0.21279f
C3534 a_15713_9426# a_18401_9426# 0.01208f
C3535 BUFX3_1.Y a_9395_15170# 0.01063f
C3536 a_30093_7834# a_31437_7834# 0.01349f
C3537 a_9093_7834# a_7833_6774# 0.27719f
C3538 AND2X1_3.B a_3045_15244# 0.01128f
C3539 VDD a_23965_15474# 0.22841f
C3540 VDD a_19580_16160# 0.12774f
C3541 a_15716_14816# a_16153_14838# 0.02104f
C3542 BUFX3_1.Y XOR2X1_0.Y 0.0438f
C3543 a_24717_7834# VDD 3.05265f
C3544 a_21777_14920# a_22383_15045# 0.0867f
C3545 VDD a_7901_12114# 0.5247f
C3546 VDD a_38745_15036# 0.2023f
C3547 AND2X1_1.Y NAND2X1_0.Y 0.04956f
C3548 a_9161_3728# VDD 0.51524f
C3549 a_18333_8118# a_18401_8082# 0.94424f
C3550 a_14537_3728# a_15881_3728# 0.01425f
C3551 a_37905_9178# a_37737_8118# 0.06895f
C3552 counter_value_o[4] a_24297_16182# 0.02122f
C3553 a_7817_6416# a_8492_6438# 0.01184f
C3554 a_3717_6490# a_6405_6490# 0.15401f
C3555 a_8424_11900# a_7833_10806# 0.03593f
C3556 a_30161_11792# a_30093_11866# 0.94424f
C3557 a_16905_5146# a_18333_4086# 0.26941f
C3558 a_26145_5430# VDD 1.45223f
C3559 VDD a_38648_15846# 0.10124f
C3560 VDD a_1033_10134# 0.21275f
C3561 VDD DFFQX1_5.D 0.32937f
C3562 a_35285_14480# a_37973_14480# 0.01208f
C3563 a_31505_7760# a_32109_7424# 0.04852f
C3564 a_24029_2706# a_26717_2706# 0.01208f
C3565 a_16153_14838# a_15881_14480# 0.0116f
C3566 a_23457_16380# a_23625_16380# 0.09255f
C3567 a_37973_7760# VDD 0.25876f
C3568 a_38580_15932# a_38913_15488# 0.01772f
C3569 a_27489_5430# a_26213_5394# 0.06964f
C3570 a_20837_5394# a_23525_5394# 0.01208f
C3571 OR3X1_1.B AND2X1_2.Y 0.1115f
C3572 a_1097_14480# a_1029_14554# 1.99572f
C3573 VDD a_18333_12150# 1.45223f
C3574 a_4121_10448# a_6809_10448# 0.01208f
C3575 VDD a_7817_14480# 0.26063f
C3576 VDD a_12621_15036# 0.13655f
C3577 AOI21BX1_0.A a_18757_15474# 0.09173f
C3578 a_31337_4050# a_32109_3392# 0.01014f
C3579 a_15813_3802# VDD 0.74211f
C3580 a_7817_9104# VDD 0.25501f
C3581 a_8623_14852# a_7833_13494# 0.01475f
C3582 VDD a_24381_14144# 0.15841f
C3583 BUFX3_31.A a_22350_16146# 0.06365f
C3584 a_9093_11866# a_10521_10806# 0.26941f
C3585 a_1029_16182# a_1097_16146# 0.94424f
C3586 a_28161_5628# VDD 0.25052f
C3587 VDD a_2373_15036# 0.20254f
C3588 VDD a_6741_10522# 1.47399f
C3589 a_26145_9462# a_27489_9462# 0.01349f
C3590 OAI21X1_1.Y a_21195_16000# 0.04124f
C3591 a_31437_14554# a_32109_14144# 0.01448f
C3592 a_37973_7760# a_38648_7782# 0.01184f
C3593 NAND4X2_0.C a_8001_16258# 0.10453f
C3594 a_32529_7834# a_35217_7834# 0.15401f
C3595 VDD BUFX3_1.Y 3.1917f
C3596 a_3717_7834# BUFX3_0.Y 0.0125f
C3597 a_19677_12150# a_18401_12114# 0.06964f
C3598 a_13025_12114# a_15713_12114# 0.01208f
C3599 a_27557_5394# a_28161_5628# 0.04852f
C3600 BUFX3_2.A a_16485_14920# 0.02588f
C3601 a_5213_5394# a_3785_5072# 0.24646f
C3602 a_1029_14838# a_2373_15036# 0.01445f
C3603 a_32109_7424# VDD 0.25358f
C3604 BUFX3_0.Y a_3969_14838# 0.01607f
C3605 NOR3X1_0.A a_23777_14480# 0.07904f
C3606 a_3717_14554# a_6405_14554# 0.15401f
C3607 a_7817_14480# a_8492_14502# 0.01184f
C3608 VDD a_20349_12348# 0.25052f
C3609 a_8153_10448# a_8085_10522# 0.43806f
C3610 VDD a_15981_15036# 0.22646f
C3611 a_16973_3728# a_19661_3728# 0.01208f
C3612 a_16905_3802# VDD 3.08491f
C3613 VDD counter_value_o[2] 0.23822f
C3614 BUFX3_1.Y a_1029_14838# 0.01422f
C3615 BUFX3_1.Y a_1365_10522# 0.19664f
C3616 a_11849_6416# a_14537_6416# 0.01208f
C3617 a_34025_6738# a_32597_6416# 0.24595f
C3618 BUFX24_2.A a_12957_14838# 0.04484f
C3619 NOR3X1_0.C a_22497_14228# 0.0215f
C3620 a_35285_11792# a_37973_11792# 0.01208f
C3621 AND2X1_1.Y XOR2X1_0.A 0.03134f
C3622 a_7817_9104# a_8492_9126# 0.01184f
C3623 a_34025_5394# VDD 0.32194f
C3624 a_3717_9178# a_6405_9178# 0.15401f
C3625 VDD a_9093_10522# 3.05687f
C3626 a_27489_9462# a_28161_9660# 0.01448f
C3627 a_35217_14554# a_37905_14554# 0.15401f
C3628 a_16905_7834# a_18333_6774# 0.26941f
C3629 NAND4X2_0.C DFFQX1_3.Q 0.04571f
C3630 a_15881_14480# a_16485_14144# 0.04852f
C3631 a_19745_12114# a_20349_12348# 0.04852f
C3632 a_38580_13244# a_38745_12348# 0.01103f
C3633 NAND4X2_0.C NAND3X1_0.B 0.10354f
C3634 a_18573_14575# a_18333_13494# 0.01151f
C3635 a_4392_6788# VDD 0.26358f
C3636 a_31269_5430# a_33957_5430# 0.15401f
C3637 NOR3X1_0.A a_23709_14554# 0.06007f
C3638 a_13025_14802# a_14537_14480# 0.22482f
C3639 VDD a_26213_12114# 0.32194f
C3640 VDD a_14469_14554# 1.46572f
C3641 a_15716_14816# AND2X1_0.Y 0.02575f
C3642 a_20837_8082# a_23525_8082# 0.01208f
C3643 counter_value_o[7] a_36981_16380# 0.03f
C3644 a_27489_8118# a_26213_8082# 0.06964f
C3645 a_30161_3728# VDD 0.32552f
C3646 a_15881_3728# a_16485_3392# 0.04852f
C3647 a_21777_14920# BUFX3_29.Y 0.11792f
C3648 a_6473_13136# a_7817_13136# 0.01425f
C3649 a_36461_6738# a_35285_6416# 0.27676f
C3650 a_15881_6416# a_15813_6490# 0.43806f
C3651 a_8492_6438# a_8757_6080# 0.02298f
C3652 a_3717_14554# a_3717_13494# 0.1104f
C3653 a_14469_9178# VDD 1.46572f
C3654 VDD a_4460_13472# 0.12134f
C3655 OR3BX1_0.B OR3X1_0.Y 0.06063f
C3656 a_37973_11792# a_38580_11900# 0.04779f
C3657 a_3717_5146# a_4121_3728# 0.01968f
C3658 a_37805_5394# VDD 0.25732f
C3659 VDD a_22349_10448# 0.38109f
C3660 a_38648_14502# a_38913_14144# 0.02298f
C3661 BUFX3_17.A BUFX3_1.Y 0.03737f
C3662 BUFX3_1.Y a_9093_14554# 0.01627f
C3663 a_31521_2742# a_31589_2706# 1.99572f
C3664 BUFX3_3.Y a_17497_14130# 0.21028f
C3665 DFFQX1_3.CK NAND2X1_0.A 0.01105f
C3666 BUFX3_12.A a_3023_15792# 0.18341f
C3667 DFFQX1_5.CK a_22245_15244# 0.03933f
C3668 a_23457_12150# a_26145_12150# 0.15401f
C3669 OR3BX1_0.B OAI21X1_0.Y 0.31619f
C3670 a_35301_5430# a_35369_5394# 0.43806f
C3671 a_5213_6738# VDD 0.51428f
C3672 a_11933_5394# a_11849_5072# 0.10882f
C3673 a_11849_14480# a_14537_14480# 0.01208f
C3674 BUFX3_0.Y a_8421_14920# 0.03429f
C3675 AND2X1_0.Y a_15881_14480# 0.06684f
C3676 VDD a_35301_12150# 0.6927f
C3677 a_11849_10448# a_11781_10522# 1.99572f
C3678 a_35369_10770# a_35285_10448# 0.10882f
C3679 a_22281_3802# a_23625_3802# 0.01349f
C3680 a_5213_8082# a_3785_7760# 0.24646f
C3681 a_2629_15510# a_3023_15792# 0.0206f
C3682 a_27557_8082# a_28161_8316# 0.04852f
C3683 DFFQX1_4.Q a_17661_15488# 0.02554f
C3684 a_7817_13136# a_8424_13244# 0.04779f
C3685 a_6405_14554# a_5145_13494# 0.26082f
C3686 AOI21BX1_0.A AOI21BX1_0.B 0.10381f
C3687 a_8757_8768# VDD 0.15604f
C3688 counter_value_o[6] a_32529_16182# 0.0178f
C3689 VDD a_7901_13458# 0.5247f
C3690 a_11849_9104# a_14537_9104# 0.01208f
C3691 a_7833_4086# a_7901_4050# 1.99572f
C3692 a_27405_5146# a_28161_4284# 0.02812f
C3693 a_31269_9462# a_31337_9426# 1.99572f
C3694 a_1029_13494# a_3717_13494# 0.15401f
C3695 a_9429_16182# a_9497_16146# 1.99572f
C3696 a_23461_14130# a_23121_13494# 0.01099f
C3697 BUFX3_1.Y a_17069_14144# 0.09796f
C3698 a_4460_12128# a_3785_11792# 0.01952f
C3699 a_27489_12150# a_27557_12114# 0.43806f
C3700 a_24297_16182# a_26985_16149# 0.01223f
C3701 a_13025_5394# a_11849_5072# 0.30073f
C3702 DFFQX1_7.Q a_27157_16182# 0.20825f
C3703 a_15645_6774# VDD 3.1238f
C3704 NAND4X2_0.C NAND3X1_0.Y 0.21601f
C3705 BUFX3_1.Y a_18165_15510# 0.20527f
C3706 a_15881_14480# a_15813_14554# 0.43806f
C3707 VDD a_36393_12150# 1.48411f
C3708 a_1433_3728# BUFX3_0.Y 0.2066f
C3709 a_15713_10770# a_15645_9462# 0.0208f
C3710 a_37805_10770# a_37973_10448# 0.06961f
C3711 a_14469_10522# a_15813_10522# 0.01349f
C3712 a_17497_14130# a_15645_13494# 0.01099f
C3713 a_31269_8118# a_33957_8118# 0.15401f
C3714 a_37905_3802# VDD 0.71482f
C3715 DFFQX1_7.Q a_24213_15488# 0.06053f
C3716 BUFX3_26.A a_5145_14838# 0.01728f
C3717 AOI21BX1_0.B a_18343_15660# 0.0295f
C3718 VDD a_20685_15488# 0.23097f
C3719 BUFX3_0.Y XOR2X1_0.Y 0.23195f
C3720 BUFX3_1.Y DFFQX1_3.D 0.02067f
C3721 VDD counter_value_o[1] 0.22133f
C3722 a_27473_9104# VDD 0.52258f
C3723 VDD a_18333_13494# 1.52328f
C3724 a_16485_11456# a_15645_10806# 0.02812f
C3725 a_19593_11866# a_20349_11004# 0.02812f
C3726 a_8492_9126# a_8757_8768# 0.02298f
C3727 clock_i a_9674_15474# 0.01982f
C3728 a_15881_9104# a_15813_9178# 0.43806f
C3729 OR3X1_1.C BUFX3_27.A 0.01619f
C3730 a_6405_5146# VDD 1.46323f
C3731 a_10589_4050# a_11933_4050# 0.01425f
C3732 VDD a_27405_10522# 3.12537f
C3733 BUFX3_31.A OR3X1_1.C 0.29306f
C3734 a_3785_13458# a_4460_13472# 0.01184f
C3735 a_34025_9426# a_35369_9426# 0.01425f
C3736 OR3X1_1.A a_21865_13494# 0.04074f
C3737 a_37989_2742# a_38057_2706# 0.43806f
C3738 a_5213_12114# a_6473_11792# 0.27274f
C3739 a_37737_5430# a_37805_5394# 0.43806f
C3740 VDD a_38745_12348# 0.2023f
C3741 BUFX3_2.Y a_18333_13494# 0.01469f
C3742 a_3717_2742# VDD 0.72864f
C3743 a_8085_3802# a_7749_2742# 0.02669f
C3744 a_11933_8082# a_11849_7760# 0.10882f
C3745 a_30161_3728# a_30093_3802# 0.94424f
C3746 a_35301_8118# a_35369_8082# 0.43806f
C3747 BUFX3_29.A a_19661_13136# 0.01466f
C3748 a_9161_13136# a_9093_13210# 1.99572f
C3749 a_19593_6490# a_22281_6490# 0.15401f
C3750 a_31437_9178# VDD 0.69838f
C3751 VDD a_20349_13692# 0.25028f
C3752 a_3785_10770# a_4392_10820# 0.04779f
C3753 a_14537_5072# VDD 0.3248f
C3754 VDD a_24297_10112# 0.25056f
C3755 a_24717_14554# a_23121_13494# 0.23154f
C3756 a_12285_16380# a_12621_16380# 0.02917f
C3757 a_5145_13494# a_7833_13494# 0.15401f
C3758 a_7833_6774# a_7901_6738# 1.99572f
C3759 a_27405_7834# a_28161_6972# 0.02812f
C3760 counter_value_o[4] a_24049_16146# 0.22232f
C3761 a_28581_12150# a_28649_12114# 1.99572f
C3762 a_7901_12114# a_8492_11814# 0.03648f
C3763 DFFQX1_1.D a_3517_15682# 0.08996f
C3764 a_38412_5444# a_38745_5628# 0.01772f
C3765 a_23525_6738# VDD 0.52435f
C3766 VDD a_22383_15045# 0.11806f
C3767 a_20349_5628# a_19661_5072# 0.01014f
C3768 BUFX3_0.Y a_3785_14480# 0.10445f
C3769 AND2X1_1.B a_7241_14816# 0.22052f
C3770 VDD a_7817_11792# 0.25487f
C3771 VDD BUFX3_0.Y 2.26138f
C3772 a_22349_10448# a_22281_10522# 0.94424f
C3773 a_7749_2742# VDD 0.73545f
C3774 DFFQX1_3.CK a_16153_14838# 0.02327f
C3775 a_13025_8082# a_11849_7760# 0.30073f
C3776 a_8424_13244# a_8757_12800# 0.01772f
C3777 a_11781_13210# a_14469_13210# 0.15401f
C3778 a_31337_13458# a_32109_12800# 0.01014f
C3779 BUFX3_3.A a_17816_14502# 0.02454f
C3780 a_14469_14554# a_12957_13494# 0.25266f
C3781 a_35217_9178# VDD 3.14104f
C3782 VDD a_3441_15952# 0.1169f
C3783 BUFX3_0.Y a_1365_10522# 0.1026f
C3784 a_27405_11866# a_27489_10806# 0.11121f
C3785 a_16973_5072# VDD 0.51278f
C3786 BUFX3_41.A a_37469_16146# 0.0417f
C3787 a_13041_16182# a_15732_16196# 0.11802f
C3788 a_37805_9426# a_38412_9476# 0.04779f
C3789 a_10521_13494# a_10589_13458# 0.94424f
C3790 a_10589_6738# a_11933_6738# 0.01425f
C3791 a_31337_12114# a_34025_12114# 0.01208f
C3792 a_33957_6774# VDD 1.45226f
C3793 VDD a_23121_14906# 0.16797f
C3794 OAI21X1_0.A a_19179_14852# 0.04862f
C3795 a_35285_3728# a_37973_3728# 0.01208f
C3796 a_37737_8118# a_37805_8082# 0.43806f
C3797 a_8909_2706# VDD 0.50741f
C3798 DFFQX1_5.Q OR3X1_1.Y 0.03781f
C3799 NAND4X2_0.C AND2X1_2.B 0.01897f
C3800 VDD a_7093_15779# 0.66175f
C3801 BUFX3_3.Y a_15645_13494# 0.01722f
C3802 a_7749_6490# a_7833_5430# 0.09008f
C3803 a_27473_6416# a_27405_6490# 1.99572f
C3804 a_1029_8118# VDD 3.08535f
C3805 VDD a_4373_15824# 0.19149f
C3806 AOI21BX1_0.A a_18343_15660# 0.02641f
C3807 a_27405_11866# a_28581_10806# 0.27765f
C3808 a_19593_9178# a_22281_9178# 0.15401f
C3809 a_22281_5146# VDD 1.53423f
C3810 BUFX3_1.Y AND2X1_2.Y 0.63005f
C3811 VDD counter_value_o[0] 0.27132f
C3812 VDD a_4460_9440# 0.12134f
C3813 a_15732_16196# a_16065_16380# 0.01772f
C3814 a_27405_14554# a_28581_13494# 0.27765f
C3815 a_11781_7834# a_11849_6416# 0.01868f
C3816 NOR3X1_0.Y BUFX3_27.A 0.0303f
C3817 clock_i NAND4X2_0.C 0.19888f
C3818 a_1097_6738# BUFX3_0.Y 0.09052f
C3819 a_35217_13210# a_35285_11792# 0.02403f
C3820 a_13025_12114# a_14537_11792# 0.22482f
C3821 a_3785_5072# a_6473_5072# 0.01208f
C3822 a_35973_6972# VDD 0.25052f
C3823 VDD a_14469_11866# 1.46572f
C3824 a_4053_10522# a_4392_9476# 0.03593f
C3825 a_27473_10448# a_30161_10448# 0.01208f
C3826 a_15377_2706# VDD 0.2084f
C3827 a_37973_3728# a_38580_3836# 0.04779f
C3828 a_38412_8132# a_38745_8316# 0.01772f
C3829 a_20349_8316# a_19661_7760# 0.01014f
C3830 a_19661_13136# a_19593_13210# 1.99572f
C3831 BUFX3_0.Y a_3785_13458# 0.0113f
C3832 a_31337_6738# a_31269_5430# 0.0208f
C3833 DFFQX1_3.CK a_12957_14838# 0.05144f
C3834 a_5145_8118# VDD 3.05823f
C3835 VDD a_28161_13692# 0.24966f
C3836 DFFQX1_0.Q AND2X1_1.Y 0.04162f
C3837 a_20769_4086# a_23457_4086# 0.15401f
C3838 a_16485_4736# VDD 0.25052f
C3839 VDD a_7901_9426# 0.5247f
C3840 VDD a_17077_16182# 0.20998f
C3841 BUFX3_2.A BUFX3_3.A 0.77743f
C3842 BUFX3_23.A a_18989_14480# 0.01477f
C3843 NOR3X1_0.C NOR3X1_0.A 0.068f
C3844 a_36461_12114# a_37805_12114# 0.01425f
C3845 a_37737_12150# a_38412_12164# 0.01169f
C3846 BUFX3_1.Y BUFX3_26.A 0.025f
C3847 a_7817_5072# a_7749_5146# 0.43806f
C3848 VDD a_8757_11456# 0.15604f
C3849 a_33873_16182# a_32597_16146# 0.06964f
C3850 a_30161_10448# a_31437_10522# 0.06964f
C3851 VDD BUFX3_29.Y 0.27256f
C3852 a_32597_6416# a_35285_6416# 0.01208f
C3853 DFFQX1_3.CK a_9161_14480# 0.05313f
C3854 a_11933_8082# VDD 0.2189f
C3855 DFFQX1_3.CK AND2X1_0.Y 0.08025f
C3856 DFFQX1_2.D a_18297_15244# 0.07539f
C3857 VDD a_34025_13458# 0.32194f
C3858 a_18333_16380# a_18589_16146# 0.01682f
C3859 a_12957_10806# a_15645_10806# 0.15401f
C3860 a_32109_11456# a_31269_10806# 0.02812f
C3861 a_27473_9104# a_27405_9178# 1.99572f
C3862 a_7749_9178# a_7833_8118# 0.09008f
C3863 a_3785_4050# a_1433_3728# 0.02019f
C3864 a_26145_4086# a_26213_4050# 0.94424f
C3865 a_35285_5072# VDD 0.52643f
C3866 VDD a_18333_9462# 1.45223f
C3867 BUFX3_0.Y DFFQX1_3.D 0.05433f
C3868 VDD a_19341_15898# 1.55908f
C3869 a_19677_13494# a_18401_13458# 0.06964f
C3870 a_13025_13458# a_15713_13458# 0.01208f
C3871 counter_value_o[6] a_32281_16146# 0.21924f
C3872 a_8492_9126# a_7901_9426# 0.03648f
C3873 a_38480_12128# a_38745_12348# 0.03941f
C3874 a_23525_5394# a_24297_4736# 0.01014f
C3875 a_31337_5394# a_31505_5072# 0.11187f
C3876 a_8492_5094# a_8424_5180# 0.15111f
C3877 a_6473_6416# VDD 0.31873f
C3878 VDD a_27473_11792# 0.52258f
C3879 a_22197_15624# a_22751_15170# 0.01664f
C3880 a_33941_16146# a_34616_16160# 0.01184f
C3881 DFFQX1_3.Q a_9429_16182# 0.29088f
C3882 a_3785_7760# a_6473_7760# 0.01208f
C3883 a_23541_2940# VDD 0.2692f
C3884 VDD a_6997_16182# 0.21031f
C3885 a_24785_13136# a_27473_13136# 0.01208f
C3886 a_3717_13210# a_4392_12164# 0.03593f
C3887 a_15813_6490# a_15645_5430# 0.11121f
C3888 a_37973_6416# a_37905_6490# 0.43806f
C3889 a_13025_8082# VDD 0.53088f
C3890 a_26985_16380# DFFQX1_7.Q 0.06846f
C3891 VDD a_37805_13458# 0.25732f
C3892 a_1029_5146# BUFX3_0.Y 0.11992f
C3893 a_37905_11866# a_37737_10806# 0.06895f
C3894 a_18333_10806# a_18401_10770# 0.94424f
C3895 a_38580_5180# VDD 0.27751f
C3896 VDD a_20349_9660# 0.25052f
C3897 a_19745_13458# a_20349_13692# 0.04852f
C3898 a_35217_14554# a_35973_13692# 0.02812f
C3899 a_5804_16160# a_6325_16182# 0.01605f
C3900 a_20769_6774# a_23457_6774# 0.15401f
C3901 BUFX3_23.A BUFX3_27.A 0.05059f
C3902 VDD a_37469_16146# 0.2579f
C3903 a_23525_12114# a_23693_11792# 0.11187f
C3904 a_31337_5394# a_32597_5072# 0.27946f
C3905 a_8424_6524# VDD 0.26381f
C3906 VDD a_31437_11866# 0.69838f
C3907 NOR3X1_0.C a_22245_15244# 0.01036f
C3908 a_15800_16160# a_15318_15510# 0.01943f
C3909 a_32597_10448# a_32529_10522# 1.99572f
C3910 a_11781_10522# a_12537_9660# 0.02812f
C3911 a_27741_2742# VDD 3.08493f
C3912 a_7817_7760# a_7749_7834# 0.43806f
C3913 a_16485_3392# a_16401_2742# 0.02812f
C3914 a_3785_2706# a_4392_2756# 0.04779f
C3915 a_22281_3802# a_22869_2742# 0.10752f
C3916 a_16905_6490# a_15645_5430# 0.27719f
C3917 a_38648_6438# a_38580_6524# 0.15111f
C3918 a_23457_8118# VDD 3.12574f
C3919 a_11009_15824# a_12288_15932# 0.04849f
C3920 OR3X1_1.B a_15318_15510# 0.05475f
C3921 NOR3X1_0.C a_22197_13608# 0.04731f
C3922 BUFX3_4.A NAND4X2_0.C 0.16332f
C3923 a_32597_9104# a_35285_9104# 0.01208f
C3924 a_3785_4050# VDD 0.25916f
C3925 VDD a_2709_16380# 0.1985f
C3926 VDD a_26213_9426# 0.32194f
C3927 DFFQX1_7.Q a_22751_15170# 0.14473f
C3928 a_20837_13458# a_21441_13692# 0.03035f
C3929 a_3785_6738# a_3785_6416# 0.10935f
C3930 a_26145_6774# a_26213_6738# 0.94424f
C3931 a_14537_9104# a_13025_9426# 0.22482f
C3932 a_35285_9104# a_35217_10522# 0.02403f
C3933 a_1097_11792# a_1029_11866# 1.99572f
C3934 a_23525_12114# a_24785_11792# 0.27946f
C3935 VDD a_1029_15898# 1.45426f
C3936 NAND2X1_1.Y BUFX3_29.A 0.16619f
C3937 a_14537_5072# a_15813_5146# 0.06964f
C3938 a_9093_5146# a_11781_5146# 0.15401f
C3939 a_11781_6490# VDD 3.18026f
C3940 VDD a_35217_11866# 3.14104f
C3941 BUFX3_27.A BUFX3_29.A 0.2438f
C3942 NOR3X1_0.C OR3X1_1.Y 1.02136f
C3943 counter_value_o[5] a_27741_16182# 0.03442f
C3944 a_35301_16182# BUFX3_41.A 0.02063f
C3945 DFFQX1_4.Q DFFQX1_5.CK 0.13588f
C3946 a_36648_16196# a_36981_16380# 0.01772f
C3947 a_35217_10522# a_37905_10522# 0.15401f
C3948 a_8492_7782# a_8424_7868# 0.15111f
C3949 a_23525_8082# a_24297_7424# 0.01014f
C3950 a_31337_8082# a_31505_7760# 0.11187f
C3951 a_34209_2742# VDD 0.69303f
C3952 a_30093_13210# a_31437_13210# 0.01349f
C3953 a_1029_15898# a_1029_14838# 0.27697f
C3954 a_9093_13210# a_7833_12150# 0.27719f
C3955 DFFQX1_1.D XOR2X1_0.A 0.05931f
C3956 VDD a_6405_13210# 1.46323f
C3957 a_3969_14838# a_4641_15036# 0.01448f
C3958 a_35301_4086# a_34025_4050# 0.06964f
C3959 a_28649_4050# a_31337_4050# 0.01208f
C3960 a_11933_4050# a_11849_3728# 0.10882f
C3961 a_15813_9178# a_15645_8118# 0.11121f
C3962 a_37973_9104# a_37905_9178# 0.43806f
C3963 a_11865_4086# VDD 0.70179f
C3964 VDD a_35301_9462# 0.6927f
C3965 OAI21X1_0.A a_18589_16146# 0.01156f
C3966 a_3313_15779# a_3441_15952# 0.0867f
C3967 a_22383_15045# a_22613_15244# 0.05497f
C3968 a_7817_11792# a_8492_11814# 0.01184f
C3969 BUFX3_0.Y AND2X1_2.Y 0.03336f
C3970 a_3717_11866# a_6405_11866# 0.15401f
C3971 a_20265_14554# a_19661_13136# 0.01246f
C3972 NAND2X1_0.A a_5213_14802# 0.04185f
C3973 a_23693_6416# VDD 0.20824f
C3974 VDD a_1029_10806# 3.08407f
C3975 BUFX3_1.Y a_21391_15175# 0.01444f
C3976 BUFX3_1.Y a_1029_13210# 0.08901f
C3977 OR3X1_1.B a_18921_14554# 0.14905f
C3978 a_38648_10470# a_38913_10112# 0.02298f
C3979 a_19593_10522# a_19677_9462# 0.11121f
C3980 a_35369_2706# VDD 0.50703f
C3981 a_24717_3802# a_26649_2742# 0.11121f
C3982 a_31337_8082# a_32597_7760# 0.27946f
C3983 a_31505_13136# a_32109_12800# 0.04852f
C3984 a_3717_5430# a_4392_5444# 0.01169f
C3985 a_1097_5394# a_3785_5394# 0.01208f
C3986 a_31337_8082# VDD 0.59593f
C3987 VDD a_14537_13136# 0.3248f
C3988 a_14117_15824# a_14724_15932# 0.04779f
C3989 a_27489_10806# a_26213_10770# 0.06964f
C3990 a_3785_10770# a_4121_10448# 0.02786f
C3991 a_20837_10770# a_23525_10770# 0.01208f
C3992 a_35369_4050# a_35973_4284# 0.04852f
C3993 a_13025_4050# a_11849_3728# 0.30073f
C3994 a_38648_9126# a_38580_9212# 0.15111f
C3995 a_16905_9178# a_15645_8118# 0.27719f
C3996 a_12957_4086# VDD 3.1114f
C3997 VDD a_36393_9462# 1.48411f
C3998 a_1097_13458# a_1097_13136# 0.58526f
C3999 a_23121_13494# a_25809_13494# 0.15401f
C4000 a_20857_15510# AOI21BX2_1.A 0.21418f
C4001 a_16973_5072# a_16905_5146# 1.99572f
C4002 a_22349_5072# a_23693_5072# 0.01425f
C4003 a_24785_6416# VDD 0.51278f
C4004 DFFQX1_5.CK a_17459_15170# 0.03031f
C4005 VDD a_5145_10806# 3.05823f
C4006 OR3X1_1.B a_22231_14180# 0.02114f
C4007 NAND3X1_0.B NAND2X1_0.A 0.37787f
C4008 a_1029_9462# a_3717_9462# 0.15401f
C4009 OR3X1_1.B a_19179_14852# 0.06651f
C4010 a_19593_10522# a_20769_9462# 0.27765f
C4011 VDD a_13109_16146# 0.53197f
C4012 OR3X1_0.Y a_22029_14280# 0.14819f
C4013 a_8841_2742# a_8909_2706# 1.99572f
C4014 a_24297_3392# a_23961_2742# 0.02812f
C4015 a_30093_3802# a_27741_2742# 0.04136f
C4016 a_9093_7834# a_11781_7834# 0.15401f
C4017 a_14537_7760# a_15813_7834# 0.06964f
C4018 BUFX3_41.A a_31269_14838# 0.07784f
C4019 a_3049_16146# a_3297_16380# 0.01102f
C4020 a_37973_13136# a_38648_13158# 0.01184f
C4021 a_32529_13210# a_35217_13210# 0.15401f
C4022 a_3717_6490# a_3785_5072# 0.01931f
C4023 a_24717_6490# a_26145_5430# 0.26941f
C4024 a_36461_8082# VDD 0.3193f
C4025 a_27912_14852# a_27980_14816# 0.15111f
C4026 VDD a_16973_13136# 0.51309f
C4027 a_10941_15898# a_9765_14838# 0.25048f
C4028 a_6493_14838# a_5213_14802# 0.07466f
C4029 a_27557_10770# a_28161_11004# 0.04852f
C4030 a_37737_4086# a_36461_4050# 0.06964f
C4031 a_19745_4050# VDD 0.20824f
C4032 clock_i a_1029_16182# 0.07741f
C4033 VDD a_38745_9660# 0.2023f
C4034 VDD a_21777_14920# 0.6293f
C4035 BUFX3_41.A a_27473_15824# 0.03163f
C4036 XOR2X1_0.Y a_3969_14838# 0.09496f
C4037 a_34881_16380# a_32597_15824# 0.01007f
C4038 a_28649_6738# a_31337_6738# 0.01208f
C4039 a_35301_6774# a_34025_6738# 0.06964f
C4040 a_23693_9104# a_23525_9426# 0.11187f
C4041 a_11849_11792# a_14537_11792# 0.01208f
C4042 a_34025_12114# a_32597_11792# 0.24595f
C4043 a_15813_5146# a_16485_4736# 0.01448f
C4044 a_30093_6490# VDD 1.46587f
C4045 VDD a_11933_10770# 0.2189f
C4046 DFFQX1_5.CK a_18031_14852# 0.04724f
C4047 a_1365_3802# enable_i 0.01992f
C4048 a_3785_9426# a_4460_9440# 0.01184f
C4049 counter_value_o[2] a_12793_16146# 0.21916f
C4050 a_4392_16196# a_4725_16380# 0.01772f
C4051 VDD a_16401_16182# 0.71804f
C4052 a_31437_3802# a_31521_2742# 0.09008f
C4053 a_16905_13210# a_18333_12150# 0.26941f
C4054 VDD a_31589_16146# 0.19311f
C4055 a_10521_5430# a_11865_5430# 0.01349f
C4056 a_24297_6080# a_23457_5430# 0.02812f
C4057 a_11781_14554# a_11849_13136# 0.01868f
C4058 VDD a_22281_13210# 1.53117f
C4059 BUFX3_29.Y a_21865_13494# 0.21014f
C4060 DFFQX1_5.Q a_32597_16146# 0.0417f
C4061 a_31269_10806# a_33957_10806# 0.15401f
C4062 a_20349_4284# a_19661_3728# 0.01014f
C4063 a_20837_4050# VDD 0.57807f
C4064 a_1097_8082# a_3785_8082# 0.01208f
C4065 a_3717_8118# a_4392_8132# 0.01169f
C4066 clock_i BUFX3_12.A 0.07107f
C4067 a_27237_14838# a_27305_14802# 0.43806f
C4068 a_23189_13458# a_25877_13458# 0.01208f
C4069 a_35369_6738# a_35973_6972# 0.04852f
C4070 a_1097_6416# BUFX3_0.Y 0.09052f
C4071 BUFX3_23.A a_24365_16146# 0.04321f
C4072 a_24785_9104# a_23525_9426# 0.27946f
C4073 a_1029_9178# a_1097_9104# 1.99572f
C4074 a_36461_12114# a_35285_11792# 0.27676f
C4075 a_15881_11792# a_15813_11866# 0.43806f
C4076 a_8492_11814# a_8757_11456# 0.02298f
C4077 a_27405_15898# a_27912_14852# 0.03593f
C4078 BUFX3_41.A a_23171_15532# 0.14146f
C4079 OR3X1_1.B a_9674_15474# 0.04532f
C4080 a_32529_6490# VDD 3.11738f
C4081 OR3X1_1.C BUFX3_23.A 0.07534f
C4082 VDD a_13025_10770# 0.53088f
C4083 a_5145_9462# a_7833_9462# 0.15401f
C4084 NAND3X1_0.Y NAND2X1_0.A 0.08282f
C4085 a_5061_16182# a_5736_16196# 0.01169f
C4086 a_15309_2742# a_15377_2706# 0.43806f
C4087 a_16973_7760# a_16905_7834# 1.99572f
C4088 clock_i a_9429_16182# 0.05217f
C4089 a_32529_3802# a_34209_2742# 0.11121f
C4090 a_22349_7760# a_23693_7760# 0.01425f
C4091 VDD a_35301_16182# 1.48466f
C4092 a_11865_5430# a_12537_5628# 0.01448f
C4093 a_3717_7834# VDD 3.0976f
C4094 a_28649_14802# a_31337_14802# 0.01208f
C4095 VDD a_16485_12800# 0.25052f
C4096 a_35301_14838# a_34025_14802# 0.06964f
C4097 a_35301_10806# a_35369_10770# 0.43806f
C4098 a_8421_14920# a_9395_15170# 0.05938f
C4099 VDD a_9429_15488# 0.23079f
C4100 VDD a_3969_14838# 0.74004f
C4101 a_9181_16146# DFFQX1_3.Q 0.20845f
C4102 a_31269_4086# VDD 3.20096f
C4103 BUFX3_41.A a_30093_14554# 0.01024f
C4104 a_24717_9178# a_26145_8118# 0.26941f
C4105 a_3717_9178# a_3785_7760# 0.01931f
C4106 a_27828_13508# a_28161_13692# 0.01772f
C4107 a_7901_13458# a_9161_13136# 0.27946f
C4108 BUFX3_2.A BUFX3_27.Y 1.38326f
C4109 BUFX3_41.A a_35217_15898# 0.17597f
C4110 a_37737_6774# a_36461_6738# 0.06964f
C4111 a_24301_14802# a_24549_14838# 0.0525f
C4112 a_23693_5072# a_24297_4736# 0.04852f
C4113 a_38913_6080# VDD 0.11104f
C4114 OAI21X1_2.Y AOI21BX2_1.A 0.23062f
C4115 BUFX3_28.A a_23461_14130# 0.23654f
C4116 VDD a_23457_10806# 3.12574f
C4117 a_30093_10522# a_28581_9462# 0.25266f
C4118 VDD a_16953_15244# 0.19458f
C4119 a_10521_9462# a_10589_9426# 0.94424f
C4120 a_24717_15898# a_24549_14838# 0.51936f
C4121 a_15813_7834# a_16485_7424# 0.01448f
C4122 a_22029_14280# a_22497_14228# 0.08137f
C4123 a_22231_14180# a_22635_14192# 0.15054f
C4124 VDD BUFX3_41.A 1.2291f
C4125 a_35217_6490# a_35301_5430# 0.11121f
C4126 a_11849_7760# VDD 0.59389f
C4127 a_3385_16182# a_3785_16146# 0.01122f
C4128 a_30161_15824# a_31437_15898# 0.06964f
C4129 a_24717_15898# a_27405_15898# 0.15401f
C4130 a_35369_14802# a_35973_15036# 0.04852f
C4131 VDD a_35285_13136# 0.52643f
C4132 a_12714_15510# a_12957_14838# 0.098f
C4133 a_35217_11866# a_35285_10448# 0.02403f
C4134 a_13025_10770# a_14537_10448# 0.22482f
C4135 a_4641_15036# a_3785_14480# 0.01014f
C4136 VDD a_12621_15488# 0.12482f
C4137 VDD a_4641_15036# 0.19781f
C4138 a_18989_14480# a_20265_14554# 0.06964f
C4139 a_24297_8768# a_23457_8118# 0.02812f
C4140 a_10521_8118# a_11865_8118# 0.01349f
C4141 BUFX3_2.A OR3X1_1.B 0.95378f
C4142 NAND2X1_0.Y a_6153_15938# 0.28667f
C4143 a_7105_15532# a_7093_15779# 0.25198f
C4144 a_31269_13494# a_33957_13494# 0.15401f
C4145 BUFX3_2.A a_21189_14906# 0.01214f
C4146 BUFX3_1.Y a_16687_14852# 0.03395f
C4147 BUFX24_2.A a_12356_15846# 0.01189f
C4148 a_32529_15898# a_33957_14838# 0.26941f
C4149 a_27405_5146# a_30093_5146# 0.15401f
C4150 a_4725_5628# VDD 0.24966f
C4151 DFFQX1_5.CK NAND2X1_1.Y 0.02067f
C4152 a_19089_2742# a_19761_2940# 0.01448f
C4153 a_27809_16146# a_27473_15824# 0.49543f
C4154 OA21X2_1.Y NOR3X1_0.A 0.30479f
C4155 BUFX3_0.Y a_1029_13210# 0.08752f
C4156 a_22231_14180# a_22865_14228# 0.14171f
C4157 DFFQX1_5.D a_23461_14130# 0.21865f
C4158 DFFQX1_4.Q a_17833_15510# 0.01941f
C4159 a_35217_6490# a_36393_5430# 0.25048f
C4160 a_15645_5430# a_15713_5394# 1.99572f
C4161 VDD a_38580_13244# 0.27751f
C4162 a_37737_14838# a_36461_14802# 0.06964f
C4163 AND2X1_1.Y DFFQX1_3.CK 0.02583f
C4164 BUFX3_27.A a_23777_14480# 0.03459f
C4165 a_37737_10806# a_37805_10770# 0.43806f
C4166 VDD a_31269_14838# 3.20307f
C4167 VDD a_8421_14920# 0.64091f
C4168 a_38480_4064# VDD 0.1086f
C4169 a_11865_8118# a_12537_8316# 0.01448f
C4170 a_35301_13494# a_35369_13458# 0.43806f
C4171 BUFX3_1.Y a_17321_15244# 0.03478f
C4172 a_20837_6738# a_22349_6416# 0.22482f
C4173 BUFX3_27.Y a_21946_15932# 0.01179f
C4174 a_31337_14802# a_32597_14480# 0.27946f
C4175 BUFX3_12.A a_2541_15488# 0.05625f
C4176 a_18031_14852# a_18085_14166# 0.01118f
C4177 a_32597_9104# a_34025_9426# 0.24595f
C4178 BUFX24_2.A a_14792_15846# 0.02128f
C4179 VDD a_5129_16146# 0.25961f
C4180 a_19593_11866# a_22281_11866# 0.15401f
C4181 a_10589_5394# VDD 0.32678f
C4182 counter_value_o[0] a_2376_16196# 0.01206f
C4183 VDD a_27473_15824# 0.51557f
C4184 VDD a_31337_10770# 0.59593f
C4185 VDD a_18573_14575# 0.23485f
C4186 a_3325_15532# a_3441_15952# 0.15054f
C4187 XOR2X1_0.A a_3517_15682# 0.03466f
C4188 a_30161_14480# a_31505_14480# 0.01425f
C4189 VDD a_18665_15244# 0.23858f
C4190 a_2629_15510# a_2541_15488# 0.01102f
C4191 a_20181_2742# a_22869_2742# 0.15401f
C4192 NAND4X2_0.C OR3X1_1.B 0.07723f
C4193 a_23693_7760# a_24297_7424# 0.04852f
C4194 DFFQX1_5.Q a_30161_15824# 0.07272f
C4195 BUFX3_1.Y a_7241_14816# 0.11132f
C4196 a_19409_15824# a_20857_15510# 0.02198f
C4197 NOR3X1_0.Y BUFX3_23.A 0.02545f
C4198 NAND2X1_1.Y a_20775_14852# 0.06333f
C4199 a_27405_13210# a_28161_12348# 0.02812f
C4200 a_7833_12150# a_7901_12114# 1.99572f
C4201 a_18401_5394# a_19745_5394# 0.01425f
C4202 a_19593_7834# VDD 3.13748f
C4203 a_32597_15824# a_32529_15898# 1.99572f
C4204 VDD a_3785_12114# 0.25345f
C4205 AOI21BX2_0.A OR3X1_1.Y 0.06565f
C4206 a_38412_10820# a_38745_11004# 0.01772f
C4207 BUFX3_27.A a_23709_14554# 0.05377f
C4208 a_15318_15510# a_15981_15036# 0.01313f
C4209 a_31337_4050# a_31505_3728# 0.11187f
C4210 VDD a_9395_15170# 0.24988f
C4211 a_23525_4050# a_24297_3392# 0.01014f
C4212 a_1433_3728# VDD 0.57233f
C4213 a_35217_9178# a_35301_8118# 0.11121f
C4214 a_19932_14852# a_20000_14816# 0.15111f
C4215 VDD XOR2X1_0.Y 0.16279f
C4216 BUFX3_2.Y a_18573_14575# 0.10505f
C4217 a_35285_9104# a_36461_9426# 0.27676f
C4218 a_30429_16182# a_30497_16146# 0.43806f
C4219 DFFQX1_5.Q a_23323_15175# 0.01376f
C4220 BUFX3_27.Y a_21441_13692# 0.0284f
C4221 XOR2X1_0.A a_6153_15938# 0.01418f
C4222 a_31437_5146# a_32109_4736# 0.01448f
C4223 a_19677_5430# VDD 0.6927f
C4224 VDD a_36461_10770# 0.3193f
C4225 a_19677_9462# a_18401_9426# 0.06964f
C4226 a_13025_9426# a_15713_9426# 0.01208f
C4227 a_22937_2706# a_23541_2940# 0.04852f
C4228 DFFQX1_5.Q a_32597_15824# 0.03206f
C4229 a_27405_7834# a_30093_7834# 0.15401f
C4230 DFFQX1_7.Q OR3X1_1.B 0.01456f
C4231 VDD a_23171_15532# 0.24957f
C4232 OAI21X1_0.A a_19409_15824# 0.02274f
C4233 VDD a_18905_16146# 0.26448f
C4234 a_10589_12114# a_11933_12114# 0.01425f
C4235 DFFQX1_5.Q a_23629_15474# 0.20025f
C4236 a_31505_7760# VDD 0.21456f
C4237 VDD a_11865_12150# 0.70179f
C4238 a_8623_14852# a_9161_14480# 0.01726f
C4239 a_23525_10770# a_23693_10448# 0.11187f
C4240 VDD a_38480_14816# 0.10776f
C4241 a_11849_3728# a_14537_3728# 0.01208f
C4242 a_31337_4050# a_32597_3728# 0.27946f
C4243 a_22231_14180# DFFQX1_5.D 0.09933f
C4244 a_35217_9178# a_36393_8118# 0.25048f
C4245 a_8085_3802# VDD 0.73103f
C4246 a_3385_16182# DFFQX1_1.D 0.21577f
C4247 a_15645_8118# a_15713_8082# 1.99572f
C4248 a_21613_13458# a_19661_13136# 0.0116f
C4249 a_37737_13494# a_37805_13458# 0.43806f
C4250 VDD a_27809_16146# 0.51338f
C4251 a_1029_6490# a_3717_6490# 0.15401f
C4252 a_28161_6972# a_27473_6416# 0.01014f
C4253 a_6473_6416# a_7749_6490# 0.06964f
C4254 VDD a_30093_14554# 1.46587f
C4255 a_7749_11866# a_7833_10806# 0.09008f
C4256 a_27473_11792# a_27405_11866# 1.99572f
C4257 a_30497_16146# DFFQX1_5.Q 0.01632f
C4258 BUFX24_2.A a_9765_14838# 0.03693f
C4259 BUFX3_1.Y BUFX3_25.Y 0.07101f
C4260 a_37905_5146# a_38580_5180# 0.01169f
C4261 VDD a_35217_15898# 3.14104f
C4262 a_20769_5430# VDD 3.1423f
C4263 a_38580_10556# a_38745_9660# 0.01103f
C4264 a_19745_9426# a_20349_9660# 0.04852f
C4265 VDD a_20937_14144# 0.19615f
C4266 BUFX3_2.A OAI21X1_1.Y 0.02686f
C4267 a_32597_14480# a_35285_14480# 0.01208f
C4268 VDD a_20433_15036# 0.1303f
C4269 VDD a_3717_16182# 0.70687f
C4270 VDD a_20856_16196# 0.27053f
C4271 a_11781_13210# a_11849_11792# 0.01868f
C4272 DFFQX1_5.Q BUFX3_27.A 0.17314f
C4273 a_32597_7760# VDD 0.56295f
C4274 OR3X1_1.B a_8673_15898# 0.01146f
C4275 BUFX3_2.A OR3BX1_0.Y 0.02076f
C4276 VDD a_12957_12150# 3.1114f
C4277 a_21777_14920# a_22613_15244# 0.01951f
C4278 a_1433_10448# a_4121_10448# 0.01208f
C4279 a_23525_10770# a_24785_10448# 0.27946f
C4280 VDD a_3785_14480# 0.5285f
C4281 a_15881_3728# a_15813_3802# 0.43806f
C4282 a_18401_8082# a_19745_8082# 0.01425f
C4283 a_11781_3802# VDD 3.18456f
C4284 a_38412_13508# a_38745_13692# 0.01772f
C4285 a_7749_6490# a_8424_6524# 0.01169f
C4286 OR3X1_1.B AOI21BX2_1.A 0.2095f
C4287 a_31337_12114# a_31269_10806# 0.0208f
C4288 a_1097_14802# a_1097_14480# 0.27826f
C4289 clock_i a_4460_16160# 0.01416f
C4290 AOI21BX2_1.A a_21189_14906# 0.08493f
C4291 a_27557_5394# VDD 0.20824f
C4292 a_16485_14144# a_16905_14144# 0.02917f
C4293 VDD a_1029_14838# 1.45471f
C4294 VDD a_1365_10522# 3.14869f
C4295 a_23457_9462# a_26145_9462# 0.15401f
C4296 BUFX3_2.A a_20333_14480# 0.03267f
C4297 DFFQX1_3.D a_8421_14920# 0.12373f
C4298 a_31437_7834# a_32109_7424# 0.01448f
C4299 a_18837_16182# a_19512_16196# 0.01169f
C4300 VDD BUFX3_2.Y 0.27203f
C4301 a_38648_7782# VDD 0.10108f
C4302 counter_value_o[3] BUFX3_2.A 0.18067f
C4303 a_19409_15824# OAI21X1_2.Y 0.01647f
C4304 a_1029_14554# a_3717_14554# 0.15401f
C4305 VDD a_19745_12114# 0.20824f
C4306 a_6473_14480# a_7749_14554# 0.06964f
C4307 a_9833_14802# a_9161_14480# 0.41091f
C4308 a_6809_10448# a_6741_10522# 0.94424f
C4309 VDD a_8492_14502# 0.12912f
C4310 a_12957_14838# a_13025_14802# 1.99572f
C4311 a_38745_16380# a_38913_16380# 0.09255f
C4312 a_23693_3728# VDD 0.20824f
C4313 clock_i a_9181_16146# 0.01112f
C4314 a_23189_13458# a_23693_13136# 0.11187f
C4315 a_9161_6416# a_11849_6416# 0.01208f
C4316 a_8492_9126# VDD 0.12771f
C4317 a_3313_15779# a_3969_14838# 0.01706f
C4318 VDD a_38580_14588# 0.27751f
C4319 a_32597_11792# a_35285_11792# 0.01208f
C4320 a_14724_15932# a_15057_15488# 0.01772f
C4321 a_28649_5394# VDD 0.51327f
C4322 a_3717_4086# a_3785_4050# 0.43806f
C4323 a_2376_16196# a_2709_16380# 0.01772f
C4324 BUFX3_2.A OR3X1_1.A 0.06481f
C4325 a_23625_5146# a_23457_4086# 0.11121f
C4326 a_1029_9178# a_3717_9178# 0.15401f
C4327 VDD a_14537_10448# 0.3248f
C4328 a_4460_9440# a_3785_9104# 0.01952f
C4329 a_27489_9462# a_27557_9426# 0.43806f
C4330 a_32529_14554# a_35217_14554# 0.15401f
C4331 NAND4X2_0.C a_9009_16380# 0.025f
C4332 a_27809_2706# a_30497_2706# 0.01208f
C4333 BUFX3_1.Y a_15648_14852# 0.01077f
C4334 XOR2X1_0.A NAND2X1_0.Y 0.03673f
C4335 a_37905_7834# a_38580_7868# 0.01169f
C4336 AND2X1_0.Y a_16905_14144# 0.02447f
C4337 OR3X1_1.C DFFQX1_5.CK 0.54746f
C4338 AND2X1_2.Y a_9429_15488# 0.07228f
C4339 a_1097_6738# VDD 0.57652f
C4340 a_28581_5430# a_31269_5430# 0.15401f
C4341 BUFX3_26.Y a_6661_16182# 0.23085f
C4342 a_7749_14554# a_8424_14588# 0.01169f
C4343 VDD a_20837_12114# 0.57859f
C4344 AOI21BX1_0.Y a_18757_15474# 0.04009f
C4345 OAI21X1_0.A OAI21X1_0.Y 0.12166f
C4346 a_15648_14852# a_15981_15036# 0.01772f
C4347 VDD BUFX3_17.A 0.23334f
C4348 VDD a_9093_14554# 3.05733f
C4349 a_24365_16146# a_24785_15824# 0.4743f
C4350 counter_value_o[7] a_36716_16160# 0.06924f
C4351 a_24785_3728# VDD 0.51278f
C4352 a_3785_13136# a_6473_13136# 0.01208f
C4353 a_7901_13458# a_7833_12150# 0.02042f
C4354 a_23189_13458# a_24785_13136# 0.2042f
C4355 BUFX3_26.Y NAND2X1_0.Y 0.09805f
C4356 a_1029_14554# a_1029_13494# 0.58425f
C4357 a_14537_6416# a_14469_6490# 0.94424f
C4358 a_9093_9178# VDD 3.05733f
C4359 AND2X1_3.Y DFFQX1_1.D 0.05668f
C4360 VDD a_3785_13458# 0.25345f
C4361 a_15813_11866# a_15645_10806# 0.11121f
C4362 a_37973_11792# a_37905_11866# 0.43806f
C4363 DFFQX1_5.CK a_17073_15938# 0.0157f
C4364 a_4460_4064# a_4725_4284# 0.03941f
C4365 a_37737_5430# VDD 0.72674f
C4366 a_24717_5146# a_23457_4086# 0.27719f
C4367 a_3049_16146# BUFX3_12.A 0.213f
C4368 a_7749_9178# a_8424_9212# 0.01169f
C4369 VDD a_16973_10448# 0.51278f
C4370 a_5213_9426# a_6473_9104# 0.27274f
C4371 a_20769_12150# a_23457_12150# 0.15401f
C4372 a_18921_14554# a_18333_13494# 0.13234f
C4373 a_33957_5430# a_34025_5394# 0.94424f
C4374 a_10589_5394# a_9161_5072# 0.24595f
C4375 a_10521_6774# VDD 1.45582f
C4376 BUFX3_0.Y a_7241_14816# 0.06463f
C4377 VDD a_31269_12150# 3.20096f
C4378 a_9161_14480# a_11849_14480# 0.01208f
C4379 a_9161_10448# a_9093_10522# 1.99572f
C4380 a_34025_10770# a_32597_10448# 0.24595f
C4381 VDD a_17069_14144# 0.18935f
C4382 a_19593_3802# a_22281_3802# 0.15401f
C4383 a_30093_3802# VDD 1.51622f
C4384 a_7817_13136# a_7749_13210# 0.43806f
C4385 a_3717_14554# a_4725_13692# 0.02812f
C4386 a_22349_9104# VDD 0.38109f
C4387 NOR3X1_0.C a_23323_15175# 0.01464f
C4388 VDD a_18165_15510# 0.19271f
C4389 VDD a_11865_13494# 0.70179f
C4390 a_16905_11866# a_15645_10806# 0.27719f
C4391 a_38648_11814# a_38580_11900# 0.15111f
C4392 a_5145_4086# a_5213_4050# 1.99572f
C4393 a_38913_5628# VDD 0.0867f
C4394 a_9161_9104# a_11849_9104# 0.01208f
C4395 VDD a_22281_10522# 1.53423f
C4396 a_28581_9462# a_28649_9426# 1.99572f
C4397 a_3717_6774# a_3785_6738# 0.43806f
C4398 a_23625_7834# a_23457_6774# 0.11121f
C4399 VDD DFFQX1_3.D 0.37789f
C4400 a_11849_9104# a_11781_10522# 0.01868f
C4401 BUFX3_2.A BUFX3_1.Y 0.60574f
C4402 a_3785_12114# a_3785_11792# 0.10935f
C4403 a_26145_12150# a_26213_12114# 0.94424f
C4404 AND2X1_2.Y a_8421_14920# 0.15861f
C4405 OAI21X1_1.Y AOI21BX2_1.A 0.02852f
C4406 a_12537_6972# VDD 0.25529f
C4407 a_14537_14480# a_14469_14554# 0.94424f
C4408 a_11781_10522# a_14469_10522# 0.15401f
C4409 a_8085_10522# a_8757_10112# 0.01448f
C4410 BUFX3_1.Y a_7833_13494# 0.01232f
C4411 a_36461_10770# a_35285_10448# 0.27676f
C4412 BUFX3_3.A a_17748_14588# 0.07844f
C4413 a_4053_3802# a_3717_2742# 0.02669f
C4414 a_32529_3802# VDD 3.19689f
C4415 a_28581_8118# a_31269_8118# 0.15401f
C4416 BUFX3_0.Y a_3045_15244# 0.36252f
C4417 a_31337_13458# a_31505_13136# 0.11187f
C4418 a_8492_13158# a_8424_13244# 0.15111f
C4419 DFFQX1_7.Q a_23965_15474# 0.22101f
C4420 AND2X1_1.B NAND2X1_0.A 0.12895f
C4421 a_31269_8118# a_31337_9426# 0.0208f
C4422 VDD a_12957_13494# 3.1114f
C4423 a_1029_5146# VDD 3.08533f
C4424 a_7901_4050# a_10589_4050# 0.01208f
C4425 a_14537_9104# a_14469_9178# 0.94424f
C4426 VDD a_16485_10112# 0.25052f
C4427 a_9429_16182# a_12117_16380# 0.03051f
C4428 a_31337_9426# a_34025_9426# 0.01208f
C4429 BUFX3_26.Y XOR2X1_0.A 0.02119f
C4430 a_3785_16146# DFFQX1_3.CK 0.01452f
C4431 a_35301_2742# a_35369_2706# 1.99572f
C4432 a_4460_6752# a_4725_6972# 0.03941f
C4433 a_24717_7834# a_23457_6774# 0.27719f
C4434 VDD a_24297_16182# 3.05535f
C4435 NOR3X1_0.C BUFX3_27.A 0.12346f
C4436 NAND2X1_0.A a_5313_15898# 0.14946f
C4437 a_18401_6738# VDD 0.32194f
C4438 a_24365_16146# DFFQX1_5.Q 0.05462f
C4439 a_36393_5430# a_36461_5394# 0.94424f
C4440 VDD a_38480_12128# 0.10776f
C4441 a_6741_3802# a_5061_2742# 0.2104f
C4442 a_27473_3728# a_27405_3802# 1.99572f
C4443 a_38913_3392# VDD 0.11575f
C4444 a_33957_8118# a_34025_8082# 0.94424f
C4445 a_10589_8082# a_9161_7760# 0.24595f
C4446 reset_n_i a_1029_9462# 0.03001f
C4447 AOI21BX1_0.Y AOI21BX1_0.B 0.28142f
C4448 a_31337_13458# a_32597_13136# 0.27946f
C4449 BUFX3_17.A a_18165_15510# 0.02668f
C4450 a_23693_6416# a_23625_6490# 0.43806f
C4451 a_27405_9178# VDD 3.12537f
C4452 a_16905_6490# a_19593_6490# 0.15401f
C4453 VDD a_19745_13458# 0.20834f
C4454 a_3717_10806# a_4392_10820# 0.01169f
C4455 a_1097_10770# a_3785_10770# 0.01208f
C4456 a_21777_14920# a_21391_15175# 0.01246f
C4457 a_9161_5072# VDD 0.51524f
C4458 VDD a_35285_10448# 0.52643f
C4459 a_12117_16380# a_12285_16380# 0.09255f
C4460 a_38664_2756# a_38732_2720# 0.15111f
C4461 OR3X1_1.A AOI21BX2_1.A 0.01976f
C4462 a_5145_6774# a_5213_6738# 1.99572f
C4463 OR3X1_1.B a_19409_15824# 0.03791f
C4464 a_22029_14280# a_22197_13608# 0.01076f
C4465 a_27489_6774# VDD 0.6927f
C4466 a_38412_5444# a_38480_5408# 0.15111f
C4467 a_19745_5394# a_19661_5072# 0.10882f
C4468 VDD a_3785_11792# 0.525f
C4469 a_19661_10448# a_19593_10522# 1.99572f
C4470 BUFX3_27.A a_21613_13458# 0.21424f
C4471 DFFQX1_5.CK a_21979_14852# 0.03766f
C4472 a_4725_2940# VDD 0.15604f
C4473 a_9093_13210# a_11781_13210# 0.15401f
C4474 a_14537_13136# a_15813_13210# 0.06964f
C4475 a_3717_6490# a_3717_5430# 0.1104f
C4476 a_24297_8768# VDD 0.25056f
C4477 DFFQX1_3.CK a_9765_14838# 0.14009f
C4478 a_11781_14554# a_12537_13692# 0.02812f
C4479 VDD a_3313_15779# 0.64974f
C4480 BUFX3_1.Y DFFQX1_7.Q 0.1529f
C4481 DFFQX1_4.Q DFFQX1_2.D 0.01626f
C4482 VDD a_21865_13494# 0.21751f
C4483 a_24717_11866# a_26145_10806# 0.26941f
C4484 a_35217_5146# a_35973_4284# 0.02812f
C4485 a_18333_4086# a_19677_4086# 0.01349f
C4486 a_15813_5146# VDD 0.6927f
C4487 a_37153_16146# a_37401_16182# 0.05055f
C4488 VDD a_38580_10556# 0.27751f
C4489 a_37737_9462# a_38412_9476# 0.01169f
C4490 a_36461_9426# a_37805_9426# 0.01425f
C4491 a_7833_13494# a_7901_13458# 1.99572f
C4492 a_7901_6738# a_10589_6738# 0.01208f
C4493 NOR3X1_0.Y a_22665_15572# 0.03704f
C4494 OR3BX1_0.B a_18989_14480# 0.12449f
C4495 a_28649_12114# a_31337_12114# 0.01208f
C4496 a_35301_12150# a_34025_12114# 0.06964f
C4497 a_20837_5394# a_19661_5072# 0.30073f
C4498 BUFX3_0.Y a_6405_14554# 0.03742f
C4499 a_28581_6774# VDD 3.06479f
C4500 VDD a_22613_15244# 0.23788f
C4501 VDD AND2X1_2.Y 0.35139f
C4502 VDD a_8492_11814# 0.12771f
C4503 BUFX3_38.Y BUFX3_41.A 0.21847f
C4504 a_32597_3728# a_35285_3728# 0.01208f
C4505 a_8841_2742# VDD 3.09243f
C4506 a_9093_3802# a_11529_2742# 0.02023f
C4507 a_36393_8118# a_36461_8082# 0.94424f
C4508 OAI21X1_0.A a_18333_16149# 0.01222f
C4509 a_6405_6490# a_5145_5430# 0.26082f
C4510 a_30161_6416# a_31505_6416# 0.01425f
C4511 a_24785_6416# a_24717_6490# 1.99572f
C4512 a_10521_10806# a_11865_10806# 0.01349f
C4513 a_24297_11456# a_23457_10806# 0.02812f
C4514 a_19677_4086# a_20349_4284# 0.01448f
C4515 a_16905_5146# VDD 3.05265f
C4516 a_23693_9104# a_23625_9178# 0.43806f
C4517 a_16905_9178# a_19593_9178# 0.15401f
C4518 VDD a_3785_9426# 0.25345f
C4519 a_38480_9440# a_38745_9660# 0.03941f
C4520 a_10589_13458# a_11933_13458# 0.01425f
C4521 BUFX3_27.Y OR3X1_0.Y 0.18417f
C4522 a_1029_6774# BUFX3_0.Y 0.09952f
C4523 a_35369_12114# a_35973_12348# 0.04852f
C4524 DFFQX1_1.D DFFQX1_3.CK 0.01618f
C4525 a_35369_6738# VDD 0.20824f
C4526 a_1097_5072# a_3785_5072# 0.01208f
C4527 VDD a_9093_11866# 3.05733f
C4528 BUFX3_1.Y AOI21BX2_1.A 0.09772f
C4529 a_24785_10448# a_27473_10448# 0.01208f
C4530 VDD a_23209_16146# 0.23197f
C4531 a_15309_2742# VDD 0.72357f
C4532 a_37973_3728# a_37905_3802# 0.43806f
C4533 a_14469_3802# a_12621_2742# 0.16815f
C4534 BUFX3_23.A DFFQX1_5.CK 0.21505f
C4535 a_19745_8082# a_19661_7760# 0.10882f
C4536 a_38412_8132# a_38480_8096# 0.15111f
C4537 VDD BUFX3_26.A 0.26976f
C4538 a_22349_13136# a_23693_13136# 0.01425f
C4539 a_16973_13136# a_16905_13210# 1.99572f
C4540 BUFX3_0.Y a_3717_13494# 0.01605f
C4541 AND2X1_1.Y NAND3X1_0.B 0.04252f
C4542 NOR3X1_0.Y DFFQX1_5.Q 0.01619f
C4543 a_4460_8096# VDD 0.12134f
C4544 VDD a_27828_13508# 0.26356f
C4545 DFFQX1_0.Q a_6661_16182# 0.05405f
C4546 a_11865_10806# a_12537_11004# 0.01448f
C4547 AOI21BX1_0.Y AOI21BX1_0.A 0.12611f
C4548 a_30161_5072# VDD 0.32552f
C4549 a_3717_9178# a_3717_8118# 0.1104f
C4550 VDD a_11865_9462# 0.70179f
C4551 OR3X1_1.B OR3X1_0.Y 0.05177f
C4552 BUFX3_23.A a_24785_15824# 0.0106f
C4553 BUFX3_29.Y a_22231_14180# 0.03136f
C4554 a_18333_6774# a_19677_6774# 0.01349f
C4555 a_35217_7834# a_35973_6972# 0.02812f
C4556 a_20924_16160# OR3X1_1.B 0.01125f
C4557 OR3BX1_0.B NAND2X1_1.Y 0.28233f
C4558 a_37737_12150# a_36461_12114# 0.06964f
C4559 a_6473_5072# a_6405_5146# 0.94424f
C4560 a_38412_6788# VDD 0.28533f
C4561 OR3X1_1.C a_22399_15524# 0.03218f
C4562 BUFX3_1.Y a_4305_15898# 0.01099f
C4563 VDD a_22349_11792# 0.38109f
C4564 BUFX3_31.A OR3BX1_0.B 0.06043f
C4565 a_6741_10522# a_7833_9462# 0.0108f
C4566 OR3X1_1.B OAI21X1_0.Y 0.0229f
C4567 a_38648_3750# a_38580_3836# 0.15111f
C4568 a_16469_2706# VDD 0.50703f
C4569 a_20837_8082# a_19661_7760# 0.30073f
C4570 a_15813_13210# a_16485_12800# 0.01448f
C4571 BUFX3_0.Y a_7833_13494# 0.01401f
C4572 a_7901_8082# VDD 0.5247f
C4573 AOI21BX1_0.Y a_18343_15660# 0.10948f
C4574 DFFQX1_2.D a_18031_14852# 0.10803f
C4575 VDD a_28649_13458# 0.51327f
C4576 a_35217_11866# a_35301_10806# 0.11121f
C4577 a_11781_11866# a_11849_10448# 0.01868f
C4578 a_23457_4086# a_23525_4050# 1.99572f
C4579 a_24785_9104# a_24717_9178# 1.99572f
C4580 a_6405_9178# a_5145_8118# 0.26082f
C4581 a_30161_9104# a_31505_9104# 0.01425f
C4582 VDD a_12957_9462# 3.1114f
C4583 a_19093_15474# OAI21X1_0.Y 0.18965f
C4584 a_32529_14554# a_31269_13494# 0.27719f
C4585 a_19677_6774# a_20349_6972# 0.01448f
C4586 a_28649_5394# a_30161_5072# 0.22482f
C4587 a_1097_6416# VDD 0.57652f
C4588 OR3X1_1.C NOR3X1_0.C 0.04828f
C4589 a_13109_16146# a_14117_15824# 0.09901f
C4590 a_33941_16146# a_34548_16196# 0.04779f
C4591 a_31337_10770# a_31269_9462# 0.0208f
C4592 a_30093_10522# a_31437_10522# 0.01349f
C4593 a_9093_10522# a_7833_9462# 0.27719f
C4594 a_16905_3802# a_16401_2742# 0.42619f
C4595 a_22937_2706# VDD 0.2362f
C4596 a_1097_7760# a_3785_7760# 0.01208f
C4597 DFFQX1_3.CK a_11781_14554# 0.05325f
C4598 a_35285_6416# a_35217_6490# 1.99572f
C4599 a_14469_6490# a_12957_5430# 0.25266f
C4600 a_18333_8118# VDD 1.45223f
C4601 VDD a_37737_13494# 0.72674f
C4602 VDD a_7105_15532# 0.34799f
C4603 a_35217_11866# a_36393_10806# 0.25048f
C4604 a_15645_10806# a_15713_10770# 1.99572f
C4605 a_26213_4050# a_27557_4050# 0.01425f
C4606 a_37905_5146# VDD 0.72638f
C4607 AND2X1_2.Y DFFQX1_3.D 0.07247f
C4608 VDD a_19745_9426# 0.20824f
C4609 NAND4X2_0.C BUFX3_0.Y 0.10947f
C4610 BUFX3_23.A a_20265_15036# 0.01071f
C4611 AOI21BX2_0.A a_23323_15175# 0.06144f
C4612 a_19593_7834# a_19661_6416# 0.01868f
C4613 a_20837_12114# a_22349_11792# 0.22482f
C4614 a_7749_6490# VDD 0.71162f
C4615 XOR2X1_0.A a_3721_14802# 0.06622f
C4616 NOR3X1_0.A a_23121_13494# 0.12959f
C4617 clock_i a_7333_16182# 0.01123f
C4618 a_32529_16182# BUFX3_41.A 0.01848f
C4619 VDD a_27405_11866# 3.12537f
C4620 a_31505_10448# a_32109_10112# 0.04852f
C4621 a_3717_2742# a_4392_2756# 0.01169f
C4622 a_1097_2706# a_3785_2706# 0.01208f
C4623 a_19593_3802# a_20181_2742# 0.40505f
C4624 a_6473_7760# a_6405_7834# 0.94424f
C4625 VDD a_24049_16146# 0.27782f
C4626 a_23693_13136# a_24297_12800# 0.04852f
C4627 a_20349_8316# VDD 0.25052f
C4628 VDD BUFX3_38.Y 0.25092f
C4629 BUFX3_23.A DFFQX1_5.Q 0.04455f
C4630 VDD a_38913_13692# 0.0867f
C4631 a_18401_10770# a_19745_10770# 0.01425f
C4632 a_7901_4050# a_8153_3728# 0.11187f
C4633 VDD a_2376_16196# 0.27164f
C4634 a_3717_4086# VDD 0.69675f
C4635 a_19580_16160# a_19409_15824# 0.01952f
C4636 VDD a_20837_9426# 0.57859f
C4637 DFFQX1_0.Q BUFX3_26.Y 0.20911f
C4638 a_20769_13494# a_20837_13458# 0.43806f
C4639 a_17077_16182# BUFX3_2.A 0.01241f
C4640 BUFX3_16.A a_17749_16182# 0.27338f
C4641 a_23457_6774# a_23525_6738# 1.99572f
C4642 a_1097_6738# a_1097_6416# 0.58526f
C4643 OR3X1_1.B a_22497_14228# 0.01129f
C4644 a_35973_5628# a_35285_5072# 0.01014f
C4645 a_15881_6416# VDD 0.20824f
C4646 a_17337_15938# BUFX3_3.A 0.09429f
C4647 a_36648_16196# a_36716_16160# 0.15111f
C4648 NOR3X1_0.A a_23189_13458# 0.02508f
C4649 VDD a_24297_11456# 0.25056f
C4650 a_37973_10448# a_38648_10470# 0.01184f
C4651 a_32529_10522# a_35217_10522# 0.15401f
C4652 a_31101_2940# VDD 0.25112f
C4653 a_28649_8082# a_30161_7760# 0.22482f
C4654 AOI21BX2_0.A BUFX3_27.A 0.0241f
C4655 a_21193_16182# DFFQX1_6.D 0.22028f
C4656 a_27405_13210# a_30093_13210# 0.15401f
C4657 BUFX3_31.A AOI21BX2_0.A 0.18967f
C4658 a_26213_8082# VDD 0.32194f
C4659 a_12356_15846# a_12714_15510# 0.04125f
C4660 VDD a_21391_15175# 0.24866f
C4661 VDD a_1029_13210# 3.08405f
C4662 a_10589_4050# a_9161_3728# 0.24595f
C4663 a_7833_4086# VDD 3.12641f
C4664 a_14469_9178# a_12957_8118# 0.25266f
C4665 a_35285_9104# a_35217_9178# 1.99572f
C4666 DFFQX1_7.Q a_23121_14906# 0.18302f
C4667 a_16687_14852# a_16953_15244# 0.06817f
C4668 VDD a_31269_9462# 3.20096f
C4669 a_26213_6738# a_27557_6738# 0.01425f
C4670 XOR2X1_0.A a_1097_14480# 0.02186f
C4671 VDD a_3325_15532# 0.34124f
C4672 a_1029_11866# a_3717_11866# 0.15401f
C4673 a_6473_11792# a_7749_11866# 0.06964f
C4674 a_28161_12348# a_27473_11792# 0.01014f
C4675 a_17833_15510# a_17661_15488# 0.02089f
C4676 NAND2X1_0.A a_5145_14838# 0.09964f
C4677 a_19661_6416# VDD 0.53123f
C4678 a_16905_10522# a_18333_9462# 0.26941f
C4679 a_5129_2706# a_7817_2706# 0.01208f
C4680 a_35301_2742# VDD 3.05374f
C4681 BUFX3_12.A BUFX3_1.Y 0.02913f
C4682 NOR3X1_0.Y NOR3X1_0.C 0.89786f
C4683 AOI21BX2_0.A a_22350_16146# 0.01109f
C4684 a_5381_15824# a_5985_15488# 0.04852f
C4685 a_35301_8118# VDD 0.6927f
C4686 VDD a_6325_16182# 0.214f
C4687 VDD a_9161_13136# 0.51524f
C4688 a_1097_10770# a_1433_10448# 0.49543f
C4689 a_7333_16182# DFFQX1_0.D 0.22245f
C4690 a_2373_15488# a_2541_15488# 0.09255f
C4691 a_3441_15952# a_3131_15770# 0.05497f
C4692 a_22751_15170# OR3X1_1.Y 0.01008f
C4693 a_7749_11866# a_8424_11900# 0.01169f
C4694 DFFQX1_0.D a_7297_15682# 0.0897f
C4695 OR3X1_1.A OR3X1_0.Y 0.20217f
C4696 a_19661_5072# a_22349_5072# 0.01208f
C4697 a_23625_6490# VDD 0.69298f
C4698 VDD a_4460_10784# 0.12134f
C4699 counter_value_o[2] a_9429_16182# 0.01751f
C4700 OR3X1_0.Y a_21525_14180# 0.13506f
C4701 VDD a_12793_16146# 0.29114f
C4702 OR3BX1_0.B OR3X1_1.C 0.05163f
C4703 a_35973_8316# a_35285_7760# 0.01014f
C4704 clock_i AND2X1_1.Y 0.02483f
C4705 OA21X2_1.Y BUFX3_27.A 0.03878f
C4706 NOR3X1_0.C a_21979_14852# 0.01969f
C4707 a_31437_13210# a_32109_12800# 0.01448f
C4708 a_4392_5444# a_4725_5628# 0.01772f
C4709 a_36393_8118# VDD 1.48411f
C4710 a_27305_14802# a_27912_14852# 0.04779f
C4711 VDD a_15813_13210# 0.6927f
C4712 a_36393_4086# a_37737_4086# 0.01349f
C4713 a_15713_4050# VDD 0.52501f
C4714 a_17829_14920# a_18297_15244# 0.08137f
C4715 VDD a_38480_9440# 0.10776f
C4716 a_4725_13692# a_3785_13136# 0.01014f
C4717 a_7901_6738# a_9161_6416# 0.27946f
C4718 a_7333_16182# BUFX3_4.A 0.02584f
C4719 a_22349_9104# a_20837_9426# 0.22482f
C4720 a_9161_11792# a_11849_11792# 0.01208f
C4721 a_24717_6490# VDD 3.05265f
C4722 a_22349_5072# a_23625_5146# 0.06964f
C4723 VDD a_7901_10770# 0.52536f
C4724 a_22635_14192# a_22497_14228# 0.21799f
C4725 a_30093_3802# a_31101_2940# 0.02737f
C4726 a_4392_16196# a_4460_16160# 0.15111f
C4727 a_22350_16146# OA21X2_1.Y 0.13012f
C4728 BUFX3_41.A a_34025_14802# 0.02449f
C4729 VDD a_32529_16182# 1.53358f
C4730 a_37905_13210# a_38580_13244# 0.01169f
C4731 a_5313_15898# a_5985_15488# 0.01448f
C4732 a_7833_5430# a_10521_5430# 0.15401f
C4733 a_7297_15682# a_7221_15952# 0.21799f
C4734 a_38745_8316# VDD 0.2023f
C4735 VDD a_16905_13210# 3.05265f
C4736 BUFX3_41.A a_27237_14838# 0.01649f
C4737 a_13041_16182# BUFX24_2.A 0.03107f
C4738 a_28581_10806# a_31269_10806# 0.15401f
C4739 a_32281_16146# a_31589_16146# 0.0125f
C4740 OR3X1_1.B a_12957_14838# 0.05881f
C4741 BUFX3_31.A DFFQX1_6.D 0.05273f
C4742 a_19745_4050# a_19661_3728# 0.10882f
C4743 a_26145_4086# VDD 1.45223f
C4744 a_37805_4050# a_38480_4064# 0.01184f
C4745 a_18435_15045# a_18297_15244# 0.21799f
C4746 AND2X1_3.Y XOR2X1_0.A 0.08567f
C4747 a_18031_14852# a_18803_15170# 0.0313f
C4748 VDD a_3785_9104# 0.52348f
C4749 a_24549_14838# a_24617_14802# 1.99572f
C4750 a_4373_15824# a_4305_15898# 0.43806f
C4751 a_4981_15510# a_5381_15824# 0.01122f
C4752 a_36716_16160# a_35285_15824# 0.01952f
C4753 BUFX3_41.A a_30093_15898# 0.07364f
C4754 a_16485_14920# a_17459_15170# 0.05938f
C4755 BUFX3_25.Y a_16953_15244# 0.07839f
C4756 a_24049_16146# a_24297_16182# 0.05057f
C4757 OR3BX1_0.Y a_18297_15244# 0.03104f
C4758 a_14537_11792# a_14469_11866# 0.94424f
C4759 OR3X1_1.B a_8673_15488# 0.04233f
C4760 a_37973_6416# VDD 0.25876f
C4761 VDD a_18333_10806# 1.45223f
C4762 AND2X1_1.Y a_6911_15770# 0.02127f
C4763 a_12621_2742# a_12689_2706# 1.99572f
C4764 a_19661_7760# a_22349_7760# 0.01208f
C4765 BUFX3_1.Y OR3X1_0.Y 0.01157f
C4766 VDD a_34616_16160# 0.12138f
C4767 BUFX3_23.A NOR3X1_0.C 0.02219f
C4768 a_7817_7760# VDD 0.25487f
C4769 a_31437_6490# a_31269_5430# 0.11121f
C4770 a_11865_5430# a_11933_5394# 0.43806f
C4771 VDD a_30161_13136# 0.32552f
C4772 a_8421_14920# a_9027_15045# 0.0867f
C4773 VDD a_11009_15824# 0.32542f
C4774 a_33957_10806# a_34025_10770# 0.94424f
C4775 a_38745_4284# a_38913_4284# 0.09255f
C4776 BUFX3_41.A a_24717_14554# 0.02138f
C4777 a_28161_4284# VDD 0.25052f
C4778 a_9009_16380# a_9181_16146# 0.01682f
C4779 a_20837_4050# a_19661_3728# 0.30073f
C4780 a_4392_8132# a_4725_8316# 0.01772f
C4781 a_27221_13458# a_27896_13472# 0.01184f
C4782 BUFX3_41.A a_24381_15488# 0.01023f
C4783 BUFX3_1.Y OAI21X1_0.Y 0.03157f
C4784 a_36393_6774# a_37737_6774# 0.01349f
C4785 a_27473_9104# a_28161_9660# 0.01014f
C4786 a_7749_9178# a_6473_9104# 0.06964f
C4787 a_23709_14838# a_24301_14802# 0.02021f
C4788 a_3717_6490# BUFX3_0.Y 0.0125f
C4789 AND2X1_1.Y DFFQX1_0.D 0.11858f
C4790 a_19409_15824# a_20685_15488# 0.04852f
C4791 a_3717_5146# a_5145_4086# 0.27326f
C4792 a_32109_6080# VDD 0.25358f
C4793 VDD a_20349_11004# 0.25052f
C4794 VDD a_16687_14852# 0.34418f
C4795 a_7833_9462# a_7901_9426# 1.99572f
C4796 a_23777_14480# a_23709_14554# 0.43806f
C4797 a_27405_10522# a_28161_9660# 0.02812f
C4798 a_22349_7760# a_23625_7834# 0.06964f
C4799 a_5736_16196# a_6069_16380# 0.01772f
C4800 VDD a_36981_16380# 0.12898f
C4801 a_23625_13210# a_23457_12150# 0.11121f
C4802 a_3717_12150# a_3785_12114# 0.43806f
C4803 AOI21BX2_0.A OR3X1_1.C 0.04488f
C4804 a_32529_6490# a_33957_5430# 0.26941f
C4805 BUFX3_2.A a_16973_13136# 0.01225f
C4806 VDD a_14117_15824# 0.25324f
C4807 DFFQX1_3.Q a_9765_14838# 0.15529f
C4808 a_18573_14575# a_18921_14554# 0.123f
C4809 BUFX3_31.A OA21X2_0.B 0.01474f
C4810 a_7833_8118# a_10521_8118# 0.15401f
C4811 BUFX3_1.Y NAND2X1_0.A 1.53227f
C4812 a_34025_4050# VDD 0.32219f
C4813 a_12537_13692# a_11849_13136# 0.01014f
C4814 BUFX3_2.A a_21777_14920# 0.02077f
C4815 a_28581_13494# a_31269_13494# 0.15401f
C4816 a_28649_14802# a_27473_14480# 0.30073f
C4817 a_37805_6738# a_38480_6752# 0.01184f
C4818 BUFX24_2.A a_10941_15898# 0.1136f
C4819 a_9674_15474# a_9429_15488# 0.01778f
C4820 a_3045_15244# XOR2X1_0.Y 0.04251f
C4821 a_4392_5444# VDD 0.26358f
C4822 a_23625_5146# a_24297_4736# 0.01448f
C4823 a_24717_5146# a_27405_5146# 0.15401f
C4824 a_31505_5072# a_31437_5146# 0.43806f
C4825 VDD a_26213_10770# 0.32194f
C4826 VDD a_17321_15244# 0.23872f
C4827 a_10589_9426# a_11933_9426# 0.01425f
C4828 a_19089_2742# a_19157_2706# 0.43806f
C4829 a_17497_16146# BUFX3_16.A 0.1989f
C4830 DFFQX1_4.Q a_16469_16146# 0.09294f
C4831 a_24717_13210# a_23457_12150# 0.27719f
C4832 DFFQX1_5.D a_22497_14228# 0.08723f
C4833 AND2X1_1.Y a_7221_15952# 0.05123f
C4834 a_4460_12128# a_4725_12348# 0.03941f
C4835 a_14469_7834# VDD 1.46572f
C4836 a_12957_5430# a_13025_5394# 1.99572f
C4837 a_36393_14838# a_37737_14838# 0.01349f
C4838 VDD a_37905_13210# 0.72638f
C4839 a_22350_16146# OA21X2_0.B 0.15202f
C4840 a_14724_15932# a_12957_14838# 0.03593f
C4841 a_36393_10806# a_36461_10770# 0.94424f
C4842 VDD a_28245_15036# 0.15604f
C4843 VDD a_15318_15510# 1.0278f
C4844 VDD a_7241_14816# 0.19739f
C4845 a_6809_3728# a_8153_3728# 0.01425f
C4846 a_11865_8118# a_11933_8082# 0.43806f
C4847 a_31437_9178# a_31269_8118# 0.11121f
C4848 a_37805_4050# VDD 0.25809f
C4849 a_20000_14816# a_18989_14480# 0.03426f
C4850 a_19681_14802# a_19932_14852# 0.04142f
C4851 NAND2X1_0.Y a_6417_15938# 0.05129f
C4852 BUFX3_29.A a_21613_13458# 0.01877f
C4853 a_22197_15624# a_21777_14920# 0.06724f
C4854 a_33957_13494# a_34025_13458# 0.94424f
C4855 DFFQX1_3.CK NAND2X1_0.Y 0.02981f
C4856 a_38745_6972# a_38913_6972# 0.09255f
C4857 VDD a_23461_14130# 0.27487f
C4858 BUFX24_2.A a_14049_15898# 0.13904f
C4859 VDD a_4725_16380# 0.15669f
C4860 a_23693_11792# a_23625_11866# 0.43806f
C4861 a_16905_11866# a_19593_11866# 0.15401f
C4862 a_5213_5394# VDD 0.51428f
C4863 counter_value_o[0] a_1029_16182# 0.01166f
C4864 a_11781_5146# a_11865_4086# 0.11121f
C4865 NOR3X1_0.A a_22349_13136# 0.01193f
C4866 VDD a_35301_10806# 0.6927f
C4867 a_27473_14480# a_30161_14480# 0.01208f
C4868 a_3325_15532# a_3313_15779# 0.25198f
C4869 OR3X1_1.B NOR3X1_0.A 0.47273f
C4870 DFFQX1_5.Q a_24785_15824# 0.1446f
C4871 a_3717_7834# a_5145_6774# 0.27326f
C4872 a_5145_12150# a_5213_12114# 1.99572f
C4873 BUFX3_38.Y a_23209_16146# 0.03937f
C4874 a_8757_7424# VDD 0.15604f
C4875 a_22873_16146# NOR3X1_0.Y 0.06133f
C4876 a_35285_15824# a_37973_15824# 0.01208f
C4877 a_15713_5394# a_18401_5394# 0.01208f
C4878 a_37805_14802# a_38480_14816# 0.01184f
C4879 VDD a_3717_12150# 0.69675f
C4880 VDD a_34025_14802# 0.32194f
C4881 a_38412_10820# a_38480_10784# 0.15111f
C4882 a_9765_14838# a_9833_14802# 1.99572f
C4883 VDD a_9027_15045# 0.1152f
C4884 a_28649_4050# a_30161_3728# 0.22482f
C4885 a_13109_16146# a_15057_15488# 0.01014f
C4886 a_32529_9178# a_33957_8118# 0.26941f
C4887 VDD a_27237_14838# 0.72772f
C4888 BUFX3_1.Y a_18297_15244# 0.03246f
C4889 a_15713_13458# a_16973_13136# 0.27946f
C4890 reset_n_i a_1033_10134# 0.21174f
C4891 a_35973_15036# a_35285_14480# 0.01014f
C4892 VDD a_3045_15244# 0.12135f
C4893 BUFX3_12.A a_4373_15824# 0.09252f
C4894 a_23171_15532# a_23033_15572# 0.21538f
C4895 OR3X1_1.B a_19677_13494# 0.01849f
C4896 VDD a_6237_16380# 0.09973f
C4897 a_3717_11866# a_3717_10806# 0.1104f
C4898 a_27741_16182# a_27809_16146# 1.99572f
C4899 BUFX3_27.Y a_20769_13494# 0.0265f
C4900 a_15645_5430# VDD 3.1238f
C4901 counter_value_o[0] BUFX3_12.A 0.01601f
C4902 a_19512_16196# a_19845_16380# 0.01772f
C4903 VDD a_30093_15898# 1.46585f
C4904 a_11781_5146# a_12957_4086# 0.27765f
C4905 VDD a_36393_10806# 1.48411f
C4906 VDD a_18921_14554# 1.49293f
C4907 AND2X1_1.Y AND2X1_1.B 0.16771f
C4908 a_31505_14480# a_31437_14554# 0.43806f
C4909 a_31505_7760# a_31437_7834# 0.43806f
C4910 a_24717_7834# a_27405_7834# 0.15401f
C4911 DFFQX1_5.Q a_31437_15898# 0.01612f
C4912 a_1097_14802# a_2625_14852# 0.01352f
C4913 a_23625_7834# a_24297_7424# 0.01448f
C4914 a_22869_2742# a_23541_2940# 0.01448f
C4915 VDD a_22803_15536# 0.13292f
C4916 VDD BUFX3_25.Y 0.31817f
C4917 a_7901_12114# a_10589_12114# 0.01208f
C4918 a_27473_7760# VDD 0.52258f
C4919 a_37973_15824# a_38648_15846# 0.01184f
C4920 VDD a_7833_12150# 3.12641f
C4921 a_38745_15036# a_38913_15036# 0.09255f
C4922 OR3BX1_0.B BUFX3_23.A 0.06944f
C4923 VDD a_37805_14802# 0.25732f
C4924 a_20837_10770# a_22349_10448# 0.22482f
C4925 clock_i a_12356_15846# 0.03237f
C4926 a_12957_8118# a_13025_8082# 1.99572f
C4927 a_9161_3728# a_11849_3728# 0.01208f
C4928 a_4053_3802# VDD 3.16048f
C4929 AOI21BX2_0.A NOR3X1_0.Y 0.20269f
C4930 DFFQX1_6.D OR3X1_1.C 0.25536f
C4931 a_20837_13458# a_19661_13136# 0.10772f
C4932 a_36393_13494# a_36461_13458# 0.94424f
C4933 a_27557_6738# a_27473_6416# 0.10882f
C4934 a_31337_14802# a_32109_14144# 0.01014f
C4935 VDD a_27741_16182# 3.06912f
C4936 OR3X1_1.B a_20769_13494# 0.02117f
C4937 VDD a_24717_14554# 3.09128f
C4938 reset_n_i BUFX3_1.Y 0.01883f
C4939 a_24785_11792# a_24717_11866# 1.99572f
C4940 a_6405_11866# a_5145_10806# 0.26082f
C4941 a_38580_15932# a_38745_15036# 0.01103f
C4942 a_30161_11792# a_31505_11792# 0.01425f
C4943 a_30429_16182# DFFQX1_5.Q 0.01226f
C4944 BUFX3_1.Y a_16153_14838# 0.01021f
C4945 a_20181_16182# a_20856_16196# 0.01169f
C4946 VDD a_24381_15488# 0.13549f
C4947 OR3X1_1.B a_17337_15938# 0.0546f
C4948 VDD a_22231_14180# 0.34607f
C4949 VDD a_38745_11004# 0.2023f
C4950 XOR2X1_0.A DFFQX1_3.CK 1.44721f
C4951 a_23961_2742# a_26649_2742# 0.15401f
C4952 a_11781_7834# a_11865_6774# 0.11121f
C4953 DFFQX1_5.Q a_32529_15898# 0.01748f
C4954 VDD a_23033_15572# 0.24706f
C4955 a_15981_15036# a_16153_14838# 0.02089f
C4956 VDD a_20181_16182# 0.71958f
C4957 a_38648_15846# a_38580_15932# 0.15111f
C4958 a_31437_7834# VDD 0.69838f
C4959 a_26145_5430# a_27489_5430# 0.01349f
C4960 a_1033_10134# a_1433_10448# 0.0112f
C4961 a_15881_3728# VDD 0.20824f
C4962 a_15713_8082# a_18401_8082# 0.01208f
C4963 a_14537_3728# a_14469_3802# 0.94424f
C4964 a_35973_4284# a_35285_3728# 0.01014f
C4965 DFFQX1_4.Q BUFX3_3.A 0.16115f
C4966 OR3BX1_0.B BUFX3_29.A 0.18618f
C4967 a_15713_13458# a_16485_12800# 0.01014f
C4968 BUFX3_26.Y DFFQX1_3.CK 0.01264f
C4969 a_22197_13608# a_22349_13136# 0.01261f
C4970 a_38412_13508# a_38480_13472# 0.15111f
C4971 BUFX3_1.Y a_19932_14852# 0.0105f
C4972 DFFQX1_5.CK a_17833_15510# 0.01879f
C4973 a_7901_6738# a_7833_5430# 0.02042f
C4974 a_28649_6738# a_27473_6416# 0.30073f
C4975 VDD a_32281_16146# 0.28027f
C4976 VDD a_37973_14480# 0.25876f
C4977 OR3X1_1.B a_22197_13608# 0.0489f
C4978 clock_i a_3785_16146# 0.0266f
C4979 a_23525_5394# VDD 0.52435f
C4980 a_38580_5180# a_38913_4736# 0.01772f
C4981 VDD a_6809_10448# 0.32533f
C4982 a_20769_9462# a_23457_9462# 0.15401f
C4983 a_31505_14480# a_32109_14144# 0.04852f
C4984 BUFX3_2.A a_18573_14575# 0.01089f
C4985 a_26717_2706# a_27321_2940# 0.04852f
C4986 a_11781_7834# a_12957_6774# 0.27765f
C4987 VDD a_17816_14502# 0.09711f
C4988 a_18333_12150# a_19677_12150# 0.01349f
C4989 a_35217_13210# a_35973_12348# 0.02812f
C4990 OR3X1_1.B OR3X1_1.Y 0.46198f
C4991 a_35217_7834# VDD 3.14104f
C4992 a_27489_5430# a_28161_5628# 0.01448f
C4993 a_19409_15824# a_19341_15898# 0.94424f
C4994 VDD a_15713_12114# 0.52435f
C4995 a_4121_10448# a_4053_10522# 1.99572f
C4996 a_28161_11004# a_27473_10448# 0.01014f
C4997 VDD a_6405_14554# 1.46323f
C4998 VDD a_15648_14852# 0.28192f
C4999 a_19661_3728# VDD 0.53123f
C5000 DFFQX1_5.CK a_22399_15524# 0.01851f
C5001 OA21X2_1.Y NOR3X1_0.Y 0.39597f
C5002 BUFX3_1.Y a_1433_10448# 0.16619f
C5003 a_6405_9178# VDD 1.46323f
C5004 NAND2X1_0.A BUFX3_0.Y 0.43314f
C5005 VDD a_37905_14554# 0.72638f
C5006 clock_i a_5736_16196# 0.01479f
C5007 enable_i BUFX3_0.Y 0.01929f
C5008 DFFQX1_7.Q BUFX3_41.A 0.42934f
C5009 VDD a_9674_15474# 1.05041f
C5010 a_1029_4086# a_1097_4050# 1.99572f
C5011 a_22281_5146# a_20769_4086# 0.25266f
C5012 a_1097_16146# a_2444_16160# 0.01184f
C5013 a_33957_5430# VDD 1.45226f
C5014 VDD a_9161_10448# 0.51524f
C5015 a_3785_9426# a_3785_9104# 0.10935f
C5016 a_37973_14480# a_38580_14588# 0.04779f
C5017 a_26145_9462# a_26213_9426# 0.94424f
C5018 BUFX3_1.Y a_1029_14554# 0.09294f
C5019 BUFX3_1.Y a_12957_14838# 0.15365f
C5020 a_1097_16146# a_1097_15824# 0.27732f
C5021 NOR3X1_0.A a_23709_14838# 0.21912f
C5022 a_19677_12150# a_20349_12348# 0.01448f
C5023 a_7901_5394# a_7817_5072# 0.08769f
C5024 a_27405_6490# a_27473_5072# 0.01868f
C5025 a_2373_15036# a_2541_15036# 0.09255f
C5026 a_1029_6774# VDD 3.08535f
C5027 a_5985_15488# a_5145_14838# 0.02812f
C5028 VDD a_26145_12150# 1.45223f
C5029 a_12453_15036# a_11849_14480# 0.01014f
C5030 a_6741_10522# a_8085_10522# 0.01349f
C5031 VDD a_14537_14480# 0.32498f
C5032 BUFX3_3.A a_17459_15170# 0.04204f
C5033 DFFQX1_5.CK NOR3X1_0.C 0.20734f
C5034 a_23625_3802# VDD 0.74696f
C5035 a_26145_8118# a_27489_8118# 0.01349f
C5036 BUFX3_1.Y a_2541_15036# 0.05629f
C5037 AOI21BX2_0.A BUFX3_23.A 0.03854f
C5038 a_1097_13136# a_3785_13136# 0.01208f
C5039 a_11849_6416# a_11781_6490# 1.99572f
C5040 BUFX3_26.Y a_6803_15792# 0.0412f
C5041 a_14537_9104# VDD 0.3248f
C5042 VDD a_3717_13494# 0.69675f
C5043 AND2X1_3.Y a_3385_16182# 0.20986f
C5044 a_1097_5394# BUFX3_0.Y 0.09053f
C5045 a_35285_11792# a_35217_11866# 1.99572f
C5046 a_14469_11866# a_12957_10806# 0.25266f
C5047 counter_value_o[7] VSS 1.83123f
C5048 counter_value_o[6] VSS 1.79082f
C5049 counter_value_o[5] VSS 1.72179f
C5050 counter_value_o[4] VSS 2.12649f
C5051 counter_value_o[3] VSS 1.57142f
C5052 counter_value_o[2] VSS 1.66569f
C5053 counter_value_o[1] VSS 1.47898f
C5054 counter_value_o[0] VSS 1.59068f
C5055 VDD VSS 1.56612f
C5056 a_34881_2709# VSS 0.04175f ; **FLOATING
C5057 a_38664_2756# VSS 0.19925f
C5058 a_34881_2940# VSS 0.0604f ; **FLOATING
C5059 a_31101_2709# VSS 0.04084f ; **FLOATING
C5060 a_31101_2940# VSS 0.05857f ; **FLOATING
C5061 a_27321_2709# VSS 0.04084f ; **FLOATING
C5062 a_27321_2940# VSS 0.06196f ; **FLOATING
C5063 a_23541_2709# VSS 0.05839f ; **FLOATING
C5064 a_24029_2706# VSS 0.03743f
C5065 a_23541_2940# VSS 0.09343f ; **FLOATING
C5066 a_19761_2709# VSS 0.04084f ; **FLOATING
C5067 a_19761_2940# VSS 0.05857f ; **FLOATING
C5068 a_15981_2709# VSS 0.04084f ; **FLOATING
C5069 a_15981_2940# VSS 0.05857f ; **FLOATING
C5070 a_12201_2709# VSS 0.04084f ; **FLOATING
C5071 a_12201_2940# VSS 0.05861f ; **FLOATING
C5072 a_8421_2709# VSS 0.04084f ; **FLOATING
C5073 a_8421_2940# VSS 0.05857f ; **FLOATING
C5074 a_4725_2709# VSS 0.01476f ; **FLOATING
C5075 a_4725_2940# VSS 0.02864f ; **FLOATING
C5076 a_4392_2756# VSS 0.16733f
C5077 a_38913_3392# VSS 0.08269f ; **FLOATING
C5078 a_38913_3802# VSS 0.01047f ; **FLOATING
C5079 a_32109_3392# VSS 0.05127f ; **FLOATING
C5080 a_38648_3750# VSS 0.1414f
C5081 a_24297_3392# VSS 0.05452f ; **FLOATING
C5082 a_32109_3802# VSS 0.04084f ; **FLOATING
C5083 a_16485_3392# VSS 0.05123f ; **FLOATING
C5084 a_24297_3802# VSS 0.04246f ; **FLOATING
C5085 a_8757_3392# VSS 0.0269f ; **FLOATING
C5086 a_16485_3802# VSS 0.04084f ; **FLOATING
C5087 a_8757_3802# VSS 0.01537f ; **FLOATING
C5088 a_38745_4053# VSS 0.02887f ; **FLOATING
C5089 a_38913_4284# VSS 0.078f ; **FLOATING
C5090 a_38745_4284# VSS 0.04967f ; **FLOATING
C5091 a_35973_4053# VSS 0.04084f ; **FLOATING
C5092 a_38412_4100# VSS 0.17902f
C5093 a_35973_4284# VSS 0.05123f ; **FLOATING
C5094 a_28161_4053# VSS 0.04084f ; **FLOATING
C5095 a_28161_4284# VSS 0.05123f ; **FLOATING
C5096 a_20349_4053# VSS 0.04084f ; **FLOATING
C5097 a_20349_4284# VSS 0.05123f ; **FLOATING
C5098 a_12537_4053# VSS 0.04084f ; **FLOATING
C5099 a_12537_4284# VSS 0.05129f ; **FLOATING
C5100 a_4725_4053# VSS 0.03934f ; **FLOATING
C5101 a_4725_4284# VSS 0.05355f ; **FLOATING
C5102 a_4392_4100# VSS 0.15301f
C5103 a_38913_4736# VSS 0.08092f ; **FLOATING
C5104 a_38913_5146# VSS 0.01047f ; **FLOATING
C5105 a_32109_4736# VSS 0.05127f ; **FLOATING
C5106 a_38648_5094# VSS 0.14078f
C5107 a_24297_4736# VSS 0.05452f ; **FLOATING
C5108 a_32109_5146# VSS 0.04084f ; **FLOATING
C5109 a_16485_4736# VSS 0.05123f ; **FLOATING
C5110 a_24297_5146# VSS 0.04246f ; **FLOATING
C5111 a_8757_4736# VSS 0.02544f ; **FLOATING
C5112 a_16485_5146# VSS 0.04084f ; **FLOATING
C5113 a_8757_5146# VSS 0.01439f ; **FLOATING
C5114 a_8492_5094# VSS 0.12243f
C5115 a_38745_5397# VSS 0.02887f ; **FLOATING
C5116 a_38913_5628# VSS 0.078f ; **FLOATING
C5117 a_38745_5628# VSS 0.04967f ; **FLOATING
C5118 a_35973_5397# VSS 0.04084f ; **FLOATING
C5119 a_38412_5444# VSS 0.17842f
C5120 a_35973_5628# VSS 0.05123f ; **FLOATING
C5121 a_28161_5397# VSS 0.04084f ; **FLOATING
C5122 a_28161_5628# VSS 0.05123f ; **FLOATING
C5123 a_20349_5397# VSS 0.04084f ; **FLOATING
C5124 a_20349_5628# VSS 0.05123f ; **FLOATING
C5125 a_12537_5397# VSS 0.04084f ; **FLOATING
C5126 a_12537_5628# VSS 0.05129f ; **FLOATING
C5127 a_4725_5397# VSS 0.03934f ; **FLOATING
C5128 a_4725_5628# VSS 0.05355f ; **FLOATING
C5129 a_4392_5444# VSS 0.15301f
C5130 a_38913_6080# VSS 0.08092f ; **FLOATING
C5131 a_38913_6490# VSS 0.01047f ; **FLOATING
C5132 a_32109_6080# VSS 0.05127f ; **FLOATING
C5133 a_38648_6438# VSS 0.14078f
C5134 a_24297_6080# VSS 0.05452f ; **FLOATING
C5135 a_32109_6490# VSS 0.04084f ; **FLOATING
C5136 a_16485_6080# VSS 0.05123f ; **FLOATING
C5137 a_24297_6490# VSS 0.04246f ; **FLOATING
C5138 a_16905_6490# VSS 0.33044f
C5139 a_8757_6080# VSS 0.02544f ; **FLOATING
C5140 a_16485_6490# VSS 0.04084f ; **FLOATING
C5141 a_8757_6490# VSS 0.01439f ; **FLOATING
C5142 a_8492_6438# VSS 0.12243f
C5143 a_7817_6416# VSS 0.09125f
C5144 a_38745_6741# VSS 0.02887f ; **FLOATING
C5145 a_38913_6972# VSS 0.078f ; **FLOATING
C5146 a_38745_6972# VSS 0.04967f ; **FLOATING
C5147 a_35973_6741# VSS 0.04084f ; **FLOATING
C5148 a_38412_6788# VSS 0.17842f
C5149 a_35973_6972# VSS 0.05123f ; **FLOATING
C5150 a_28161_6741# VSS 0.04084f ; **FLOATING
C5151 a_28161_6972# VSS 0.05123f ; **FLOATING
C5152 a_20349_6741# VSS 0.04084f ; **FLOATING
C5153 a_20349_6972# VSS 0.05123f ; **FLOATING
C5154 a_12537_6741# VSS 0.04084f ; **FLOATING
C5155 a_12537_6972# VSS 0.05129f ; **FLOATING
C5156 a_4725_6741# VSS 0.03934f ; **FLOATING
C5157 a_4725_6972# VSS 0.05355f ; **FLOATING
C5158 a_4392_6788# VSS 0.15301f
C5159 a_38913_7424# VSS 0.08092f ; **FLOATING
C5160 a_38913_7834# VSS 0.01047f ; **FLOATING
C5161 a_32109_7424# VSS 0.05127f ; **FLOATING
C5162 a_38580_7868# VSS 0.18512f
C5163 a_24297_7424# VSS 0.05452f ; **FLOATING
C5164 a_32109_7834# VSS 0.04084f ; **FLOATING
C5165 a_30093_7834# VSS 0.64836f
C5166 a_16485_7424# VSS 0.05123f ; **FLOATING
C5167 a_27473_7760# VSS 0.0299f
C5168 a_24297_7834# VSS 0.04246f ; **FLOATING
C5169 a_8757_7424# VSS 0.02544f ; **FLOATING
C5170 a_16485_7834# VSS 0.04084f ; **FLOATING
C5171 a_8757_7834# VSS 0.01439f ; **FLOATING
C5172 a_8424_7868# VSS 0.15083f
C5173 a_7817_7760# VSS 0.09125f
C5174 a_38745_8085# VSS 0.02887f ; **FLOATING
C5175 a_38913_8316# VSS 0.078f ; **FLOATING
C5176 a_38745_8316# VSS 0.04967f ; **FLOATING
C5177 a_35973_8085# VSS 0.04084f ; **FLOATING
C5178 a_38412_8132# VSS 0.17842f
C5179 a_35973_8316# VSS 0.05123f ; **FLOATING
C5180 a_28161_8085# VSS 0.04084f ; **FLOATING
C5181 a_28161_8316# VSS 0.05123f ; **FLOATING
C5182 a_20349_8085# VSS 0.04084f ; **FLOATING
C5183 a_20349_8316# VSS 0.05123f ; **FLOATING
C5184 a_12537_8085# VSS 0.04084f ; **FLOATING
C5185 a_12537_8316# VSS 0.05129f ; **FLOATING
C5186 a_4725_8085# VSS 0.03934f ; **FLOATING
C5187 a_4725_8316# VSS 0.05355f ; **FLOATING
C5188 a_4392_8132# VSS 0.15301f
C5189 a_38913_8768# VSS 0.08092f ; **FLOATING
C5190 a_38913_9178# VSS 0.01047f ; **FLOATING
C5191 a_32109_8768# VSS 0.05127f ; **FLOATING
C5192 a_38648_9126# VSS 0.14078f
C5193 a_24297_8768# VSS 0.05452f ; **FLOATING
C5194 a_32109_9178# VSS 0.04084f ; **FLOATING
C5195 a_24717_9178# VSS 0.33095f
C5196 a_16485_8768# VSS 0.05123f ; **FLOATING
C5197 a_24297_9178# VSS 0.04246f ; **FLOATING
C5198 a_8757_8768# VSS 0.02544f ; **FLOATING
C5199 a_16485_9178# VSS 0.04084f ; **FLOATING
C5200 a_8757_9178# VSS 0.01439f ; **FLOATING
C5201 a_8492_9126# VSS 0.12243f
C5202 a_38745_9429# VSS 0.02887f ; **FLOATING
C5203 a_38913_9660# VSS 0.078f ; **FLOATING
C5204 a_38745_9660# VSS 0.04967f ; **FLOATING
C5205 a_35973_9429# VSS 0.04084f ; **FLOATING
C5206 a_38480_9440# VSS 0.13762f
C5207 a_35973_9660# VSS 0.05123f ; **FLOATING
C5208 a_28161_9429# VSS 0.04084f ; **FLOATING
C5209 a_28161_9660# VSS 0.05123f ; **FLOATING
C5210 a_20349_9429# VSS 0.04084f ; **FLOATING
C5211 a_20349_9660# VSS 0.05123f ; **FLOATING
C5212 a_12537_9429# VSS 0.04084f ; **FLOATING
C5213 a_12537_9660# VSS 0.05129f ; **FLOATING
C5214 a_4725_9429# VSS 0.03934f ; **FLOATING
C5215 a_4725_9660# VSS 0.05355f ; **FLOATING
C5216 a_4392_9476# VSS 0.15301f
C5217 a_38913_10112# VSS 0.08092f ; **FLOATING
C5218 a_38913_10522# VSS 0.01047f ; **FLOATING
C5219 a_32109_10112# VSS 0.05127f ; **FLOATING
C5220 a_38648_10470# VSS 0.14078f
C5221 a_24297_10112# VSS 0.05452f ; **FLOATING
C5222 a_37973_10448# VSS 0.15953f
C5223 a_35285_10448# VSS 0.80059f
C5224 a_32109_10522# VSS 0.04084f ; **FLOATING
C5225 a_31437_10522# VSS 0.04535f
C5226 a_16485_10112# VSS 0.05123f ; **FLOATING
C5227 a_24785_10448# VSS 0.69634f
C5228 a_24297_10522# VSS 0.04246f ; **FLOATING
C5229 a_22281_10522# VSS 0.6941f
C5230 a_8757_10112# VSS 0.02524f ; **FLOATING
C5231 a_16485_10522# VSS 0.04084f ; **FLOATING
C5232 a_15813_10522# VSS 0.30793f
C5233 a_14537_10448# VSS 0.38911f
C5234 a_8757_10522# VSS 0.01537f ; **FLOATING
C5235 a_8153_10448# VSS 0.24482f
C5236 a_6809_10448# VSS 0.38616f
C5237 a_1033_10134# VSS 0.30276f
C5238 a_38745_10773# VSS 0.02887f ; **FLOATING
C5239 a_38913_11004# VSS 0.078f ; **FLOATING
C5240 a_38745_11004# VSS 0.04967f ; **FLOATING
C5241 a_35973_10773# VSS 0.04084f ; **FLOATING
C5242 a_38412_10820# VSS 0.17842f
C5243 a_35973_11004# VSS 0.05123f ; **FLOATING
C5244 a_28161_10773# VSS 0.04084f ; **FLOATING
C5245 a_35369_10770# VSS 0.24534f
C5246 a_33957_10806# VSS 0.03399f
C5247 a_28161_11004# VSS 0.05123f ; **FLOATING
C5248 a_20349_10773# VSS 0.04084f ; **FLOATING
C5249 a_20349_11004# VSS 0.05123f ; **FLOATING
C5250 a_12537_10773# VSS 0.04084f ; **FLOATING
C5251 a_12537_11004# VSS 0.05129f ; **FLOATING
C5252 a_4725_10773# VSS 0.03934f ; **FLOATING
C5253 a_4725_11004# VSS 0.05355f ; **FLOATING
C5254 a_4460_10784# VSS 0.12477f
C5255 a_38913_11456# VSS 0.08092f ; **FLOATING
C5256 a_38913_11866# VSS 0.01047f ; **FLOATING
C5257 a_32109_11456# VSS 0.05127f ; **FLOATING
C5258 a_38580_11900# VSS 0.18512f
C5259 a_24297_11456# VSS 0.05452f ; **FLOATING
C5260 a_37973_11792# VSS 0.15953f
C5261 a_35285_11792# VSS 0.67871f
C5262 a_32109_11866# VSS 0.04084f ; **FLOATING
C5263 a_24717_11866# VSS 0.06888f
C5264 a_16485_11456# VSS 0.05123f ; **FLOATING
C5265 a_31505_11792# VSS 0.24468f
C5266 a_24297_11866# VSS 0.04246f ; **FLOATING
C5267 a_22281_11866# VSS 0.03169f
C5268 a_8757_11456# VSS 0.02544f ; **FLOATING
C5269 a_16485_11866# VSS 0.04084f ; **FLOATING
C5270 a_14537_11792# VSS 0.38911f
C5271 a_8757_11866# VSS 0.01439f ; **FLOATING
C5272 a_8424_11900# VSS 0.15083f
C5273 a_3785_11792# VSS 0.72113f
C5274 a_38745_12117# VSS 0.02887f ; **FLOATING
C5275 a_38913_12348# VSS 0.078f ; **FLOATING
C5276 a_38745_12348# VSS 0.04967f ; **FLOATING
C5277 a_35973_12117# VSS 0.04084f ; **FLOATING
C5278 a_38480_12128# VSS 0.13762f
C5279 a_35973_12348# VSS 0.05123f ; **FLOATING
C5280 a_28161_12117# VSS 0.04084f ; **FLOATING
C5281 a_28161_12348# VSS 0.05123f ; **FLOATING
C5282 a_20349_12117# VSS 0.04084f ; **FLOATING
C5283 a_20349_12348# VSS 0.05123f ; **FLOATING
C5284 a_12537_12117# VSS 0.04084f ; **FLOATING
C5285 a_12537_12348# VSS 0.05129f ; **FLOATING
C5286 a_4725_12117# VSS 0.03934f ; **FLOATING
C5287 a_4725_12348# VSS 0.05355f ; **FLOATING
C5288 a_4460_12128# VSS 0.12477f
C5289 a_38913_12800# VSS 0.08092f ; **FLOATING
C5290 a_38913_13210# VSS 0.01047f ; **FLOATING
C5291 a_32109_12800# VSS 0.05127f ; **FLOATING
C5292 a_38648_13158# VSS 0.14078f
C5293 a_37905_13210# VSS 0.0292f
C5294 a_35217_13210# VSS 1.41836f
C5295 a_24297_12800# VSS 0.05502f ; **FLOATING
C5296 a_32109_13210# VSS 0.04084f ; **FLOATING
C5297 a_30093_13210# VSS 0.64836f
C5298 a_27405_13210# VSS 0.34106f
C5299 a_24717_13210# VSS 0.4036f
C5300 a_16485_12800# VSS 0.05123f ; **FLOATING
C5301 a_24297_13210# VSS 0.04246f ; **FLOATING
C5302 a_8757_12800# VSS 0.02544f ; **FLOATING
C5303 a_22349_13136# VSS 0.41112f
C5304 a_16485_13210# VSS 0.04084f ; **FLOATING
C5305 a_14469_13210# VSS 0.68355f
C5306 a_8757_13210# VSS 0.01439f ; **FLOATING
C5307 a_8492_13158# VSS 0.12243f
C5308 a_3717_13210# VSS 0.06691f
C5309 a_38745_13461# VSS 0.02887f ; **FLOATING
C5310 a_38913_13692# VSS 0.078f ; **FLOATING
C5311 a_38745_13692# VSS 0.04967f ; **FLOATING
C5312 a_35973_13461# VSS 0.04084f ; **FLOATING
C5313 a_38480_13472# VSS 0.13762f
C5314 a_35973_13692# VSS 0.05123f ; **FLOATING
C5315 a_28161_13461# VSS 0.03828f ; **FLOATING
C5316 a_28161_13692# VSS 0.05143f ; **FLOATING
C5317 a_27828_13508# VSS 0.15048f
C5318 a_22377_13948# VSS 1.17624f
C5319 a_22291_13948# VSS 1.38295f
C5320 a_22197_13608# VSS 0.31112f
C5321 a_21441_13461# VSS 0.01199f ; **FLOATING
C5322 a_20349_13461# VSS 0.04084f ; **FLOATING
C5323 a_21865_13494# VSS 0.20443f
C5324 a_21441_13692# VSS 0.02219f ; **FLOATING
C5325 a_20349_13692# VSS 0.05087f ; **FLOATING
C5326 a_12537_13461# VSS 0.04084f ; **FLOATING
C5327 a_12537_13692# VSS 0.05129f ; **FLOATING
C5328 a_4725_13461# VSS 0.03934f ; **FLOATING
C5329 a_4725_13692# VSS 0.05355f ; **FLOATING
C5330 a_4392_13508# VSS 0.15301f
C5331 a_38913_14144# VSS 0.08092f ; **FLOATING
C5332 a_38913_14554# VSS 0.01047f ; **FLOATING
C5333 a_32109_14144# VSS 0.05127f ; **FLOATING
C5334 a_38580_14588# VSS 0.18512f
C5335 a_35217_14554# VSS 0.06094f
C5336 a_24381_14144# VSS 0.02676f ; **FLOATING
C5337 a_22967_14228# VSS 0.0569f
C5338 a_22599_14228# VSS 0.02141f
C5339 a_22435_14228# VSS 0.08574f
C5340 a_37973_14480# VSS 0.21794f
C5341 a_32109_14554# VSS 0.04084f ; **FLOATING
C5342 a_24717_14554# VSS 0.07f
C5343 a_31505_14480# VSS 0.15398f
C5344 a_24381_14554# VSS 0.01589f ; **FLOATING
C5345 a_23709_14554# VSS 0.03291f
C5346 a_21705_14180# VSS 0.12329f
C5347 a_22979_14608# VSS 0.02877f
C5348 a_22865_14228# VSS 0.0569f
C5349 a_22611_14608# VSS 0.43519f
C5350 a_22447_14608# VSS 0.13674f
C5351 a_21105_14144# VSS 0.02175f ; **FLOATING
C5352 a_20937_14144# VSS 0.0485f ; **FLOATING
C5353 a_20937_14554# VSS 0.03201f ; **FLOATING
C5354 a_18534_14670# VSS 0.18957f
C5355 a_17748_14588# VSS 0.1412f
C5356 a_20333_14480# VSS 0.1686f
C5357 a_18989_14480# VSS 0.34507f
C5358 a_16905_14144# VSS 0.02444f ; **FLOATING
C5359 a_16485_14144# VSS 0.05399f ; **FLOATING
C5360 a_17197_14656# VSS 0.15321f
C5361 a_17069_14144# VSS 0.02395f
C5362 a_16905_14554# VSS 0.0104f ; **FLOATING
C5363 a_8757_14144# VSS 0.02544f ; **FLOATING
C5364 a_16485_14554# VSS 0.04084f ; **FLOATING
C5365 a_14469_14554# VSS 0.68414f
C5366 a_8757_14554# VSS 0.01439f ; **FLOATING
C5367 a_8492_14502# VSS 0.12704f
C5368 a_3717_14554# VSS 0.41148f
C5369 a_38745_14805# VSS 0.02887f ; **FLOATING
C5370 a_38913_15036# VSS 0.078f ; **FLOATING
C5371 a_38745_15036# VSS 0.04967f ; **FLOATING
C5372 a_35973_14805# VSS 0.04084f ; **FLOATING
C5373 a_38412_14852# VSS 0.17838f
C5374 a_35973_15036# VSS 0.05123f ; **FLOATING
C5375 a_28245_14805# VSS 0.01439f ; **FLOATING
C5376 a_35369_14802# VSS 0.24534f
C5377 a_34025_14802# VSS 0.39421f
C5378 a_28245_15036# VSS 0.02544f ; **FLOATING
C5379 a_27912_14852# VSS 0.15083f
C5380 a_23803_14838# VSS 0.24502f
C5381 a_22727_14900# VSS 0.0584f
C5382 a_22359_14900# VSS 0.12679f
C5383 a_22195_14900# VSS 0.0938f
C5384 BUFX3_28.A VSS 0.26179f
C5385 a_23323_15175# VSS 0.58669f
C5386 a_20775_14852# VSS 0.58511f
C5387 NOR3X1_0.A VSS 0.13287f
C5388 a_22183_15244# VSS 0.36478f
C5389 a_22383_15045# VSS 0.10336f
C5390 a_21391_15175# VSS 0.49225f
C5391 a_20433_14805# VSS 0.0116f ; **FLOATING
C5392 a_20265_14805# VSS 0.03478f ; **FLOATING
C5393 a_21189_14906# VSS 0.11508f
C5394 a_20869_15292# VSS 0.14527f
C5395 a_20433_15036# VSS 0.02216f ; **FLOATING
C5396 a_20265_15036# VSS 0.0496f ; **FLOATING
C5397 a_19179_14852# VSS 0.35895f
C5398 a_19932_14852# VSS 0.13657f
C5399 a_18779_14900# VSS 0.17525f
C5400 a_18411_14900# VSS 0.35506f
C5401 a_18247_14900# VSS 0.12381f
C5402 a_17435_14900# VSS 0.02839f
C5403 a_16903_14900# VSS 0.10615f
C5404 a_18399_15244# VSS 0.6317f
C5405 a_18235_15244# VSS 0.06495f
C5406 a_18435_15045# VSS 0.54968f
C5407 a_15981_14805# VSS 0.03028f ; **FLOATING
C5408 a_17055_15244# VSS 0.09192f
C5409 a_16891_15244# VSS 0.45384f
C5410 a_16953_15244# VSS 0.1033f
C5411 a_16153_14838# VSS 0.08087f
C5412 a_15981_15036# VSS 0.04749f ; **FLOATING
C5413 a_12621_14805# VSS 0.01003f ; **FLOATING
C5414 a_12453_14805# VSS 0.02501f ; **FLOATING
C5415 a_15648_14852# VSS 0.14355f
C5416 a_12621_15036# VSS 0.02259f ; **FLOATING
C5417 a_12453_15036# VSS 0.04755f ; **FLOATING
C5418 a_9371_14900# VSS 0.05696f
C5419 a_9003_14900# VSS 0.12466f
C5420 a_8839_14900# VSS 0.10375f
C5421 a_8095_14852# VSS 0.27009f
C5422 a_7777_14852# VSS 0.06244f
C5423 a_7675_14852# VSS 0.06363f
C5424 a_7369_14852# VSS 0.14961f
C5425 a_6949_14852# VSS 0.15013f
C5426 a_8991_15244# VSS 0.02852f
C5427 a_8827_15244# VSS 0.29502f
C5428 a_4809_14805# VSS 0.0123f ; **FLOATING
C5429 a_4641_14805# VSS 0.03827f ; **FLOATING
C5430 a_3451_14838# VSS 0.07533f
C5431 a_8001_14852# VSS 0.07631f
C5432 a_6493_14838# VSS 0.55499f
C5433 a_4809_15036# VSS 0.02313f ; **FLOATING
C5434 a_4641_15036# VSS 0.04738f ; **FLOATING
C5435 a_4037_14802# VSS 0.22267f
C5436 a_2719_14852# VSS 0.11495f
C5437 a_3309_15244# VSS 0.15737f
C5438 a_3139_15244# VSS 0.06065f
C5439 a_2373_14805# VSS 0.03208f ; **FLOATING
C5440 XOR2X1_0.Y VSS 0.07196f
C5441 a_2625_14852# VSS 0.08649f
C5442 a_2541_15036# VSS 0.01933f ; **FLOATING
C5443 a_2373_15036# VSS 0.04624f ; **FLOATING
C5444 a_38913_15488# VSS 0.08092f ; **FLOATING
C5445 a_38913_15898# VSS 0.01047f ; **FLOATING
C5446 a_32109_15488# VSS 0.05747f ; **FLOATING
C5447 a_38648_15846# VSS 0.14167f
C5448 a_24381_15488# VSS 0.02511f ; **FLOATING
C5449 a_24213_15488# VSS 0.05389f ; **FLOATING
C5450 a_37973_15824# VSS 0.21153f
C5451 a_32109_15898# VSS 0.04084f ; **FLOATING
C5452 a_31437_15898# VSS 0.36313f
C5453 a_24381_15898# VSS 0.01052f ; **FLOATING
C5454 a_24213_15898# VSS 0.02604f ; **FLOATING
C5455 a_23135_15572# VSS 0.29201f
C5456 a_22767_15572# VSS 0.26464f
C5457 a_22603_15572# VSS 0.12381f
C5458 a_21289_15524# VSS 0.18443f
C5459 a_23147_15952# VSS 0.07552f
C5460 a_21742_15932# VSS 0.01273f
C5461 a_20685_15488# VSS 0.05261f ; **FLOATING
C5462 a_18343_15660# VSS 0.09276f
C5463 a_21195_16000# VSS 0.39665f
C5464 a_20685_15898# VSS 0.03284f ; **FLOATING
C5465 a_17661_15488# VSS 0.05186f ; **FLOATING
C5466 a_18463_16014# VSS 0.34312f
C5467 OR3BX1_0.Y VSS 0.05408f
C5468 a_17661_15898# VSS 0.01963f ; **FLOATING
C5469 a_16905_15488# VSS 0.05403f ; **FLOATING
C5470 a_17337_15938# VSS 0.2527f
C5471 a_16905_15898# VSS 0.03035f ; **FLOATING
C5472 a_15225_15488# VSS 0.0191f ; **FLOATING
C5473 a_15057_15488# VSS 0.0469f ; **FLOATING
C5474 a_15057_15898# VSS 0.03058f ; **FLOATING
C5475 a_14792_15846# VSS 0.12175f
C5476 a_12621_15488# VSS 0.02278f ; **FLOATING
C5477 a_14049_15898# VSS 0.34792f
C5478 a_12621_15898# VSS 0.01108f ; **FLOATING
C5479 a_12356_15846# VSS 0.12689f
C5480 a_9429_15488# VSS 0.05138f ; **FLOATING
C5481 a_10941_15898# VSS 0.67885f
C5482 a_9429_15898# VSS 0.02043f ; **FLOATING
C5483 a_8673_15488# VSS 0.05759f ; **FLOATING
C5484 a_7601_15572# VSS 0.09747f
C5485 a_7437_15572# VSS 0.27881f
C5486 a_7069_15572# VSS 0.29481f
C5487 DFFQX1_3.D VSS 0.13903f
C5488 a_9181_15474# VSS 0.07918f
C5489 a_8673_15898# VSS 0.02742f ; **FLOATING
C5490 a_8218_15932# VSS 0.06193f
C5491 a_6559_15572# VSS 0.24428f
C5492 a_7589_15952# VSS 0.69927f
C5493 a_7057_15952# VSS 0.2525f
C5494 a_5985_15488# VSS 0.05267f ; **FLOATING
C5495 a_3821_15572# VSS 0.28213f
C5496 a_3657_15572# VSS 0.28032f
C5497 a_3289_15572# VSS 0.24229f
C5498 a_6417_15938# VSS 1.2435f
C5499 a_5985_15898# VSS 0.03483f ; **FLOATING
C5500 a_4373_15824# VSS 0.16984f
C5501 a_3809_15952# VSS 0.03608f
C5502 a_2541_15488# VSS 0.01862f ; **FLOATING
C5503 a_2373_15488# VSS 0.04883f ; **FLOATING
C5504 a_3517_15682# VSS 0.31485f
C5505 a_2373_15898# VSS 0.03234f ; **FLOATING
C5506 a_38745_16149# VSS 0.03143f ; **FLOATING
C5507 a_38913_16380# VSS 0.08432f ; **FLOATING
C5508 a_38745_16380# VSS 0.06678f ; **FLOATING
C5509 a_36981_16149# VSS 0.011f ; **FLOATING
C5510 a_36981_16380# VSS 0.02904f ; **FLOATING
C5511 a_34881_16149# VSS 0.03919f ; **FLOATING
C5512 a_36648_16196# VSS 0.15287f
C5513 a_34881_16380# VSS 0.07224f ; **FLOATING
C5514 a_31101_16149# VSS 0.04084f ; **FLOATING
C5515 a_34548_16196# VSS 0.159f
C5516 a_31101_16380# VSS 0.06981f ; **FLOATING
C5517 a_26985_16149# VSS 0.02051f ; **FLOATING
C5518 a_26985_16380# VSS 0.0661f ; **FLOATING
C5519 a_23625_16149# VSS 0.01537f ; **FLOATING
C5520 a_23457_16149# VSS 0.03262f ; **FLOATING
C5521 a_24049_16146# VSS 0.06377f
C5522 a_23625_16380# VSS 0.03831f ; **FLOATING
C5523 a_23457_16380# VSS 0.08216f ; **FLOATING
C5524 a_22484_16182# VSS 0.1828f
C5525 a_22057_16196# VSS 0.37344f
C5526 a_22613_16650# VSS 0.30808f
C5527 a_19845_16149# VSS 0.01439f ; **FLOATING
C5528 a_23209_16146# VSS 0.38504f
C5529 AOI21BX2_0.A VSS 0.25585f
C5530 DFFQX1_6.D VSS 0.11094f
C5531 a_21193_16182# VSS 0.34289f
C5532 a_20856_16196# VSS 0.15889f
C5533 a_19845_16380# VSS 0.03121f ; **FLOATING
C5534 a_18333_16149# VSS 0.02022f ; **FLOATING
C5535 a_19580_16160# VSS 0.13429f
C5536 AOI21BX1_0.Y VSS 0.09077f
C5537 a_18589_16146# VSS 0.10758f
C5538 a_18333_16380# VSS 0.06995f ; **FLOATING
C5539 OAI21X1_0.A VSS 0.06318f
C5540 a_16065_16149# VSS 0.01439f ; **FLOATING
C5541 BUFX3_2.A VSS 0.10015f
C5542 a_16065_16380# VSS 0.03259f ; **FLOATING
C5543 a_12621_16149# VSS 0.0103f ; **FLOATING
C5544 a_12285_16149# VSS 0.01003f ; **FLOATING
C5545 a_12117_16149# VSS 0.02501f ; **FLOATING
C5546 a_15732_16196# VSS 0.15026f
C5547 a_12621_16380# VSS 0.03205f ; **FLOATING
C5548 a_12285_16380# VSS 0.02932f ; **FLOATING
C5549 a_12117_16380# VSS 0.0672f ; **FLOATING
C5550 a_8841_16149# VSS 0.02779f ; **FLOATING
C5551 a_8265_16258# VSS 0.37004f
C5552 a_8095_16258# VSS 0.45152f
C5553 a_9009_16380# VSS 0.02733f ; **FLOATING
C5554 a_8841_16380# VSS 0.0708f ; **FLOATING
C5555 a_6069_16149# VSS 0.02977f ; **FLOATING
C5556 NAND3X1_0.B VSS 0.22524f
C5557 a_7333_16182# VSS 0.22223f
C5558 a_6661_16182# VSS 0.17016f
C5559 a_6237_16380# VSS 0.02579f ; **FLOATING
C5560 a_6069_16380# VSS 0.0682f ; **FLOATING
C5561 a_4725_16149# VSS 0.01476f ; **FLOATING
C5562 a_5736_16196# VSS 0.16087f
C5563 a_4725_16380# VSS 0.03187f ; **FLOATING
C5564 a_4392_16196# VSS 0.16039f
C5565 a_3385_16182# VSS 0.67056f
C5566 a_3297_16380# VSS 0.02835f ; **FLOATING
C5567 a_2709_16149# VSS 0.0297f ; **FLOATING
C5568 a_2877_16380# VSS 0.02733f ; **FLOATING
C5569 a_2709_16380# VSS 0.06806f ; **FLOATING
C5570 a_2444_16160# VSS 0.13725f
C5571 BUFX3_1.Y.n0 VSS 1.25774f
C5572 BUFX3_1.Y.n1 VSS 1.23498f
C5573 BUFX3_1.Y.n2 VSS 1.33554f
C5574 BUFX3_1.Y.n3 VSS 3.25523f
C5575 BUFX3_1.Y.n4 VSS 3.07321f
C5576 BUFX3_1.Y.n5 VSS 1.61959f
C5577 BUFX3_1.Y.n6 VSS 4.20582f
C5578 BUFX3_1.Y.t0 VSS 0.2581f
C5579 VSS.t861 VSS 2.69096f
C5580 VSS.t844 VSS 1.72397f
C5581 VSS.t661 VSS 0.25799f
C5582 VSS.t610 VSS 0.12858f
C5583 VSS.t1 VSS 1.56027f
C5584 VSS.t1137 VSS 0.3376f
C5585 VSS.t107 VSS 1.00179f
C5586 VSS.t778 VSS 0.65178f
C5587 VSS.t490 VSS 2.06842f
C5588 VSS.t43 VSS 3.58711f
C5589 VSS.t38 VSS 2.01108f
C5590 VSS.t268 VSS 0.79132f
C5591 VSS.t705 VSS 3.50225f
C5592 VSS.t1513 VSS 2.48811f
C5593 VSS.t869 VSS 3.41469f
C5594 VSS.t455 VSS 3.4496f
C5595 VSS.t241 VSS 1.75224f
C5596 VSS.t796 VSS 0.36811f
C5597 VSS.t31 VSS 2.47162f
C5598 VSS.t564 VSS 0.95992f
C5599 VSS.t212 VSS 1.70202f
C5600 VSS.t314 VSS 2.40032f
C5601 VSS.t222 VSS 1.9065f
C5602 VSS.t468 VSS 1.75049f
C5603 VSS.t131 VSS 2.33964f
C5604 VSS.t757 VSS 3.13068f
C5605 VSS.t7 VSS 3.0244f
C5606 VSS.t1100 VSS 1.62815f
C5607 VSS.t588 VSS 0.38495f
C5608 VSS.t1507 VSS 1.77426f
C5609 VSS.t362 VSS 0.90517f
C5610 VSS.t316 VSS 2.64127f
C5611 VSS.t764 VSS 2.2546f
C5612 VSS.t370 VSS 2.48514f
C5613 VSS.t374 VSS 2.64625f
C5614 VSS.t328 VSS 0.72249f
C5615 VSS.t769 VSS 2.56791f
C5616 VSS.t103 VSS 0.229f
C5617 VSS.t381 VSS 2.62887f
C5618 VSS.t859 VSS 2.84744f
C5619 VSS.t581 VSS 2.43396f
C5620 VSS.t885 VSS 2.14239f
C5621 VSS.t231 VSS 2.38746f
C5622 VSS.t1384 VSS 1.67639f
C5623 VSS.t1364 VSS 3.43945f
C5624 VSS.t349 VSS 0.49772f
C5625 VSS.t24 VSS 3.70208f
C5626 VSS.t177 VSS 1.2823f
C5627 VSS.t170 VSS 0.67403f
C5628 VSS.t206 VSS 2.32102f
C5629 VSS.t419 VSS 3.80031f
C5630 VSS.t776 VSS 2.32099f
C5631 VSS.t202 VSS 4.10406f
C5632 VSS.t62 VSS 2.27366f
C5633 VSS.t303 VSS 3.79658f
C5634 VSS.t550 VSS 0.95187f
C5635 VSS.t45 VSS 2.39712f
C5636 VSS.t278 VSS 0.64019f
C5637 VSS.t36 VSS 1.66921f
C5638 VSS.t813 VSS 1.89125f
C5639 VSS.t1393 VSS 3.0978f
C5640 VSS.t18 VSS 1.49141f
C5641 VSS.t998 VSS 2.41678f
C5642 VSS.t514 VSS 1.66921f
C5643 VSS.t1549 VSS 1.79943f
C5644 VSS.t872 VSS 1.77273f
C5645 VSS.t857 VSS 0.41348f
C5646 VSS.t579 VSS 1.32858f
C5647 VSS.t717 VSS 1.35866f
C5648 VSS.t50 VSS 2.61763f
C5649 VSS.t508 VSS 0.96954f
C5650 VSS.t72 VSS 0.8191f
C5651 VSS.t70 VSS 0.65826f
C5652 VSS.t1371 VSS 0.47427f
C5653 VSS.t115 VSS 1.32502f
C5654 VSS.t789 VSS 0.31529f
C5655 VSS.t787 VSS 2.30037f
C5656 VSS.t238 VSS 2.06662f
C5657 VSS.t936 VSS 2.08699f
C5658 VSS.t1491 VSS 2.03506f
C5659 VSS.t29 VSS 0.68355f
C5660 VSS.t355 VSS 3.73324f
C5661 VSS.t179 VSS 2.0131f
C5662 VSS.t668 VSS 3.4695f
C5663 VSS.t190 VSS 3.4695f
C5664 VSS.t412 VSS 2.04479f
C5665 VSS.t485 VSS 3.43061f
C5666 VSS.t209 VSS 3.74852f
C5667 VSS.t1541 VSS 1.98507f
C5668 VSS.t312 VSS 3.42654f
C5669 VSS.t423 VSS 3.37995f
C5670 VSS.t1044 VSS 1.26018f
C5671 VSS.t218 VSS 3.58828f
C5672 VSS.t466 VSS 3.3959f
C5673 VSS.t129 VSS 3.37904f
C5674 VSS.t819 VSS 3.40804f
C5675 VSS.t766 VSS 0.6941f
C5676 VSS.t509 VSS 1.07731f
C5677 VSS.t1098 VSS 2.05735f
C5678 VSS.t342 VSS 0.98942f
C5679 VSS.t246 VSS 2.40456f
C5680 VSS.t1603 VSS 2.56755f
C5681 VSS.t1344 VSS 0.34916f
C5682 VSS.t914 VSS 2.24566f
C5683 VSS.t911 VSS 1.94183f
C5684 VSS.t882 VSS 1.94997f
C5685 VSS.t229 VSS 2.34771f
C5686 VSS.t956 VSS 1.96435f
C5687 VSS.t501 VSS 2.02398f
C5688 VSS.t702 VSS 2.0945f
C5689 VSS.t808 VSS 3.35085f
C5690 VSS.t345 VSS 2.02424f
C5691 VSS.t925 VSS 3.39933f
C5692 VSS.t1688 VSS 0.6713f
C5693 VSS.t91 VSS 2.39447f
C5694 VSS.t526 VSS 3.33249f
C5695 VSS.t126 VSS 1.96437f
C5696 VSS.t573 VSS 2.06062f
C5697 VSS.t1070 VSS 3.31849f
C5698 VSS.t559 VSS 0.63428f
C5699 VSS.t478 VSS 0.63428f
C5700 VSS.t141 VSS 3.31849f
C5701 VSS.t431 VSS 2.00043f
C5702 VSS.t737 VSS 2.47767f
C5703 VSS.t204 VSS 2.05482f
C5704 VSS.t441 VSS 2.02991f
C5705 VSS.t832 VSS 0.97378f
C5706 VSS.t200 VSS 2.00043f
C5707 VSS.t64 VSS 2.32719f
C5708 VSS.t57 VSS 1.95707f
C5709 VSS.t651 VSS 2.42598f
C5710 VSS.t544 VSS 0.64262f
C5711 VSS.t815 VSS 0.83195f
C5712 VSS.t1423 VSS 0.64262f
C5713 VSS.t318 VSS 1.99513f
C5714 VSS.t935 VSS 1.67529f
C5715 VSS.t356 VSS 1.73759f
C5716 VSS.t181 VSS 1.65993f
C5717 VSS.t414 VSS 1.75117f
C5718 VSS.t483 VSS 1.35069f
C5719 VSS.t208 VSS 0.74614f
C5720 VSS.t421 VSS 3.10746f
C5721 VSS.t983 VSS 2.73158f
C5722 VSS.t1327 VSS 2.38501f
C5723 VSS.t552 VSS 1.74421f
C5724 VSS.t281 VSS 2.73067f
C5725 VSS.t821 VSS 0.30924f
C5726 VSS.t762 VSS 1.78995f
C5727 VSS.t1096 VSS 1.35069f
C5728 VSS.t340 VSS 1.32031f
C5729 VSS.t248 VSS 1.47103f
C5730 VSS.t894 VSS 0.16733f
C5731 VSS.t1333 VSS 0.44733f
C5732 VSS.t1370 VSS 2.02998f
C5733 VSS.t1345 VSS 0.34916f
C5734 VSS.t1308 VSS 0.34916f
C5735 VSS.t1411 VSS 0.76338f
C5736 VSS.t886 VSS 1.41767f
C5737 VSS.t113 VSS 1.92771f
C5738 VSS.t156 VSS 3.24487f
C5739 VSS.t1030 VSS 0.64758f
C5740 VSS.t1377 VSS 0.34754f
C5741 VSS.t595 VSS 0.68562f
C5742 VSS.t954 VSS 0.11949f
C5743 VSS.t499 VSS 2.69821f
C5744 VSS.t698 VSS 1.72967f
C5745 VSS.t795 VSS 1.66574f
C5746 VSS.t346 VSS 2.82669f
C5747 VSS.t921 VSS 1.32279f
C5748 VSS.t89 VSS 0.5172f
C5749 VSS.t523 VSS 0.06789f
C5750 VSS.t121 VSS 1.51141f
C5751 VSS.t566 VSS 1.62968f
C5752 VSS.t1083 VSS 2.82669f
C5753 VSS.t561 VSS 1.80176f
C5754 VSS.t474 VSS 1.32279f
C5755 VSS.t185 VSS 2.79535f
C5756 VSS.t428 VSS 1.32175f
C5757 VSS.t735 VSS 1.81554f
C5758 VSS.t453 VSS 2.81715f
C5759 VSS.t301 VSS 1.76514f
C5760 VSS.t330 VSS 1.51645f
C5761 VSS.t771 VSS 1.7912f
C5762 VSS.t60 VSS 1.80405f
C5763 VSS.t55 VSS 2.69821f
C5764 VSS.t41 VSS 3.02435f
C5765 VSS.t674 VSS 2.03892f
C5766 VSS.t34 VSS 1.69128f
C5767 VSS.t542 VSS 1.6932f
C5768 VSS.t266 VSS 3.12511f
C5769 VSS.t811 VSS 0.55579f
C5770 VSS.t9 VSS 2.67956f
C5771 VSS.t706 VSS 1.45718f
C5772 VSS.t320 VSS 2.84025f
C5773 VSS.t755 VSS 0.49668f
C5774 VSS.t870 VSS 1.78048f
C5775 VSS.t448 VSS 0.61083f
C5776 VSS.t386 VSS 1.66741f
C5777 VSS.t1165 VSS 0.31211f
C5778 VSS.t158 VSS 1.7929f
C5779 VSS.t264 VSS 0.63962f
C5780 VSS.t1590 VSS 2.69698f
C5781 VSS.t244 VSS 3.05543f
C5782 VSS.t105 VSS 0.412f
C5783 VSS.t152 VSS 0.04789f
C5784 VSS.t197 VSS 0.36043f
C5785 VSS.t783 VSS 0.9492f
C5786 VSS.t87 VSS 2.31761f
C5787 VSS.t1305 VSS 2.39703f
C5788 VSS.t952 VSS 2.38206f
C5789 VSS.t752 VSS 1.82339f
C5790 VSS.t293 VSS 0.44288f
C5791 VSS.t295 VSS 0.8062f
C5792 VSS.t383 VSS 0.61717f
C5793 VSS.t74 VSS 0.22909f
C5794 VSS.t237 VSS 0.30931f
C5795 VSS.t365 VSS 2.81751f
C5796 VSS.t1388 VSS 0.07873f
C5797 VSS.t876 VSS 0.12083f
C5798 VSS.t922 VSS 5.73943f
C5799 VSS.t26 VSS 3.09639f
C5800 VSS.t172 VSS 1.35866f
C5801 VSS.t785 VSS 0.31491f
C5802 VSS.t647 VSS 0.46704f
C5803 VSS.t165 VSS 7.55803f
C5804 VSS.t457 VSS 2.51878f
C5805 VSS.t626 VSS 0.47057f
C5806 VSS.t11 VSS 5.17986f
C5807 VSS.t1158 VSS 0.35439f
C5808 VSS.t117 VSS 3.33588f
C5809 VSS.t1240 VSS 1.4967f
C5810 VSS.t154 VSS 0.57516f
C5811 VSS.t133 VSS 0.57836f
C5812 VSS.t393 VSS 0.66379f
C5813 VSS.t163 VSS 0.9049f
C5814 VSS.t14 VSS 1.6874f
C5815 VSS.t160 VSS 0.7455f
C5816 VSS.t554 VSS 0.64913f
C5817 VSS.t612 VSS 1.38116f
C5818 VSS.t1191 VSS 0.67885f
C5819 VSS.t608 VSS 1.38116f
C5820 VSS.t94 VSS 0.79751f
C5821 VSS.t1121 VSS 0.90809f
C5822 VSS.t1118 VSS 0.27364f
C5823 VSS.t663 VSS 2.98522f
C5824 VSS.t1473 VSS 0.11846f
C5825 VSS.t665 VSS 0.70943f
C5826 VSS.t1399 VSS 0.37466f
C5827 VSS.t444 VSS 3.056f
C5828 VSS.t896 VSS 0.53731f
C5829 VSS.t602 VSS 0.75801f
C5830 VSS.t395 VSS 0.89081f
C5831 VSS.t1264 VSS 0.08983f
C5832 VSS.t139 VSS 1.08603f
C5833 VSS.t101 VSS 1.11454f
C5834 VSS.t904 VSS 0.07811f
C5835 VSS.t799 VSS 3.33989f
C5836 VSS.t338 VSS 1.5147f
C5837 VSS.t889 VSS 1.44128f
C5838 VSS.t67 VSS 3.27206f
C5839 VSS.t20 VSS 3.6443f
C5840 VSS.t352 VSS 5.80619f
C5841 VSS.t97 VSS 2.9714f
C5842 VSS.t305 VSS 4.03298f
C5843 VSS.t216 VSS 1.69238f
C5844 VSS.t1785 VSS 0.36043f
C5845 VSS.t439 VSS 0.15301f
C5846 VSS.t53 VSS 7.32156f
C5847 VSS.t725 VSS 3.43484f
C5848 VSS.t723 VSS 2.37022f
C5849 VSS.t1436 VSS 0.47094f
C5850 VSS.t235 VSS 0.37789f
C5851 VSS.t233 VSS 1.89509f
C5852 VSS.t880 VSS 1.52594f
C5853 VSS.t1647 VSS 0.3793f
C5854 VSS.t1483 VSS 1.58479f
C5855 VSS.t251 VSS 5.71854f
C5856 VSS.t425 VSS 2.72267f
C5857 VSS.t256 VSS 0.30924f
C5858 VSS.t254 VSS 0.30924f
C5859 VSS.t297 VSS 1.3835f
C5860 VSS.t1311 VSS 1.38761f
C5861 VSS.t1301 VSS 0.35459f
C5862 VSS.t481 VSS 1.05702f
C5863 VSS.t1753 VSS 0.30924f
C5864 VSS.t410 VSS 0.63968f
C5865 VSS.t192 VSS 1.26785f
C5866 VSS.t143 VSS 0.30931f
C5867 VSS.t290 VSS 0.31491f
C5868 VSS.t284 VSS 0.9492f
C5869 VSS.t48 VSS 0.49946f
C5870 VSS.t475 VSS 7.21418f
C5871 VSS.t530 VSS 0.30924f
C5872 VSS.t124 VSS 0.30924f
C5873 VSS.t1806 VSS 0.36054f
C5874 VSS.t451 VSS 0.50026f
C5875 VSS.t520 VSS 5.11625f
C5876 VSS.t1503 VSS 3.62552f
C5877 VSS.t583 VSS 0.40035f
C5878 VSS.t970 VSS 0.23676f
C5879 VSS.t1573 VSS 5.07243f
C5880 VSS.t262 VSS 1.24357f
C5881 VSS.t968 VSS 0.72329f
C5882 VSS.t700 VSS 3.02941f
C5883 VSS.t1672 VSS 0.07873f
C5884 VSS.t931 VSS 0.15301f
C5885 VSS.t497 VSS 5.71493f
C5886 VSS.t1605 VSS 1.77475f
C5887 VSS.t3 VSS 1.4141f
C5888 VSS.t1467 VSS 1.32691f
C5889 VSS.t109 VSS 0.57126f
C5890 VSS.t993 VSS 0.37734f
C5891 VSS.t78 VSS 0.14334f
C5892 VSS.t76 VSS 1.90813f
C5893 VSS.t1268 VSS 0.31168f
C5894 VSS.t81 VSS 7.1352f
C5895 VSS.t310 VSS 0.15301f
C5896 VSS.t224 VSS 6.22769f
C5897 VSS.t1652 VSS 0.34921f
C5898 VSS.t1337 VSS 1.89636f
C5899 VSS.t506 VSS 0.34916f
C5900 VSS.t504 VSS 2.27589f
C5901 VSS.t1544 VSS 0.37942f
C5902 VSS.t1286 VSS 0.387f
C5903 VSS.t1284 VSS 3.44534f
C5904 VDD.n0 VSS 0.34038f
C5905 VDD.n1 VSS 0.41351f
C5906 VDD.n2 VSS 0.41351f
C5907 VDD.n3 VSS 0.41351f
C5908 VDD.n4 VSS 0.41351f
C5909 VDD.n5 VSS 0.41351f
C5910 VDD.n6 VSS 0.41351f
C5911 VDD.n7 VSS 0.41351f
C5912 VDD.n8 VSS 0.61896f
C5913 VDD.n9 VSS 0.49487f
C5914 VDD.n10 VSS 0.17411f
C5915 VDD.n11 VSS 0.21644f
C5916 VDD.n12 VSS 0.33391f
C5917 VDD.n13 VSS 0.37189f
C5918 VDD.n14 VSS 0.50551f
C5919 VDD.n15 VSS 0.53004f
C5920 VDD.n16 VSS 0.31049f
C5921 VDD.n17 VSS 0.3959f
C5922 VDD.n18 VSS 0.35932f
C5923 VDD.n19 VSS 0.32581f
C5924 VDD.n20 VSS 0.18594f
C5925 VDD.n21 VSS 0.2995f
C5926 VDD.n22 VSS 0.35544f
C5927 VDD.n23 VSS 0.35544f
C5928 VDD.n24 VSS 0.36242f
C5929 VDD.t8 VSS 81.5526f
C5930 VDD.n25 VSS 0.3423f
C5931 VDD.n26 VSS 0.18594f
C5932 VDD.n27 VSS 0.35824f
C5933 VDD.n28 VSS 0.29635f
C5934 VDD.n29 VSS 0.24878f
C5935 VDD.n30 VSS 0.31555f
C5936 VDD.n31 VSS 0.35748f
C5937 VDD.n32 VSS 0.35748f
C5938 VDD.n33 VSS 0.35748f
C5939 VDD.n34 VSS 0.31555f
C5940 VDD.n35 VSS 0.35748f
C5941 VDD.n36 VSS 0.35748f
C5942 VDD.n37 VSS 0.35748f
C5943 VDD.n38 VSS 0.35748f
C5944 VDD.n39 VSS 0.27963f
C5945 VDD.n40 VSS 0.37189f
C5946 VDD.n41 VSS 0.33972f
C5947 VDD.n42 VSS 0.29081f
C5948 VDD.n43 VSS 0.23787f
C5949 VDD.n44 VSS 0.36865f
C5950 VDD.n45 VSS 0.3077f
C5951 VDD.n46 VSS 0.36127f
C5952 VDD.n47 VSS 0.3077f
C5953 VDD.n48 VSS 0.36127f
C5954 VDD.n49 VSS 0.3077f
C5955 VDD.n50 VSS 0.36127f
C5956 VDD.n51 VSS 0.3077f
C5957 VDD.n52 VSS 0.36127f
C5958 VDD.n53 VSS 0.3077f
C5959 VDD.n54 VSS 0.36127f
C5960 VDD.n55 VSS 0.3077f
C5961 VDD.n56 VSS 0.36127f
C5962 VDD.n57 VSS 0.3077f
C5963 VDD.n58 VSS 0.36127f
C5964 VDD.n59 VSS 0.3077f
C5965 VDD.n60 VSS 0.36127f
C5966 VDD.n61 VSS 0.3077f
C5967 VDD.n62 VSS 0.36127f
C5968 VDD.n63 VSS 0.24196f
C5969 VDD.n64 VSS 0.24954f
C5970 VDD.n65 VSS 0.23243f
C5971 VDD.n66 VSS 0.31809f
C5972 VDD.n67 VSS 0.34614f
C5973 VDD.n68 VSS 0.26235f
C5974 VDD.n69 VSS 0.36057f
C5975 VDD.n70 VSS 0.28272f
C5976 VDD.n71 VSS 0.1858f
C5977 VDD.n72 VSS 0.26964f
C5978 VDD.n73 VSS 0.50902f
C5979 VDD.n74 VSS 0.08113f
C5980 VDD.n75 VSS 0.32349f
C5981 VDD.n76 VSS 0.19155f
C5982 VDD.n77 VSS 0.26104f
C5983 VDD.n78 VSS 0.38326f
C5984 VDD.n79 VSS 0.22423f
C5985 VDD.n80 VSS 0.39595f
C5986 VDD.n81 VSS 0.28887f
C5987 VDD.n82 VSS 0.26892f
C5988 VDD.n83 VSS 0.23696f
C5989 VDD.n84 VSS 0.38507f
C5990 VDD.n85 VSS 0.36242f
C5991 VDD.n86 VSS 0.35783f
C5992 VDD.n87 VSS 0.33157f
C5993 VDD.n88 VSS 0.34555f
C5994 VDD.n90 VSS 0.24675f
C5995 VDD.n91 VSS 0.30724f
C5996 VDD.n92 VSS 0.27051f
C5997 VDD.n93 VSS 1.54811f
C5998 VDD.n94 VSS 1.54811f
C5999 VDD.n95 VSS 1.94451f
C6000 VDD.n96 VSS 1.54811f
C6001 VDD.n97 VSS 1.54811f
C6002 VDD.n98 VSS 1.54811f
C6003 VDD.n99 VSS 1.94451f
C6004 VDD.n100 VSS 1.54811f
C6005 VDD.n101 VSS 1.54811f
C6006 VDD.n102 VSS 1.54811f
C6007 VDD.n103 VSS 1.54811f
C6008 VDD.n104 VSS 1.94451f
C6009 VDD.n105 VSS 1.54811f
C6010 VDD.n106 VSS 1.54811f
C6011 VDD.n107 VSS 1.54811f
C6012 VDD.n108 VSS 1.94451f
C6013 VDD.n109 VSS 0.10677f
C6014 VDD.n110 VSS 0.1485f
C6015 VDD.n111 VSS 0.11263f
C6016 VDD.n112 VSS 0.14823f
C6017 VDD.n113 VSS 0.11256f
C6018 VDD.n114 VSS 0.32311f
C6019 VDD.n115 VSS 0.11256f
C6020 VDD.n116 VSS 0.32311f
C6021 VDD.n117 VSS 0.11256f
C6022 VDD.n118 VSS 0.31852f
C6023 VDD.n119 VSS 0.11256f
C6024 VDD.n120 VSS 0.32311f
C6025 VDD.n121 VSS 0.32311f
C6026 VDD.n122 VSS 0.11256f
C6027 VDD.n123 VSS 0.31852f
C6028 VDD.n124 VSS 0.11256f
C6029 VDD.n125 VSS 0.32311f
C6030 VDD.n126 VSS 0.11256f
C6031 VDD.n127 VSS 0.32311f
C6032 VDD.n128 VSS 0.31852f
C6033 VDD.n129 VSS 0.11256f
C6034 VDD.n130 VSS 0.32311f
C6035 VDD.n131 VSS 0.11256f
C6036 VDD.n132 VSS 0.32311f
C6037 VDD.n133 VSS 0.11256f
C6038 VDD.n134 VSS 0.31852f
C6039 VDD.n135 VSS 0.32311f
C6040 VDD.n136 VSS 0.11256f
C6041 VDD.n137 VSS 0.32311f
C6042 VDD.n138 VSS 0.11256f
C6043 VDD.n139 VSS 0.31852f
C6044 VDD.n140 VSS 0.11256f
C6045 VDD.n141 VSS 0.32311f
C6046 VDD.n142 VSS 0.11256f
C6047 VDD.n143 VSS 0.32311f
C6048 VDD.n144 VSS 0.11256f
C6049 VDD.n145 VSS 0.31852f
C6050 VDD.n146 VSS 0.11256f
C6051 VDD.n147 VSS 0.32311f
C6052 VDD.n148 VSS 0.11256f
C6053 VDD.n149 VSS 0.32311f
C6054 VDD.n150 VSS 0.31852f
C6055 VDD.n151 VSS 0.33473f
C6056 VDD.n152 VSS 0.31852f
C6057 VDD.n153 VSS 0.15828f
C6058 VDD.n154 VSS 0.32716f
C6059 VDD.n155 VSS 0.31852f
C6060 VDD.n156 VSS 0.34179f
C6061 VDD.n157 VSS 0.11256f
C6062 VDD.n158 VSS 0.34179f
C6063 VDD.n159 VSS 0.34179f
C6064 VDD.n160 VSS 0.34179f
C6065 VDD.n161 VSS 0.11256f
C6066 VDD.n162 VSS 0.34179f
C6067 VDD.n163 VSS 0.34179f
C6068 VDD.n164 VSS 0.11256f
C6069 VDD.n165 VSS 0.34179f
C6070 VDD.n166 VSS 0.11256f
C6071 VDD.n167 VSS 0.34179f
C6072 VDD.n168 VSS 0.18202f
C6073 VDD.n169 VSS 0.27513f
C6074 VDD.n170 VSS 0.22788f
C6075 VDD.n171 VSS 0.25522f
C6076 VDD.n172 VSS 0.29716f
C6077 VDD.n173 VSS 0.25522f
C6078 VDD.n174 VSS 0.29716f
C6079 VDD.n175 VSS 0.25522f
C6080 VDD.n176 VSS 0.29716f
C6081 VDD.n177 VSS 0.25522f
C6082 VDD.n178 VSS 0.29716f
C6083 VDD.n179 VSS 0.25522f
C6084 VDD.n180 VSS 0.29716f
C6085 VDD.n181 VSS 0.25522f
C6086 VDD.n182 VSS 0.29716f
C6087 VDD.n183 VSS 0.25522f
C6088 VDD.n184 VSS 0.29716f
C6089 VDD.n185 VSS 0.25522f
C6090 VDD.n186 VSS 0.29716f
C6091 VDD.n187 VSS 0.25522f
C6092 VDD.n188 VSS 0.29716f
C6093 VDD.n189 VSS 0.37189f
C6094 VDD.n190 VSS 0.105f
C6095 VDD.n191 VSS 0.31526f
C6096 VDD.n192 VSS 0.20405f
C6097 VDD.n193 VSS 0.04507f
C6098 VDD.n194 VSS 0.19722f
C6099 VDD.n195 VSS 0.15072f
C6100 VDD.n196 VSS 0.26819f
C6101 VDD.n197 VSS 0.26819f
C6102 VDD.n198 VSS 0.36242f
C6103 VDD.n199 VSS 0.32846f
C6104 VDD.n200 VSS 0.36242f
C6105 VDD.n201 VSS 0.36242f
C6106 VDD.n202 VSS 0.32846f
C6107 VDD.n203 VSS 0.36242f
C6108 VDD.n204 VSS 0.36242f
C6109 VDD.n205 VSS 0.32846f
C6110 VDD.n206 VSS 0.36242f
C6111 VDD.n207 VSS 0.36242f
C6112 VDD.n208 VSS 0.32846f
C6113 VDD.n209 VSS 0.36242f
C6114 VDD.n210 VSS 0.36242f
C6115 VDD.n211 VSS 0.32846f
C6116 VDD.n212 VSS 0.36242f
C6117 VDD.n213 VSS 0.36242f
C6118 VDD.n214 VSS 0.32846f
C6119 VDD.n215 VSS 0.36242f
C6120 VDD.n216 VSS 0.36242f
C6121 VDD.n217 VSS 0.32846f
C6122 VDD.n218 VSS 0.36242f
C6123 VDD.n219 VSS 0.36242f
C6124 VDD.n220 VSS 0.36242f
C6125 VDD.n221 VSS 0.36242f
C6126 VDD.t5 VSS 81.5526f
C6127 VDD.t100 VSS 81.5526f
C6128 VDD.n222 VSS 0.3196f
C6129 VDD.t93 VSS 81.5526f
C6130 VDD.n223 VSS 0.31555f
C6131 VDD.n224 VSS 0.11256f
C6132 VDD.n225 VSS 0.31555f
C6133 VDD.n226 VSS 0.16585f
C6134 VDD.n227 VSS 0.3196f
C6135 VDD.n228 VSS 0.31555f
C6136 VDD.t281 VSS 81.5526f
C6137 VDD.n229 VSS 0.11256f
C6138 VDD.n230 VSS 0.31555f
C6139 VDD.n231 VSS 0.3196f
C6140 VDD.n232 VSS 0.31555f
C6141 VDD.n233 VSS 0.31555f
C6142 VDD.n234 VSS 0.30798f
C6143 VDD.n235 VSS 0.11256f
C6144 VDD.n236 VSS 0.31555f
C6145 VDD.t29 VSS 81.5526f
C6146 VDD.n237 VSS 0.16585f
C6147 VDD.n238 VSS 0.3196f
C6148 VDD.t39 VSS 81.5526f
C6149 VDD.n239 VSS 0.31555f
C6150 VDD.n240 VSS 0.11256f
C6151 VDD.n241 VSS 0.31555f
C6152 VDD.n242 VSS 0.3196f
C6153 VDD.n243 VSS 0.31555f
C6154 VDD.t68 VSS 81.5526f
C6155 VDD.n244 VSS 0.11256f
C6156 VDD.n245 VSS 0.31555f
C6157 VDD.n246 VSS 0.16585f
C6158 VDD.n247 VSS 0.3196f
C6159 VDD.n248 VSS 0.11256f
C6160 VDD.n249 VSS 0.31555f
C6161 VDD.t83 VSS 81.5526f
C6162 VDD.n250 VSS 0.16585f
C6163 VDD.n251 VSS 0.3196f
C6164 VDD.n253 VSS 0.10777f
C6165 VDD.n254 VSS 0.37189f
C6166 VDD.n255 VSS 0.29716f
C6167 VDD.n256 VSS 0.29716f
C6168 VDD.n257 VSS 0.16585f
C6169 VDD.n258 VSS 0.29716f
C6170 VDD.n259 VSS 0.29716f
C6171 VDD.n260 VSS 0.16585f
C6172 VDD.n261 VSS 0.29716f
C6173 VDD.n262 VSS 0.29716f
C6174 VDD.n263 VSS 0.16585f
C6175 VDD.n264 VSS 0.29716f
C6176 VDD.n265 VSS 0.10256f
C6177 VDD.n266 VSS 0.18121f
C6178 VDD.n267 VSS 0.3077f
C6179 VDD.n268 VSS 0.3077f
C6180 VDD.n269 VSS 0.3077f
C6181 VDD.n270 VSS 0.11542f
C6182 VDD.n271 VSS 0.3077f
C6183 VDD.n272 VSS 0.11256f
C6184 VDD.n273 VSS 0.3077f
C6185 VDD.n274 VSS 0.11542f
C6186 VDD.n275 VSS 0.3077f
C6187 VDD.n276 VSS 0.3077f
C6188 VDD.n277 VSS 0.11542f
C6189 VDD.n278 VSS 0.11256f
C6190 VDD.n279 VSS 0.3077f
C6191 VDD.n280 VSS 0.2499f
C6192 VDD.n281 VSS 0.28783f
C6193 VDD.n282 VSS 0.31743f
C6194 VDD.n283 VSS 0.31743f
C6195 VDD.n284 VSS 0.31743f
C6196 VDD.n285 VSS 0.31743f
C6197 VDD.n286 VSS 0.31743f
C6198 VDD.n287 VSS 0.31743f
C6199 VDD.n288 VSS 0.31743f
C6200 VDD.n289 VSS 0.35783f
C6201 VDD.n290 VSS 0.3608f
C6202 VDD.n291 VSS 0.3608f
C6203 VDD.n292 VSS 0.3608f
C6204 VDD.n293 VSS 0.33252f
C6205 VDD.n294 VSS 0.35783f
C6206 VDD.n295 VSS 0.3608f
C6207 VDD.n296 VSS 0.3608f
C6208 VDD.n297 VSS 0.3608f
C6209 VDD.n298 VSS 0.33252f
C6210 VDD.n299 VSS 0.35783f
C6211 VDD.n300 VSS 0.3608f
C6212 VDD.n301 VSS 0.3608f
C6213 VDD.n302 VSS 0.3608f
C6214 VDD.n303 VSS 0.33252f
C6215 VDD.n304 VSS 0.35783f
C6216 VDD.n305 VSS 0.3608f
C6217 VDD.n306 VSS 0.3608f
C6218 VDD.n307 VSS 0.3608f
C6219 VDD.n308 VSS 0.33252f
C6220 VDD.n309 VSS 0.3608f
C6221 VDD.n310 VSS 0.3608f
C6222 VDD.n311 VSS 0.3608f
C6223 VDD.n312 VSS 0.33252f
C6224 VDD.n313 VSS 0.35783f
C6225 VDD.n314 VSS 0.3608f
C6226 VDD.n315 VSS 0.3608f
C6227 VDD.n316 VSS 0.3608f
C6228 VDD.n317 VSS 0.33252f
C6229 VDD.n318 VSS 0.35783f
C6230 VDD.n319 VSS 0.3608f
C6231 VDD.n320 VSS 0.3608f
C6232 VDD.n321 VSS 0.3608f
C6233 VDD.n322 VSS 0.33252f
C6234 VDD.n323 VSS 0.35783f
C6235 VDD.n324 VSS 0.3608f
C6236 VDD.n325 VSS 0.33252f
C6237 VDD.n326 VSS 0.33252f
C6238 VDD.n327 VSS 0.2189f
C6239 VDD.n328 VSS 0.2189f
C6240 VDD.n329 VSS 0.15984f
C6241 VDD.n330 VSS 0.16316f
C6242 VDD.n331 VSS 0.24635f
C6243 VDD.n332 VSS 0.16385f
C6244 VDD.n333 VSS 0.24635f
C6245 VDD.n334 VSS 0.16385f
C6246 VDD.n335 VSS 0.16223f
C6247 VDD.n336 VSS 0.23919f
C6248 VDD.n337 VSS 0.17154f
C6249 VDD.n338 VSS 0.38773f
C6250 VDD.n339 VSS 0.2601f
C6251 VDD.n340 VSS 0.17648f
C6252 VDD.n341 VSS 0.35017f
C6253 VDD.n342 VSS 0.19188f
C6254 VDD.n343 VSS 0.16918f
C6255 VDD.n344 VSS 0.2013f
C6256 VDD.n345 VSS 0.18098f
C6257 VDD.n346 VSS 0.23818f
C6258 VDD.n347 VSS 0.2353f
C6259 VDD.n348 VSS 0.18594f
C6260 VDD.n349 VSS 0.18594f
C6261 VDD.n350 VSS 0.18594f
C6262 VDD.n351 VSS 0.18594f
C6263 VDD.n352 VSS 0.18594f
C6264 VDD.n353 VSS 0.175f
C6265 VDD.n354 VSS 0.18594f
C6266 VDD.n355 VSS 0.18036f
C6267 VDD.n356 VSS 0.31451f
C6268 VDD.n357 VSS 0.31451f
C6269 VDD.n358 VSS 0.31451f
C6270 VDD.n359 VSS 0.31451f
C6271 VDD.n360 VSS 0.31451f
C6272 VDD.n361 VSS 0.31451f
C6273 VDD.n362 VSS 0.31451f
C6274 VDD.n363 VSS 0.19109f
C6275 VDD.n364 VSS 0.31159f
C6276 VDD.n365 VSS 0.31159f
C6277 VDD.n366 VSS 0.31159f
C6278 VDD.n367 VSS 0.31159f
C6279 VDD.n368 VSS 0.17188f
C6280 VDD.n369 VSS 0.11256f
C6281 VDD.n370 VSS 0.30175f
C6282 VDD.n371 VSS 0.11256f
C6283 VDD.n372 VSS 0.30175f
C6284 VDD.n373 VSS 0.11256f
C6285 VDD.n374 VSS 0.30175f
C6286 VDD.n375 VSS 0.11256f
C6287 VDD.n376 VSS 0.30175f
C6288 VDD.n377 VSS 0.30175f
C6289 VDD.n378 VSS 0.30175f
C6290 VDD.n379 VSS 0.30175f
C6291 VDD.n380 VSS 0.30175f
C6292 VDD.n381 VSS 0.30175f
C6293 VDD.n382 VSS 0.30175f
C6294 VDD.n383 VSS 0.11256f
C6295 VDD.n384 VSS 0.30175f
C6296 VDD.n385 VSS 0.30175f
C6297 VDD.n386 VSS 0.30175f
C6298 VDD.n387 VSS 0.11256f
C6299 VDD.n388 VSS 0.30175f
C6300 VDD.n389 VSS 0.11256f
C6301 VDD.n390 VSS 0.30175f
C6302 VDD.n391 VSS 0.30175f
C6303 VDD.n392 VSS 0.30175f
C6304 VDD.n393 VSS 0.30175f
C6305 VDD.n394 VSS 0.30175f
C6306 VDD.n395 VSS 0.11256f
C6307 VDD.n396 VSS 0.30175f
C6308 VDD.n397 VSS 0.30175f
C6309 VDD.n398 VSS 0.30175f
C6310 VDD.n399 VSS 0.11256f
C6311 VDD.n400 VSS 0.30175f
C6312 VDD.n401 VSS 0.30175f
C6313 VDD.n402 VSS 0.11256f
C6314 VDD.n403 VSS 0.30175f
C6315 VDD.n404 VSS 0.30175f
C6316 VDD.n405 VSS 0.30175f
C6317 VDD.n406 VSS 0.30175f
C6318 VDD.n407 VSS 0.30175f
C6319 VDD.n408 VSS 0.30175f
C6320 VDD.n409 VSS 0.30175f
C6321 VDD.n410 VSS 0.23757f
C6322 VDD.n411 VSS 0.28783f
C6323 VDD.t0 VSS 44.2813f
C6324 VDD.n412 VSS 0.23959f
C6325 VDD.t354 VSS 81.6217f
C6326 VDD.n413 VSS 0.18689f
C6327 VDD.n414 VSS 0.29799f
C6328 VDD.n415 VSS 0.2173f
C6329 VDD.n416 VSS 0.18176f
C6330 VDD.n417 VSS 0.18689f
C6331 VDD.n418 VSS 0.18689f
C6332 VDD.n419 VSS 0.22002f
C6333 VDD.n420 VSS 0.22976f
C6334 VDD.n421 VSS 0.25012f
C6335 VDD.n422 VSS 0.17648f
C6336 VDD.n423 VSS 0.17648f
C6337 VDD.n424 VSS 0.17648f
C6338 VDD.n425 VSS 0.17845f
C6339 VDD.t941 VSS 0.1392f
C6340 VDD.t1728 VSS 0.21717f
C6341 VDD.t936 VSS 0.03992f
C6342 VDD.t1080 VSS 0.18751f
C6343 VDD.t1541 VSS 0.03992f
C6344 VDD.t935 VSS 0.11267f
C6345 VDD.t1885 VSS 0.10363f
C6346 VDD.t1826 VSS 0.03992f
C6347 VDD.t1542 VSS 0.04452f
C6348 VDD.t1544 VSS 0.87149f
C6349 VDD.t1825 VSS 0.80336f
C6350 VDD.t1828 VSS 0.18062f
C6351 VDD.t1546 VSS 0.03992f
C6352 VDD.t1903 VSS 0.10043f
C6353 VDD.t1827 VSS 0.17602f
C6354 VDD.t1337 VSS 0.05474f
C6355 VDD.t1904 VSS 0.10675f
C6356 VDD.t1813 VSS 0.2886f
C6357 VDD.t1336 VSS 0.12035f
C6358 VDD.t1814 VSS 0.29492f
C6359 VDD.t1410 VSS 0.26359f
C6360 VDD.t1688 VSS 0.03992f
C6361 VDD.t1409 VSS 1.16285f
C6362 VDD.t1413 VSS 0.04452f
C6363 VDD.t1689 VSS 0.18165f
C6364 VDD.t1690 VSS 0.73961f
C6365 VDD.t1412 VSS 0.03992f
C6366 VDD.t1961 VSS 0.0549f
C6367 VDD.t1691 VSS 0.03992f
C6368 VDD.t1658 VSS 0.19621f
C6369 VDD.t1960 VSS 0.12112f
C6370 VDD.t1918 VSS 0.03992f
C6371 VDD.t1659 VSS 0.20081f
C6372 VDD.t1661 VSS 0.04452f
C6373 VDD.t904 VSS 0.19608f
C6374 VDD.t902 VSS 0.04452f
C6375 VDD.t977 VSS 0.08275f
C6376 VDD.t1386 VSS 0.31359f
C6377 VDD.t1385 VSS 0.21656f
C6378 VDD.t920 VSS 0.83959f
C6379 VDD.t1383 VSS 0.43536f
C6380 VDD.t978 VSS 0.03992f
C6381 VDD.t1384 VSS 0.03992f
C6382 VDD.t906 VSS 0.19148f
C6383 VDD.t979 VSS 0.21583f
C6384 VDD.t976 VSS 0.08735f
C6385 VDD.t447 VSS 0.13695f
C6386 VDD.t449 VSS 0.03992f
C6387 VDD.t1339 VSS 0.03992f
C6388 VDD.t1333 VSS 0.03992f
C6389 VDD.t444 VSS 0.11793f
C6390 VDD.t445 VSS 0.05426f
C6391 VDD.t1332 VSS 0.04452f
C6392 VDD.t921 VSS 0.03992f
C6393 VDD.t1331 VSS 0.87373f
C6394 VDD.t922 VSS 0.04452f
C6395 VDD.t1330 VSS 0.73446f
C6396 VDD.t919 VSS 0.84419f
C6397 VDD.t703 VSS 0.13695f
C6398 VDD.t705 VSS 0.13063f
C6399 VDD.t764 VSS 0.03992f
C6400 VDD.t1455 VSS 0.03992f
C6401 VDD.t1783 VSS 0.425f
C6402 VDD.t1784 VSS 0.41868f
C6403 VDD.t1454 VSS 0.04452f
C6404 VDD.t460 VSS 0.03992f
C6405 VDD.t1453 VSS 0.84419f
C6406 VDD.t459 VSS 0.04452f
C6407 VDD.t1452 VSS 0.83959f
C6408 VDD.t456 VSS 0.89045f
C6409 VDD.t689 VSS 0.13695f
C6410 VDD.t688 VSS 0.13063f
C6411 VDD.t1364 VSS 0.76912f
C6412 VDD.t531 VSS 0.42843f
C6413 VDD.t1576 VSS 0.17477f
C6414 VDD.t530 VSS 0.4221f
C6415 VDD.t767 VSS 0.03992f
C6416 VDD.t1577 VSS 0.17937f
C6417 VDD.t1574 VSS 0.04452f
C6418 VDD.t766 VSS 0.74977f
C6419 VDD.t765 VSS 0.16412f
C6420 VDD.t1575 VSS 0.03992f
C6421 VDD.t1964 VSS 0.03992f
C6422 VDD.t998 VSS 0.04452f
C6423 VDD.t1000 VSS 0.16641f
C6424 VDD.t1963 VSS 0.12221f
C6425 VDD.t1607 VSS 0.06298f
C6426 VDD.t1002 VSS 0.03992f
C6427 VDD.t907 VSS 0.09833f
C6428 VDD.t1606 VSS 0.16153f
C6429 VDD.t908 VSS 0.10465f
C6430 VDD.t1570 VSS 0.10309f
C6431 VDD.t483 VSS 0.18392f
C6432 VDD.t1083 VSS 0.29159f
C6433 VDD.t1084 VSS 0.28527f
C6434 VDD.t999 VSS 0.03992f
C6435 VDD.t1463 VSS 0.76234f
C6436 VDD.t90 VSS 0.11424f
C6437 VDD.t91 VSS 0.10791f
C6438 VDD.t1461 VSS 0.93666f
C6439 VDD.t1366 VSS 0.03992f
C6440 VDD.t1459 VSS 0.04452f
C6441 VDD.t1367 VSS 0.19226f
C6442 VDD.t1458 VSS 0.03992f
C6443 VDD.t1363 VSS 0.77372f
C6444 VDD.t543 VSS 0.04452f
C6445 VDD.t544 VSS 0.90118f
C6446 VDD.t863 VSS 0.03992f
C6447 VDD.t1712 VSS 0.10216f
C6448 VDD.t1711 VSS 0.10848f
C6449 VDD.t545 VSS 0.89658f
C6450 VDD.t1535 VSS 0.15645f
C6451 VDD.t511 VSS 0.03992f
C6452 VDD.t1536 VSS 0.16105f
C6453 VDD.t510 VSS 0.26782f
C6454 VDD.t1538 VSS 0.04452f
C6455 VDD.t513 VSS 0.93771f
C6456 VDD.t1539 VSS 0.03992f
C6457 VDD.t514 VSS 0.03992f
C6458 VDD.t848 VSS 0.09887f
C6459 VDD.t1286 VSS 0.09778f
C6460 VDD.t849 VSS 0.10519f
C6461 VDD.t1285 VSS 0.1041f
C6462 VDD.t1609 VSS 0.17994f
C6463 VDD.t1686 VSS 0.11115f
C6464 VDD.t864 VSS 0.04452f
C6465 VDD.t860 VSS 0.98641f
C6466 VDD.t542 VSS 0.03992f
C6467 VDD.t1626 VSS 0.13867f
C6468 VDD.t861 VSS 0.03992f
C6469 VDD.t1627 VSS 0.13234f
C6470 VDD.t355 VSS 0.11061f
C6471 VDD.t1394 VSS 0.1037f
C6472 VDD.t1395 VSS 0.03992f
C6473 VDD.t1772 VSS 0.17506f
C6474 VDD.t356 VSS 0.10429f
C6475 VDD.t1872 VSS 0.03992f
C6476 VDD.t1773 VSS 0.17966f
C6477 VDD.t1770 VSS 0.80312f
C6478 VDD.t1870 VSS 0.16594f
C6479 VDD.t1868 VSS 0.04452f
C6480 VDD.t1771 VSS 0.79852f
C6481 VDD.t1867 VSS 0.03992f
C6482 VDD.t697 VSS 0.03992f
C6483 VDD.t1474 VSS 0.1037f
C6484 VDD.t1475 VSS 0.09737f
C6485 VDD.t880 VSS 0.03992f
C6486 VDD.t696 VSS 0.04452f
C6487 VDD.t695 VSS 0.84856f
C6488 VDD.t879 VSS 0.19426f
C6489 VDD.t876 VSS 0.08196f
C6490 VDD.t694 VSS 0.18206f
C6491 VDD.t955 VSS 0.31915f
C6492 VDD.t877 VSS 0.03992f
C6493 VDD.t954 VSS 0.03992f
C6494 VDD.t1568 VSS 0.11349f
C6495 VDD.t1484 VSS 0.28611f
C6496 VDD.t1485 VSS 0.27978f
C6497 VDD.t1522 VSS 0.03992f
C6498 VDD.t1567 VSS 0.10717f
C6499 VDD.t1755 VSS 0.03992f
C6500 VDD.t1523 VSS 0.04452f
C6501 VDD.t1520 VSS 0.17966f
C6502 VDD.t1754 VSS 0.16865f
C6503 VDD.t1753 VSS 0.04452f
C6504 VDD.t1521 VSS 0.03992f
C6505 VDD.t1752 VSS 0.03992f
C6506 VDD.t1430 VSS 0.28007f
C6507 VDD.t453 VSS 0.03992f
C6508 VDD.t1431 VSS 0.27375f
C6509 VDD.t1766 VSS 0.17711f
C6510 VDD.t452 VSS 0.04452f
C6511 VDD.t451 VSS 0.87688f
C6512 VDD.t1767 VSS 0.18171f
C6513 VDD.t1764 VSS 0.80312f
C6514 VDD.t450 VSS 0.73509f
C6515 VDD.t1765 VSS 0.03992f
C6516 VDD.t1424 VSS 0.32251f
C6517 VDD.t1425 VSS 0.21835f
C6518 VDD.t1906 VSS 0.10525f
C6519 VDD.t989 VSS 0.11188f
C6520 VDD.t1907 VSS 0.09893f
C6521 VDD.t1919 VSS 0.03992f
C6522 VDD.t988 VSS 0.03992f
C6523 VDD.t1662 VSS 0.03992f
C6524 VDD.t1920 VSS 0.99307f
C6525 VDD.t1917 VSS 0.04452f
C6526 VDD.t256 VSS 0.03992f
C6527 VDD.t239 VSS 0.05577f
C6528 VDD.t388 VSS 0.15952f
C6529 VDD.t257 VSS 0.04452f
C6530 VDD.t253 VSS 0.84548f
C6531 VDD.t383 VSS 0.16412f
C6532 VDD.t385 VSS 0.04452f
C6533 VDD.t254 VSS 0.03992f
C6534 VDD.t828 VSS 0.23697f
C6535 VDD.t1446 VSS 0.73627f
C6536 VDD.t831 VSS 0.04452f
C6537 VDD.t1447 VSS 0.87863f
C6538 VDD.t832 VSS 0.03992f
C6539 VDD.t1449 VSS 0.04452f
C6540 VDD.t78 VSS 0.05426f
C6541 VDD.t77 VSS 0.11793f
C6542 VDD.t1451 VSS 0.03992f
C6543 VDD.t749 VSS 0.03992f
C6544 VDD.t1900 VSS 0.0626f
C6545 VDD.t1899 VSS 0.15962f
C6546 VDD.t243 VSS 0.15447f
C6547 VDD.t242 VSS 0.14815f
C6548 VDD.t829 VSS 0.07841f
C6549 VDD.t240 VSS 0.12546f
C6550 VDD.t677 VSS 0.15962f
C6551 VDD.t676 VSS 0.0626f
C6552 VDD.t834 VSS 0.03992f
C6553 VDD.t522 VSS 0.11874f
C6554 VDD.t1955 VSS 0.03992f
C6555 VDD.t521 VSS 0.05442f
C6556 VDD.t752 VSS 0.0474f
C6557 VDD.t1954 VSS 0.07824f
C6558 VDD.t1951 VSS 0.17937f
C6559 VDD.t750 VSS 0.0819f
C6560 VDD.t748 VSS 0.16412f
C6561 VDD.t1952 VSS 0.03992f
C6562 VDD.t263 VSS 0.4335f
C6563 VDD.t474 VSS 0.3437f
C6564 VDD.t475 VSS 0.7537f
C6565 VDD.t262 VSS 0.43983f
C6566 VDD.t759 VSS 0.13215f
C6567 VDD.t476 VSS 0.03992f
C6568 VDD.t1895 VSS 0.05453f
C6569 VDD.t758 VSS 0.13848f
C6570 VDD.t1896 VSS 0.11926f
C6571 VDD.t1902 VSS 0.10309f
C6572 VDD.t1898 VSS 0.18392f
C6573 VDD.t259 VSS 0.13697f
C6574 VDD.t260 VSS 0.13065f
C6575 VDD.t473 VSS 0.21722f
C6576 VDD.t322 VSS 0.03992f
C6577 VDD.t80 VSS 0.11424f
C6578 VDD.t81 VSS 0.03992f
C6579 VDD.t320 VSS 0.21424f
C6580 VDD.t835 VSS 0.03992f
C6581 VDD.t318 VSS 0.08695f
C6582 VDD.t836 VSS 0.19226f
C6583 VDD.t317 VSS 0.03992f
C6584 VDD.t833 VSS 0.04452f
C6585 VDD.n426 VSS 0.1138f
C6586 VDD.t685 VSS 0.13695f
C6587 VDD.t686 VSS 0.13063f
C6588 VDD.t384 VSS 0.03992f
C6589 VDD.t431 VSS 0.17459f
C6590 VDD.t524 VSS 0.10359f
C6591 VDD.t526 VSS 0.09727f
C6592 VDD.t429 VSS 0.17919f
C6593 VDD.t757 VSS 0.16029f
C6594 VDD.t427 VSS 0.7054f
C6595 VDD.t756 VSS 0.16489f
C6596 VDD.t426 VSS 0.03992f
C6597 VDD.t753 VSS 0.72343f
C6598 VDD.t424 VSS 0.13695f
C6599 VDD.t423 VSS 0.13063f
C6600 VDD.t755 VSS 0.71883f
C6601 VDD.t421 VSS 0.10937f
C6602 VDD.t252 VSS 0.21123f
C6603 VDD.t422 VSS 0.10304f
C6604 VDD.t673 VSS 0.76935f
C6605 VDD.t251 VSS 0.21583f
C6606 VDD.t248 VSS 0.04452f
C6607 VDD.t672 VSS 0.92551f
C6608 VDD.t671 VSS 0.04452f
C6609 VDD.t249 VSS 0.03992f
C6610 VDD.t245 VSS 0.13695f
C6611 VDD.t246 VSS 0.13063f
C6612 VDD.t670 VSS 0.03992f
C6613 VDD.t520 VSS 0.17448f
C6614 VDD.t394 VSS 0.10359f
C6615 VDD.t395 VSS 0.09727f
C6616 VDD.t518 VSS 0.17908f
C6617 VDD.t440 VSS 0.03992f
C6618 VDD.t516 VSS 0.04452f
C6619 VDD.t441 VSS 0.04452f
C6620 VDD.t515 VSS 0.03992f
C6621 VDD.t438 VSS 0.1643f
C6622 VDD.t472 VSS 0.16097f
C6623 VDD.t1444 VSS 0.1375f
C6624 VDD.t439 VSS 0.1597f
C6625 VDD.t1443 VSS 0.03992f
C6626 VDD.t76 VSS 0.17634f
C6627 VDD.t70 VSS 0.10311f
C6628 VDD.t75 VSS 0.18094f
C6629 VDD.t69 VSS 0.09679f
C6630 VDD.t72 VSS 0.04452f
C6631 VDD.t1894 VSS 0.03992f
C6632 VDD.t73 VSS 0.03992f
C6633 VDD.t1892 VSS 0.04452f
C6634 VDD.t1890 VSS 0.89952f
C6635 VDD.t393 VSS 0.1029f
C6636 VDD.t435 VSS 0.2843f
C6637 VDD.t1889 VSS 0.76109f
C6638 VDD.t436 VSS 0.21315f
C6639 VDD.t469 VSS 0.21422f
C6640 VDD.t684 VSS 0.03992f
C6641 VDD.t468 VSS 0.21882f
C6642 VDD.t682 VSS 0.04452f
C6643 VDD.t467 VSS 0.04452f
C6644 VDD.t680 VSS 0.21882f
C6645 VDD.t466 VSS 0.03992f
C6646 VDD.t679 VSS 0.03992f
C6647 VDD.n427 VSS 0.17648f
C6648 VDD.t45 VSS 0.03992f
C6649 VDD.t1977 VSS 0.03992f
C6650 VDD.t202 VSS 0.03992f
C6651 VDD.t1949 VSS 0.03992f
C6652 VDD.t1948 VSS 0.11108f
C6653 VDD.t815 VSS 0.1029f
C6654 VDD.t203 VSS 0.86606f
C6655 VDD.t205 VSS 0.04452f
C6656 VDD.t218 VSS 0.03992f
C6657 VDD.t207 VSS 0.03992f
C6658 VDD.t217 VSS 0.04452f
C6659 VDD.t661 VSS 0.09679f
C6660 VDD.t220 VSS 0.84233f
C6661 VDD.t662 VSS 0.10311f
C6662 VDD.t221 VSS 0.83773f
C6663 VDD.t593 VSS 0.03992f
C6664 VDD.t223 VSS 0.1597f
C6665 VDD.t594 VSS 0.1375f
C6666 VDD.t1491 VSS 0.10122f
C6667 VDD.t222 VSS 0.1643f
C6668 VDD.t1937 VSS 0.03992f
C6669 VDD.t225 VSS 0.04452f
C6670 VDD.t1938 VSS 0.04452f
C6671 VDD.t226 VSS 0.03992f
C6672 VDD.t1939 VSS 0.17908f
C6673 VDD.t746 VSS 0.41858f
C6674 VDD.t744 VSS 0.4249f
C6675 VDD.t1940 VSS 0.17448f
C6676 VDD.t803 VSS 0.03992f
C6677 VDD.t508 VSS 0.28528f
C6678 VDD.t507 VSS 0.29161f
C6679 VDD.t817 VSS 0.03992f
C6680 VDD.t804 VSS 0.19608f
C6681 VDD.t805 VSS 0.9563f
C6682 VDD.t1059 VSS 0.04452f
C6683 VDD.t1057 VSS 0.19608f
C6684 VDD.t647 VSS 0.21123f
C6685 VDD.t559 VSS 0.29091f
C6686 VDD.t558 VSS 0.03992f
C6687 VDD.t579 VSS 0.74892f
C6688 VDD.t638 VSS 0.10937f
C6689 VDD.t648 VSS 0.03992f
C6690 VDD.t639 VSS 0.03992f
C6691 VDD.t1061 VSS 0.03992f
C6692 VDD.t649 VSS 0.04452f
C6693 VDD.t646 VSS 0.21583f
C6694 VDD.t800 VSS 0.13695f
C6695 VDD.t801 VSS 0.13063f
C6696 VDD.t1927 VSS 0.03992f
C6697 VDD.t159 VSS 0.07359f
C6698 VDD.t1934 VSS 0.10359f
C6699 VDD.t1935 VSS 0.09727f
C6700 VDD.t157 VSS 0.07819f
C6701 VDD.t580 VSS 0.03992f
C6702 VDD.t155 VSS 0.17919f
C6703 VDD.t581 VSS 0.16489f
C6704 VDD.t156 VSS 0.03992f
C6705 VDD.t578 VSS 0.75352f
C6706 VDD.t584 VSS 0.13695f
C6707 VDD.t585 VSS 0.13063f
C6708 VDD.t563 VSS 0.03992f
C6709 VDD.t645 VSS 0.03992f
C6710 VDD.t652 VSS 0.10359f
C6711 VDD.t653 VSS 0.09727f
C6712 VDD.t643 VSS 0.04452f
C6713 VDD.t1072 VSS 0.19388f
C6714 VDD.t641 VSS 0.84419f
C6715 VDD.t1073 VSS 0.19848f
C6716 VDD.t640 VSS 0.17769f
C6717 VDD.t1070 VSS 0.90922f
C6718 VDD.t1932 VSS 0.13695f
C6719 VDD.t1931 VSS 0.13063f
C6720 VDD.t197 VSS 0.03992f
C6721 VDD.t407 VSS 0.10424f
C6722 VDD.t37 VSS 0.03992f
C6723 VDD.t406 VSS 0.09792f
C6724 VDD.t565 VSS 0.03992f
C6725 VDD.t36 VSS 0.07824f
C6726 VDD.t33 VSS 0.17937f
C6727 VDD.t562 VSS 0.16412f
C6728 VDD.t561 VSS 0.04452f
C6729 VDD.t34 VSS 0.03992f
C6730 VDD.t656 VSS 0.4335f
C6731 VDD.t1111 VSS 0.04452f
C6732 VDD.t1113 VSS 0.16641f
C6733 VDD.t655 VSS 0.43983f
C6734 VDD.t588 VSS 0.03992f
C6735 VDD.t1115 VSS 0.03992f
C6736 VDD.t1066 VSS 0.09833f
C6737 VDD.t587 VSS 0.29839f
C6738 VDD.t1067 VSS 0.10465f
C6739 VDD.t38 VSS 0.10309f
C6740 VDD.t572 VSS 0.18392f
C6741 VDD.t366 VSS 0.13697f
C6742 VDD.t367 VSS 0.03992f
C6743 VDD.t1110 VSS 0.03992f
C6744 VDD.t571 VSS 0.03992f
C6745 VDD.t346 VSS 0.11424f
C6746 VDD.t347 VSS 0.03992f
C6747 VDD.t569 VSS 0.04452f
C6748 VDD.t198 VSS 0.03992f
C6749 VDD.t567 VSS 0.21424f
C6750 VDD.t199 VSS 0.04452f
C6751 VDD.t566 VSS 0.20964f
C6752 VDD.t196 VSS 0.19226f
C6753 VDD.t630 VSS 0.89423f
C6754 VDD.t1055 VSS 0.19226f
C6755 VDD.t631 VSS 0.03992f
C6756 VDD.t1052 VSS 0.04452f
C6757 VDD.t556 VSS 0.03992f
C6758 VDD.t550 VSS 0.84512f
C6759 VDD.t552 VSS 0.04452f
C6760 VDD.t555 VSS 0.12221f
C6761 VDD.t194 VSS 0.06298f
C6762 VDD.t554 VSS 0.03992f
C6763 VDD.t127 VSS 0.09833f
C6764 VDD.t193 VSS 0.16153f
C6765 VDD.t128 VSS 0.26419f
C6766 VDD.t382 VSS 0.17616f
C6767 VDD.t291 VSS 0.18392f
C6768 VDD.t1096 VSS 0.29159f
C6769 VDD.t1097 VSS 0.28527f
C6770 VDD.t549 VSS 0.03992f
C6771 VDD.t634 VSS 0.03992f
C6772 VDD.t26 VSS 0.43979f
C6773 VDD.t28 VSS 0.43347f
C6774 VDD.t632 VSS 0.25695f
C6775 VDD.t1056 VSS 0.18766f
C6776 VDD.t125 VSS 0.13695f
C6777 VDD.t124 VSS 0.03992f
C6778 VDD.t1053 VSS 0.03992f
C6779 VDD.t188 VSS 0.44293f
C6780 VDD.t794 VSS 0.17477f
C6781 VDD.t187 VSS 0.37861f
C6782 VDD.t895 VSS 0.74517f
C6783 VDD.t795 VSS 0.17937f
C6784 VDD.t791 VSS 0.04452f
C6785 VDD.t893 VSS 0.74977f
C6786 VDD.t891 VSS 0.16412f
C6787 VDD.t792 VSS 0.03992f
C6788 VDD.t378 VSS 0.29157f
C6789 VDD.t379 VSS 0.28525f
C6790 VDD.t890 VSS 0.03992f
C6791 VDD.t887 VSS 0.03992f
C6792 VDD.t190 VSS 0.4249f
C6793 VDD.t191 VSS 0.41858f
C6794 VDD.t886 VSS 0.18229f
C6795 VDD.t23 VSS 0.03992f
C6796 VDD.t885 VSS 0.74087f
C6797 VDD.t24 VSS 0.04452f
C6798 VDD.t884 VSS 0.03992f
C6799 VDD.t20 VSS 0.89024f
C6800 VDD.t867 VSS 0.31211f
C6801 VDD.t866 VSS 0.03992f
C6802 VDD.t21 VSS 0.88564f
C6803 VDD.t858 VSS 0.10962f
C6804 VDD.t298 VSS 0.03992f
C6805 VDD.t857 VSS 0.03992f
C6806 VDD.t727 VSS 0.73616f
C6807 VDD.t938 VSS 0.03992f
C6808 VDD.t1496 VSS 0.03992f
C6809 VDD.t728 VSS 0.74076f
C6810 VDD.t725 VSS 0.18415f
C6811 VDD.t1495 VSS 0.74977f
C6812 VDD.t1493 VSS 0.16412f
C6813 VDD.t726 VSS 0.03992f
C6814 VDD.t944 VSS 0.31211f
C6815 VDD.t943 VSS 0.03992f
C6816 VDD.t599 VSS 0.03992f
C6817 VDD.t939 VSS 0.10962f
C6818 VDD.t1634 VSS 0.13695f
C6819 VDD.t1635 VSS 0.13063f
C6820 VDD.t1526 VSS 0.03992f
C6821 VDD.t854 VSS 0.03992f
C6822 VDD.t1923 VSS 0.4249f
C6823 VDD.t1924 VSS 0.03992f
C6824 VDD.t853 VSS 0.04452f
C6825 VDD.t602 VSS 0.03992f
C6826 VDD.t852 VSS 0.18229f
C6827 VDD.t601 VSS 0.04452f
C6828 VDD.t851 VSS 0.03992f
C6829 VDD.t598 VSS 0.89024f
C6830 VDD.t952 VSS 0.29093f
C6831 VDD.t951 VSS 0.03992f
C6832 VDD.t1014 VSS 0.03992f
C6833 VDD.t1402 VSS 0.44293f
C6834 VDD.t1024 VSS 0.17477f
C6835 VDD.t1401 VSS 0.37861f
C6836 VDD.t1529 VSS 0.06982f
C6837 VDD.t1025 VSS 0.17937f
C6838 VDD.t1022 VSS 0.04452f
C6839 VDD.t1528 VSS 0.07442f
C6840 VDD.t1527 VSS 0.16412f
C6841 VDD.t1023 VSS 0.03992f
C6842 VDD.t1511 VSS 0.11588f
C6843 VDD.t1791 VSS 0.84512f
C6844 VDD.t1793 VSS 0.04452f
C6845 VDD.t1510 VSS 0.12221f
C6846 VDD.t1029 VSS 0.2229f
C6847 VDD.t1795 VSS 0.03992f
C6848 VDD.t324 VSS 0.09833f
C6849 VDD.t1028 VSS 0.32145f
C6850 VDD.t323 VSS 0.26419f
C6851 VDD.t1314 VSS 0.10309f
C6852 VDD.t963 VSS 0.10744f
C6853 VDD.t1354 VSS 0.29159f
C6854 VDD.t1355 VSS 0.03992f
C6855 VDD.t1790 VSS 0.16181f
C6856 VDD.t1743 VSS 0.20964f
C6857 VDD.t1717 VSS 0.11424f
C6858 VDD.t1718 VSS 0.03992f
C6859 VDD.t1742 VSS 0.21424f
C6860 VDD.t1016 VSS 0.03992f
C6861 VDD.t1741 VSS 0.04452f
C6862 VDD.t1017 VSS 0.19226f
C6863 VDD.t1740 VSS 0.03992f
C6864 VDD.t1013 VSS 0.04452f
C6865 VDD.n428 VSS 0.1138f
C6866 VDD.t1816 VSS 0.29157f
C6867 VDD.t1817 VSS 0.28525f
C6868 VDD.t1492 VSS 0.03992f
C6869 VDD.t1623 VSS 0.17459f
C6870 VDD.t1433 VSS 0.10359f
C6871 VDD.t1434 VSS 0.09727f
C6872 VDD.t1622 VSS 0.17919f
C6873 VDD.t1821 VSS 0.03992f
C6874 VDD.t1621 VSS 0.04452f
C6875 VDD.t1822 VSS 0.04452f
C6876 VDD.t1620 VSS 0.03992f
C6877 VDD.t1819 VSS 0.16489f
C6878 VDD.t1738 VSS 0.13695f
C6879 VDD.t1737 VSS 0.13063f
C6880 VDD.t1820 VSS 0.16029f
C6881 VDD.t1381 VSS 0.43536f
C6882 VDD.t1647 VSS 0.03992f
C6883 VDD.t1380 VSS 0.03992f
C6884 VDD.t1586 VSS 0.03992f
C6885 VDD.t1644 VSS 0.04452f
C6886 VDD.t1643 VSS 0.89516f
C6887 VDD.t1584 VSS 0.04452f
C6888 VDD.t1582 VSS 0.19608f
C6889 VDD.t1722 VSS 0.88762f
C6890 VDD.t1721 VSS 0.04452f
C6891 VDD.t1389 VSS 0.89056f
C6892 VDD.t1477 VSS 0.31428f
C6893 VDD.t1479 VSS 0.21726f
C6894 VDD.t1720 VSS 0.03992f
C6895 VDD.t1884 VSS 0.17448f
C6896 VDD.t870 VSS 0.4249f
C6897 VDD.t871 VSS 0.41858f
C6898 VDD.t1882 VSS 0.17908f
C6899 VDD.t327 VSS 0.03992f
C6900 VDD.t1880 VSS 0.04452f
C6901 VDD.t328 VSS 0.07447f
C6902 VDD.t1879 VSS 0.03992f
C6903 VDD.t325 VSS 0.17178f
C6904 VDD.t1031 VSS 0.16097f
C6905 VDD.t1838 VSS 0.29495f
C6906 VDD.t326 VSS 0.04741f
C6907 VDD.t1837 VSS 0.13117f
C6908 VDD.t489 VSS 0.17634f
C6909 VDD.t278 VSS 0.10311f
C6910 VDD.t490 VSS 0.18094f
C6911 VDD.t277 VSS 0.09679f
C6912 VDD.t487 VSS 0.04452f
C6913 VDD.t1408 VSS 0.03992f
C6914 VDD.t488 VSS 0.03992f
C6915 VDD.t1405 VSS 0.04452f
C6916 VDD.t1404 VSS 0.17835f
C6917 VDD.t1809 VSS 0.16331f
C6918 VDD.t1503 VSS 0.26809f
C6919 VDD.t1406 VSS 0.03992f
C6920 VDD.t1504 VSS 0.26177f
C6921 VDD.t1517 VSS 0.03992f
C6922 VDD.t722 VSS 0.03992f
C6923 VDD.t1516 VSS 0.04452f
C6924 VDD.t721 VSS 0.04452f
C6925 VDD.t1515 VSS 0.26239f
C6926 VDD.t719 VSS 0.21882f
C6927 VDD.t1514 VSS 0.0835f
C6928 VDD.t718 VSS 0.03992f
C6929 VDD.n429 VSS 0.17648f
C6930 VDD.t1155 VSS 0.03992f
C6931 VDD.t1323 VSS 0.03992f
C6932 VDD.t1776 VSS 0.03992f
C6933 VDD.t874 VSS 0.26177f
C6934 VDD.t873 VSS 0.26809f
C6935 VDD.t1587 VSS 0.1029f
C6936 VDD.t1777 VSS 0.86749f
C6937 VDD.t1778 VSS 0.04452f
C6938 VDD.t1598 VSS 0.03992f
C6939 VDD.t1779 VSS 0.03992f
C6940 VDD.t1597 VSS 0.04452f
C6941 VDD.t1282 VSS 0.44588f
C6942 VDD.t1600 VSS 0.18141f
C6943 VDD.t1283 VSS 0.4522f
C6944 VDD.t1599 VSS 0.17681f
C6945 VDD.t1714 VSS 0.03992f
C6946 VDD.t771 VSS 0.83792f
C6947 VDD.t1715 VSS 0.1375f
C6948 VDD.t1789 VSS 0.16558f
C6949 VDD.t770 VSS 0.84252f
C6950 VDD.t1698 VSS 0.03992f
C6951 VDD.t773 VSS 0.04452f
C6952 VDD.t1699 VSS 0.04452f
C6953 VDD.t774 VSS 0.03992f
C6954 VDD.t1701 VSS 0.88613f
C6955 VDD.t1533 VSS 0.41858f
C6956 VDD.t1532 VSS 0.4249f
C6957 VDD.t1703 VSS 0.74697f
C6958 VDD.t101 VSS 0.03992f
C6959 VDD.t1500 VSS 0.0626f
C6960 VDD.t1499 VSS 0.15962f
C6961 VDD.t1734 VSS 0.76208f
C6962 VDD.t102 VSS 0.04452f
C6963 VDD.t104 VSS 0.92658f
C6964 VDD.t1732 VSS 0.93799f
C6965 VDD.t1735 VSS 0.04452f
C6966 VDD.t106 VSS 0.77042f
C6967 VDD.t172 VSS 0.03992f
C6968 VDD.t1736 VSS 0.03992f
C6969 VDD.t173 VSS 0.10937f
C6970 VDD.t1438 VSS 0.03992f
C6971 VDD.t1255 VSS 0.29773f
C6972 VDD.t1256 VSS 0.30405f
C6973 VDD.t1437 VSS 0.17238f
C6974 VDD.t1441 VSS 0.04452f
C6975 VDD.t1480 VSS 0.04455f
C6976 VDD.t1205 VSS 0.15832f
C6977 VDD.t179 VSS 0.24229f
C6978 VDD.t1704 VSS 0.07483f
C6979 VDD.t1146 VSS 0.05464f
C6980 VDD.t1440 VSS 0.03992f
C6981 VDD.t1672 VSS 0.3763f
C6982 VDD.t1506 VSS 0.10003f
C6983 VDD.t375 VSS 0.02357f
C6984 VDD.t397 VSS 0.10887f
C6985 VDD.t1671 VSS 0.4429f
C6986 VDD.t1604 VSS 0.13158f
C6987 VDD.t398 VSS 0.46026f
C6988 VDD.t1603 VSS 0.13791f
C6989 VDD.t1617 VSS 0.13341f
C6990 VDD.t1618 VSS 0.30833f
C6991 VDD.t1483 VSS 0.05978f
C6992 VDD.t1313 VSS 0.595f
C6993 VDD.t1481 VSS 0.14551f
C6994 VDD.t163 VSS 0.01844f
C6995 VDD.t1210 VSS 0.10455f
C6996 VDD.t613 VSS 0.14768f
C6997 VDD.t992 VSS 0.25907f
C6998 VDD.t621 VSS 0.04235f
C6999 VDD.t1012 VSS 0.01854f
C7000 VDD.t548 VSS 0.02439f
C7001 VDD.t1436 VSS 0.23529f
C7002 VDD.t289 VSS 0.01844f
C7003 VDD.t957 VSS 0.19848f
C7004 VDD.t1032 VSS 0.17192f
C7005 VDD.t1241 VSS 0.01854f
C7006 VDD.t991 VSS 0.02071f
C7007 VDD.t623 VSS 0.04235f
C7008 VDD.t724 VSS 0.29058f
C7009 VDD.t665 VSS 0.03785f
C7010 VDD.t622 VSS 0.04235f
C7011 VDD.t161 VSS 0.04226f
C7012 VDD.t1310 VSS 0.0385f
C7013 VDD.t664 VSS 0.01844f
C7014 VDD.t1208 VSS 0.23694f
C7015 VDD.t372 VSS 0.01844f
C7016 VDD.t614 VSS 0.01844f
C7017 VDD.t1139 VSS 0.05464f
C7018 VDD.t374 VSS 0.01844f
C7019 VDD.t1239 VSS 0.46024f
C7020 VDD.t1835 VSS 0.07556f
C7021 VDD.t1289 VSS 0.05464f
C7022 VDD.t162 VSS 0.49793f
C7023 VDD.t1238 VSS 0.03992f
C7024 VDD.t1195 VSS 0.01844f
C7025 VDD.t1265 VSS 0.05464f
C7026 VDD.t6 VSS 0.09233f
C7027 VDD.t1836 VSS 0.02071f
C7028 VDD.t180 VSS 0.01861f
C7029 VDD.t1694 VSS 0.16329f
C7030 VDD.t1684 VSS 0.01854f
C7031 VDD.t1178 VSS 0.14762f
C7032 VDD.t288 VSS 1.30574f
C7033 VDD.t948 VSS 0.21209f
C7034 VDD.t1311 VSS 0.01857f
C7035 VDD.t1232 VSS 0.02235f
C7036 VDD.t146 VSS 0.16967f
C7037 VDD.t373 VSS 0.01855f
C7038 VDD.t370 VSS 0.369f
C7039 VDD.t371 VSS 0.15859f
C7040 VDD.t1164 VSS 1.05207f
C7041 VDD.t357 VSS 0.13551f
C7042 VDD.t1162 VSS 0.05737f
C7043 VDD.t1160 VSS 0.05737f
C7044 VDD.t1158 VSS 0.05737f
C7045 VDD.t1909 VSS 0.07338f
C7046 VDD.t1157 VSS 0.05734f
C7047 VDD.t1215 VSS 0.03992f
C7048 VDD.t1275 VSS 0.05687f
C7049 VDD.t1566 VSS 0.1603f
C7050 VDD.t1229 VSS 0.10896f
C7051 VDD.t1216 VSS 0.04452f
C7052 VDD.t1213 VSS 0.88936f
C7053 VDD.t1228 VSS 0.03992f
C7054 VDD.t1173 VSS 0.05737f
C7055 VDD.t1171 VSS 0.05737f
C7056 VDD.t1169 VSS 0.58732f
C7057 VDD.t1167 VSS 0.53007f
C7058 VDD.t1166 VSS 0.05734f
C7059 VDD.t1214 VSS 0.03992f
C7060 VDD.t1786 VSS 1.11676f
C7061 VDD.t780 VSS 0.03992f
C7062 VDD.t1142 VSS 0.16543f
C7063 VDD.t1182 VSS 0.1042f
C7064 VDD.t781 VSS 0.04452f
C7065 VDD.t778 VSS 0.17285f
C7066 VDD.t1181 VSS 0.03992f
C7067 VDD.t1273 VSS 0.32184f
C7068 VDD.t1193 VSS 0.05734f
C7069 VDD.t1191 VSS 0.05737f
C7070 VDD.t1189 VSS 0.05737f
C7071 VDD.t1187 VSS 0.50041f
C7072 VDD.t779 VSS 0.16825f
C7073 VDD.t1185 VSS 0.18986f
C7074 VDD.t1179 VSS 0.14587f
C7075 VDD.t123 VSS 0.04923f
C7076 VDD.t149 VSS 0.31347f
C7077 VDD.t120 VSS 0.03785f
C7078 VDD.t381 VSS 0.04235f
C7079 VDD.t1222 VSS 0.04226f
C7080 VDD.t148 VSS 0.1853f
C7081 VDD.t167 VSS 0.29603f
C7082 VDD.t1044 VSS 0.01844f
C7083 VDD.t481 VSS 1.34266f
C7084 VDD.t121 VSS 0.02061f
C7085 VDD.t389 VSS 0.01854f
C7086 VDD.t1221 VSS 0.01845f
C7087 VDD.t1696 VSS 0.15832f
C7088 VDD.t1242 VSS 0.29951f
C7089 VDD.t119 VSS 0.1876f
C7090 VDD.t122 VSS 1.53708f
C7091 VDD.t1243 VSS 0.34886f
C7092 VDD.t1278 VSS 0.01844f
C7093 VDD.t1224 VSS 0.26285f
C7094 VDD.t118 VSS 0.60963f
C7095 VDD.t1140 VSS 0.02235f
C7096 VDD.t176 VSS 0.12714f
C7097 VDD.t747 VSS 0.01855f
C7098 VDD.t433 VSS 0.10406f
C7099 VDD.t432 VSS 0.09774f
C7100 VDD.t178 VSS 0.03992f
C7101 VDD.t659 VSS 0.05464f
C7102 VDD.t391 VSS 0.28443f
C7103 VDD.t1305 VSS 0.26891f
C7104 VDD.t390 VSS 0.10827f
C7105 VDD.t482 VSS 0.10859f
C7106 VDD.t1306 VSS 0.03992f
C7107 VDD.t1138 VSS 0.01854f
C7108 VDD.t369 VSS 0.2149f
C7109 VDD.t1194 VSS 0.36383f
C7110 VDD.t168 VSS 0.17323f
C7111 VDD.t603 VSS 0.20461f
C7112 VDD.t660 VSS 0.05464f
C7113 VDD.t1695 VSS 2.70068f
C7114 VDD.t303 VSS 0.47846f
C7115 VDD.t1200 VSS 0.13711f
C7116 VDD.t302 VSS 0.38141f
C7117 VDD.t1199 VSS 0.13079f
C7118 VDD.n430 VSS 0.17188f
C7119 VDD.t139 VSS 0.32855f
C7120 VDD.t170 VSS 0.31785f
C7121 VDD.t1040 VSS 0.03992f
C7122 VDD.t1234 VSS 0.66544f
C7123 VDD.t618 VSS 0.08635f
C7124 VDD.t1043 VSS 0.38371f
C7125 VDD.t1042 VSS 0.38831f
C7126 VDD.t1039 VSS 0.76756f
C7127 VDD.t1294 VSS 0.31258f
C7128 VDD.t1293 VSS 0.3189f
C7129 VDD.t1973 VSS 0.11233f
C7130 VDD.t1220 VSS 0.33724f
C7131 VDD.t615 VSS 0.05464f
C7132 VDD.t160 VSS 0.06336f
C7133 VDD.t611 VSS 0.02061f
C7134 VDD.t377 VSS 0.3018f
C7135 VDD.t1062 VSS 0.18303f
C7136 VDD.t287 VSS 0.28989f
C7137 VDD.t1226 VSS 0.17283f
C7138 VDD.t1245 VSS 0.3068f
C7139 VDD.t1246 VSS 0.30048f
C7140 VDD.t1211 VSS 0.30922f
C7141 VDD.t592 VSS 0.08162f
C7142 VDD.t596 VSS 0.1175f
C7143 VDD.t590 VSS 0.35006f
C7144 VDD.t597 VSS 0.05464f
C7145 VDD.t1123 VSS 0.32716f
C7146 VDD.t1124 VSS 0.32083f
C7147 VDD.t147 VSS 0.05464f
C7148 VDD.t1254 VSS 0.5747f
C7149 VDD.t1250 VSS 0.03992f
C7150 VDD.t1251 VSS 0.04452f
C7151 VDD.t1248 VSS 1.11123f
C7152 VDD.t1249 VSS 0.78828f
C7153 VDD.t925 VSS 0.35006f
C7154 VDD.t985 VSS 0.16318f
C7155 VDD.t986 VSS 0.06331f
C7156 VDD.t142 VSS 0.1215f
C7157 VDD.t143 VSS 0.45239f
C7158 VDD.t140 VSS 0.04452f
C7159 VDD.t141 VSS 0.03992f
C7160 VDD.t1557 VSS 0.52634f
C7161 VDD.t1556 VSS 0.53266f
C7162 VDD.t1 VSS 0.11196f
C7163 VDD.t461 VSS 0.05464f
C7164 VDD.t3 VSS 0.53321f
C7165 VDD.t2 VSS 0.5911f
C7166 VDD.t1559 VSS 0.11456f
C7167 VDD.t1864 VSS 0.17948f
C7168 VDD.t1865 VSS 0.17316f
C7169 VDD.t1562 VSS 0.54356f
C7170 VDD.t1563 VSS 0.53723f
C7171 VDD.t1175 VSS 0.05464f
C7172 VDD.t1553 VSS 0.31657f
C7173 VDD.t1554 VSS 0.31024f
C7174 VDD.t1747 VSS 0.76694f
C7175 VDD.t97 VSS 0.03992f
C7176 VDD.t1749 VSS 0.21424f
C7177 VDD.t1422 VSS 0.38248f
C7178 VDD.t1421 VSS 0.45679f
C7179 VDD.t1751 VSS 0.03992f
C7180 VDD.t839 VSS 0.03992f
C7181 VDD.t540 VSS 0.13065f
C7182 VDD.t539 VSS 0.13697f
C7183 VDD.t847 VSS 0.4335f
C7184 VDD.t840 VSS 0.16641f
C7185 VDD.t841 VSS 0.04452f
C7186 VDD.t845 VSS 0.43983f
C7187 VDD.t927 VSS 0.29207f
C7188 VDD.t842 VSS 0.03992f
C7189 VDD.t1427 VSS 0.03992f
C7190 VDD.t926 VSS 0.29839f
C7191 VDD.t1428 VSS 0.10465f
C7192 VDD.t934 VSS 0.17616f
C7193 VDD.t790 VSS 0.18392f
C7194 VDD.t98 VSS 0.04452f
C7195 VDD.t1746 VSS 0.76234f
C7196 VDD.t94 VSS 0.19226f
C7197 VDD.t692 VSS 0.29093f
C7198 VDD.t691 VSS 0.13063f
C7199 VDD.t95 VSS 0.03992f
C7200 VDD.t1958 VSS 0.10424f
C7201 VDD.t1913 VSS 0.17477f
C7202 VDD.t1957 VSS 0.09792f
C7203 VDD.t538 VSS 0.15952f
C7204 VDD.t1914 VSS 0.17937f
C7205 VDD.t1911 VSS 0.04452f
C7206 VDD.t536 VSS 0.16412f
C7207 VDD.t534 VSS 0.72664f
C7208 VDD.t1912 VSS 0.03992f
C7209 VDD.t484 VSS 0.31424f
C7210 VDD.t485 VSS 0.21722f
C7211 VDD.t533 VSS 0.03992f
C7212 VDD.t1761 VSS 0.03992f
C7213 VDD.t715 VSS 0.11801f
C7214 VDD.t716 VSS 0.05428f
C7215 VDD.t1760 VSS 0.04452f
C7216 VDD.t1328 VSS 0.03992f
C7217 VDD.t1759 VSS 0.85171f
C7218 VDD.t1327 VSS 0.04452f
C7219 VDD.t1758 VSS 0.03992f
C7220 VDD.t1324 VSS 0.23674f
C7221 VDD.t1416 VSS 0.31211f
C7222 VDD.t1415 VSS 0.14815f
C7223 VDD.t1326 VSS 0.07837f
C7224 VDD.t1419 VSS 0.45737f
C7225 VDD.t1970 VSS 0.03992f
C7226 VDD.t1418 VSS 0.03992f
C7227 VDD.t275 VSS 0.21475f
C7228 VDD.t1969 VSS 0.04452f
C7229 VDD.t1966 VSS 0.18497f
C7230 VDD.t274 VSS 0.91866f
C7231 VDD.t272 VSS 0.16412f
C7232 VDD.t1967 VSS 0.03992f
C7233 VDD.t1665 VSS 0.31424f
C7234 VDD.t1666 VSS 0.21722f
C7235 VDD.t271 VSS 0.15952f
C7236 VDD.t110 VSS 0.70091f
C7237 VDD.t1594 VSS 0.43924f
C7238 VDD.t1595 VSS 0.37557f
C7239 VDD.t109 VSS 0.70551f
C7240 VDD.t1650 VSS 0.03992f
C7241 VDD.t108 VSS 0.17919f
C7242 VDD.t1651 VSS 0.16489f
C7243 VDD.t107 VSS 0.17459f
C7244 VDD.t1648 VSS 0.07462f
C7245 VDD.t1316 VSS 0.13695f
C7246 VDD.t1315 VSS 0.13063f
C7247 VDD.t1649 VSS 0.07002f
C7248 VDD.t1675 VSS 0.10937f
C7249 VDD.t1390 VSS 0.03992f
C7250 VDD.t1674 VSS 0.03992f
C7251 VDD.t1723 VSS 0.88302f
C7252 VDD.t1391 VSS 0.04452f
C7253 VDD.t1388 VSS 0.89516f
C7254 VDD.n431 VSS 0.1138f
C7255 VDD.t1611 VSS 0.21424f
C7256 VDD.t1549 VSS 0.03992f
C7257 VDD.t1612 VSS 0.08695f
C7258 VDD.t882 VSS 0.38248f
C7259 VDD.t881 VSS 0.45679f
C7260 VDD.t1613 VSS 0.03992f
C7261 VDD.t1677 VSS 0.03992f
C7262 VDD.t1352 VSS 0.21722f
C7263 VDD.t1351 VSS 0.31427f
C7264 VDD.t1811 VSS 0.4335f
C7265 VDD.t1678 VSS 0.16641f
C7266 VDD.t1679 VSS 0.04452f
C7267 VDD.t1810 VSS 0.43983f
C7268 VDD.t1508 VSS 0.29207f
C7269 VDD.t1680 VSS 0.03992f
C7270 VDD.t1637 VSS 0.03992f
C7271 VDD.t1507 VSS 0.29839f
C7272 VDD.t1638 VSS 0.26419f
C7273 VDD.t1616 VSS 0.17616f
C7274 VDD.t950 VSS 0.10744f
C7275 VDD.t1550 VSS 0.04452f
C7276 VDD.t1610 VSS 0.03992f
C7277 VDD.t1547 VSS 0.88391f
C7278 VDD.t1874 VSS 0.29093f
C7279 VDD.t1873 VSS 0.13063f
C7280 VDD.t1548 VSS 0.03992f
C7281 VDD.t983 VSS 0.10424f
C7282 VDD.t117 VSS 0.03992f
C7283 VDD.t982 VSS 0.09792f
C7284 VDD.t933 VSS 0.83927f
C7285 VDD.t116 VSS 0.04452f
C7286 VDD.t113 VSS 0.83949f
C7287 VDD.t930 VSS 0.84387f
C7288 VDD.t929 VSS 0.04452f
C7289 VDD.t114 VSS 0.83489f
C7290 VDD.t280 VSS 0.10101f
C7291 VDD.t1019 VSS 0.32468f
C7292 VDD.t931 VSS 0.03992f
C7293 VDD.t712 VSS 0.03992f
C7294 VDD.t1020 VSS 0.22611f
C7295 VDD.t1129 VSS 0.10311f
C7296 VDD.t711 VSS 0.04452f
C7297 VDD.t710 VSS 0.18453f
C7298 VDD.t1130 VSS 0.03992f
C7299 VDD.t1801 VSS 0.03992f
C7300 VDD.t709 VSS 0.03992f
C7301 VDD.t1800 VSS 0.78306f
C7302 VDD.t1797 VSS 0.39373f
C7303 VDD.t1833 VSS 0.11206f
C7304 VDD.t1832 VSS 0.03992f
C7305 VDD.t1708 VSS 0.38087f
C7306 VDD.t1798 VSS 0.22456f
C7307 VDD.n432 VSS 0.1138f
C7308 VDD.t312 VSS 0.20858f
C7309 VDD.t786 VSS 0.03992f
C7310 VDD.t313 VSS 0.04452f
C7311 VDD.t1848 VSS 0.03992f
C7312 VDD.t1847 VSS 0.44046f
C7313 VDD.t314 VSS 0.03992f
C7314 VDD.t1266 VSS 0.03992f
C7315 VDD.t961 VSS 0.03992f
C7316 VDD.t960 VSS 0.29159f
C7317 VDD.t1706 VSS 0.4335f
C7318 VDD.t1267 VSS 0.85428f
C7319 VDD.t1269 VSS 0.24696f
C7320 VDD.t1705 VSS 0.43983f
C7321 VDD.t707 VSS 0.29178f
C7322 VDD.t1271 VSS 0.24236f
C7323 VDD.t164 VSS 0.03992f
C7324 VDD.t706 VSS 0.2981f
C7325 VDD.t165 VSS 0.25778f
C7326 VDD.t1687 VSS 0.10302f
C7327 VDD.t1468 VSS 0.18481f
C7328 VDD.t787 VSS 0.04452f
C7329 VDD.t311 VSS 0.03992f
C7330 VDD.t784 VSS 0.88555f
C7331 VDD.t1981 VSS 0.13695f
C7332 VDD.t1980 VSS 0.03992f
C7333 VDD.t785 VSS 0.03992f
C7334 VDD.t55 VSS 0.10424f
C7335 VDD.t1853 VSS 0.03992f
C7336 VDD.t54 VSS 0.09792f
C7337 VDD.t610 VSS 0.70513f
C7338 VDD.t1854 VSS 0.83937f
C7339 VDD.t1850 VSS 0.04452f
C7340 VDD.t608 VSS 0.70973f
C7341 VDD.t606 VSS 0.16448f
C7342 VDD.t1851 VSS 0.03992f
C7343 VDD.t1709 VSS 0.10122f
C7344 VDD.t1876 VSS 0.28063f
C7345 VDD.t605 VSS 0.15988f
C7346 VDD.t1300 VSS 0.74354f
C7347 VDD.t1877 VSS 0.21466f
C7348 VDD.t1842 VSS 0.03992f
C7349 VDD.t1297 VSS 0.88627f
C7350 VDD.t1843 VSS 0.04452f
C7351 VDD.t1296 VSS 0.04452f
C7352 VDD.t1840 VSS 0.16657f
C7353 VDD.t1298 VSS 0.03992f
C7354 VDD.t1841 VSS 0.03992f
C7355 VDD.t462 VSS 0.05464f
C7356 VDD.t290 VSS 0.24633f
C7357 VDD.t1132 VSS 0.05464f
C7358 VDD.t376 VSS 0.01846f
C7359 VDD.t1212 VSS 0.05464f
C7360 VDD.t1466 VSS 0.13971f
C7361 VDD.t959 VSS 0.2943f
C7362 VDD.n433 VSS 0.1138f
C7363 VDD.t1038 VSS 0.35942f
C7364 VDD.t1037 VSS 0.36402f
C7365 VDD.t1034 VSS 0.04452f
C7366 VDD.t1035 VSS 0.03992f
C7367 VDD.t1292 VSS 0.05464f
C7368 VDD.t1488 VSS 0.01857f
C7369 VDD.t136 VSS 0.0693f
C7370 VDD.t7 VSS 0.01855f
C7371 VDD.t1237 VSS 0.05464f
C7372 VDD.t1203 VSS 0.27687f
C7373 VDD.t1144 VSS 0.21405f
C7374 VDD.t1143 VSS 0.2248f
C7375 VDD.t1202 VSS 0.30584f
C7376 VDD.t1204 VSS 0.11218f
C7377 VDD.t1147 VSS 0.32331f
C7378 VDD.t1149 VSS 0.31699f
C7379 VDD.t1231 VSS 0.1151f
C7380 VDD.t1260 VSS 0.33767f
C7381 VDD.t1262 VSS 0.23062f
C7382 VDD.t1198 VSS 0.7252f
C7383 VDD.t619 VSS 0.39502f
C7384 VDD.t292 VSS 0.17579f
C7385 VDD.t1134 VSS 0.54666f
C7386 VDD.t1135 VSS 0.5759f
C7387 VDD.t1176 VSS 0.19761f
C7388 VDD.t1153 VSS 0.04452f
C7389 VDD.t1321 VSS 0.04452f
C7390 VDD.t1151 VSS 0.26239f
C7391 VDD.t1319 VSS 0.8752f
C7392 VDD.t1150 VSS 0.0835f
C7393 VDD.t1318 VSS 0.8706f
C7394 VDD.n434 VSS 0.17648f
C7395 VDD.n435 VSS 0.12596f
C7396 VDD.t1090 VSS 0.21663f
C7397 VDD.t1046 VSS 0.03992f
C7398 VDD.t901 VSS 0.71523f
C7399 VDD.t970 VSS 0.17023f
C7400 VDD.t1045 VSS 0.11267f
C7401 VDD.t130 VSS 0.1029f
C7402 VDD.t16 VSS 0.07387f
C7403 VDD.t971 VSS 0.17483f
C7404 VDD.t972 VSS 0.73444f
C7405 VDD.t15 VSS 0.07847f
C7406 VDD.t18 VSS 0.1803f
C7407 VDD.t973 VSS 0.72984f
C7408 VDD.t1668 VSS 0.03992f
C7409 VDD.t19 VSS 0.03992f
C7410 VDD.t1092 VSS 0.71699f
C7411 VDD.t1669 VSS 0.43241f
C7412 VDD.t337 VSS 0.03992f
C7413 VDD.t338 VSS 0.29107f
C7414 VDD.t1091 VSS 0.72159f
C7415 VDD.t9 VSS 0.03992f
C7416 VDD.t1094 VSS 0.1648f
C7417 VDD.t10 VSS 0.17913f
C7418 VDD.t1095 VSS 0.1602f
C7419 VDD.t11 VSS 0.73898f
C7420 VDD.t1050 VSS 0.09727f
C7421 VDD.t1048 VSS 0.10359f
C7422 VDD.t12 VSS 0.73438f
C7423 VDD.t181 VSS 0.03992f
C7424 VDD.t637 VSS 0.03992f
C7425 VDD.t635 VSS 0.13695f
C7426 VDD.t359 VSS 0.89056f
C7427 VDD.t182 VSS 0.88762f
C7428 VDD.t184 VSS 0.04452f
C7429 VDD.t358 VSS 0.89516f
C7430 VDD.t361 VSS 0.04452f
C7431 VDD.t185 VSS 0.03992f
C7432 VDD.t731 VSS 0.03992f
C7433 VDD.t362 VSS 0.03992f
C7434 VDD.t732 VSS 0.43536f
C7435 VDD.t132 VSS 0.83919f
C7436 VDD.t494 VSS 0.13063f
C7437 VDD.t493 VSS 0.13695f
C7438 VDD.t131 VSS 0.84379f
C7439 VDD.t495 VSS 0.03992f
C7440 VDD.t134 VSS 0.04452f
C7441 VDD.t496 VSS 0.84006f
C7442 VDD.t135 VSS 0.03992f
C7443 VDD.t497 VSS 0.24341f
C7444 VDD.t465 VSS 0.41858f
C7445 VDD.t463 VSS 0.4249f
C7446 VDD.t498 VSS 0.23881f
C7447 VDD.t624 VSS 0.03992f
C7448 VDD.t295 VSS 0.13063f
C7449 VDD.t293 VSS 0.13695f
C7450 VDD.t297 VSS 0.04865f
C7451 VDD.t625 VSS 0.04452f
C7452 VDD.t626 VSS 0.83947f
C7453 VDD.t296 VSS 0.08816f
C7454 VDD.t299 VSS 0.18415f
C7455 VDD.t627 VSS 0.03992f
C7456 VDD.t899 VSS 0.71983f
C7457 VDD.t897 VSS 0.19117f
C7458 VDD.t1089 VSS 0.22123f
C7459 VDD.t1086 VSS 0.04452f
C7460 VDD.t896 VSS 0.18657f
C7461 VDD.t1664 VSS 0.05464f
C7462 VDD.t1088 VSS 0.04149f
C7463 VDD.t969 VSS 0.03992f
C7464 VDD.t1807 VSS 0.03992f
C7465 VDD.t1857 VSS 0.03992f
C7466 VDD.t1572 VSS 0.03992f
C7467 VDD.t1571 VSS 0.27812f
C7468 VDD.t947 VSS 0.16331f
C7469 VDD.t1858 VSS 0.76565f
C7470 VDD.t1860 VSS 0.17818f
C7471 VDD.t284 VSS 0.03992f
C7472 VDD.t1862 VSS 0.03992f
C7473 VDD.t282 VSS 0.84522f
C7474 VDD.t1654 VSS 0.09679f
C7475 VDD.t285 VSS 0.04452f
C7476 VDD.t1655 VSS 0.10311f
C7477 VDD.t286 VSS 0.03992f
C7478 VDD.t700 VSS 0.13095f
C7479 VDD.t401 VSS 0.03992f
C7480 VDD.t701 VSS 0.29473f
C7481 VDD.t1580 VSS 0.10122f
C7482 VDD.t400 VSS 0.04452f
C7483 VDD.t1588 VSS 0.03992f
C7484 VDD.t404 VSS 0.87216f
C7485 VDD.t1589 VSS 0.17908f
C7486 VDD.t403 VSS 0.74778f
C7487 VDD.t1591 VSS 0.07816f
C7488 VDD.t1641 VSS 0.37557f
C7489 VDD.t1640 VSS 0.43924f
C7490 VDD.t1593 VSS 0.07356f
C7491 VDD.t1581 VSS 0.03992f
C7492 VDD.t776 VSS 0.03992f
C7493 VDD.t775 VSS 0.29161f
C7494 VDD.t1646 VSS 0.03992f
C7495 VDD.t967 VSS 0.04452f
C7496 VDD.t1805 VSS 0.04452f
C7497 VDD.t965 VSS 0.21882f
C7498 VDD.t1803 VSS 0.21882f
C7499 VDD.t964 VSS 0.21422f
C7500 VDD.t1802 VSS 0.03992f
C7501 VDD.n436 VSS 0.17648f
C7502 VDD.n437 VSS 0.12596f
C7503 VDD.n438 VSS 0.12596f
C7504 VDD.n439 VSS 0.11542f
C7505 VDD.t1119 VSS 0.84088f
C7506 VDD.t1108 VSS 0.10962f
C7507 VDD.t1071 VSS 0.21286f
C7508 VDD.t1063 VSS 0.03992f
C7509 VDD.t1064 VSS 0.15447f
C7510 VDD.t1107 VSS 0.1033f
C7511 VDD.t1930 VSS 0.03992f
C7512 VDD.t1120 VSS 0.84548f
C7513 VDD.t1117 VSS 0.04452f
C7514 VDD.t1928 VSS 0.83947f
C7515 VDD.t1926 VSS 0.04452f
C7516 VDD.t1118 VSS 0.03992f
C7517 VDD.n440 VSS 0.11542f
C7518 VDD.n441 VSS 0.1138f
C7519 VDD.t1943 VSS 0.21424f
C7520 VDD.t1373 VSS 0.03992f
C7521 VDD.t1944 VSS 0.04452f
C7522 VDD.t1375 VSS 0.03992f
C7523 VDD.t1374 VSS 0.11424f
C7524 VDD.t1947 VSS 0.03992f
C7525 VDD.t809 VSS 0.03992f
C7526 VDD.t1378 VSS 0.13065f
C7527 VDD.t1377 VSS 0.13697f
C7528 VDD.t1399 VSS 0.4335f
C7529 VDD.t810 VSS 0.72323f
C7530 VDD.t812 VSS 0.33609f
C7531 VDD.t1398 VSS 0.43983f
C7532 VDD.t1127 VSS 0.29207f
C7533 VDD.t814 VSS 0.16181f
C7534 VDD.t214 VSS 0.03992f
C7535 VDD.t1126 VSS 0.29839f
C7536 VDD.t215 VSS 0.26419f
C7537 VDD.t1426 VSS 0.10309f
C7538 VDD.t743 VSS 0.10744f
C7539 VDD.t1372 VSS 0.19226f
C7540 VDD.t1945 VSS 0.03992f
C7541 VDD.t1369 VSS 0.04452f
C7542 VDD.t137 VSS 0.29093f
C7543 VDD.t138 VSS 0.03992f
C7544 VDD.t1370 VSS 0.03992f
C7545 VDD.t668 VSS 0.10424f
C7546 VDD.t1359 VSS 0.03992f
C7547 VDD.t667 VSS 0.09792f
C7548 VDD.t505 VSS 0.03992f
C7549 VDD.t1360 VSS 0.04452f
C7550 VDD.t1357 VSS 0.17937f
C7551 VDD.t504 VSS 0.07442f
C7552 VDD.t502 VSS 0.16412f
C7553 VDD.t1358 VSS 0.03992f
C7554 VDD.t236 VSS 0.13695f
C7555 VDD.t237 VSS 0.03992f
C7556 VDD.t501 VSS 0.03992f
C7557 VDD.t742 VSS 0.03992f
C7558 VDD.t233 VSS 0.11793f
C7559 VDD.t234 VSS 0.05426f
C7560 VDD.t740 VSS 0.04452f
C7561 VDD.t64 VSS 0.03992f
C7562 VDD.t738 VSS 0.84419f
C7563 VDD.t65 VSS 0.04452f
C7564 VDD.t737 VSS 0.03992f
C7565 VDD.t62 VSS 0.89024f
C7566 VDD.t735 VSS 0.15447f
C7567 VDD.t734 VSS 0.14815f
C7568 VDD.t63 VSS 0.03992f
C7569 VDD.t212 VSS 0.10962f
C7570 VDD.t825 VSS 0.03992f
C7571 VDD.t211 VSS 0.1033f
C7572 VDD.t53 VSS 0.03992f
C7573 VDD.t826 VSS 0.04452f
C7574 VDD.t822 VSS 1.04572f
C7575 VDD.t51 VSS 0.04452f
C7576 VDD.t49 VSS 0.16412f
C7577 VDD.t823 VSS 0.24016f
C7578 VDD.t230 VSS 0.13695f
C7579 VDD.t231 VSS 0.13063f
C7580 VDD.t50 VSS 0.15952f
C7581 VDD.t353 VSS 0.17459f
C7582 VDD.t227 VSS 0.4249f
C7583 VDD.t229 VSS 0.41858f
C7584 VDD.t351 VSS 0.17919f
C7585 VDD.t61 VSS 0.16029f
C7586 VDD.t349 VSS 0.87061f
C7587 VDD.t60 VSS 0.16489f
C7588 VDD.t350 VSS 0.20514f
C7589 VDD.t57 VSS 0.72343f
C7590 VDD.t209 VSS 0.13695f
C7591 VDD.t208 VSS 0.13063f
C7592 VDD.t59 VSS 0.71883f
C7593 VDD.t47 VSS 0.10937f
C7594 VDD.t818 VSS 0.21123f
C7595 VDD.t46 VSS 0.10304f
C7596 VDD.t806 VSS 0.22228f
C7597 VDD.t819 VSS 0.21583f
C7598 VDD.t816 VSS 0.04452f
C7599 VDD.n442 VSS 0.1138f
C7600 VDD.n443 VSS 0.1138f
C7601 VDD.t418 VSS 0.29161f
C7602 VDD.t419 VSS 0.28528f
C7603 VDD.t1058 VSS 0.19148f
C7604 VDD.t1106 VSS 0.03992f
C7605 VDD.t363 VSS 0.4249f
C7606 VDD.t364 VSS 0.41858f
C7607 VDD.t1104 VSS 0.04452f
C7608 VDD.t342 VSS 0.03992f
C7609 VDD.t1102 VSS 0.83994f
C7610 VDD.t343 VSS 0.04452f
C7611 VDD.t1101 VSS 0.03992f
C7612 VDD.t340 VSS 0.1643f
C7613 VDD.t1100 VSS 0.16097f
C7614 VDD.t31 VSS 0.1375f
C7615 VDD.t341 VSS 0.1597f
C7616 VDD.t30 VSS 0.03992f
C7617 VDD.t415 VSS 0.73542f
C7618 VDD.t798 VSS 0.10311f
C7619 VDD.t416 VSS 0.87643f
C7620 VDD.t797 VSS 0.09679f
C7621 VDD.t412 VSS 0.04452f
C7622 VDD.t154 VSS 0.03992f
C7623 VDD.t413 VSS 0.03992f
C7624 VDD.t152 VSS 0.04452f
C7625 VDD.t150 VSS 0.86606f
C7626 VDD.t1069 VSS 0.1029f
C7627 VDD.t409 VSS 0.12728f
C7628 VDD.t151 VSS 0.86146f
C7629 VDD.t410 VSS 0.05613f
C7630 VDD.t309 VSS 0.03992f
C7631 VDD.t577 VSS 0.03992f
C7632 VDD.t308 VSS 0.8752f
C7633 VDD.t575 VSS 0.04452f
C7634 VDD.t306 VSS 0.04452f
C7635 VDD.t573 VSS 0.21882f
C7636 VDD.t305 VSS 0.03992f
C7637 VDD.t574 VSS 0.03992f
C7638 VDD.n444 VSS 0.17648f
C7639 VDD.n445 VSS 0.12596f
C7640 VDD.t43 VSS 0.04452f
C7641 VDD.t1976 VSS 0.04452f
C7642 VDD.t41 VSS 0.21882f
C7643 VDD.t1975 VSS 0.21882f
C7644 VDD.t40 VSS 0.21422f
C7645 VDD.t1974 VSS 0.03992f
C7646 VDD.n446 VSS 0.17648f
C7647 VDD.n447 VSS 0.12596f
C7648 VDD.n448 VSS 0.12596f
C7649 VDD.n449 VSS 0.11542f
C7650 VDD.t1630 VSS 0.03992f
C7651 VDD.t1346 VSS 0.44083f
C7652 VDD.t457 VSS 0.88585f
C7653 VDD.t1348 VSS 0.03992f
C7654 VDD.t1349 VSS 0.31211f
C7655 VDD.t1345 VSS 0.03992f
C7656 VDD.t1343 VSS 0.03992f
C7657 VDD.t1631 VSS 0.18415f
C7658 VDD.t1628 VSS 0.08816f
C7659 VDD.t1342 VSS 0.74977f
C7660 VDD.t1340 VSS 0.16412f
C7661 VDD.t1629 VSS 0.04865f
C7662 VDD.n450 VSS 0.11542f
C7663 VDD.n451 VSS 1.53288f
C7664 VDD.n452 VSS 1.53288f
C7665 VDD.n453 VSS 0.1138f
C7666 VDD.t1009 VSS 0.13695f
C7667 VDD.t1010 VSS 0.03992f
C7668 VDD.t903 VSS 0.03992f
C7669 VDD.t997 VSS 0.03992f
C7670 VDD.t1469 VSS 0.10359f
C7671 VDD.t1470 VSS 0.09727f
C7672 VDD.t995 VSS 0.70539f
C7673 VDD.t916 VSS 0.1597f
C7674 VDD.t993 VSS 0.17908f
C7675 VDD.t917 VSS 0.1643f
C7676 VDD.t994 VSS 0.17448f
C7677 VDD.t913 VSS 0.7233f
C7678 VDD.t1956 VSS 0.16097f
C7679 VDD.t528 VSS 0.13727f
C7680 VDD.t914 VSS 0.7187f
C7681 VDD.t527 VSS 0.03992f
C7682 VDD.t1005 VSS 0.03992f
C7683 VDD.t762 VSS 0.42026f
C7684 VDD.t1006 VSS 0.04452f
C7685 VDD.t761 VSS 0.41393f
C7686 VDD.t1003 VSS 0.84522f
C7687 VDD.t270 VSS 0.17358f
C7688 VDD.t1004 VSS 0.03992f
C7689 VDD.t268 VSS 0.17818f
C7690 VDD.t266 VSS 0.04452f
C7691 VDD.t1464 VSS 0.1029f
C7692 VDD.t910 VSS 0.27812f
C7693 VDD.t265 VSS 0.03992f
C7694 VDD.t911 VSS 0.27179f
C7695 VDD.t334 VSS 0.03992f
C7696 VDD.t89 VSS 0.03992f
C7697 VDD.t333 VSS 0.04452f
C7698 VDD.t87 VSS 0.21882f
C7699 VDD.t332 VSS 0.21882f
C7700 VDD.t85 VSS 0.0881f
C7701 VDD.t331 VSS 0.03992f
C7702 VDD.t84 VSS 0.0835f
C7703 VDD.n454 VSS 0.17648f
C7704 VDD.n455 VSS 0.12596f
C7705 VDD.n456 VSS 1.53288f
C7706 VDD.t1079 VSS 0.19211f
C7707 VDD.t1078 VSS 0.04452f
C7708 VDD.t1729 VSS 0.22177f
C7709 VDD.t1726 VSS 0.04452f
C7710 VDD.t1077 VSS 0.03992f
C7711 VDD.t946 VSS 0.17589f
C7712 VDD.t1727 VSS 0.04149f
.ends
