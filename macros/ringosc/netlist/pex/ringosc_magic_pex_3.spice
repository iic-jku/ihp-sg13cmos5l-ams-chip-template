* PEX produced on Sat Nov  7 06:34:59 PM CET 2026 using /foss/tools/sak/sak-pex.sh with m=3 and s=1 (extresist threshold=10000 mOhm, minres=1000 mOhm, mindelay=1 ps)
* NGSPICE file created from ringosc_pex.ext - technology: ihp-sg13cmos5l

.subckt ringosc_pex vout VDD VSS
X0 VDD inverter_1.vin.t21 inverter_0.vin.t7 VDD sg13_lv_pmos ad=1.14p pd=6.38u as=1.14p ps=6.38u w=6u l=1u
X1 inverter_0.vin.t11 inverter_1.vin.t20 VSS.t71 VSS.t76 sg13_lv_nmos ad=0.19p pd=1.38u as=0.19p ps=1.38u w=1u l=1u
X2 VSS.t22 inverter_2.vin.t20 inverter_1.vin.t5 VSS.t21 sg13_lv_nmos ad=0.19p pd=1.38u as=0.19p ps=1.38u w=1u l=1u
X3 inverter_2.vin.t6 inverter_0.vin.t23 VDD VDD sg13_lv_pmos ad=1.14p pd=6.38u as=1.14p ps=6.38u w=6u l=1u
X4 inverter_1.vin.t15 inverter_2.vin.t21 VDD VDD sg13_lv_pmos ad=1.14p pd=6.38u as=1.14p ps=6.38u w=6u l=1u
X5 VDD inverter_0.vin.t23 inverter_2.vin.t7 VDD sg13_lv_pmos ad=1.14p pd=6.38u as=1.14p ps=6.38u w=6u l=1u
X6 VSS.t37 inverter_0.vin.t20 vout VSS.t36 sg13_lv_nmos ad=0.19p pd=1.38u as=0.19p ps=1.38u w=1u l=1u
X7 inverter_0.vin.t7 inverter_1.vin.t21 VDD VDD sg13_lv_pmos ad=1.14p pd=6.38u as=1.14p ps=6.38u w=6u l=1u
X8 inverter_2.vin.t9 inverter_0.vin.t23 VDD VDD sg13_lv_pmos ad=1.14p pd=6.38u as=1.14p ps=6.38u w=6u l=1u
X9 inverter_1.vin.t1 inverter_2.vin.t20 VSS.t9 VSS.t12 sg13_lv_nmos ad=0.19p pd=1.38u as=0.19p ps=1.38u w=1u l=1u
X10 VDD inverter_1.vin.t21 inverter_0.vin.t8 VDD sg13_lv_pmos ad=1.14p pd=6.38u as=1.14p ps=6.38u w=6u l=1u
X11 inverter_1.vin.t5 inverter_2.vin.t20 VSS.t11 VSS.t10 sg13_lv_nmos ad=0.19p pd=1.38u as=0.19p ps=1.38u w=1u l=1u
X12 VSS.t73 inverter_1.vin.t20 inverter_0.vin.t13 VSS.t72 sg13_lv_nmos ad=0.19p pd=1.38u as=0.19p ps=1.38u w=1u l=1u
X13 inverter_1.vin.t8 inverter_2.vin.t20 VSS.t5 VSS.t4 sg13_lv_nmos ad=0.19p pd=1.38u as=0.19p ps=1.38u w=1u l=1u
X14 inverter_1.vin.t14 inverter_2.vin.t21 VDD VDD sg13_lv_pmos ad=1.14p pd=6.38u as=1.14p ps=6.38u w=6u l=1u
X15 VDD VDD VDD VDD sg13_lv_pmos ad=1.14p pd=6.38u as=0.58725n ps=1.08582m w=6u l=1u
X16 VDD VDD VDD VDD sg13_lv_pmos ad=2.04p pd=12.68u as=0 ps=0 w=6u l=1u
X17 VSS.t58 inverter_0.vin.t20 vout VSS.t57 sg13_lv_nmos ad=0.19p pd=1.38u as=0.19p ps=1.38u w=1u l=1u
X18 vout inverter_0.vin.t22 VDD VDD sg13_lv_pmos ad=1.14p pd=6.38u as=1.14p ps=6.38u w=6u l=1u
X19 vout inverter_0.vin.t20 VSS.t43 VSS.t44 sg13_lv_nmos ad=0.19p pd=1.38u as=0.19p ps=1.38u w=1u l=1u
X20 inverter_2.vin.t15 inverter_0.vin.t21 VSS.t104 VSS.t103 sg13_lv_nmos ad=0.19p pd=1.38u as=0.19p ps=1.38u w=1u l=1u
X21 VSS.t71 inverter_1.vin.t20 inverter_0.vin.t10 VSS.t70 sg13_lv_nmos ad=0.19p pd=1.38u as=0.19p ps=1.38u w=1u l=1u
X22 vout inverter_0.vin.t20 VSS.t34 VSS.t35 sg13_lv_nmos ad=0.19p pd=1.38u as=0.19p ps=1.38u w=1u l=1u
X23 inverter_2.vin.t10 inverter_0.vin.t21 VSS.t98 VSS.t97 sg13_lv_nmos ad=0.19p pd=1.38u as=0.19p ps=1.38u w=1u l=1u
X24 inverter_0.vin.t5 inverter_1.vin.t21 VDD VDD sg13_lv_pmos ad=1.14p pd=6.38u as=1.14p ps=6.38u w=6u l=1u
X25 VSS.t5 inverter_2.vin.t20 inverter_1.vin.t7 VSS.t25 sg13_lv_nmos ad=0.19p pd=1.38u as=0.19p ps=1.38u w=1u l=1u
X26 VDD inverter_1.vin.t21 inverter_0.vin.t6 VDD sg13_lv_pmos ad=1.14p pd=6.38u as=1.14p ps=6.38u w=6u l=1u
X27 VSS.t9 inverter_2.vin.t20 inverter_1.vin.t0 VSS.t8 sg13_lv_nmos ad=0.19p pd=1.38u as=0.19p ps=1.38u w=1u l=1u
X28 inverter_0.vin.t8 inverter_1.vin.t21 VDD VDD sg13_lv_pmos ad=1.14p pd=6.38u as=1.14p ps=6.38u w=6u l=1u
X29 vout inverter_0.vin.t20 VSS.t55 VSS.t56 sg13_lv_nmos ad=0.19p pd=1.38u as=0.19p ps=1.38u w=1u l=1u
X30 VDD inverter_0.vin.t22 vout VDD sg13_lv_pmos ad=1.14p pd=6.38u as=1.14p ps=6.38u w=6u l=1u
X31 VSS.t63 inverter_1.vin.t20 inverter_0.vin.t17 VSS.t87 sg13_lv_nmos ad=0.19p pd=1.38u as=0.19p ps=1.38u w=1u l=1u
X32 VSS.t96 inverter_0.vin.t21 inverter_2.vin.t17 VSS.t118 sg13_lv_nmos ad=0.19p pd=1.38u as=0.19p ps=1.38u w=1u l=1u
X33 inverter_0.vin.t13 inverter_1.vin.t20 VSS.t79 VSS.t80 sg13_lv_nmos ad=0.19p pd=1.38u as=0.19p ps=1.38u w=1u l=1u
X34 inverter_1.vin.t18 inverter_2.vin.t21 VDD VDD sg13_lv_pmos ad=1.14p pd=6.38u as=1.14p ps=6.38u w=6u l=1u
X35 VSS.t126 VSS.t124 VSS.t98 VSS.t125 sg13_lv_nmos ad=0.34p pd=2.68u as=0 ps=0 w=1u l=1u
X36 inverter_2.vin.t0 inverter_0.vin.t23 VDD VDD sg13_lv_pmos ad=1.14p pd=6.38u as=1.14p ps=6.38u w=6u l=1u
X37 VDD inverter_2.vin.t21 inverter_1.vin.t13 VDD sg13_lv_pmos ad=1.14p pd=6.38u as=1.14p ps=6.38u w=6u l=1u
X38 VDD inverter_2.vin.t21 inverter_1.vin.t19 VDD sg13_lv_pmos ad=1.14p pd=6.38u as=1.14p ps=6.38u w=6u l=1u
X39 VDD inverter_0.vin.t22 vout VDD sg13_lv_pmos ad=1.14p pd=6.38u as=1.14p ps=6.38u w=6u l=1u
X40 VSS.t43 inverter_0.vin.t20 vout VSS.t42 sg13_lv_nmos ad=0.19p pd=1.38u as=0.19p ps=1.38u w=1u l=1u
X41 inverter_1.vin.t0 inverter_2.vin.t20 VSS.t7 VSS.t6 sg13_lv_nmos ad=0.19p pd=1.38u as=0.19p ps=1.38u w=1u l=1u
X42 VSS.t30 VSS.t133 VSS.t135 VSS.t134 sg13_lv_nmos ad=0.19p pd=1.38u as=0 ps=0 w=1u l=1u
X43 inverter_1.vin.t3 inverter_2.vin.t20 VSS.t15 VSS.t16 sg13_lv_nmos ad=0.19p pd=1.38u as=0.19p ps=1.38u w=1u l=1u
X44 VDD inverter_0.vin.t22 vout VDD sg13_lv_pmos ad=1.14p pd=6.38u as=1.14p ps=6.38u w=6u l=1u
X45 inverter_2.vin.t17 inverter_0.vin.t21 VSS.t102 VSS.t117 sg13_lv_nmos ad=0.19p pd=1.38u as=0.19p ps=1.38u w=1u l=1u
X46 inverter_1.vin.t7 inverter_2.vin.t20 VSS.t1 VSS.t24 sg13_lv_nmos ad=0.19p pd=1.38u as=0.19p ps=1.38u w=1u l=1u
X47 VDD inverter_0.vin.t23 inverter_2.vin.t6 VDD sg13_lv_pmos ad=1.14p pd=6.38u as=1.14p ps=6.38u w=6u l=1u
X48 inverter_2.vin.t8 inverter_0.vin.t23 VDD VDD sg13_lv_pmos ad=1.14p pd=6.38u as=1.14p ps=6.38u w=6u l=1u
X49 vout inverter_0.vin.t20 VSS.t49 VSS.t50 sg13_lv_nmos ad=0.19p pd=1.38u as=0.19p ps=1.38u w=1u l=1u
X50 VSS.t15 inverter_2.vin.t20 inverter_1.vin.t2 VSS.t14 sg13_lv_nmos ad=0.19p pd=1.38u as=0.19p ps=1.38u w=1u l=1u
X51 VSS.t108 inverter_0.vin.t21 inverter_2.vin.t12 VSS.t107 sg13_lv_nmos ad=0.19p pd=1.38u as=0.19p ps=1.38u w=1u l=1u
X52 VSS.t79 inverter_1.vin.t20 inverter_0.vin.t12 VSS.t78 sg13_lv_nmos ad=0.19p pd=1.38u as=0.19p ps=1.38u w=1u l=1u
X53 vout inverter_0.vin.t22 VDD VDD sg13_lv_pmos ad=1.14p pd=6.38u as=1.14p ps=6.38u w=6u l=1u
X54 VSS.t123 inverter_0.vin.t21 inverter_2.vin.t19 VSS.t122 sg13_lv_nmos ad=0.19p pd=1.38u as=0.19p ps=1.38u w=1u l=1u
X55 VSS.t92 inverter_1.vin.t20 inverter_0.vin.t19 VSS.t91 sg13_lv_nmos ad=0.19p pd=1.38u as=0.19p ps=1.38u w=1u l=1u
X56 VSS.t30 inverter_2.vin.t20 inverter_1.vin.t9 VSS.t29 sg13_lv_nmos ad=0.19p pd=1.38u as=0.19p ps=1.38u w=1u l=1u
X57 inverter_1.vin.t11 inverter_2.vin.t21 VDD VDD sg13_lv_pmos ad=1.14p pd=6.38u as=1.14p ps=6.38u w=6u l=1u
X58 vout inverter_0.vin.t22 VDD VDD sg13_lv_pmos ad=1.14p pd=6.38u as=1.14p ps=6.38u w=6u l=1u
X59 VSS.t61 VSS.t145 VSS.t147 VSS.t146 sg13_lv_nmos ad=0.19p pd=1.38u as=0 ps=0 w=1u l=1u
X60 VDD inverter_2.vin.t21 inverter_1.vin.t12 VDD sg13_lv_pmos ad=1.14p pd=6.38u as=1.14p ps=6.38u w=6u l=1u
X61 VDD inverter_2.vin.t21 inverter_1.vin.t18 VDD sg13_lv_pmos ad=1.14p pd=6.38u as=1.14p ps=6.38u w=6u l=1u
X62 VSS.t49 inverter_0.vin.t20 vout VSS.t48 sg13_lv_nmos ad=0.19p pd=1.38u as=0.19p ps=1.38u w=1u l=1u
X63 VDD inverter_0.vin.t22 vout VDD sg13_lv_pmos ad=1.14p pd=6.38u as=1.14p ps=6.38u w=6u l=1u
X64 inverter_0.vin.t12 inverter_1.vin.t20 VSS.t75 VSS.t74 sg13_lv_nmos ad=0.19p pd=1.38u as=0.19p ps=1.38u w=1u l=1u
X65 VDD inverter_0.vin.t23 inverter_2.vin.t0 VDD sg13_lv_pmos ad=1.14p pd=6.38u as=1.14p ps=6.38u w=6u l=1u
X66 inverter_0.vin.t15 inverter_1.vin.t20 VSS.t67 VSS.t66 sg13_lv_nmos ad=0.19p pd=1.38u as=0.19p ps=1.38u w=1u l=1u
X67 VDD inverter_1.vin.t21 inverter_0.vin.t5 VDD sg13_lv_pmos ad=1.14p pd=6.38u as=1.14p ps=6.38u w=6u l=1u
X68 inverter_1.vin.t9 inverter_2.vin.t20 VSS.t27 VSS.t28 sg13_lv_nmos ad=0.19p pd=1.38u as=0.19p ps=1.38u w=1u l=1u
X69 inverter_1.vin.t2 inverter_2.vin.t20 VSS.t3 VSS.t2 sg13_lv_nmos ad=0.19p pd=1.38u as=0.19p ps=1.38u w=1u l=1u
X70 inverter_2.vin.t4 inverter_0.vin.t23 VDD VDD sg13_lv_pmos ad=1.14p pd=6.38u as=1.14p ps=6.38u w=6u l=1u
X71 vout inverter_0.vin.t22 VDD VDD sg13_lv_pmos ad=1.14p pd=6.38u as=1.14p ps=6.38u w=6u l=1u
X72 VDD inverter_0.vin.t23 inverter_2.vin.t5 VDD sg13_lv_pmos ad=1.14p pd=6.38u as=1.14p ps=6.38u w=6u l=1u
X73 VDD inverter_1.vin.t21 inverter_0.vin.t3 VDD sg13_lv_pmos ad=1.14p pd=6.38u as=1.14p ps=6.38u w=6u l=1u
X74 VDD inverter_0.vin.t22 vout VDD sg13_lv_pmos ad=1.14p pd=6.38u as=1.14p ps=6.38u w=6u l=1u
X75 inverter_2.vin.t7 inverter_0.vin.t23 VDD VDD sg13_lv_pmos ad=1.14p pd=6.38u as=1.14p ps=6.38u w=6u l=1u
X76 VDD VDD VDD VDD sg13_lv_pmos ad=1.14p pd=6.38u as=0 ps=0 w=6u l=1u
X77 inverter_2.vin.t19 inverter_0.vin.t21 VSS.t120 VSS.t121 sg13_lv_nmos ad=0.19p pd=1.38u as=0.19p ps=1.38u w=1u l=1u
X78 VSS.t67 inverter_1.vin.t20 inverter_0.vin.t14 VSS.t82 sg13_lv_nmos ad=0.19p pd=1.38u as=0.19p ps=1.38u w=1u l=1u
X79 VSS.t104 inverter_0.vin.t21 inverter_2.vin.t14 VSS.t113 sg13_lv_nmos ad=0.19p pd=1.38u as=0.19p ps=1.38u w=1u l=1u
X80 VDD inverter_2.vin.t21 inverter_1.vin.t10 VDD sg13_lv_pmos ad=1.14p pd=6.38u as=1.14p ps=6.38u w=6u l=1u
X81 VDD VDD VDD VDD sg13_lv_pmos ad=2.04p pd=12.68u as=0 ps=0 w=6u l=1u
X82 inverter_1.vin.t12 inverter_2.vin.t21 VDD VDD sg13_lv_pmos ad=1.14p pd=6.38u as=1.14p ps=6.38u w=6u l=1u
X83 vout inverter_0.vin.t22 VDD VDD sg13_lv_pmos ad=1.14p pd=6.38u as=1.14p ps=6.38u w=6u l=1u
X84 VSS.t11 inverter_2.vin.t20 inverter_1.vin.t4 VSS.t20 sg13_lv_nmos ad=0.19p pd=1.38u as=0.19p ps=1.38u w=1u l=1u
X85 inverter_0.vin.t10 inverter_1.vin.t20 VSS.t69 VSS.t68 sg13_lv_nmos ad=0.19p pd=1.38u as=0.19p ps=1.38u w=1u l=1u
X86 VDD inverter_0.vin.t23 inverter_2.vin.t3 VDD sg13_lv_pmos ad=1.14p pd=6.38u as=1.14p ps=6.38u w=6u l=1u
X87 inverter_0.vin.t17 inverter_1.vin.t20 VSS.t65 VSS.t86 sg13_lv_nmos ad=0.19p pd=1.38u as=0.19p ps=1.38u w=1u l=1u
X88 inverter_2.vin.t5 inverter_0.vin.t23 VDD VDD sg13_lv_pmos ad=1.14p pd=6.38u as=1.14p ps=6.38u w=6u l=1u
X89 inverter_0.vin.t3 inverter_1.vin.t21 VDD VDD sg13_lv_pmos ad=1.14p pd=6.38u as=1.14p ps=6.38u w=6u l=1u
X90 VDD inverter_1.vin.t21 inverter_0.vin.t4 VDD sg13_lv_pmos ad=1.14p pd=6.38u as=1.14p ps=6.38u w=6u l=1u
X91 VSS.t55 inverter_0.vin.t20 vout VSS.t54 sg13_lv_nmos ad=0.19p pd=1.38u as=0.19p ps=1.38u w=1u l=1u
X92 inverter_0.vin.t6 inverter_1.vin.t21 VDD VDD sg13_lv_pmos ad=1.14p pd=6.38u as=1.14p ps=6.38u w=6u l=1u
X93 vout inverter_0.vin.t22 VDD VDD sg13_lv_pmos ad=1.14p pd=6.38u as=1.14p ps=6.38u w=6u l=1u
X94 inverter_0.vin.t14 inverter_1.vin.t20 VSS.t73 VSS.t81 sg13_lv_nmos ad=0.19p pd=1.38u as=0.19p ps=1.38u w=1u l=1u
X95 vout inverter_0.vin.t20 VSS.t40 VSS.t41 sg13_lv_nmos ad=0.19p pd=1.38u as=0.19p ps=1.38u w=1u l=1u
X96 VSS.t138 VSS.t136 VSS.t69 VSS.t137 sg13_lv_nmos ad=0.34p pd=2.68u as=0 ps=0 w=1u l=1u
X97 VDD inverter_0.vin.t22 vout VDD sg13_lv_pmos ad=1.14p pd=6.38u as=1.14p ps=6.38u w=6u l=1u
X98 inverter_1.vin.t16 inverter_2.vin.t21 VDD VDD sg13_lv_pmos ad=1.14p pd=6.38u as=1.14p ps=6.38u w=6u l=1u
X99 VSS.t1 inverter_2.vin.t20 inverter_1.vin.t6 VSS.t0 sg13_lv_nmos ad=0.19p pd=1.38u as=0.19p ps=1.38u w=1u l=1u
X100 VDD inverter_2.vin.t21 inverter_1.vin.t11 VDD sg13_lv_pmos ad=1.14p pd=6.38u as=1.14p ps=6.38u w=6u l=1u
X101 VDD inverter_2.vin.t21 inverter_1.vin.t17 VDD sg13_lv_pmos ad=1.14p pd=6.38u as=1.14p ps=6.38u w=6u l=1u
X102 VSS.t132 VSS.t130 VSS.t7 VSS.t131 sg13_lv_nmos ad=0.34p pd=2.68u as=0 ps=0 w=1u l=1u
X103 VDD VDD VDD VDD sg13_lv_pmos ad=2.04p pd=12.68u as=0 ps=0 w=6u l=1u
X104 inverter_1.vin.t19 inverter_2.vin.t21 VDD VDD sg13_lv_pmos ad=1.14p pd=6.38u as=1.14p ps=6.38u w=6u l=1u
X105 VSS.t65 inverter_1.vin.t20 inverter_0.vin.t16 VSS.t64 sg13_lv_nmos ad=0.19p pd=1.38u as=0.19p ps=1.38u w=1u l=1u
X106 VSS.t102 inverter_0.vin.t21 inverter_2.vin.t16 VSS.t101 sg13_lv_nmos ad=0.19p pd=1.38u as=0.19p ps=1.38u w=1u l=1u
X107 VDD inverter_1.vin.t21 inverter_0.vin.t2 VDD sg13_lv_pmos ad=1.14p pd=6.38u as=1.14p ps=6.38u w=6u l=1u
X108 inverter_2.vin.t12 inverter_0.vin.t21 VSS.t94 VSS.t93 sg13_lv_nmos ad=0.19p pd=1.38u as=0.19p ps=1.38u w=1u l=1u
X109 VDD inverter_0.vin.t23 inverter_2.vin.t4 VDD sg13_lv_pmos ad=1.14p pd=6.38u as=1.14p ps=6.38u w=6u l=1u
X110 inverter_0.vin.t4 inverter_1.vin.t21 VDD VDD sg13_lv_pmos ad=1.14p pd=6.38u as=1.14p ps=6.38u w=6u l=1u
X111 VSS.t40 inverter_0.vin.t20 vout VSS.t39 sg13_lv_nmos ad=0.19p pd=1.38u as=0.19p ps=1.38u w=1u l=1u
X112 VDD inverter_0.vin.t23 inverter_2.vin.t2 VDD sg13_lv_pmos ad=1.14p pd=6.38u as=1.14p ps=6.38u w=6u l=1u
X113 inverter_0.vin.t16 inverter_1.vin.t20 VSS.t84 VSS.t85 sg13_lv_nmos ad=0.19p pd=1.38u as=0.19p ps=1.38u w=1u l=1u
X114 VDD VDD VDD VDD sg13_lv_pmos ad=2.04p pd=12.68u as=0 ps=0 w=6u l=1u
X115 VDD inverter_2.vin.t21 inverter_1.vin.t15 VDD sg13_lv_pmos ad=1.14p pd=6.38u as=1.14p ps=6.38u w=6u l=1u
X116 inverter_1.vin.t17 inverter_2.vin.t21 VDD VDD sg13_lv_pmos ad=1.14p pd=6.38u as=1.14p ps=6.38u w=6u l=1u
X117 inverter_0.vin.t19 inverter_1.vin.t20 VSS.t89 VSS.t90 sg13_lv_nmos ad=0.19p pd=1.38u as=0.19p ps=1.38u w=1u l=1u
X118 VSS.t61 inverter_0.vin.t20 vout VSS.t60 sg13_lv_nmos ad=0.19p pd=1.38u as=0.19p ps=1.38u w=1u l=1u
X119 inverter_0.vin.t9 inverter_1.vin.t21 VDD VDD sg13_lv_pmos ad=1.14p pd=6.38u as=1.14p ps=6.38u w=6u l=1u
X120 VDD inverter_2.vin.t21 inverter_1.vin.t16 VDD sg13_lv_pmos ad=1.14p pd=6.38u as=1.14p ps=6.38u w=6u l=1u
X121 vout inverter_0.vin.t20 VSS.t46 VSS.t47 sg13_lv_nmos ad=0.19p pd=1.38u as=0.19p ps=1.38u w=1u l=1u
X122 VSS.t75 inverter_1.vin.t20 inverter_0.vin.t11 VSS.t77 sg13_lv_nmos ad=0.19p pd=1.38u as=0.19p ps=1.38u w=1u l=1u
X123 VSS.t3 inverter_2.vin.t20 inverter_1.vin.t1 VSS.t13 sg13_lv_nmos ad=0.19p pd=1.38u as=0.19p ps=1.38u w=1u l=1u
X124 VSS.t34 inverter_0.vin.t20 vout VSS.t33 sg13_lv_nmos ad=0.19p pd=1.38u as=0.19p ps=1.38u w=1u l=1u
X125 VSS.t94 inverter_0.vin.t21 inverter_2.vin.t11 VSS.t106 sg13_lv_nmos ad=0.19p pd=1.38u as=0.19p ps=1.38u w=1u l=1u
X126 VSS.t89 inverter_1.vin.t20 inverter_0.vin.t18 VSS.t88 sg13_lv_nmos ad=0.19p pd=1.38u as=0.19p ps=1.38u w=1u l=1u
X127 inverter_0.vin.t0 inverter_1.vin.t21 VDD VDD sg13_lv_pmos ad=1.14p pd=6.38u as=1.14p ps=6.38u w=6u l=1u
X128 VSS.t27 inverter_2.vin.t20 inverter_1.vin.t8 VSS.t26 sg13_lv_nmos ad=0.19p pd=1.38u as=0.19p ps=1.38u w=1u l=1u
X129 inverter_2.vin.t2 inverter_0.vin.t23 VDD VDD sg13_lv_pmos ad=1.14p pd=6.38u as=1.14p ps=6.38u w=6u l=1u
X130 VDD inverter_1.vin.t21 inverter_0.vin.t1 VDD sg13_lv_pmos ad=1.14p pd=6.38u as=1.14p ps=6.38u w=6u l=1u
X131 vout inverter_0.vin.t22 VDD VDD sg13_lv_pmos ad=1.14p pd=6.38u as=1.14p ps=6.38u w=6u l=1u
X132 VDD inverter_0.vin.t22 vout VDD sg13_lv_pmos ad=1.14p pd=6.38u as=1.14p ps=6.38u w=6u l=1u
X133 vout inverter_0.vin.t22 VDD VDD sg13_lv_pmos ad=1.14p pd=6.38u as=1.14p ps=6.38u w=6u l=1u
X134 inverter_1.vin.t4 inverter_2.vin.t20 VSS.t18 VSS.t19 sg13_lv_nmos ad=0.19p pd=1.38u as=0.19p ps=1.38u w=1u l=1u
X135 VSS.t120 inverter_0.vin.t21 inverter_2.vin.t18 VSS.t119 sg13_lv_nmos ad=0.19p pd=1.38u as=0.19p ps=1.38u w=1u l=1u
X136 inverter_2.vin.t14 inverter_0.vin.t21 VSS.t111 VSS.t112 sg13_lv_nmos ad=0.19p pd=1.38u as=0.19p ps=1.38u w=1u l=1u
X137 VSS.t100 inverter_0.vin.t21 inverter_2.vin.t10 VSS.t99 sg13_lv_nmos ad=0.19p pd=1.38u as=0.19p ps=1.38u w=1u l=1u
X138 VSS.t46 inverter_0.vin.t20 vout VSS.t45 sg13_lv_nmos ad=0.19p pd=1.38u as=0.19p ps=1.38u w=1u l=1u
X139 VDD VDD VDD VDD sg13_lv_pmos ad=1.14p pd=6.38u as=0 ps=0 w=6u l=1u
X140 vout inverter_0.vin.t20 VSS.t32 VSS.t31 sg13_lv_nmos ad=0.19p pd=1.38u as=0.19p ps=1.38u w=1u l=1u
X141 inverter_1.vin.t10 inverter_2.vin.t21 VDD VDD sg13_lv_pmos ad=1.14p pd=6.38u as=1.14p ps=6.38u w=6u l=1u
X142 inverter_2.vin.t11 inverter_0.vin.t21 VSS.t100 VSS.t105 sg13_lv_nmos ad=0.19p pd=1.38u as=0.19p ps=1.38u w=1u l=1u
X143 inverter_0.vin.t18 inverter_1.vin.t20 VSS.t63 VSS.t62 sg13_lv_nmos ad=0.19p pd=1.38u as=0.19p ps=1.38u w=1u l=1u
X144 inverter_2.vin.t18 inverter_0.vin.t21 VSS.t96 VSS.t95 sg13_lv_nmos ad=0.19p pd=1.38u as=0.19p ps=1.38u w=1u l=1u
X145 VDD inverter_0.vin.t23 inverter_2.vin.t1 VDD sg13_lv_pmos ad=1.14p pd=6.38u as=1.14p ps=6.38u w=6u l=1u
X146 inverter_0.vin.t1 inverter_1.vin.t21 VDD VDD sg13_lv_pmos ad=1.14p pd=6.38u as=1.14p ps=6.38u w=6u l=1u
X147 VDD inverter_0.vin.t22 vout VDD sg13_lv_pmos ad=1.14p pd=6.38u as=1.14p ps=6.38u w=6u l=1u
X148 inverter_2.vin.t3 inverter_0.vin.t23 VDD VDD sg13_lv_pmos ad=1.14p pd=6.38u as=1.14p ps=6.38u w=6u l=1u
X149 vout inverter_0.vin.t20 VSS.t52 VSS.t53 sg13_lv_nmos ad=0.19p pd=1.38u as=0.19p ps=1.38u w=1u l=1u
X150 VSS.t18 inverter_2.vin.t20 inverter_1.vin.t3 VSS.t17 sg13_lv_nmos ad=0.19p pd=1.38u as=0.19p ps=1.38u w=1u l=1u
X151 vout inverter_0.vin.t22 VDD VDD sg13_lv_pmos ad=1.14p pd=6.38u as=1.14p ps=6.38u w=6u l=1u
X152 VSS.t111 inverter_0.vin.t21 inverter_2.vin.t13 VSS.t110 sg13_lv_nmos ad=0.19p pd=1.38u as=0.19p ps=1.38u w=1u l=1u
X153 VDD inverter_0.vin.t22 vout VDD sg13_lv_pmos ad=1.14p pd=6.38u as=1.14p ps=6.38u w=6u l=1u
X154 VDD inverter_0.vin.t23 inverter_2.vin.t8 VDD sg13_lv_pmos ad=1.14p pd=6.38u as=1.14p ps=6.38u w=6u l=1u
X155 VSS.t144 VSS.t142 VSS.t32 VSS.t143 sg13_lv_nmos ad=0.34p pd=2.68u as=0 ps=0 w=1u l=1u
X156 VDD VDD VDD VDD sg13_lv_pmos ad=1.14p pd=6.38u as=0 ps=0 w=6u l=1u
X157 VDD inverter_1.vin.t21 inverter_0.vin.t9 VDD sg13_lv_pmos ad=1.14p pd=6.38u as=1.14p ps=6.38u w=6u l=1u
X158 inverter_1.vin.t6 inverter_2.vin.t20 VSS.t22 VSS.t23 sg13_lv_nmos ad=0.19p pd=1.38u as=0.19p ps=1.38u w=1u l=1u
X159 VSS.t52 inverter_0.vin.t20 vout VSS.t51 sg13_lv_nmos ad=0.19p pd=1.38u as=0.19p ps=1.38u w=1u l=1u
X160 inverter_2.vin.t13 inverter_0.vin.t21 VSS.t108 VSS.t109 sg13_lv_nmos ad=0.19p pd=1.38u as=0.19p ps=1.38u w=1u l=1u
X161 VDD inverter_0.vin.t23 inverter_2.vin.t9 VDD sg13_lv_pmos ad=1.14p pd=6.38u as=1.14p ps=6.38u w=6u l=1u
X162 inverter_2.vin.t16 inverter_0.vin.t21 VSS.t115 VSS.t116 sg13_lv_nmos ad=0.19p pd=1.38u as=0.19p ps=1.38u w=1u l=1u
X163 inverter_2.vin.t1 inverter_0.vin.t23 VDD VDD sg13_lv_pmos ad=1.14p pd=6.38u as=1.14p ps=6.38u w=6u l=1u
X164 VDD inverter_1.vin.t21 inverter_0.vin.t0 VDD sg13_lv_pmos ad=1.14p pd=6.38u as=1.14p ps=6.38u w=6u l=1u
X165 inverter_1.vin.t13 inverter_2.vin.t21 VDD VDD sg13_lv_pmos ad=1.14p pd=6.38u as=1.14p ps=6.38u w=6u l=1u
X166 inverter_0.vin.t2 inverter_1.vin.t21 VDD VDD sg13_lv_pmos ad=1.14p pd=6.38u as=1.14p ps=6.38u w=6u l=1u
X167 vout inverter_0.vin.t20 VSS.t37 VSS.t38 sg13_lv_nmos ad=0.19p pd=1.38u as=0.19p ps=1.38u w=1u l=1u
X168 vout inverter_0.vin.t22 VDD VDD sg13_lv_pmos ad=1.14p pd=6.38u as=1.14p ps=6.38u w=6u l=1u
X169 VDD inverter_2.vin.t21 inverter_1.vin.t14 VDD sg13_lv_pmos ad=1.14p pd=6.38u as=1.14p ps=6.38u w=6u l=1u
X170 VDD inverter_0.vin.t22 vout VDD sg13_lv_pmos ad=1.14p pd=6.38u as=1.14p ps=6.38u w=6u l=1u
X171 vout inverter_0.vin.t20 VSS.t58 VSS.t59 sg13_lv_nmos ad=0.19p pd=1.38u as=0.19p ps=1.38u w=1u l=1u
X172 VSS.t92 VSS.t139 VSS.t141 VSS.t140 sg13_lv_nmos ad=0.19p pd=1.38u as=0 ps=0 w=1u l=1u
X173 VSS.t123 VSS.t127 VSS.t129 VSS.t128 sg13_lv_nmos ad=0.19p pd=1.38u as=0 ps=0 w=1u l=1u
X174 VSS.t84 inverter_1.vin.t20 inverter_0.vin.t15 VSS.t83 sg13_lv_nmos ad=0.19p pd=1.38u as=0.19p ps=1.38u w=1u l=1u
X175 VSS.t115 inverter_0.vin.t21 inverter_2.vin.t15 VSS.t114 sg13_lv_nmos ad=0.19p pd=1.38u as=0.19p ps=1.38u w=1u l=1u
R0 VSS.n459 VSS.n343 554.529
R1 VSS.t128 VSS.n45 7.82518
R2 VSS.n53 VSS.n344 29.6822
R3 VSS.n18 VSS.n131 29.7451
R4 VSS.t122 VSS.n41 185.602
R5 VSS.t33 VSS.n2 25.8412
R6 VSS.n23 VSS.t97 185.597
R7 VSS.t6 VSS.n405 177.45
R8 VSS.n349 VSS.t29 177.45
R9 VSS.t68 VSS.n192 177.45
R10 VSS.n136 VSS.t91 177.45
R11 VSS.t121 VSS.n40 174.512
R12 VSS.n6 VSS.t59 25.8413
R13 VSS.n2 VSS.t35 41.4227
R14 VSS.n24 VSS.t99 174.506
R15 VSS.t8 VSS.n402 166.359
R16 VSS.n352 VSS.t28 166.359
R17 VSS.t70 VSS.n189 166.359
R18 VSS.n139 VSS.t90 166.359
R19 VSS.t119 VSS.n39 163.422
R20 VSS.t35 VSS.n3 163.418
R21 VSS.t57 VSS.n11 33.0458
R22 VSS.n25 VSS.t105 163.417
R23 VSS.t12 VSS.n399 155.268
R24 VSS.n355 VSS.t26 155.268
R25 VSS.t76 VSS.n186 155.268
R26 VSS.n142 VSS.t88 155.268
R27 VSS.t95 VSS.n38 152.331
R28 VSS.t36 VSS.n4 152.327
R29 VSS.n26 VSS.t106 152.326
R30 VSS.t13 VSS.n396 144.178
R31 VSS.n358 VSS.t4 144.178
R32 VSS.t77 VSS.n183 144.178
R33 VSS.n145 VSS.t62 144.178
R34 VSS.t118 VSS.n37 141.239
R35 VSS.n10 VSS.t38 141.238
R36 VSS.n8 VSS.t146 0.00177265
R37 VSS.n27 VSS.t93 141.236
R38 VSS.t2 VSS.n393 133.088
R39 VSS.n361 VSS.t25 133.088
R40 VSS.t74 VSS.n180 133.088
R41 VSS.n148 VSS.t87 133.088
R42 VSS.t117 VSS.n36 130.149
R43 VSS.n10 VSS.t146 0.00171198
R44 VSS.n28 VSS.t107 130.144
R45 VSS.t14 VSS.n390 121.996
R46 VSS.n364 VSS.t24 121.996
R47 VSS.t78 VSS.n177 121.996
R48 VSS.n151 VSS.t86 121.996
R49 VSS.t101 VSS.n35 119.058
R50 VSS.t113 VSS.n31 119.058
R51 VSS.t47 VSS.n5 49.8589
R52 VSS.n33 VSS.t103 119.053
R53 VSS.n29 VSS.t109 119.053
R54 VSS.t16 VSS.n387 110.906
R55 VSS.n379 VSS.t20 110.906
R56 VSS.t10 VSS.n375 110.906
R57 VSS.n367 VSS.t0 110.906
R58 VSS.t80 VSS.n174 110.906
R59 VSS.n166 VSS.t82 110.906
R60 VSS.t66 VSS.n162 110.906
R61 VSS.n154 VSS.t64 110.906
R62 VSS.t116 VSS.n34 107.969
R63 VSS.t112 VSS.n30 107.969
R64 VSS.n0 VSS.t44 51.0603
R65 VSS.t146 VSS.t48 51.0604
R66 VSS.n34 VSS.t114 107.963
R67 VSS.n30 VSS.t110 107.963
R68 VSS.t17 VSS.n384 99.8157
R69 VSS.n382 VSS.t19 99.8157
R70 VSS.t21 VSS.n372 99.8157
R71 VSS.n370 VSS.t23 99.8157
R72 VSS.t72 VSS.n171 99.8157
R73 VSS.n169 VSS.t81 99.8157
R74 VSS.t83 VSS.n159 99.8157
R75 VSS.n157 VSS.t85 99.8157
R76 VSS.t114 VSS.n33 96.8775
R77 VSS.t110 VSS.n29 96.8775
R78 VSS.n0 VSS.t45 119.056
R79 VSS.n7 VSS.t51 49.859
R80 VSS.n9 VSS.t42 51.0618
R81 VSS.n35 VSS.t116 96.8728
R82 VSS.n31 VSS.t112 96.8728
R83 VSS.n385 VSS.t17 88.7251
R84 VSS.t19 VSS.n381 88.7251
R85 VSS.n373 VSS.t21 88.7251
R86 VSS.t23 VSS.n369 88.7251
R87 VSS.n172 VSS.t72 88.7251
R88 VSS.t81 VSS.n168 88.7251
R89 VSS.n160 VSS.t83 88.7251
R90 VSS.t85 VSS.n156 88.7251
R91 VSS.t103 VSS.n32 85.7872
R92 VSS.t109 VSS.n28 85.787
R93 VSS.t45 VSS.n5 85.7854
R94 VSS.n7 VSS.t146 0.00273569
R95 VSS.t41 VSS.n9 49.8591
R96 VSS.n32 VSS.t113 85.7825
R97 VSS.n36 VSS.t101 85.7823
R98 VSS.n388 VSS.t16 77.6345
R99 VSS.t20 VSS.n378 77.6345
R100 VSS.n376 VSS.t10 77.6345
R101 VSS.t0 VSS.n366 77.6345
R102 VSS.n175 VSS.t80 77.6345
R103 VSS.t82 VSS.n165 77.6345
R104 VSS.n163 VSS.t66 77.6345
R105 VSS.t64 VSS.n153 77.6345
R106 VSS.t107 VSS.n27 74.6964
R107 VSS.t53 VSS.t146 47.4576
R108 VSS.n10 VSS.t39 47.4573
R109 VSS.n37 VSS.t117 74.6917
R110 VSS.n391 VSS.t14 66.5439
R111 VSS.t24 VSS.n363 66.5439
R112 VSS.n178 VSS.t78 66.5439
R113 VSS.t86 VSS.n150 66.5439
R114 VSS.t93 VSS.n26 63.6058
R115 VSS.n8 VSS.t54 43.8545
R116 VSS.t38 VSS.n4 63.6017
R117 VSS.n38 VSS.t118 63.6011
R118 VSS.n394 VSS.t2 55.4534
R119 VSS.t25 VSS.n360 55.4534
R120 VSS.n181 VSS.t74 55.4534
R121 VSS.t87 VSS.n147 55.4534
R122 VSS.t106 VSS.n25 52.5153
R123 VSS.t56 VSS.n11 52.5135
R124 VSS.n3 VSS.t36 52.5111
R125 VSS.n39 VSS.t95 52.5106
R126 VSS.n397 VSS.t13 44.3628
R127 VSS.t4 VSS.n357 44.3628
R128 VSS.n184 VSS.t77 44.3628
R129 VSS.t62 VSS.n144 44.3628
R130 VSS.t105 VSS.n24 41.4247
R131 VSS.n40 VSS.t119 41.42
R132 VSS.n400 VSS.t12 33.2722
R133 VSS.t26 VSS.n354 33.2722
R134 VSS.n187 VSS.t76 33.2722
R135 VSS.t88 VSS.n141 33.2722
R136 VSS.t99 VSS.n23 30.3341
R137 VSS.n6 VSS.t60 17.4361
R138 VSS.n41 VSS.t121 30.3294
R139 VSS.n342 VSS.n17 29.3796
R140 VSS.n377 VSS.n114 29.2386
R141 VSS.n377 VSS.n113 29.2386
R142 VSS.n203 VSS.n164 29.2386
R143 VSS.n202 VSS.n164 29.2386
R144 VSS.n250 VSS.n137 28.8069
R145 VSS.n248 VSS.n140 28.8069
R146 VSS.n245 VSS.n146 28.8069
R147 VSS.n242 VSS.n149 28.8069
R148 VSS.n241 VSS.n152 28.8069
R149 VSS.n238 VSS.n155 28.8069
R150 VSS.n236 VSS.n158 28.8069
R151 VSS.n234 VSS.n161 28.8069
R152 VSS.n231 VSS.n167 28.8069
R153 VSS.n229 VSS.n170 28.8069
R154 VSS.n227 VSS.n173 28.8069
R155 VSS.n223 VSS.n179 28.8069
R156 VSS.n221 VSS.n182 28.8069
R157 VSS.n219 VSS.n185 28.8069
R158 VSS.n217 VSS.n188 28.8069
R159 VSS.n215 VSS.n191 28.8069
R160 VSS.n214 VSS.n194 28.8069
R161 VSS.n254 VSS.n134 28.8069
R162 VSS.n345 VSS.n128 28.8069
R163 VSS.n347 VSS.n126 28.8069
R164 VSS.n359 VSS.n121 28.8069
R165 VSS.n380 VSS.n111 28.8069
R166 VSS.n392 VSS.n102 28.8069
R167 VSS.n395 VSS.n100 28.8069
R168 VSS.n398 VSS.n98 28.8069
R169 VSS.n213 VSS.n195 28.8069
R170 VSS.n410 VSS.n46 29.8719
R171 VSS.n410 VSS.n96 28.8069
R172 VSS.n409 VSS.n96 28.8069
R173 VSS.n409 VSS.n94 28.8069
R174 VSS.n408 VSS.n92 28.8069
R175 VSS.n407 VSS.n92 28.8069
R176 VSS.n407 VSS.n91 28.8069
R177 VSS.n404 VSS.n97 28.8069
R178 VSS.n404 VSS.n90 28.8069
R179 VSS.n401 VSS.n89 28.8069
R180 VSS.n401 VSS.n88 28.8069
R181 VSS.n398 VSS.n87 28.8069
R182 VSS.n395 VSS.n99 28.8069
R183 VSS.n392 VSS.n101 28.8069
R184 VSS.n389 VSS.n105 28.8069
R185 VSS.n389 VSS.n86 28.8069
R186 VSS.n386 VSS.n106 28.8069
R187 VSS.n386 VSS.n85 28.8069
R188 VSS.n383 VSS.n109 28.8069
R189 VSS.n383 VSS.n84 28.8069
R190 VSS.n380 VSS.n110 28.8069
R191 VSS.n374 VSS.n83 28.8069
R192 VSS.n374 VSS.n82 28.8069
R193 VSS.n371 VSS.n81 28.8069
R194 VSS.n371 VSS.n80 28.8069
R195 VSS.n368 VSS.n116 28.8069
R196 VSS.n368 VSS.n79 28.8069
R197 VSS.n365 VSS.n78 28.8069
R198 VSS.n365 VSS.n77 28.8069
R199 VSS.n362 VSS.n119 28.8069
R200 VSS.n362 VSS.n76 28.8069
R201 VSS.n359 VSS.n75 28.8069
R202 VSS.n356 VSS.n74 28.8069
R203 VSS.n356 VSS.n73 28.8069
R204 VSS.n353 VSS.n72 28.8069
R205 VSS.n353 VSS.n71 28.8069
R206 VSS.n350 VSS.n70 28.8069
R207 VSS.n350 VSS.n69 28.8069
R208 VSS.n347 VSS.n124 28.8069
R209 VSS.n346 VSS.n126 28.8069
R210 VSS.n345 VSS.n68 28.8069
R211 VSS.n344 VSS.n128 28.8069
R212 VSS.n342 VSS.n341 28.8069
R213 VSS.n341 VSS.n196 28.8069
R214 VSS.n209 VSS.n196 28.8069
R215 VSS.n213 VSS.n194 28.8069
R216 VSS.n207 VSS.n191 28.8069
R217 VSS.n216 VSS.n188 28.8069
R218 VSS.n218 VSS.n185 28.8069
R219 VSS.n206 VSS.n182 28.8069
R220 VSS.n222 VSS.n179 28.8069
R221 VSS.n225 VSS.n176 28.8069
R222 VSS.n205 VSS.n176 28.8069
R223 VSS.n226 VSS.n173 28.8069
R224 VSS.n204 VSS.n170 28.8069
R225 VSS.n230 VSS.n167 28.8069
R226 VSS.n233 VSS.n161 28.8069
R227 VSS.n201 VSS.n158 28.8069
R228 VSS.n237 VSS.n155 28.8069
R229 VSS.n240 VSS.n152 28.8069
R230 VSS.n200 VSS.n149 28.8069
R231 VSS.n244 VSS.n146 28.8069
R232 VSS.n199 VSS.n143 28.8069
R233 VSS.n198 VSS.n143 28.8069
R234 VSS.n247 VSS.n140 28.8069
R235 VSS.n249 VSS.n137 28.8069
R236 VSS.n197 VSS.n134 28.8069
R237 VSS.n254 VSS.n133 28.8069
R238 VSS.n253 VSS.n132 28.8069
R239 VSS.n251 VSS.n132 28.8069
R240 VSS.n251 VSS.n131 28.8069
R241 VSS.n403 VSS.t8 22.1816
R242 VSS.t28 VSS.n351 22.1816
R243 VSS.n190 VSS.t70 22.1816
R244 VSS.t90 VSS.n138 22.1816
R245 VSS.t97 VSS.t125 19.2466
R246 VSS.t31 VSS.t146 17.4345
R247 VSS.n14 VSS.n55 4.24492
R248 VSS.t146 VSS.n56 1.85963
R249 VSS.n44 VSS.n412 17.0005
R250 VSS.n44 VSS.n455 17.0005
R251 VSS.n44 VSS.n442 17.0005
R252 VSS.n44 VSS.n441 17.0005
R253 VSS.n21 VSS.n53 0.345442
R254 VSS.n21 VSS.n58 4.24485
R255 VSS.n21 VSS.n61 1.86016
R256 VSS.n49 VSS.n348 17.0005
R257 VSS.n49 VSS.n349 17.0005
R258 VSS.n49 VSS.n351 17.0005
R259 VSS.n49 VSS.n352 17.0005
R260 VSS.n49 VSS.n354 17.0005
R261 VSS.n49 VSS.n355 17.0005
R262 VSS.n49 VSS.n357 17.0005
R263 VSS.n49 VSS.n358 17.0005
R264 VSS.n49 VSS.n360 17.0005
R265 VSS.n49 VSS.n361 17.0005
R266 VSS.n49 VSS.n363 17.0005
R267 VSS.n49 VSS.n364 17.0005
R268 VSS.n49 VSS.n366 17.0005
R269 VSS.n49 VSS.n367 17.0005
R270 VSS.n49 VSS.n369 17.0005
R271 VSS.n49 VSS.n370 17.0005
R272 VSS.n49 VSS.n372 17.0005
R273 VSS.n49 VSS.n373 17.0005
R274 VSS.n49 VSS.n375 17.0005
R275 VSS.n49 VSS.n376 17.0005
R276 VSS.n49 VSS.n378 17.0005
R277 VSS.n49 VSS.n379 17.0005
R278 VSS.n49 VSS.n381 17.0005
R279 VSS.n49 VSS.n382 17.0005
R280 VSS.n49 VSS.n384 17.0005
R281 VSS.n49 VSS.n385 17.0005
R282 VSS.n49 VSS.n387 17.0005
R283 VSS.n49 VSS.n388 17.0005
R284 VSS.n49 VSS.n390 17.0005
R285 VSS.n49 VSS.n391 17.0005
R286 VSS.n49 VSS.n393 17.0005
R287 VSS.n49 VSS.n394 17.0005
R288 VSS.n49 VSS.n396 17.0005
R289 VSS.n49 VSS.n397 17.0005
R290 VSS.n49 VSS.n399 17.0005
R291 VSS.n49 VSS.n400 17.0005
R292 VSS.n49 VSS.n402 17.0005
R293 VSS.n49 VSS.n403 17.0005
R294 VSS.n49 VSS.n405 17.0005
R295 VSS.n49 VSS.n406 17.0005
R296 VSS.n14 VSS.n59 1.86016
R297 VSS.n15 VSS.n135 17.0005
R298 VSS.n15 VSS.n136 17.0005
R299 VSS.n15 VSS.n138 17.0005
R300 VSS.n15 VSS.n139 17.0005
R301 VSS.n15 VSS.n141 17.0005
R302 VSS.n15 VSS.n142 17.0005
R303 VSS.n15 VSS.n144 17.0005
R304 VSS.n15 VSS.n145 17.0005
R305 VSS.n15 VSS.n147 17.0005
R306 VSS.n15 VSS.n148 17.0005
R307 VSS.n15 VSS.n150 17.0005
R308 VSS.n15 VSS.n151 17.0005
R309 VSS.n15 VSS.n153 17.0005
R310 VSS.n15 VSS.n154 17.0005
R311 VSS.n15 VSS.n156 17.0005
R312 VSS.n15 VSS.n157 17.0005
R313 VSS.n15 VSS.n159 17.0005
R314 VSS.n15 VSS.n160 17.0005
R315 VSS.n15 VSS.n162 17.0005
R316 VSS.n15 VSS.n163 17.0005
R317 VSS.n15 VSS.n165 17.0005
R318 VSS.n15 VSS.n166 17.0005
R319 VSS.n15 VSS.n168 17.0005
R320 VSS.n15 VSS.n169 17.0005
R321 VSS.n15 VSS.n171 17.0005
R322 VSS.n15 VSS.n172 17.0005
R323 VSS.n15 VSS.n174 17.0005
R324 VSS.n15 VSS.n175 17.0005
R325 VSS.n15 VSS.n177 17.0005
R326 VSS.n15 VSS.n178 17.0005
R327 VSS.n15 VSS.n180 17.0005
R328 VSS.n15 VSS.n181 17.0005
R329 VSS.n15 VSS.n183 17.0005
R330 VSS.n15 VSS.n184 17.0005
R331 VSS.n15 VSS.n186 17.0005
R332 VSS.n15 VSS.n187 17.0005
R333 VSS.n15 VSS.n189 17.0005
R334 VSS.n15 VSS.n190 17.0005
R335 VSS.n15 VSS.n192 17.0005
R336 VSS.n15 VSS.n193 17.0005
R337 VSS.t146 VSS.n265 17.0005
R338 VSS.t146 VSS.n264 17.0005
R339 VSS.t146 VSS.n263 17.0005
R340 VSS.t61 VSS.n283 17.0005
R341 VSS.n285 VSS.t61 17.0005
R342 VSS.t61 VSS.n284 17.0005
R343 VSS.n283 VSS.t147 17.0005
R344 VSS.n285 VSS.t147 17.0005
R345 VSS.n284 VSS.t147 17.0005
R346 VSS.t126 VSS.n453 17.0005
R347 VSS.n454 VSS.t126 17.0005
R348 VSS.t126 VSS.n443 17.0005
R349 VSS.n453 VSS.t98 17.0005
R350 VSS.n454 VSS.t98 17.0005
R351 VSS.t98 VSS.n443 17.0005
R352 VSS.t143 VSS.t146 7.82596
R353 VSS.t139 VSS.n301 15.0005
R354 VSS.n57 VSS.t142 15.0005
R355 VSS.t133 VSS.n321 15.0005
R356 VSS.t136 VSS.n327 15.0005
R357 VSS.t127 VSS.n413 15.0005
R358 VSS.t130 VSS.n423 15.0005
R359 VSS.n249 VSS.n138 14.4037
R360 VSS.n247 VSS.n141 14.4037
R361 VSS.n198 VSS.n142 14.4037
R362 VSS.n244 VSS.n147 14.4037
R363 VSS.n240 VSS.n153 14.4037
R364 VSS.n237 VSS.n156 14.4037
R365 VSS.n233 VSS.n162 14.4037
R366 VSS.n202 VSS.n163 14.4037
R367 VSS.n230 VSS.n168 14.4037
R368 VSS.n226 VSS.n174 14.4037
R369 VSS.n205 VSS.n175 14.4037
R370 VSS.n225 VSS.n177 14.4037
R371 VSS.n222 VSS.n180 14.4037
R372 VSS.n218 VSS.n186 14.4037
R373 VSS.n216 VSS.n189 14.4037
R374 VSS.n348 VSS.n124 14.4037
R375 VSS.n349 VSS.n69 14.4037
R376 VSS.n352 VSS.n71 14.4037
R377 VSS.n355 VSS.n73 14.4037
R378 VSS.n361 VSS.n76 14.4037
R379 VSS.n363 VSS.n119 14.4037
R380 VSS.n364 VSS.n77 14.4037
R381 VSS.n367 VSS.n79 14.4037
R382 VSS.n369 VSS.n116 14.4037
R383 VSS.n370 VSS.n80 14.4037
R384 VSS.n373 VSS.n82 14.4037
R385 VSS.n378 VSS.n113 14.4037
R386 VSS.n381 VSS.n110 14.4037
R387 VSS.n382 VSS.n84 14.4037
R388 VSS.n384 VSS.n109 14.4037
R389 VSS.n385 VSS.n85 14.4037
R390 VSS.n387 VSS.n106 14.4037
R391 VSS.n388 VSS.n86 14.4037
R392 VSS.n390 VSS.n105 14.4037
R393 VSS.n393 VSS.n101 14.4037
R394 VSS.n396 VSS.n99 14.4037
R395 VSS.n400 VSS.n88 14.4037
R396 VSS.n403 VSS.n90 14.4037
R397 VSS.n405 VSS.n97 14.4037
R398 VSS.n406 VSS.n91 14.4037
R399 VSS.t131 VSS.n94 14.4037
R400 VSS.n346 VSS.t134 14.4037
R401 VSS.n209 VSS.t137 14.4037
R402 VSS.t140 VSS.n133 14.4037
R403 VSS.n408 VSS.t131 14.4037
R404 VSS.n402 VSS.n89 14.4037
R405 VSS.n399 VSS.n87 14.4037
R406 VSS.n397 VSS.n98 14.4037
R407 VSS.n394 VSS.n100 14.4037
R408 VSS.n391 VSS.n102 14.4037
R409 VSS.n379 VSS.n111 14.4037
R410 VSS.n376 VSS.n114 14.4037
R411 VSS.n375 VSS.n83 14.4037
R412 VSS.n372 VSS.n81 14.4037
R413 VSS.n366 VSS.n78 14.4037
R414 VSS.n360 VSS.n75 14.4037
R415 VSS.n358 VSS.n121 14.4037
R416 VSS.n357 VSS.n74 14.4037
R417 VSS.n354 VSS.n72 14.4037
R418 VSS.n351 VSS.n70 14.4037
R419 VSS.t134 VSS.n68 14.4037
R420 VSS.t137 VSS.n195 14.4037
R421 VSS.n214 VSS.n193 14.4037
R422 VSS.n207 VSS.n192 14.4037
R423 VSS.n215 VSS.n190 14.4037
R424 VSS.n217 VSS.n187 14.4037
R425 VSS.n219 VSS.n184 14.4037
R426 VSS.n206 VSS.n183 14.4037
R427 VSS.n221 VSS.n181 14.4037
R428 VSS.n223 VSS.n178 14.4037
R429 VSS.n227 VSS.n172 14.4037
R430 VSS.n204 VSS.n171 14.4037
R431 VSS.n229 VSS.n169 14.4037
R432 VSS.n231 VSS.n166 14.4037
R433 VSS.n203 VSS.n165 14.4037
R434 VSS.n234 VSS.n160 14.4037
R435 VSS.n201 VSS.n159 14.4037
R436 VSS.n236 VSS.n157 14.4037
R437 VSS.n238 VSS.n154 14.4037
R438 VSS.n241 VSS.n151 14.4037
R439 VSS.n200 VSS.n150 14.4037
R440 VSS.n242 VSS.n148 14.4037
R441 VSS.n245 VSS.n145 14.4037
R442 VSS.n199 VSS.n144 14.4037
R443 VSS.n248 VSS.n139 14.4037
R444 VSS.n250 VSS.n136 14.4037
R445 VSS.n197 VSS.n135 14.4037
R446 VSS.n253 VSS.t140 14.4037
R447 VSS.n406 VSS.t6 11.0911
R448 VSS.t29 VSS.n348 11.0911
R449 VSS.n193 VSS.t68 11.0911
R450 VSS.t91 VSS.n135 11.0911
R451 VSS.n260 VSS.n18 3.06929
R452 VSS.n260 VSS.n19 556.216
R453 VSS.n260 VSS.n15 3.40102
R454 VSS.n44 VSS.n46 557.769
R455 VSS.n53 VSS.n459 3.82106
R456 VSS.n130 VSS.n12 8.501
R457 VSS.n19 VSS.n258 4.25272
R458 VSS.n20 VSS.t146 0.00400052
R459 VSS.n50 VSS.n49 0.00396277
R460 VSS.n49 VSS.n51 8.5005
R461 VSS.n47 VSS.n51 0.00681125
R462 VSS.n48 VSS.n458 8.5005
R463 VSS.n14 VSS.n252 8.49847
R464 VSS.n14 VSS.n255 8.49847
R465 VSS.t146 VSS.n259 8.49847
R466 VSS.t146 VSS.n54 8.49847
R467 VSS.n44 VSS.n411 8.49847
R468 VSS.n21 VSS.n127 8.49847
R469 VSS.n21 VSS.n125 8.49847
R470 VSS.n21 VSS.n93 8.49847
R471 VSS.n21 VSS.n95 8.49847
R472 VSS.n14 VSS.n208 8.49847
R473 VSS.n14 VSS.n210 8.49847
R474 VSS.n44 VSS.n415 8.49847
R475 VSS.n44 VSS.n45 0.00105554
R476 VSS.n302 VSS.t139 7.49847
R477 VSS.t142 VSS.n297 7.49847
R478 VSS.n322 VSS.t133 7.49847
R479 VSS.n328 VSS.t136 7.49847
R480 VSS.n414 VSS.t127 7.49847
R481 VSS.n424 VSS.t130 7.49847
R482 VSS.n343 VSS.n17 7.48837
R483 VSS.n14 VSS.n18 0.277844
R484 VSS.n459 VSS.n22 5.66778
R485 VSS.n343 VSS.n16 3.40098
R486 VSS.n459 VSS.n49 5.66767
R487 VSS.n343 VSS.n15 5.66767
R488 VSS.n261 VSS.n15 3.40072
R489 VSS.n460 VSS.n22 3.40076
R490 VSS.n211 VSS.n12 5.66717
R491 VSS.n58 VSS.n460 0.017238
R492 VSS.t92 VSS.n339 4.5005
R493 VSS.t32 VSS.n295 4.5005
R494 VSS.n320 VSS.t30 4.5005
R495 VSS.n331 VSS.t69 4.5005
R496 VSS.t7 VSS.n60 4.5005
R497 VSS.n430 VSS.t123 4.5005
R498 VSS.n298 VSS.t146 4.24676
R499 VSS.n21 VSS.n47 2.83073
R500 VSS.n14 VSS.n212 3.39719
R501 VSS.n296 VSS.n257 3.0005
R502 VSS.n304 VSS.n303 3.0005
R503 VSS.n286 VSS.t145 3.0005
R504 VSS.n330 VSS.n329 3.0005
R505 VSS.n324 VSS.n323 3.0005
R506 VSS.n426 VSS.n425 3.0005
R507 VSS.n429 VSS.n412 3.0005
R508 VSS.n452 VSS.t124 3.0005
R509 VSS.n332 VSS.t71 2.48177
R510 VSS.n333 VSS.t75 2.48177
R511 VSS.n334 VSS.t79 2.48177
R512 VSS.n308 VSS.t73 2.48177
R513 VSS.n335 VSS.t84 2.48177
R514 VSS.n336 VSS.t65 2.48177
R515 VSS.n337 VSS.t63 2.48177
R516 VSS.n338 VSS.t89 2.48177
R517 VSS.n294 VSS.t34 2.48177
R518 VSS.n292 VSS.t37 2.48177
R519 VSS.n291 VSS.t40 2.48177
R520 VSS.n290 VSS.t43 2.48177
R521 VSS.n277 VSS.t49 2.48177
R522 VSS.n289 VSS.t52 2.48177
R523 VSS.n288 VSS.t55 2.48177
R524 VSS.n287 VSS.t58 2.48177
R525 VSS.n462 VSS.t9 2.48177
R526 VSS.n463 VSS.t3 2.48177
R527 VSS.n464 VSS.t15 2.48177
R528 VSS.n67 VSS.t18 2.48177
R529 VSS.t22 VSS.n66 2.48177
R530 VSS.n317 VSS.t1 2.48177
R531 VSS.n318 VSS.t5 2.48177
R532 VSS.n319 VSS.t27 2.48177
R533 VSS.n451 VSS.t100 2.48177
R534 VSS.n450 VSS.t94 2.48177
R535 VSS.n449 VSS.t108 2.48177
R536 VSS.n448 VSS.t111 2.48177
R537 VSS.t115 VSS.n434 2.48177
R538 VSS.n433 VSS.t102 2.48177
R539 VSS.n432 VSS.t96 2.48177
R540 VSS.n431 VSS.t120 2.48177
R541 VSS.n300 VSS.t141 2.2505
R542 VSS.n299 VSS.t144 2.2505
R543 VSS.n325 VSS.t135 2.2505
R544 VSS.n326 VSS.t138 2.2505
R545 VSS.n427 VSS.t132 2.2505
R546 VSS.n428 VSS.t129 2.2505
R547 VSS.n456 VSS.n44 2.12281
R548 VSS.n14 VSS.n340 2.09947
R549 VSS.n14 VSS.n246 2.09947
R550 VSS.n14 VSS.n243 2.09947
R551 VSS.n14 VSS.n239 2.09947
R552 VSS.n14 VSS.n235 2.09947
R553 VSS.n14 VSS.n232 2.09947
R554 VSS.n14 VSS.n228 2.09947
R555 VSS.n14 VSS.n224 2.09947
R556 VSS.n14 VSS.n220 2.09947
R557 VSS.n59 VSS.n313 0.0886655
R558 VSS.n21 VSS.n123 2.09947
R559 VSS.n21 VSS.n122 2.09947
R560 VSS.n21 VSS.n120 2.09947
R561 VSS.n21 VSS.n118 2.09947
R562 VSS.n21 VSS.n115 2.09947
R563 VSS.n21 VSS.n64 2.09947
R564 VSS.n21 VSS.n108 2.09947
R565 VSS.n21 VSS.n104 2.09947
R566 VSS.n21 VSS.n52 2.09947
R567 VSS.n461 VSS.n61 0.0886655
R568 VSS.n44 VSS.n418 2.09887
R569 VSS.n44 VSS.n436 2.09887
R570 VSS.n44 VSS.n437 2.09887
R571 VSS.n44 VSS.n439 2.09887
R572 VSS.n44 VSS.n440 2.09887
R573 VSS.t146 VSS.n266 2.09868
R574 VSS.t146 VSS.n267 2.09868
R575 VSS.t146 VSS.n268 2.09868
R576 VSS.t146 VSS.n269 2.09868
R577 VSS.t146 VSS.n270 2.09868
R578 VSS.t146 VSS.n271 2.09868
R579 VSS.t146 VSS.n272 2.09868
R580 VSS.t146 VSS.n273 2.09868
R581 VSS.n56 VSS.n293 0.0894933
R582 VSS.n44 VSS.n416 2.09849
R583 VSS.n44 VSS.n417 2.09849
R584 VSS.n44 VSS.n419 2.09849
R585 VSS.n44 VSS.n438 2.09849
R586 VSS.n465 VSS.n63 1.99725
R587 VSS.n278 VSS.n62 1.99725
R588 VSS.n286 VSS.n285 1.52811
R589 VSS.n454 VSS.n452 1.52811
R590 VSS.n443 VSS.n43 1.41417
R591 VSS.n284 VSS.n20 1.37998
R592 VSS.n13 VSS.n130 1.30493
R593 VSS.n14 VSS.n197 1.29964
R594 VSS.n14 VSS.n250 1.29964
R595 VSS.n14 VSS.n249 1.29964
R596 VSS.n14 VSS.n248 1.29964
R597 VSS.n14 VSS.n247 1.29964
R598 VSS.n14 VSS.n198 1.29964
R599 VSS.n14 VSS.n199 1.29964
R600 VSS.n14 VSS.n245 1.29964
R601 VSS.n14 VSS.n244 1.29964
R602 VSS.n14 VSS.n242 1.29964
R603 VSS.n14 VSS.n200 1.29964
R604 VSS.n14 VSS.n241 1.29964
R605 VSS.n14 VSS.n240 1.29964
R606 VSS.n14 VSS.n238 1.29964
R607 VSS.n14 VSS.n237 1.29964
R608 VSS.n14 VSS.n236 1.29964
R609 VSS.n14 VSS.n201 1.29964
R610 VSS.n14 VSS.n234 1.29964
R611 VSS.n14 VSS.n233 1.29964
R612 VSS.n14 VSS.n202 1.29964
R613 VSS.n14 VSS.n203 1.29964
R614 VSS.n14 VSS.n231 1.29964
R615 VSS.n14 VSS.n230 1.29964
R616 VSS.n14 VSS.n229 1.29964
R617 VSS.n14 VSS.n204 1.29964
R618 VSS.n14 VSS.n227 1.29964
R619 VSS.n14 VSS.n226 1.29964
R620 VSS.n14 VSS.n205 1.29964
R621 VSS.n14 VSS.n225 1.29964
R622 VSS.n14 VSS.n223 1.29964
R623 VSS.n14 VSS.n222 1.29964
R624 VSS.n14 VSS.n221 1.29964
R625 VSS.n14 VSS.n206 1.29964
R626 VSS.n14 VSS.n219 1.29964
R627 VSS.n14 VSS.n218 1.29964
R628 VSS.n14 VSS.n217 1.29964
R629 VSS.n14 VSS.n216 1.29964
R630 VSS.n14 VSS.n215 1.29964
R631 VSS.n14 VSS.n207 1.29964
R632 VSS.n14 VSS.n214 1.29964
R633 VSS.n14 VSS.n251 1.29964
R634 VSS.n14 VSS.n253 1.29964
R635 VSS.n14 VSS.n254 1.29964
R636 VSS.n21 VSS.n128 1.29964
R637 VSS.n21 VSS.n68 1.29964
R638 VSS.n21 VSS.n126 1.29964
R639 VSS.n21 VSS.n124 1.29964
R640 VSS.n21 VSS.n69 1.29964
R641 VSS.n21 VSS.n70 1.29964
R642 VSS.n21 VSS.n71 1.29964
R643 VSS.n21 VSS.n72 1.29964
R644 VSS.n21 VSS.n73 1.29964
R645 VSS.n21 VSS.n74 1.29964
R646 VSS.n21 VSS.n121 1.29964
R647 VSS.n21 VSS.n75 1.29964
R648 VSS.n21 VSS.n76 1.29964
R649 VSS.n21 VSS.n119 1.29964
R650 VSS.n21 VSS.n77 1.29964
R651 VSS.n21 VSS.n78 1.29964
R652 VSS.n21 VSS.n79 1.29964
R653 VSS.n21 VSS.n116 1.29964
R654 VSS.n21 VSS.n80 1.29964
R655 VSS.n21 VSS.n81 1.29964
R656 VSS.n21 VSS.n82 1.29964
R657 VSS.n21 VSS.n83 1.29964
R658 VSS.n21 VSS.n114 1.29964
R659 VSS.n21 VSS.n113 1.29964
R660 VSS.n21 VSS.n111 1.29964
R661 VSS.n21 VSS.n110 1.29964
R662 VSS.n21 VSS.n84 1.29964
R663 VSS.n21 VSS.n109 1.29964
R664 VSS.n21 VSS.n85 1.29964
R665 VSS.n21 VSS.n106 1.29964
R666 VSS.n21 VSS.n86 1.29964
R667 VSS.n21 VSS.n105 1.29964
R668 VSS.n21 VSS.n102 1.29964
R669 VSS.n21 VSS.n101 1.29964
R670 VSS.n21 VSS.n100 1.29964
R671 VSS.n21 VSS.n99 1.29964
R672 VSS.n21 VSS.n98 1.29964
R673 VSS.n21 VSS.n87 1.29964
R674 VSS.n21 VSS.n88 1.29964
R675 VSS.n21 VSS.n89 1.29964
R676 VSS.n21 VSS.n90 1.29964
R677 VSS.n21 VSS.n97 1.29964
R678 VSS.n21 VSS.n91 1.29964
R679 VSS.n21 VSS.n92 1.29964
R680 VSS.n21 VSS.n94 1.29964
R681 VSS.n21 VSS.n96 1.29964
R682 VSS.n21 VSS.n46 0.140655
R683 VSS.n49 VSS.n344 1.29964
R684 VSS.n49 VSS.n345 1.29964
R685 VSS.n49 VSS.n346 1.29964
R686 VSS.n49 VSS.n347 1.29964
R687 VSS.n49 VSS.n350 1.29964
R688 VSS.n49 VSS.n353 1.29964
R689 VSS.n49 VSS.n356 1.29964
R690 VSS.n49 VSS.n359 1.29964
R691 VSS.n49 VSS.n362 1.29964
R692 VSS.n49 VSS.n365 1.29964
R693 VSS.n49 VSS.n368 1.29964
R694 VSS.n49 VSS.n371 1.29964
R695 VSS.n49 VSS.n374 1.29964
R696 VSS.n49 VSS.n380 1.29964
R697 VSS.n49 VSS.n383 1.29964
R698 VSS.n49 VSS.n386 1.29964
R699 VSS.n49 VSS.n389 1.29964
R700 VSS.n49 VSS.n392 1.29964
R701 VSS.n49 VSS.n395 1.29964
R702 VSS.n49 VSS.n398 1.29964
R703 VSS.n49 VSS.n401 1.29964
R704 VSS.n49 VSS.n404 1.29964
R705 VSS.n49 VSS.n407 1.29964
R706 VSS.n49 VSS.n408 1.29964
R707 VSS.n49 VSS.n409 1.29964
R708 VSS.n49 VSS.n410 1.29964
R709 VSS.n14 VSS.n213 1.29964
R710 VSS.n14 VSS.n209 1.29964
R711 VSS.n341 VSS.n14 1.29964
R712 VSS.n15 VSS.n131 1.29964
R713 VSS.n15 VSS.n132 1.29964
R714 VSS.n15 VSS.n133 1.29964
R715 VSS.n15 VSS.n134 1.29964
R716 VSS.n15 VSS.n137 1.29964
R717 VSS.n15 VSS.n140 1.29964
R718 VSS.n15 VSS.n143 1.29964
R719 VSS.n15 VSS.n146 1.29964
R720 VSS.n15 VSS.n149 1.29964
R721 VSS.n15 VSS.n152 1.29964
R722 VSS.n15 VSS.n155 1.29964
R723 VSS.n15 VSS.n158 1.29964
R724 VSS.n15 VSS.n161 1.29964
R725 VSS.n15 VSS.n167 1.29964
R726 VSS.n15 VSS.n170 1.29964
R727 VSS.n15 VSS.n173 1.29964
R728 VSS.n15 VSS.n176 1.29964
R729 VSS.n15 VSS.n179 1.29964
R730 VSS.n15 VSS.n182 1.29964
R731 VSS.n15 VSS.n185 1.29964
R732 VSS.n15 VSS.n188 1.29964
R733 VSS.n15 VSS.n191 1.29964
R734 VSS.n15 VSS.n194 1.29964
R735 VSS.n15 VSS.n195 1.29964
R736 VSS.n15 VSS.n196 1.29964
R737 VSS.n15 VSS.n342 1.29964
R738 VSS.n20 VSS.n262 1.17279
R739 VSS.n457 VSS.n43 1.14589
R740 VSS.n49 VSS.n377 1.08379
R741 VSS.n15 VSS.n164 1.08379
R742 VSS VSS.n62 1.01015
R743 VSS VSS.n465 0.94914
R744 VSS.n44 VSS.n42 0.910152
R745 VSS.t146 VSS.n1 0.909238
R746 VSS.n14 VSS.n17 0.676348
R747 VSS.n287 VSS.n286 0.209825
R748 VSS.n452 VSS.n451 0.209825
R749 VSS.t71 VSS.n313 0.200997
R750 VSS.t75 VSS.n312 0.200997
R751 VSS.t79 VSS.n311 0.200997
R752 VSS.t73 VSS.n310 0.200997
R753 VSS.t84 VSS.n307 0.200997
R754 VSS.t65 VSS.n306 0.200997
R755 VSS.t63 VSS.n305 0.200997
R756 VSS.t89 VSS.n256 0.200997
R757 VSS.t34 VSS.n293 0.200997
R758 VSS.t37 VSS.n274 0.200997
R759 VSS.t40 VSS.n275 0.200997
R760 VSS.t43 VSS.n276 0.200997
R761 VSS.t49 VSS.n279 0.200997
R762 VSS.t52 VSS.n280 0.200997
R763 VSS.t55 VSS.n281 0.200997
R764 VSS.t58 VSS.n282 0.200997
R765 VSS.t9 VSS.n461 0.200997
R766 VSS.n103 VSS.t3 0.200997
R767 VSS.n107 VSS.t15 0.200997
R768 VSS.n112 VSS.t18 0.200997
R769 VSS.n117 VSS.t22 0.200997
R770 VSS.t1 VSS.n316 0.200997
R771 VSS.t5 VSS.n315 0.200997
R772 VSS.t27 VSS.n314 0.200997
R773 VSS.t100 VSS.n444 0.200997
R774 VSS.t94 VSS.n445 0.200997
R775 VSS.t108 VSS.n446 0.200997
R776 VSS.t111 VSS.n447 0.200997
R777 VSS.n435 VSS.t115 0.200997
R778 VSS.t102 VSS.n420 0.200997
R779 VSS.t96 VSS.n421 0.200997
R780 VSS.t120 VSS.n422 0.200997
R781 VSS.n333 VSS.n332 0.16242
R782 VSS.n334 VSS.n333 0.16242
R783 VSS.n308 VSS.n334 0.16242
R784 VSS.n309 VSS.n308 0.16242
R785 VSS.n335 VSS.n309 0.16242
R786 VSS.n336 VSS.n335 0.16242
R787 VSS.n337 VSS.n336 0.16242
R788 VSS.n338 VSS.n337 0.16242
R789 VSS.n294 VSS.n292 0.16242
R790 VSS.n292 VSS.n291 0.16242
R791 VSS.n291 VSS.n290 0.16242
R792 VSS.n290 VSS.n278 0.16242
R793 VSS.n278 VSS.n277 0.16242
R794 VSS.n277 VSS.n289 0.16242
R795 VSS.n289 VSS.n288 0.16242
R796 VSS.n288 VSS.n287 0.16242
R797 VSS.n463 VSS.n462 0.16242
R798 VSS.n464 VSS.n463 0.16242
R799 VSS.n67 VSS.n464 0.16242
R800 VSS.n65 VSS.n67 0.16242
R801 VSS.n65 VSS.n66 0.16242
R802 VSS.n317 VSS.n66 0.16242
R803 VSS.n318 VSS.n317 0.16242
R804 VSS.n319 VSS.n318 0.16242
R805 VSS.n451 VSS.n450 0.16242
R806 VSS.n450 VSS.n449 0.16242
R807 VSS.n449 VSS.n448 0.16242
R808 VSS.n448 VSS.n63 0.16242
R809 VSS.n434 VSS.n63 0.16242
R810 VSS.n434 VSS.n433 0.16242
R811 VSS.n433 VSS.n432 0.16242
R812 VSS.n432 VSS.n431 0.16242
R813 VSS.n339 VSS.n338 0.158764
R814 VSS.n295 VSS.n294 0.158764
R815 VSS.n320 VSS.n319 0.158764
R816 VSS.n332 VSS.n331 0.158764
R817 VSS.n462 VSS.n60 0.158764
R818 VSS.n431 VSS.n430 0.158764
R819 VSS.n282 VSS.n1 0.147221
R820 VSS.n444 VSS.n42 0.145771
R821 VSS.n313 VSS.n220 0.0952183
R822 VSS.n461 VSS.n52 0.0952183
R823 VSS.n444 VSS.n440 0.0944516
R824 VSS.t69 VSS.n59 0.0841505
R825 VSS.n61 VSS.t7 0.0841505
R826 VSS.n293 VSS.n273 0.0942639
R827 VSS.n422 VSS.n417 0.0936876
R828 VSS.n282 VSS.n266 0.0935007
R829 VSS.t32 VSS.n56 0.0833126
R830 VSS.t123 VSS.n416 0.0928455
R831 VSS.n312 VSS.n224 0.0927738
R832 VSS.n104 VSS.n103 0.0927738
R833 VSS.n256 VSS.n246 0.0925656
R834 VSS.n314 VSS.n122 0.0925656
R835 VSS.n445 VSS.n439 0.0920071
R836 VSS.n274 VSS.n272 0.0918194
R837 VSS.n340 VSS.t92 0.0917235
R838 VSS.t30 VSS.n123 0.0917235
R839 VSS.n281 VSS.n267 0.0910563
R840 VSS.n421 VSS.n418 0.0908667
R841 VSS.n311 VSS.n228 0.0903294
R842 VSS.t67 VSS.n235 0.0903294
R843 VSS.n108 VSS.n107 0.0903294
R844 VSS.n115 VSS.t11 0.0903294
R845 VSS.n305 VSS.n243 0.0901212
R846 VSS.n315 VSS.n120 0.0901212
R847 VSS.t104 VSS.n436 0.0895627
R848 VSS.n275 VSS.n271 0.089375
R849 VSS.t46 VSS.n269 0.089375
R850 VSS.n446 VSS.n438 0.0891812
R851 VSS.n420 VSS.n419 0.0887988
R852 VSS.t46 VSS.n270 0.0886118
R853 VSS.n280 VSS.n268 0.0886118
R854 VSS.n437 VSS.t104 0.0884223
R855 VSS.n310 VSS.n232 0.0878849
R856 VSS.n307 VSS.n239 0.0878849
R857 VSS.n64 VSS.n112 0.0878849
R858 VSS.n118 VSS.n117 0.0878849
R859 VSS.t67 VSS.n232 0.0876767
R860 VSS.n306 VSS.n239 0.0876767
R861 VSS.t11 VSS.n64 0.0876767
R862 VSS.n316 VSS.n118 0.0876767
R863 VSS.n447 VSS.n437 0.0871182
R864 VSS.n276 VSS.n270 0.0869305
R865 VSS.n279 VSS.n268 0.0869305
R866 VSS.n435 VSS.n419 0.0867368
R867 VSS.n447 VSS.n438 0.0863543
R868 VSS.n276 VSS.n271 0.0861674
R869 VSS.n279 VSS.n269 0.0861674
R870 VSS.n436 VSS.n435 0.0859778
R871 VSS.n306 VSS.n243 0.0854405
R872 VSS.n316 VSS.n120 0.0854405
R873 VSS.n310 VSS.n228 0.0852323
R874 VSS.n307 VSS.n235 0.0852323
R875 VSS.n112 VSS.n108 0.0852323
R876 VSS.n117 VSS.n115 0.0852323
R877 VSS.n420 VSS.n418 0.0846738
R878 VSS.n280 VSS.n267 0.0844861
R879 VSS.t124 VSS.n42 0.0840092
R880 VSS.n275 VSS.n272 0.083723
R881 VSS.n446 VSS.n439 0.0835334
R882 VSS.n305 VSS.n246 0.082996
R883 VSS.n315 VSS.n122 0.082996
R884 VSS.n311 VSS.n224 0.0827878
R885 VSS.n107 VSS.n104 0.0827878
R886 VSS.t145 VSS.n1 0.0825618
R887 VSS.n281 VSS.n266 0.0820417
R888 VSS.n421 VSS.n417 0.0818479
R889 VSS.n274 VSS.n273 0.0812785
R890 VSS.n445 VSS.n440 0.0810889
R891 VSS.n340 VSS.n256 0.0805516
R892 VSS.n314 VSS.n123 0.0805516
R893 VSS.n312 VSS.n220 0.0803434
R894 VSS.n103 VSS.n52 0.0803434
R895 VSS.n422 VSS.n416 0.0794034
R896 VSS.n300 VSS.n299 0.0725217
R897 VSS.n326 VSS.n325 0.0725217
R898 VSS.n428 VSS.n427 0.0725217
R899 VSS.n262 VSS.n13 1.14523
R900 VSS.n458 VSS.n129 0.0467185
R901 VSS.n130 VSS.n129 0.0467185
R902 VSS.n50 VSS.n457 1.17661
R903 VSS.t104 VSS.n63 0.0394177
R904 VSS.n309 VSS.t67 0.0394177
R905 VSS.n278 VSS.t46 0.0394177
R906 VSS.t11 VSS.n65 0.0394177
R907 VSS.n465 VSS.n65 0.0389615
R908 VSS.n309 VSS.n62 0.0389615
R909 VSS.n456 VSS.t129 0.0288491
R910 VSS.t138 VSS.n212 0.0254128
R911 VSS.t144 VSS.n298 0.0238708
R912 VSS.n58 VSS.t135 0.0168381
R913 VSS.t141 VSS.n55 0.0165881
R914 VSS.n457 VSS.n456 0.0201377
R915 VSS.n339 VSS.n304 0.0169553
R916 VSS.n304 VSS.n300 0.0169553
R917 VSS.n299 VSS.n257 0.0169553
R918 VSS.n295 VSS.n257 0.0169553
R919 VSS.n324 VSS.n320 0.0169553
R920 VSS.n325 VSS.n324 0.0169553
R921 VSS.n330 VSS.n326 0.0169553
R922 VSS.n331 VSS.n330 0.0169553
R923 VSS.n430 VSS.n429 0.0169553
R924 VSS.n429 VSS.n428 0.0169553
R925 VSS.n427 VSS.n426 0.0169553
R926 VSS.n426 VSS.n60 0.0169553
R927 VSS.n262 VSS.n261 0.0154051
R928 VSS.n262 VSS.n258 0.0154051
R929 VSS.n460 VSS.n129 0.0154051
R930 VSS.n211 VSS.n129 0.0154051
R931 VSS.n457 VSS.n51 0.0154051
R932 VSS.t145 VSS.n265 0.0133922
R933 VSS.t124 VSS.n441 0.0133922
R934 VSS.n261 VSS.n55 0.0174886
R935 VSS.n302 VSS.n255 0.0116323
R936 VSS.n297 VSS.n54 0.0116323
R937 VSS.n322 VSS.n125 0.0116323
R938 VSS.n328 VSS.n210 0.0116323
R939 VSS.n424 VSS.n95 0.0116323
R940 VSS.n415 VSS.n414 0.0116323
R941 VSS.n423 VSS.t7 0.0109336
R942 VSS.n327 VSS.t69 0.0109336
R943 VSS.n321 VSS.t135 0.0109336
R944 VSS.t32 VSS.n57 0.0109336
R945 VSS.n301 VSS.t141 0.0109336
R946 VSS.n413 VSS.n412 0.0106355
R947 VSS.n298 VSS.n258 0.00922027
R948 VSS.n47 VSS.t132 0.0272738
R949 VSS.n285 VSS.n264 0.00798582
R950 VSS.n285 VSS.n263 0.00798582
R951 VSS.n454 VSS.n442 0.00798582
R952 VSS.n455 VSS.n454 0.00798582
R953 VSS.n212 VSS.n211 0.0076754
R954 VSS.n283 VSS.n265 0.00756994
R955 VSS.n283 VSS.n264 0.00756994
R956 VSS.n284 VSS.n263 0.00756994
R957 VSS.n453 VSS.n441 0.00756994
R958 VSS.n453 VSS.n442 0.00756994
R959 VSS.n455 VSS.n443 0.00756994
R960 VSS.t92 VSS.n255 0.00636434
R961 VSS.t144 VSS.n54 0.00636434
R962 VSS.t30 VSS.n125 0.00636434
R963 VSS.t138 VSS.n210 0.00636434
R964 VSS.n411 VSS.t129 0.00636434
R965 VSS.t132 VSS.n95 0.00636434
R966 VSS.t123 VSS.n415 0.00636434
R967 VSS.n303 VSS.n252 0.00606624
R968 VSS.n296 VSS.n259 0.00606624
R969 VSS.n301 VSS.n252 0.00606624
R970 VSS.n57 VSS.n259 0.00606624
R971 VSS.n413 VSS.n411 0.00606624
R972 VSS.n323 VSS.n127 0.00606624
R973 VSS.n425 VSS.n93 0.00606624
R974 VSS.n329 VSS.n208 0.00606624
R975 VSS.n321 VSS.n127 0.00606624
R976 VSS.n327 VSS.n208 0.00606624
R977 VSS.n423 VSS.n93 0.00606624
R978 VSS.n303 VSS.n302 0.00606604
R979 VSS.n297 VSS.n296 0.00606604
R980 VSS.n323 VSS.n322 0.00606604
R981 VSS.n329 VSS.n328 0.00606604
R982 VSS.n414 VSS.n412 0.00606604
R983 VSS.n425 VSS.n424 0.00606604
R984 VSS.n15 VSS.n13 0.00474814
R985 VSS.n458 VSS.n50 1.26308
R986 VSS.n22 VSS.n21 0.00459994
R987 VSS.n44 VSS.n43 0.00390718
R988 VSS.n21 VSS.n49 0.00379971
R989 VSS.n44 VSS.n23 0.00189631
R990 VSS.n44 VSS.n24 0.00189631
R991 VSS.n44 VSS.n25 0.00189631
R992 VSS.n44 VSS.n26 0.00189631
R993 VSS.n44 VSS.n27 0.00189631
R994 VSS.n44 VSS.n28 0.00189631
R995 VSS.n44 VSS.n29 0.00189631
R996 VSS.n44 VSS.n30 0.00189631
R997 VSS.n44 VSS.n31 0.00189631
R998 VSS.n44 VSS.n33 0.00189631
R999 VSS.n44 VSS.n34 0.00189631
R1000 VSS.n44 VSS.n35 0.00189631
R1001 VSS.n44 VSS.n36 0.00189631
R1002 VSS.n44 VSS.n37 0.00189631
R1003 VSS.n44 VSS.n38 0.00189631
R1004 VSS.n44 VSS.n39 0.00189631
R1005 VSS.n44 VSS.n40 0.00189631
R1006 VSS.n44 VSS.n41 0.00189631
R1007 VSS.n45 VSS.t122 19.2407
R1008 VSS.n15 VSS.n14 0.00609984
R1009 VSS.n19 VSS.t146 0.00381436
R1010 VSS.t146 VSS.n4 0.00187013
R1011 VSS.t146 VSS.n3 0.00187013
R1012 VSS.n44 VSS.n32 0.00178861
R1013 VSS.n15 VSS.n12 0.00339998
R1014 VSS.n48 VSS.n22 0.00339996
R1015 VSS.n49 VSS.n48 0.0032
R1016 VSS.n16 VSS.n12 0.0027999
R1017 VSS.n9 VSS.t146 0.00192385
R1018 VSS.n14 VSS.n16 0.00269996
R1019 VSS.n44 VSS.t125 0.00257906
R1020 VSS.t146 VSS.n5 0.0022013
R1021 VSS.t146 VSS.n6 0.00271138
R1022 VSS.t146 VSS.n0 0.00270607
R1023 VSS.t146 VSS.n11 0.00234204
R1024 VSS.t146 VSS.n2 0.00228137
R1025 VSS.n8 VSS.t56 152.327
R1026 VSS.n7 VSS.t50 51.0633
R1027 inverter_1.vin.n0 inverter_1.vin.t0 10.2939
R1028 inverter_1.vin.n0 inverter_1.vin.t1 10.2939
R1029 inverter_1.vin.n0 inverter_1.vin.t2 10.2939
R1030 inverter_1.vin.n0 inverter_1.vin.t3 10.2939
R1031 inverter_1.vin.n0 inverter_1.vin.t4 10.2939
R1032 inverter_1.vin.n0 inverter_1.vin.t5 10.2939
R1033 inverter_1.vin.n0 inverter_1.vin.t6 10.2939
R1034 inverter_1.vin inverter_1.vin.t7 10.2939
R1035 inverter_1.vin inverter_1.vin.t8 10.2939
R1036 inverter_1.vin inverter_1.vin.t9 10.2939
R1037 inverter_1.vin inverter_1.vin.t19 2.09074
R1038 inverter_1.vin.n0 inverter_1.vin.t15 2.08896
R1039 inverter_1.vin inverter_1.vin.t18 2.08893
R1040 inverter_1.vin inverter_1.vin.t17 2.08823
R1041 inverter_1.vin.n0 inverter_1.vin.t16 2.08818
R1042 inverter_1.vin.n0 inverter_1.vin.t11 2.06995
R1043 inverter_1.vin.n0 inverter_1.vin.t12 2.0693
R1044 inverter_1.vin.n0 inverter_1.vin.t13 2.06888
R1045 inverter_1.vin.n0 inverter_1.vin.t14 2.06888
R1046 inverter_1.vin.n0 inverter_1.vin.t10 2.06754
R1047 inverter_1.vin.t21 inverter_1.vin 1.61676
R1048 inverter_1.vin inverter_1.vin.n0 1.46365
R1049 inverter_1.vin inverter_1.vin.t20 1.13653
R1050 inverter_2.vin.n0 inverter_2.vin.t10 10.2939
R1051 inverter_2.vin.n0 inverter_2.vin.t11 10.2939
R1052 inverter_2.vin.n0 inverter_2.vin.t12 10.2939
R1053 inverter_2.vin.n0 inverter_2.vin.t13 10.2939
R1054 inverter_2.vin.n0 inverter_2.vin.t14 10.2939
R1055 inverter_2.vin.n0 inverter_2.vin.t15 10.2939
R1056 inverter_2.vin.n0 inverter_2.vin.t16 10.2939
R1057 inverter_2.vin inverter_2.vin.t17 10.2939
R1058 inverter_2.vin inverter_2.vin.t18 10.2939
R1059 inverter_2.vin inverter_2.vin.t19 10.2939
R1060 inverter_2.vin inverter_2.vin.t9 2.09074
R1061 inverter_2.vin inverter_2.vin.t8 2.08902
R1062 inverter_2.vin.n0 inverter_2.vin.t6 2.08814
R1063 inverter_2.vin.n0 inverter_2.vin.t5 2.08731
R1064 inverter_2.vin inverter_2.vin.t7 2.08723
R1065 inverter_2.vin.n0 inverter_2.vin.t1 2.06982
R1066 inverter_2.vin.n0 inverter_2.vin.t2 2.06964
R1067 inverter_2.vin.n0 inverter_2.vin.t4 2.06902
R1068 inverter_2.vin.n0 inverter_2.vin.t3 2.06896
R1069 inverter_2.vin.n0 inverter_2.vin.t0 2.06753
R1070 inverter_2.vin.t21 inverter_2.vin 1.61676
R1071 inverter_2.vin inverter_2.vin.n0 1.46365
R1072 inverter_2.vin inverter_2.vin.t20 1.13653
R1073 inverter_0.vin.n0 inverter_0.vin.t10 10.2939
R1074 inverter_0.vin.n0 inverter_0.vin.t11 10.2939
R1075 inverter_0.vin.n0 inverter_0.vin.t12 10.2939
R1076 inverter_0.vin.n0 inverter_0.vin.t13 10.2939
R1077 inverter_0.vin.n0 inverter_0.vin.t14 10.2939
R1078 inverter_0.vin.n0 inverter_0.vin.t15 10.2939
R1079 inverter_0.vin.n0 inverter_0.vin.t16 10.2939
R1080 inverter_0.vin inverter_0.vin.t17 10.2939
R1081 inverter_0.vin inverter_0.vin.t18 10.2939
R1082 inverter_0.vin inverter_0.vin.t19 10.2939
R1083 inverter_0.vin inverter_0.vin.t9 2.09074
R1084 inverter_0.vin.n0 inverter_0.vin.t6 2.089
R1085 inverter_0.vin.n0 inverter_0.vin.t5 2.08873
R1086 inverter_0.vin inverter_0.vin.t7 2.08854
R1087 inverter_0.vin inverter_0.vin.t8 2.08826
R1088 inverter_0.vin.n0 inverter_0.vin.t1 2.06998
R1089 inverter_0.vin.n0 inverter_0.vin.t2 2.06977
R1090 inverter_0.vin.n0 inverter_0.vin.t4 2.06964
R1091 inverter_0.vin.n0 inverter_0.vin.t3 2.06802
R1092 inverter_0.vin.n0 inverter_0.vin.t0 2.06775
R1093 inverter_0.vin.t22 inverter_0.vin 1.61676
R1094 inverter_0.vin.t23 inverter_0.vin 1.61676
R1095 inverter_0.vin inverter_0.vin.n0 1.46365
R1096 inverter_0.vin inverter_0.vin.t20 1.13653
R1097 inverter_0.vin inverter_0.vin.t21 1.13653
C0 inverter_2.vin inverter_1.vin 16.0541f
C1 VDD inverter_1.vin 37.6992f
C2 inverter_2.vin VDD 37.689f
C3 vout inverter_0.vin 16.0789f
C4 vout VDD 11.2008f
C5 inverter_0.vin inverter_1.vin 18.8685f
C6 inverter_2.vin inverter_0.vin 18.8493f
C7 VDD inverter_0.vin 64.847f
C8 vout VSS 18.06776f
C9 inverter_1.vin VSS 31.78617f
C10 inverter_2.vin VSS 31.92035f
C11 inverter_0.vin VSS 63.11675f
C12 inverter_0.vin.n0 VSS 19.1108f
C13 inverter_0.vin.t19 VSS 0.1395f
C14 inverter_0.vin.t8 VSS 0.99857f
C15 inverter_0.vin.t18 VSS 0.1395f
C16 inverter_0.vin.t7 VSS 11.91412f
C17 inverter_0.vin.t17 VSS 0.1395f
C18 inverter_0.vin.t6 VSS 0.99842f
C19 inverter_0.vin.t16 VSS 0.1395f
C20 inverter_0.vin.t5 VSS 0.99846f
C21 inverter_0.vin.t15 VSS 0.1395f
C22 inverter_0.vin.t4 VSS 0.99041f
C23 inverter_0.vin.t14 VSS 0.1395f
C24 inverter_0.vin.t3 VSS 0.99075f
C25 inverter_0.vin.t13 VSS 0.1395f
C26 inverter_0.vin.t2 VSS 0.99041f
C27 inverter_0.vin.t12 VSS 0.1395f
C28 inverter_0.vin.t1 VSS 0.99034f
C29 inverter_0.vin.t11 VSS 3.27543f
C30 inverter_0.vin.t0 VSS 0.99084f
C31 inverter_0.vin.t10 VSS 0.1395f
C32 inverter_0.vin.t9 VSS 0.99797f
C33 inverter_2.vin.n0 VSS 18.5028f
C34 inverter_2.vin.t19 VSS 0.13506f
C35 inverter_2.vin.t8 VSS 0.96665f
C36 inverter_2.vin.t18 VSS 0.13506f
C37 inverter_2.vin.t7 VSS 0.96707f
C38 inverter_2.vin.t17 VSS 0.13506f
C39 inverter_2.vin.t6 VSS 12.2354f
C40 inverter_2.vin.t16 VSS 0.13506f
C41 inverter_2.vin.t5 VSS 0.96705f
C42 inverter_2.vin.t15 VSS 3.3724f
C43 inverter_2.vin.t4 VSS 0.959f
C44 inverter_2.vin.t14 VSS 0.13506f
C45 inverter_2.vin.t3 VSS 0.95903f
C46 inverter_2.vin.t13 VSS 0.13506f
C47 inverter_2.vin.t2 VSS 0.95891f
C48 inverter_2.vin.t12 VSS 0.13506f
C49 inverter_2.vin.t1 VSS 0.95889f
C50 inverter_2.vin.t11 VSS 0.13506f
C51 inverter_2.vin.t0 VSS 0.95937f
C52 inverter_2.vin.t10 VSS 0.13506f
C53 inverter_2.vin.t9 VSS 0.96624f
C54 inverter_1.vin.n0 VSS 18.5119f
C55 inverter_1.vin.t9 VSS 0.13513f
C56 inverter_1.vin.t18 VSS 0.96716f
C57 inverter_1.vin.t8 VSS 0.13513f
C58 inverter_1.vin.t17 VSS 0.96732f
C59 inverter_1.vin.t7 VSS 0.13513f
C60 inverter_1.vin.t16 VSS 0.96734f
C61 inverter_1.vin.t6 VSS 0.13513f
C62 inverter_1.vin.t15 VSS 11.87739f
C63 inverter_1.vin.t5 VSS 3.26953f
C64 inverter_1.vin.t14 VSS 0.95959f
C65 inverter_1.vin.t4 VSS 0.13513f
C66 inverter_1.vin.t13 VSS 0.95959f
C67 inverter_1.vin.t3 VSS 0.13513f
C68 inverter_1.vin.t12 VSS 0.95948f
C69 inverter_1.vin.t2 VSS 0.13513f
C70 inverter_1.vin.t11 VSS 0.95933f
C71 inverter_1.vin.t1 VSS 0.13513f
C72 inverter_1.vin.t10 VSS 0.95982f
C73 inverter_1.vin.t0 VSS 0.13513f
C74 inverter_1.vin.t19 VSS 0.96671f
C75 VSS.t22 VSS 3.1344f
C76 VSS.t37 VSS 3.23733f
C77 VSS.t71 VSS 3.13594f
C78 VSS.t104 VSS 3.23733f
.ends
