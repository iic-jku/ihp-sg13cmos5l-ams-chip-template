* PEX produced on Sat Nov  7 04:10:01 PM CET 2026 using /foss/tools/sak/sak-pex.sh with m=3 and s=1 (extresist threshold=10000 mOhm, minres=1000 mOhm, mindelay=1 ps)
* NGSPICE file created from ringosc_pex.ext - technology: ihp-sg13cmos5l

.subckt ringosc_pex vout VDD VSS
X0 VDD inverter_1.vin.t21 inverter_0.vin.t7 VDD sg13_lv_pmos ad=1.14p pd=6.38u as=1.14p ps=6.38u w=6u l=1u
X1 inverter_0.vin.t11 inverter_1.vin.t20 VSS.t40 VSS.t41 sg13_lv_nmos ad=0.19p pd=1.38u as=0.19p ps=1.38u w=1u l=1u
X2 VSS.t20 inverter_2.vin.t20 inverter_1.vin.t5 VSS.t19 sg13_lv_nmos ad=0.19p pd=1.38u as=0.19p ps=1.38u w=1u l=1u
X3 inverter_2.vin.t16 inverter_0.vin.t23 VDD VDD sg13_lv_pmos ad=1.14p pd=6.38u as=1.14p ps=6.38u w=6u l=1u
X4 inverter_1.vin.t15 inverter_2.vin.t21 VDD VDD sg13_lv_pmos ad=1.14p pd=6.38u as=1.14p ps=6.38u w=6u l=1u
X5 VDD inverter_0.vin.t23 inverter_2.vin.t17 VDD sg13_lv_pmos ad=1.14p pd=6.38u as=1.14p ps=6.38u w=6u l=1u
X6 VSS.t99 inverter_0.vin.t20 vout VSS.t98 sg13_lv_nmos ad=0.19p pd=1.38u as=0.19p ps=1.38u w=1u l=1u
X7 inverter_0.vin.t7 inverter_1.vin.t21 VDD VDD sg13_lv_pmos ad=1.14p pd=6.38u as=1.14p ps=6.38u w=6u l=1u
X8 inverter_2.vin.t19 inverter_0.vin.t23 VDD VDD sg13_lv_pmos ad=1.14p pd=6.38u as=1.14p ps=6.38u w=6u l=1u
X9 inverter_1.vin.t1 inverter_2.vin.t20 VSS.t7 VSS.t10 sg13_lv_nmos ad=0.19p pd=1.38u as=0.19p ps=1.38u w=1u l=1u
X10 VDD inverter_1.vin.t21 inverter_0.vin.t8 VDD sg13_lv_pmos ad=1.14p pd=6.38u as=1.14p ps=6.38u w=6u l=1u
X11 inverter_1.vin.t5 inverter_2.vin.t20 VSS.t9 VSS.t8 sg13_lv_nmos ad=0.19p pd=1.38u as=0.19p ps=1.38u w=1u l=1u
X12 VSS.t34 inverter_1.vin.t20 inverter_0.vin.t13 VSS.t33 sg13_lv_nmos ad=0.19p pd=1.38u as=0.19p ps=1.38u w=1u l=1u
X13 inverter_1.vin.t8 inverter_2.vin.t20 VSS.t26 VSS.t27 sg13_lv_nmos ad=0.19p pd=1.38u as=0.19p ps=1.38u w=1u l=1u
X14 inverter_1.vin.t14 inverter_2.vin.t21 VDD VDD sg13_lv_pmos ad=1.14p pd=6.38u as=1.14p ps=6.38u w=6u l=1u
X15 VDD VDD VDD VDD sg13_lv_pmos ad=1.14p pd=6.38u as=0.58725n ps=1.08582m w=6u l=1u
X16 VDD VDD VDD VDD sg13_lv_pmos ad=2.04p pd=12.68u as=0 ps=0 w=6u l=1u
X17 VSS.t120 inverter_0.vin.t20 vout VSS.t119 sg13_lv_nmos ad=0.19p pd=1.38u as=0.19p ps=1.38u w=1u l=1u
X18 vout inverter_0.vin.t22 VDD VDD sg13_lv_pmos ad=1.14p pd=6.38u as=1.14p ps=6.38u w=6u l=1u
X19 vout inverter_0.vin.t20 VSS.t105 VSS.t106 sg13_lv_nmos ad=0.19p pd=1.38u as=0.19p ps=1.38u w=1u l=1u
X20 inverter_2.vin.t5 inverter_0.vin.t21 VSS.t79 VSS.t82 sg13_lv_nmos ad=0.19p pd=1.38u as=0.19p ps=1.38u w=1u l=1u
X21 VSS.t40 inverter_1.vin.t20 inverter_0.vin.t10 VSS.t39 sg13_lv_nmos ad=0.19p pd=1.38u as=0.19p ps=1.38u w=1u l=1u
X22 vout inverter_0.vin.t20 VSS.t96 VSS.t97 sg13_lv_nmos ad=0.19p pd=1.38u as=0.19p ps=1.38u w=1u l=1u
X23 inverter_2.vin.t0 inverter_0.vin.t21 VSS.t63 VSS.t62 sg13_lv_nmos ad=0.19p pd=1.38u as=0.19p ps=1.38u w=1u l=1u
X24 inverter_0.vin.t5 inverter_1.vin.t21 VDD VDD sg13_lv_pmos ad=1.14p pd=6.38u as=1.14p ps=6.38u w=6u l=1u
X25 VSS.t26 inverter_2.vin.t20 inverter_1.vin.t7 VSS.t25 sg13_lv_nmos ad=0.19p pd=1.38u as=0.19p ps=1.38u w=1u l=1u
X26 VDD inverter_1.vin.t21 inverter_0.vin.t6 VDD sg13_lv_pmos ad=1.14p pd=6.38u as=1.14p ps=6.38u w=6u l=1u
X27 VSS.t7 inverter_2.vin.t20 inverter_1.vin.t0 VSS.t6 sg13_lv_nmos ad=0.19p pd=1.38u as=0.19p ps=1.38u w=1u l=1u
X28 inverter_0.vin.t8 inverter_1.vin.t21 VDD VDD sg13_lv_pmos ad=1.14p pd=6.38u as=1.14p ps=6.38u w=6u l=1u
X29 vout inverter_0.vin.t20 VSS.t117 VSS.t118 sg13_lv_nmos ad=0.19p pd=1.38u as=0.19p ps=1.38u w=1u l=1u
X30 VDD inverter_0.vin.t22 vout VDD sg13_lv_pmos ad=1.14p pd=6.38u as=1.14p ps=6.38u w=6u l=1u
X31 VSS.t54 inverter_1.vin.t20 inverter_0.vin.t17 VSS.t56 sg13_lv_nmos ad=0.19p pd=1.38u as=0.19p ps=1.38u w=1u l=1u
X32 VSS.t81 inverter_0.vin.t21 inverter_2.vin.t7 VSS.t87 sg13_lv_nmos ad=0.19p pd=1.38u as=0.19p ps=1.38u w=1u l=1u
X33 inverter_0.vin.t13 inverter_1.vin.t20 VSS.t44 VSS.t45 sg13_lv_nmos ad=0.19p pd=1.38u as=0.19p ps=1.38u w=1u l=1u
X34 inverter_1.vin.t18 inverter_2.vin.t21 VDD VDD sg13_lv_pmos ad=1.14p pd=6.38u as=1.14p ps=6.38u w=6u l=1u
X35 VSS.t126 VSS.t124 VSS.t63 VSS.t125 sg13_lv_nmos ad=0.34p pd=2.68u as=0 ps=0 w=1u l=1u
X36 inverter_2.vin.t10 inverter_0.vin.t23 VDD VDD sg13_lv_pmos ad=1.14p pd=6.38u as=1.14p ps=6.38u w=6u l=1u
X37 VDD inverter_2.vin.t21 inverter_1.vin.t13 VDD sg13_lv_pmos ad=1.14p pd=6.38u as=1.14p ps=6.38u w=6u l=1u
X38 VDD inverter_2.vin.t21 inverter_1.vin.t19 VDD sg13_lv_pmos ad=1.14p pd=6.38u as=1.14p ps=6.38u w=6u l=1u
X39 VDD inverter_0.vin.t22 vout VDD sg13_lv_pmos ad=1.14p pd=6.38u as=1.14p ps=6.38u w=6u l=1u
X40 VSS.t105 inverter_0.vin.t20 vout VSS.t104 sg13_lv_nmos ad=0.19p pd=1.38u as=0.19p ps=1.38u w=1u l=1u
X41 inverter_1.vin.t0 inverter_2.vin.t20 VSS.t5 VSS.t4 sg13_lv_nmos ad=0.19p pd=1.38u as=0.19p ps=1.38u w=1u l=1u
X42 VSS.t23 VSS.t133 VSS.t135 VSS.t134 sg13_lv_nmos ad=0.19p pd=1.38u as=0 ps=0 w=1u l=1u
X43 inverter_1.vin.t3 inverter_2.vin.t20 VSS.t13 VSS.t14 sg13_lv_nmos ad=0.19p pd=1.38u as=0.19p ps=1.38u w=1u l=1u
X44 VDD inverter_0.vin.t22 vout VDD sg13_lv_pmos ad=1.14p pd=6.38u as=1.14p ps=6.38u w=6u l=1u
X45 inverter_2.vin.t7 inverter_0.vin.t21 VSS.t67 VSS.t86 sg13_lv_nmos ad=0.19p pd=1.38u as=0.19p ps=1.38u w=1u l=1u
X46 inverter_1.vin.t7 inverter_2.vin.t20 VSS.t3 VSS.t24 sg13_lv_nmos ad=0.19p pd=1.38u as=0.19p ps=1.38u w=1u l=1u
X47 VDD inverter_0.vin.t23 inverter_2.vin.t16 VDD sg13_lv_pmos ad=1.14p pd=6.38u as=1.14p ps=6.38u w=6u l=1u
X48 inverter_2.vin.t18 inverter_0.vin.t23 VDD VDD sg13_lv_pmos ad=1.14p pd=6.38u as=1.14p ps=6.38u w=6u l=1u
X49 vout inverter_0.vin.t20 VSS.t111 VSS.t112 sg13_lv_nmos ad=0.19p pd=1.38u as=0.19p ps=1.38u w=1u l=1u
X50 VSS.t13 inverter_2.vin.t20 inverter_1.vin.t2 VSS.t12 sg13_lv_nmos ad=0.19p pd=1.38u as=0.19p ps=1.38u w=1u l=1u
X51 VSS.t75 inverter_0.vin.t21 inverter_2.vin.t2 VSS.t74 sg13_lv_nmos ad=0.19p pd=1.38u as=0.19p ps=1.38u w=1u l=1u
X52 VSS.t44 inverter_1.vin.t20 inverter_0.vin.t12 VSS.t43 sg13_lv_nmos ad=0.19p pd=1.38u as=0.19p ps=1.38u w=1u l=1u
X53 vout inverter_0.vin.t22 VDD VDD sg13_lv_pmos ad=1.14p pd=6.38u as=1.14p ps=6.38u w=6u l=1u
X54 VSS.t92 inverter_0.vin.t21 inverter_2.vin.t9 VSS.t91 sg13_lv_nmos ad=0.19p pd=1.38u as=0.19p ps=1.38u w=1u l=1u
X55 VSS.t61 inverter_1.vin.t20 inverter_0.vin.t19 VSS.t60 sg13_lv_nmos ad=0.19p pd=1.38u as=0.19p ps=1.38u w=1u l=1u
X56 VSS.t23 inverter_2.vin.t20 inverter_1.vin.t9 VSS.t22 sg13_lv_nmos ad=0.19p pd=1.38u as=0.19p ps=1.38u w=1u l=1u
X57 inverter_1.vin.t11 inverter_2.vin.t21 VDD VDD sg13_lv_pmos ad=1.14p pd=6.38u as=1.14p ps=6.38u w=6u l=1u
X58 vout inverter_0.vin.t22 VDD VDD sg13_lv_pmos ad=1.14p pd=6.38u as=1.14p ps=6.38u w=6u l=1u
X59 VSS.t123 VSS.t145 VSS.t147 VSS.t146 sg13_lv_nmos ad=0.19p pd=1.38u as=0 ps=0 w=1u l=1u
X60 VDD inverter_2.vin.t21 inverter_1.vin.t12 VDD sg13_lv_pmos ad=1.14p pd=6.38u as=1.14p ps=6.38u w=6u l=1u
X61 VDD inverter_2.vin.t21 inverter_1.vin.t18 VDD sg13_lv_pmos ad=1.14p pd=6.38u as=1.14p ps=6.38u w=6u l=1u
X62 VSS.t111 inverter_0.vin.t20 vout VSS.t110 sg13_lv_nmos ad=0.19p pd=1.38u as=0.19p ps=1.38u w=1u l=1u
X63 VDD inverter_0.vin.t22 vout VDD sg13_lv_pmos ad=1.14p pd=6.38u as=1.14p ps=6.38u w=6u l=1u
X64 inverter_0.vin.t12 inverter_1.vin.t20 VSS.t36 VSS.t35 sg13_lv_nmos ad=0.19p pd=1.38u as=0.19p ps=1.38u w=1u l=1u
X65 VDD inverter_0.vin.t23 inverter_2.vin.t10 VDD sg13_lv_pmos ad=1.14p pd=6.38u as=1.14p ps=6.38u w=6u l=1u
X66 inverter_0.vin.t15 inverter_1.vin.t20 VSS.t32 VSS.t31 sg13_lv_nmos ad=0.19p pd=1.38u as=0.19p ps=1.38u w=1u l=1u
X67 VDD inverter_1.vin.t21 inverter_0.vin.t5 VDD sg13_lv_pmos ad=1.14p pd=6.38u as=1.14p ps=6.38u w=6u l=1u
X68 inverter_1.vin.t9 inverter_2.vin.t20 VSS.t29 VSS.t30 sg13_lv_nmos ad=0.19p pd=1.38u as=0.19p ps=1.38u w=1u l=1u
X69 inverter_1.vin.t2 inverter_2.vin.t20 VSS.t1 VSS.t0 sg13_lv_nmos ad=0.19p pd=1.38u as=0.19p ps=1.38u w=1u l=1u
X70 inverter_2.vin.t14 inverter_0.vin.t23 VDD VDD sg13_lv_pmos ad=1.14p pd=6.38u as=1.14p ps=6.38u w=6u l=1u
X71 vout inverter_0.vin.t22 VDD VDD sg13_lv_pmos ad=1.14p pd=6.38u as=1.14p ps=6.38u w=6u l=1u
X72 VDD inverter_0.vin.t23 inverter_2.vin.t15 VDD sg13_lv_pmos ad=1.14p pd=6.38u as=1.14p ps=6.38u w=6u l=1u
X73 VDD inverter_1.vin.t21 inverter_0.vin.t3 VDD sg13_lv_pmos ad=1.14p pd=6.38u as=1.14p ps=6.38u w=6u l=1u
X74 VDD inverter_0.vin.t22 vout VDD sg13_lv_pmos ad=1.14p pd=6.38u as=1.14p ps=6.38u w=6u l=1u
X75 inverter_2.vin.t17 inverter_0.vin.t23 VDD VDD sg13_lv_pmos ad=1.14p pd=6.38u as=1.14p ps=6.38u w=6u l=1u
X76 VDD VDD VDD VDD sg13_lv_pmos ad=1.14p pd=6.38u as=0 ps=0 w=6u l=1u
X77 inverter_2.vin.t9 inverter_0.vin.t21 VSS.t89 VSS.t90 sg13_lv_nmos ad=0.19p pd=1.38u as=0.19p ps=1.38u w=1u l=1u
X78 VSS.t32 inverter_1.vin.t20 inverter_0.vin.t14 VSS.t47 sg13_lv_nmos ad=0.19p pd=1.38u as=0.19p ps=1.38u w=1u l=1u
X79 VSS.t79 inverter_0.vin.t21 inverter_2.vin.t4 VSS.t78 sg13_lv_nmos ad=0.19p pd=1.38u as=0.19p ps=1.38u w=1u l=1u
X80 VDD inverter_2.vin.t21 inverter_1.vin.t10 VDD sg13_lv_pmos ad=1.14p pd=6.38u as=1.14p ps=6.38u w=6u l=1u
X81 VDD VDD VDD VDD sg13_lv_pmos ad=2.04p pd=12.68u as=0 ps=0 w=6u l=1u
X82 inverter_1.vin.t12 inverter_2.vin.t21 VDD VDD sg13_lv_pmos ad=1.14p pd=6.38u as=1.14p ps=6.38u w=6u l=1u
X83 vout inverter_0.vin.t22 VDD VDD sg13_lv_pmos ad=1.14p pd=6.38u as=1.14p ps=6.38u w=6u l=1u
X84 VSS.t9 inverter_2.vin.t20 inverter_1.vin.t4 VSS.t18 sg13_lv_nmos ad=0.19p pd=1.38u as=0.19p ps=1.38u w=1u l=1u
X85 inverter_0.vin.t10 inverter_1.vin.t20 VSS.t38 VSS.t37 sg13_lv_nmos ad=0.19p pd=1.38u as=0.19p ps=1.38u w=1u l=1u
X86 VDD inverter_0.vin.t23 inverter_2.vin.t13 VDD sg13_lv_pmos ad=1.14p pd=6.38u as=1.14p ps=6.38u w=6u l=1u
X87 inverter_0.vin.t17 inverter_1.vin.t20 VSS.t52 VSS.t55 sg13_lv_nmos ad=0.19p pd=1.38u as=0.19p ps=1.38u w=1u l=1u
X88 inverter_2.vin.t15 inverter_0.vin.t23 VDD VDD sg13_lv_pmos ad=1.14p pd=6.38u as=1.14p ps=6.38u w=6u l=1u
X89 inverter_0.vin.t3 inverter_1.vin.t21 VDD VDD sg13_lv_pmos ad=1.14p pd=6.38u as=1.14p ps=6.38u w=6u l=1u
X90 VDD inverter_1.vin.t21 inverter_0.vin.t4 VDD sg13_lv_pmos ad=1.14p pd=6.38u as=1.14p ps=6.38u w=6u l=1u
X91 VSS.t117 inverter_0.vin.t20 vout VSS.t116 sg13_lv_nmos ad=0.19p pd=1.38u as=0.19p ps=1.38u w=1u l=1u
X92 inverter_0.vin.t6 inverter_1.vin.t21 VDD VDD sg13_lv_pmos ad=1.14p pd=6.38u as=1.14p ps=6.38u w=6u l=1u
X93 vout inverter_0.vin.t22 VDD VDD sg13_lv_pmos ad=1.14p pd=6.38u as=1.14p ps=6.38u w=6u l=1u
X94 inverter_0.vin.t14 inverter_1.vin.t20 VSS.t34 VSS.t46 sg13_lv_nmos ad=0.19p pd=1.38u as=0.19p ps=1.38u w=1u l=1u
X95 vout inverter_0.vin.t20 VSS.t102 VSS.t103 sg13_lv_nmos ad=0.19p pd=1.38u as=0.19p ps=1.38u w=1u l=1u
X96 VSS.t138 VSS.t136 VSS.t38 VSS.t137 sg13_lv_nmos ad=0.34p pd=2.68u as=0 ps=0 w=1u l=1u
X97 VDD inverter_0.vin.t22 vout VDD sg13_lv_pmos ad=1.14p pd=6.38u as=1.14p ps=6.38u w=6u l=1u
X98 inverter_1.vin.t16 inverter_2.vin.t21 VDD VDD sg13_lv_pmos ad=1.14p pd=6.38u as=1.14p ps=6.38u w=6u l=1u
X99 VSS.t3 inverter_2.vin.t20 inverter_1.vin.t6 VSS.t2 sg13_lv_nmos ad=0.19p pd=1.38u as=0.19p ps=1.38u w=1u l=1u
X100 VDD inverter_2.vin.t21 inverter_1.vin.t11 VDD sg13_lv_pmos ad=1.14p pd=6.38u as=1.14p ps=6.38u w=6u l=1u
X101 VDD inverter_2.vin.t21 inverter_1.vin.t17 VDD sg13_lv_pmos ad=1.14p pd=6.38u as=1.14p ps=6.38u w=6u l=1u
X102 VSS.t132 VSS.t130 VSS.t5 VSS.t131 sg13_lv_nmos ad=0.34p pd=2.68u as=0 ps=0 w=1u l=1u
X103 VDD VDD VDD VDD sg13_lv_pmos ad=2.04p pd=12.68u as=0 ps=0 w=6u l=1u
X104 inverter_1.vin.t19 inverter_2.vin.t21 VDD VDD sg13_lv_pmos ad=1.14p pd=6.38u as=1.14p ps=6.38u w=6u l=1u
X105 VSS.t52 inverter_1.vin.t20 inverter_0.vin.t16 VSS.t51 sg13_lv_nmos ad=0.19p pd=1.38u as=0.19p ps=1.38u w=1u l=1u
X106 VSS.t67 inverter_0.vin.t21 inverter_2.vin.t6 VSS.t66 sg13_lv_nmos ad=0.19p pd=1.38u as=0.19p ps=1.38u w=1u l=1u
X107 VDD inverter_1.vin.t21 inverter_0.vin.t2 VDD sg13_lv_pmos ad=1.14p pd=6.38u as=1.14p ps=6.38u w=6u l=1u
X108 inverter_2.vin.t2 inverter_0.vin.t21 VSS.t71 VSS.t70 sg13_lv_nmos ad=0.19p pd=1.38u as=0.19p ps=1.38u w=1u l=1u
X109 VDD inverter_0.vin.t23 inverter_2.vin.t14 VDD sg13_lv_pmos ad=1.14p pd=6.38u as=1.14p ps=6.38u w=6u l=1u
X110 inverter_0.vin.t4 inverter_1.vin.t21 VDD VDD sg13_lv_pmos ad=1.14p pd=6.38u as=1.14p ps=6.38u w=6u l=1u
X111 VSS.t102 inverter_0.vin.t20 vout VSS.t101 sg13_lv_nmos ad=0.19p pd=1.38u as=0.19p ps=1.38u w=1u l=1u
X112 VDD inverter_0.vin.t23 inverter_2.vin.t12 VDD sg13_lv_pmos ad=1.14p pd=6.38u as=1.14p ps=6.38u w=6u l=1u
X113 inverter_0.vin.t16 inverter_1.vin.t20 VSS.t49 VSS.t50 sg13_lv_nmos ad=0.19p pd=1.38u as=0.19p ps=1.38u w=1u l=1u
X114 VDD VDD VDD VDD sg13_lv_pmos ad=2.04p pd=12.68u as=0 ps=0 w=6u l=1u
X115 VDD inverter_2.vin.t21 inverter_1.vin.t15 VDD sg13_lv_pmos ad=1.14p pd=6.38u as=1.14p ps=6.38u w=6u l=1u
X116 inverter_1.vin.t17 inverter_2.vin.t21 VDD VDD sg13_lv_pmos ad=1.14p pd=6.38u as=1.14p ps=6.38u w=6u l=1u
X117 inverter_0.vin.t19 inverter_1.vin.t20 VSS.t58 VSS.t59 sg13_lv_nmos ad=0.19p pd=1.38u as=0.19p ps=1.38u w=1u l=1u
X118 VSS.t123 inverter_0.vin.t20 vout VSS.t122 sg13_lv_nmos ad=0.19p pd=1.38u as=0.19p ps=1.38u w=1u l=1u
X119 inverter_0.vin.t9 inverter_1.vin.t21 VDD VDD sg13_lv_pmos ad=1.14p pd=6.38u as=1.14p ps=6.38u w=6u l=1u
X120 VDD inverter_2.vin.t21 inverter_1.vin.t16 VDD sg13_lv_pmos ad=1.14p pd=6.38u as=1.14p ps=6.38u w=6u l=1u
X121 vout inverter_0.vin.t20 VSS.t108 VSS.t109 sg13_lv_nmos ad=0.19p pd=1.38u as=0.19p ps=1.38u w=1u l=1u
X122 VSS.t36 inverter_1.vin.t20 inverter_0.vin.t11 VSS.t42 sg13_lv_nmos ad=0.19p pd=1.38u as=0.19p ps=1.38u w=1u l=1u
X123 VSS.t1 inverter_2.vin.t20 inverter_1.vin.t1 VSS.t11 sg13_lv_nmos ad=0.19p pd=1.38u as=0.19p ps=1.38u w=1u l=1u
X124 VSS.t96 inverter_0.vin.t20 vout VSS.t95 sg13_lv_nmos ad=0.19p pd=1.38u as=0.19p ps=1.38u w=1u l=1u
X125 VSS.t71 inverter_0.vin.t21 inverter_2.vin.t1 VSS.t73 sg13_lv_nmos ad=0.19p pd=1.38u as=0.19p ps=1.38u w=1u l=1u
X126 VSS.t58 inverter_1.vin.t20 inverter_0.vin.t18 VSS.t57 sg13_lv_nmos ad=0.19p pd=1.38u as=0.19p ps=1.38u w=1u l=1u
X127 inverter_0.vin.t0 inverter_1.vin.t21 VDD VDD sg13_lv_pmos ad=1.14p pd=6.38u as=1.14p ps=6.38u w=6u l=1u
X128 VSS.t29 inverter_2.vin.t20 inverter_1.vin.t8 VSS.t28 sg13_lv_nmos ad=0.19p pd=1.38u as=0.19p ps=1.38u w=1u l=1u
X129 inverter_2.vin.t12 inverter_0.vin.t23 VDD VDD sg13_lv_pmos ad=1.14p pd=6.38u as=1.14p ps=6.38u w=6u l=1u
X130 VDD inverter_1.vin.t21 inverter_0.vin.t1 VDD sg13_lv_pmos ad=1.14p pd=6.38u as=1.14p ps=6.38u w=6u l=1u
X131 vout inverter_0.vin.t22 VDD VDD sg13_lv_pmos ad=1.14p pd=6.38u as=1.14p ps=6.38u w=6u l=1u
X132 VDD inverter_0.vin.t22 vout VDD sg13_lv_pmos ad=1.14p pd=6.38u as=1.14p ps=6.38u w=6u l=1u
X133 vout inverter_0.vin.t22 VDD VDD sg13_lv_pmos ad=1.14p pd=6.38u as=1.14p ps=6.38u w=6u l=1u
X134 inverter_1.vin.t4 inverter_2.vin.t20 VSS.t16 VSS.t17 sg13_lv_nmos ad=0.19p pd=1.38u as=0.19p ps=1.38u w=1u l=1u
X135 VSS.t89 inverter_0.vin.t21 inverter_2.vin.t8 VSS.t88 sg13_lv_nmos ad=0.19p pd=1.38u as=0.19p ps=1.38u w=1u l=1u
X136 inverter_2.vin.t4 inverter_0.vin.t21 VSS.t69 VSS.t77 sg13_lv_nmos ad=0.19p pd=1.38u as=0.19p ps=1.38u w=1u l=1u
X137 VSS.t65 inverter_0.vin.t21 inverter_2.vin.t0 VSS.t64 sg13_lv_nmos ad=0.19p pd=1.38u as=0.19p ps=1.38u w=1u l=1u
X138 VSS.t108 inverter_0.vin.t20 vout VSS.t107 sg13_lv_nmos ad=0.19p pd=1.38u as=0.19p ps=1.38u w=1u l=1u
X139 VDD VDD VDD VDD sg13_lv_pmos ad=1.14p pd=6.38u as=0 ps=0 w=6u l=1u
X140 vout inverter_0.vin.t20 VSS.t94 VSS.t93 sg13_lv_nmos ad=0.19p pd=1.38u as=0.19p ps=1.38u w=1u l=1u
X141 inverter_1.vin.t10 inverter_2.vin.t21 VDD VDD sg13_lv_pmos ad=1.14p pd=6.38u as=1.14p ps=6.38u w=6u l=1u
X142 inverter_2.vin.t1 inverter_0.vin.t21 VSS.t65 VSS.t72 sg13_lv_nmos ad=0.19p pd=1.38u as=0.19p ps=1.38u w=1u l=1u
X143 inverter_0.vin.t18 inverter_1.vin.t20 VSS.t54 VSS.t53 sg13_lv_nmos ad=0.19p pd=1.38u as=0.19p ps=1.38u w=1u l=1u
X144 inverter_2.vin.t8 inverter_0.vin.t21 VSS.t81 VSS.t80 sg13_lv_nmos ad=0.19p pd=1.38u as=0.19p ps=1.38u w=1u l=1u
X145 VDD inverter_0.vin.t23 inverter_2.vin.t11 VDD sg13_lv_pmos ad=1.14p pd=6.38u as=1.14p ps=6.38u w=6u l=1u
X146 inverter_0.vin.t1 inverter_1.vin.t21 VDD VDD sg13_lv_pmos ad=1.14p pd=6.38u as=1.14p ps=6.38u w=6u l=1u
X147 VDD inverter_0.vin.t22 vout VDD sg13_lv_pmos ad=1.14p pd=6.38u as=1.14p ps=6.38u w=6u l=1u
X148 inverter_2.vin.t13 inverter_0.vin.t23 VDD VDD sg13_lv_pmos ad=1.14p pd=6.38u as=1.14p ps=6.38u w=6u l=1u
X149 vout inverter_0.vin.t20 VSS.t114 VSS.t115 sg13_lv_nmos ad=0.19p pd=1.38u as=0.19p ps=1.38u w=1u l=1u
X150 VSS.t16 inverter_2.vin.t20 inverter_1.vin.t3 VSS.t15 sg13_lv_nmos ad=0.19p pd=1.38u as=0.19p ps=1.38u w=1u l=1u
X151 vout inverter_0.vin.t22 VDD VDD sg13_lv_pmos ad=1.14p pd=6.38u as=1.14p ps=6.38u w=6u l=1u
X152 VSS.t69 inverter_0.vin.t21 inverter_2.vin.t3 VSS.t68 sg13_lv_nmos ad=0.19p pd=1.38u as=0.19p ps=1.38u w=1u l=1u
X153 VDD inverter_0.vin.t22 vout VDD sg13_lv_pmos ad=1.14p pd=6.38u as=1.14p ps=6.38u w=6u l=1u
X154 VDD inverter_0.vin.t23 inverter_2.vin.t18 VDD sg13_lv_pmos ad=1.14p pd=6.38u as=1.14p ps=6.38u w=6u l=1u
X155 VSS.t144 VSS.t142 VSS.t94 VSS.t143 sg13_lv_nmos ad=0.34p pd=2.68u as=0 ps=0 w=1u l=1u
X156 VDD VDD VDD VDD sg13_lv_pmos ad=1.14p pd=6.38u as=0 ps=0 w=6u l=1u
X157 VDD inverter_1.vin.t21 inverter_0.vin.t9 VDD sg13_lv_pmos ad=1.14p pd=6.38u as=1.14p ps=6.38u w=6u l=1u
X158 inverter_1.vin.t6 inverter_2.vin.t20 VSS.t20 VSS.t21 sg13_lv_nmos ad=0.19p pd=1.38u as=0.19p ps=1.38u w=1u l=1u
X159 VSS.t114 inverter_0.vin.t20 vout VSS.t113 sg13_lv_nmos ad=0.19p pd=1.38u as=0.19p ps=1.38u w=1u l=1u
X160 inverter_2.vin.t3 inverter_0.vin.t21 VSS.t75 VSS.t76 sg13_lv_nmos ad=0.19p pd=1.38u as=0.19p ps=1.38u w=1u l=1u
X161 VDD inverter_0.vin.t23 inverter_2.vin.t19 VDD sg13_lv_pmos ad=1.14p pd=6.38u as=1.14p ps=6.38u w=6u l=1u
X162 inverter_2.vin.t6 inverter_0.vin.t21 VSS.t84 VSS.t85 sg13_lv_nmos ad=0.19p pd=1.38u as=0.19p ps=1.38u w=1u l=1u
X163 inverter_2.vin.t11 inverter_0.vin.t23 VDD VDD sg13_lv_pmos ad=1.14p pd=6.38u as=1.14p ps=6.38u w=6u l=1u
X164 VDD inverter_1.vin.t21 inverter_0.vin.t0 VDD sg13_lv_pmos ad=1.14p pd=6.38u as=1.14p ps=6.38u w=6u l=1u
X165 inverter_1.vin.t13 inverter_2.vin.t21 VDD VDD sg13_lv_pmos ad=1.14p pd=6.38u as=1.14p ps=6.38u w=6u l=1u
X166 inverter_0.vin.t2 inverter_1.vin.t21 VDD VDD sg13_lv_pmos ad=1.14p pd=6.38u as=1.14p ps=6.38u w=6u l=1u
X167 vout inverter_0.vin.t20 VSS.t99 VSS.t100 sg13_lv_nmos ad=0.19p pd=1.38u as=0.19p ps=1.38u w=1u l=1u
X168 vout inverter_0.vin.t22 VDD VDD sg13_lv_pmos ad=1.14p pd=6.38u as=1.14p ps=6.38u w=6u l=1u
X169 VDD inverter_2.vin.t21 inverter_1.vin.t14 VDD sg13_lv_pmos ad=1.14p pd=6.38u as=1.14p ps=6.38u w=6u l=1u
X170 VDD inverter_0.vin.t22 vout VDD sg13_lv_pmos ad=1.14p pd=6.38u as=1.14p ps=6.38u w=6u l=1u
X171 vout inverter_0.vin.t20 VSS.t120 VSS.t121 sg13_lv_nmos ad=0.19p pd=1.38u as=0.19p ps=1.38u w=1u l=1u
X172 VSS.t61 VSS.t139 VSS.t141 VSS.t140 sg13_lv_nmos ad=0.19p pd=1.38u as=0 ps=0 w=1u l=1u
X173 VSS.t92 VSS.t127 VSS.t129 VSS.t128 sg13_lv_nmos ad=0.19p pd=1.38u as=0 ps=0 w=1u l=1u
X174 VSS.t49 inverter_1.vin.t20 inverter_0.vin.t15 VSS.t48 sg13_lv_nmos ad=0.19p pd=1.38u as=0.19p ps=1.38u w=1u l=1u
X175 VSS.t84 inverter_0.vin.t21 inverter_2.vin.t5 VSS.t83 sg13_lv_nmos ad=0.19p pd=1.38u as=0.19p ps=1.38u w=1u l=1u
R0 VSS.n2 VSS.n238 557.909
R1 VSS.n6 VSS.n44 556.217
R2 VSS.t128 VSS.n237 196.692
R3 VSS.t91 VSS.n236 185.602
R4 VSS.n29 VSS.t95 30.3322
R5 VSS.n31 VSS.t122 185.599
R6 VSS.n218 VSS.t62 185.597
R7 VSS.n2 VSS.t22 17.4384
R8 VSS.n6 VSS.t60 17.437
R9 VSS.t90 VSS.n235 174.512
R10 VSS.t95 VSS.n28 174.508
R11 VSS.t121 VSS.n18 174.508
R12 VSS.n219 VSS.t64 174.506
R13 VSS.t57 VSS.n6 33.0469
R14 VSS.t88 VSS.n234 163.422
R15 VSS.t97 VSS.n27 163.417
R16 VSS.n32 VSS.t119 163.417
R17 VSS.n220 VSS.t72 163.417
R18 VSS.t80 VSS.n233 152.331
R19 VSS.t98 VSS.n26 152.327
R20 VSS.t118 VSS.n19 152.327
R21 VSS.n221 VSS.t73 152.326
R22 VSS.n2 VSS.t27 39.0517
R23 VSS.t42 VSS.n6 39.0515
R24 VSS.n6 VSS.t53 39.0515
R25 VSS.t87 VSS.n232 141.239
R26 VSS.t100 VSS.n25 141.237
R27 VSS.n20 VSS.t116 141.237
R28 VSS.n222 VSS.t70 141.236
R29 VSS.n2 VSS.t25 43.8554
R30 VSS.t86 VSS.n231 130.149
R31 VSS.n33 VSS.t115 130.147
R32 VSS.n37 VSS.t101 130.145
R33 VSS.n223 VSS.t74 130.144
R34 VSS.n2 VSS.t24 47.4579
R35 VSS.n6 VSS.t45 49.8594
R36 VSS.n6 VSS.t55 47.4582
R37 VSS.t66 VSS.n230 119.058
R38 VSS.t78 VSS.n226 119.058
R39 VSS.n35 VSS.t109 119.056
R40 VSS.t103 VSS.n24 119.055
R41 VSS.n34 VSS.t113 119.055
R42 VSS.n23 VSS.t107 119.055
R43 VSS.n228 VSS.t82 119.053
R44 VSS.n224 VSS.t76 119.053
R45 VSS.t17 VSS.n4 96.8755
R46 VSS.n2 VSS.t2 49.8595
R47 VSS.n6 VSS.n5 0.0088707
R48 VSS.n13 VSS.t47 119.055
R49 VSS.t85 VSS.n229 107.969
R50 VSS.t77 VSS.n225 107.969
R51 VSS.n36 VSS.t106 107.966
R52 VSS.t110 VSS.n21 107.965
R53 VSS.n36 VSS.t104 107.965
R54 VSS.t112 VSS.n21 107.965
R55 VSS.n229 VSS.t83 107.963
R56 VSS.n225 VSS.t68 107.963
R57 VSS.t15 VSS.n0 51.0607
R58 VSS.n3 VSS.n2 0.0117498
R59 VSS.t83 VSS.n228 96.8775
R60 VSS.t68 VSS.n224 96.8775
R61 VSS.t106 VSS.n23 96.8748
R62 VSS.n34 VSS.t112 96.8744
R63 VSS.n35 VSS.t110 96.8741
R64 VSS.t104 VSS.n24 96.8741
R65 VSS.n230 VSS.t85 96.8728
R66 VSS.n226 VSS.t77 96.8728
R67 VSS.n3 VSS.t19 51.056
R68 VSS.t46 VSS.n13 96.8744
R69 VSS.n14 VSS.t48 96.8744
R70 VSS.t50 VSS.n7 51.0604
R71 VSS.t82 VSS.n227 85.7872
R72 VSS.t76 VSS.n223 85.787
R73 VSS.n37 VSS.t103 85.7845
R74 VSS.t107 VSS.n22 85.7845
R75 VSS.t113 VSS.n33 85.7835
R76 VSS.t109 VSS.n22 85.783
R77 VSS.n227 VSS.t78 85.7825
R78 VSS.n231 VSS.t66 85.7823
R79 VSS.n3 VSS.t8 49.8695
R80 VSS.t47 VSS.n12 85.7845
R81 VSS.n12 VSS.t31 85.783
R82 VSS.t74 VSS.n222 74.6964
R83 VSS.t101 VSS.n25 74.6939
R84 VSS.t115 VSS.n20 74.6932
R85 VSS.n232 VSS.t86 74.6917
R86 VSS.n6 VSS.t43 47.4577
R87 VSS.t70 VSS.n221 63.6058
R88 VSS.n26 VSS.t100 63.6027
R89 VSS.t116 VSS.n19 63.6027
R90 VSS.n233 VSS.t87 63.6011
R91 VSS.t73 VSS.n220 52.5153
R92 VSS.n32 VSS.t118 52.5121
R93 VSS.n27 VSS.t98 52.5118
R94 VSS.n234 VSS.t80 52.5106
R95 VSS.t72 VSS.n219 41.4247
R96 VSS.t119 VSS.n18 41.4215
R97 VSS.n28 VSS.t97 41.4212
R98 VSS.n235 VSS.t88 41.42
R99 VSS.t64 VSS.n218 30.3341
R100 VSS.n31 VSS.t121 30.3309
R101 VSS.n236 VSS.t90 30.3294
R102 VSS.t131 VSS.n2 7.82586
R103 VSS.n2 VSS.t134 7.82375
R104 VSS.n8 VSS.n6 0.00233088
R105 VSS.t137 VSS.n6 7.82586
R106 VSS.n6 VSS.t41 33.0473
R107 VSS.n6 VSS.t140 7.82422
R108 VSS.t62 VSS.t125 19.2466
R109 VSS.t122 VSS.t146 19.2417
R110 VSS.n29 VSS.t93 17.4328
R111 VSS.n237 VSS.t91 19.2388
R112 VSS.n6 VSS.n15 1.88482
R113 VSS.n38 VSS.n46 1.85963
R114 VSS.n217 VSS.n171 17.0005
R115 VSS.n217 VSS.n203 17.0005
R116 VSS.n217 VSS.n202 17.0005
R117 VSS.n217 VSS.n201 17.0005
R118 VSS.n1 VSS.t135 0.04116
R119 VSS.n2 VSS.n50 1.86016
R120 VSS.n2 VSS.t30 25.8419
R121 VSS.n2 VSS.t28 33.0468
R122 VSS.n2 VSS.t21 51.0604
R123 VSS.n4 VSS.t18 49.8595
R124 VSS.n2 VSS.n4 0.00146929
R125 VSS.n2 VSS.t10 33.0467
R126 VSS.n2 VSS.t6 25.8414
R127 VSS.n6 VSS.n48 1.86016
R128 VSS.n6 VSS.t59 25.8414
R129 VSS.n6 VSS.t51 49.8593
R130 VSS.n6 VSS.n7 0.00164798
R131 VSS.n6 VSS.n14 0.00162059
R132 VSS.n6 VSS.n12 0.00176257
R133 VSS.n5 VSS.t33 51.0567
R134 VSS.n6 VSS.t35 43.8551
R135 VSS.n38 VSS.n92 17.0005
R136 VSS.n38 VSS.n91 17.0005
R137 VSS.n38 VSS.n90 17.0005
R138 VSS.t123 VSS.n110 17.0005
R139 VSS.n112 VSS.t123 17.0005
R140 VSS.t123 VSS.n111 17.0005
R141 VSS.n110 VSS.t147 17.0005
R142 VSS.n112 VSS.t147 17.0005
R143 VSS.n111 VSS.t147 17.0005
R144 VSS.t126 VSS.n214 17.0005
R145 VSS.t126 VSS.n213 17.0005
R146 VSS.n215 VSS.t126 17.0005
R147 VSS.n214 VSS.t63 17.0005
R148 VSS.n213 VSS.t63 17.0005
R149 VSS.n215 VSS.t63 17.0005
R150 VSS.n39 VSS.n44 3.34649
R151 VSS.t139 VSS.n128 15.0005
R152 VSS.n47 VSS.t142 15.0005
R153 VSS.t133 VSS.n148 15.0005
R154 VSS.t136 VSS.n154 15.0005
R155 VSS.t127 VSS.n172 15.0005
R156 VSS.t130 VSS.n182 15.0005
R157 VSS.t4 VSS.n2 17.4347
R158 VSS.t0 VSS.n2 43.8551
R159 VSS.n2 VSS.t14 49.8596
R160 VSS.n2 VSS.n0 0.00152996
R161 VSS.n6 VSS.t39 25.8414
R162 VSS.n14 VSS.t31 119.055
R163 VSS.n7 VSS.t48 107.966
R164 VSS.n6 VSS.t37 17.4345
R165 VSS.n11 VSS.n6 0.00468138
R166 VSS.n2 VSS.n8 557.905
R167 VSS.n16 VSS.n42 4.25195
R168 VSS.n38 VSS.n16 0.00151739
R169 VSS.n43 VSS.n89 8.5005
R170 VSS.n10 VSS.n2 0.753705
R171 VSS.n6 VSS.n83 8.49847
R172 VSS.n6 VSS.n84 8.49847
R173 VSS.n38 VSS.n87 8.49847
R174 VSS.n38 VSS.n45 8.49847
R175 VSS.n217 VSS.n170 8.49847
R176 VSS.n2 VSS.n71 8.49847
R177 VSS.n2 VSS.n70 8.49847
R178 VSS.n2 VSS.n57 8.49847
R179 VSS.n2 VSS.n58 8.49847
R180 VSS.n6 VSS.n72 8.49847
R181 VSS.n6 VSS.n73 8.49847
R182 VSS.n217 VSS.n174 8.49847
R183 VSS.n38 VSS.n39 0.00109613
R184 VSS.n238 VSS.t128 8.14886
R185 VSS.n129 VSS.t139 7.49847
R186 VSS.t142 VSS.n124 7.49847
R187 VSS.n149 VSS.t133 7.49847
R188 VSS.n155 VSS.t136 7.49847
R189 VSS.n173 VSS.t127 7.49847
R190 VSS.n183 VSS.t130 7.49847
R191 VSS.n43 VSS.n44 3.40114
R192 VSS.t61 VSS.n166 4.5005
R193 VSS.t94 VSS.n122 4.5005
R194 VSS.n147 VSS.t23 4.5005
R195 VSS.n158 VSS.t38 4.5005
R196 VSS.t5 VSS.n49 4.5005
R197 VSS.n189 VSS.t92 4.5005
R198 VSS.n125 VSS.n38 4.24676
R199 VSS.n6 VSS.n74 4.24676
R200 VSS.n123 VSS.n86 3.0005
R201 VSS.n131 VSS.n130 3.0005
R202 VSS.n113 VSS.t145 3.0005
R203 VSS.n157 VSS.n156 3.0005
R204 VSS.n151 VSS.n150 3.0005
R205 VSS.n185 VSS.n184 3.0005
R206 VSS.n188 VSS.n171 3.0005
R207 VSS.n212 VSS.t124 3.0005
R208 VSS.n159 VSS.t40 2.48177
R209 VSS.n160 VSS.t36 2.48177
R210 VSS.n161 VSS.t44 2.48177
R211 VSS.n135 VSS.t34 2.48177
R212 VSS.n162 VSS.t49 2.48177
R213 VSS.n163 VSS.t52 2.48177
R214 VSS.n164 VSS.t54 2.48177
R215 VSS.n165 VSS.t58 2.48177
R216 VSS.n121 VSS.t96 2.48177
R217 VSS.n119 VSS.t99 2.48177
R218 VSS.n118 VSS.t102 2.48177
R219 VSS.n117 VSS.t105 2.48177
R220 VSS.n104 VSS.t111 2.48177
R221 VSS.n116 VSS.t114 2.48177
R222 VSS.n115 VSS.t117 2.48177
R223 VSS.n114 VSS.t120 2.48177
R224 VSS.n240 VSS.t7 2.48177
R225 VSS.n241 VSS.t1 2.48177
R226 VSS.n242 VSS.t13 2.48177
R227 VSS.n56 VSS.t16 2.48177
R228 VSS.t20 VSS.n55 2.48177
R229 VSS.n144 VSS.t3 2.48177
R230 VSS.n145 VSS.t26 2.48177
R231 VSS.n146 VSS.t29 2.48177
R232 VSS.n211 VSS.t65 2.48177
R233 VSS.n210 VSS.t71 2.48177
R234 VSS.n209 VSS.t75 2.48177
R235 VSS.n208 VSS.t69 2.48177
R236 VSS.t84 VSS.n193 2.48177
R237 VSS.n192 VSS.t67 2.48177
R238 VSS.n191 VSS.t81 2.48177
R239 VSS.n190 VSS.t89 2.48177
R240 VSS.n127 VSS.t141 2.2505
R241 VSS.n126 VSS.t144 2.2505
R242 VSS.n152 VSS.t135 2.2505
R243 VSS.n153 VSS.t138 2.2505
R244 VSS.n186 VSS.t132 2.2505
R245 VSS.n187 VSS.t129 2.2505
R246 VSS.n217 VSS.n169 2.12281
R247 VSS.n6 VSS.n167 2.09947
R248 VSS.n6 VSS.n82 2.09947
R249 VSS.n6 VSS.n81 2.09947
R250 VSS.n6 VSS.n80 2.09947
R251 VSS.n6 VSS.n79 2.09947
R252 VSS.n6 VSS.n78 2.09947
R253 VSS.n6 VSS.n77 2.09947
R254 VSS.n6 VSS.n76 2.09947
R255 VSS.n6 VSS.n75 2.09947
R256 VSS.n48 VSS.n140 0.0886655
R257 VSS.n2 VSS.n69 2.09947
R258 VSS.n2 VSS.n68 2.09947
R259 VSS.n2 VSS.n67 2.09947
R260 VSS.n2 VSS.n66 2.09947
R261 VSS.n2 VSS.n64 2.09947
R262 VSS.n2 VSS.n53 2.09947
R263 VSS.n2 VSS.n62 2.09947
R264 VSS.n2 VSS.n60 2.09947
R265 VSS.n2 VSS.n40 2.09947
R266 VSS.n239 VSS.n50 0.0886655
R267 VSS.n217 VSS.n175 2.09887
R268 VSS.n217 VSS.n178 2.09887
R269 VSS.n217 VSS.n196 2.09887
R270 VSS.n217 VSS.n197 2.09887
R271 VSS.n217 VSS.n198 2.09887
R272 VSS.n38 VSS.n93 2.09868
R273 VSS.n38 VSS.n94 2.09868
R274 VSS.n38 VSS.n95 2.09868
R275 VSS.n38 VSS.n96 2.09868
R276 VSS.n38 VSS.n97 2.09868
R277 VSS.n38 VSS.n98 2.09868
R278 VSS.n38 VSS.n99 2.09868
R279 VSS.n38 VSS.n100 2.09868
R280 VSS.n46 VSS.n120 0.0894933
R281 VSS.n217 VSS.n176 2.09849
R282 VSS.n217 VSS.n177 2.09849
R283 VSS.n217 VSS.n195 2.09849
R284 VSS.n217 VSS.n199 2.09849
R285 VSS.n243 VSS.n52 1.99725
R286 VSS.n105 VSS.n51 1.99725
R287 VSS.n113 VSS.n112 1.52811
R288 VSS.n213 VSS.n212 1.52811
R289 VSS.n216 VSS.n215 1.41417
R290 VSS.n111 VSS.n17 1.37902
R291 VSS.n6 VSS.t56 43.855
R292 VSS.n6 VSS.n13 0.00162059
R293 VSS.n0 VSS.t17 107.966
R294 VSS.n2 VSS.t12 47.4581
R295 VSS.n2 VSS.t11 39.0513
R296 VSS.n89 VSS.n17 1.2984
R297 VSS.n10 VSS.n168 0.00814105
R298 VSS.n216 VSS.n168 1.14589
R299 VSS VSS.n51 1.01015
R300 VSS VSS.n243 0.94914
R301 VSS.n217 VSS.n200 0.909682
R302 VSS.n38 VSS.n30 0.909238
R303 VSS.n114 VSS.n113 0.209825
R304 VSS.n212 VSS.n211 0.209825
R305 VSS.t40 VSS.n140 0.200997
R306 VSS.t36 VSS.n139 0.200997
R307 VSS.t44 VSS.n138 0.200997
R308 VSS.t34 VSS.n137 0.200997
R309 VSS.t49 VSS.n134 0.200997
R310 VSS.t52 VSS.n133 0.200997
R311 VSS.t54 VSS.n132 0.200997
R312 VSS.t58 VSS.n85 0.200997
R313 VSS.t96 VSS.n120 0.200997
R314 VSS.t99 VSS.n101 0.200997
R315 VSS.t102 VSS.n102 0.200997
R316 VSS.t105 VSS.n103 0.200997
R317 VSS.t111 VSS.n106 0.200997
R318 VSS.t114 VSS.n107 0.200997
R319 VSS.t117 VSS.n108 0.200997
R320 VSS.t120 VSS.n109 0.200997
R321 VSS.t7 VSS.n239 0.200997
R322 VSS.n59 VSS.t1 0.200997
R323 VSS.n61 VSS.t13 0.200997
R324 VSS.n63 VSS.t16 0.200997
R325 VSS.n65 VSS.t20 0.200997
R326 VSS.t3 VSS.n143 0.200997
R327 VSS.t26 VSS.n142 0.200997
R328 VSS.t29 VSS.n141 0.200997
R329 VSS.t65 VSS.n204 0.200997
R330 VSS.t71 VSS.n205 0.200997
R331 VSS.t75 VSS.n206 0.200997
R332 VSS.t69 VSS.n207 0.200997
R333 VSS.n194 VSS.t84 0.200997
R334 VSS.t67 VSS.n179 0.200997
R335 VSS.t81 VSS.n180 0.200997
R336 VSS.t89 VSS.n181 0.200997
R337 VSS.n160 VSS.n159 0.16242
R338 VSS.n161 VSS.n160 0.16242
R339 VSS.n135 VSS.n161 0.16242
R340 VSS.n136 VSS.n135 0.16242
R341 VSS.n162 VSS.n136 0.16242
R342 VSS.n163 VSS.n162 0.16242
R343 VSS.n164 VSS.n163 0.16242
R344 VSS.n165 VSS.n164 0.16242
R345 VSS.n121 VSS.n119 0.16242
R346 VSS.n119 VSS.n118 0.16242
R347 VSS.n118 VSS.n117 0.16242
R348 VSS.n117 VSS.n105 0.16242
R349 VSS.n105 VSS.n104 0.16242
R350 VSS.n104 VSS.n116 0.16242
R351 VSS.n116 VSS.n115 0.16242
R352 VSS.n115 VSS.n114 0.16242
R353 VSS.n241 VSS.n240 0.16242
R354 VSS.n242 VSS.n241 0.16242
R355 VSS.n56 VSS.n242 0.16242
R356 VSS.n54 VSS.n56 0.16242
R357 VSS.n54 VSS.n55 0.16242
R358 VSS.n144 VSS.n55 0.16242
R359 VSS.n145 VSS.n144 0.16242
R360 VSS.n146 VSS.n145 0.16242
R361 VSS.n211 VSS.n210 0.16242
R362 VSS.n210 VSS.n209 0.16242
R363 VSS.n209 VSS.n208 0.16242
R364 VSS.n208 VSS.n52 0.16242
R365 VSS.n193 VSS.n52 0.16242
R366 VSS.n193 VSS.n192 0.16242
R367 VSS.n192 VSS.n191 0.16242
R368 VSS.n191 VSS.n190 0.16242
R369 VSS.n166 VSS.n165 0.158764
R370 VSS.n122 VSS.n121 0.158764
R371 VSS.n147 VSS.n146 0.158764
R372 VSS.n159 VSS.n158 0.158764
R373 VSS.n240 VSS.n49 0.158764
R374 VSS.n190 VSS.n189 0.158764
R375 VSS.n109 VSS.n30 0.147221
R376 VSS.n204 VSS.n200 0.146212
R377 VSS.n140 VSS.n75 0.0952183
R378 VSS.n239 VSS.n40 0.0952183
R379 VSS.t38 VSS.n48 0.0841505
R380 VSS.n50 VSS.t5 0.0841505
R381 VSS.n120 VSS.n100 0.0942639
R382 VSS.n204 VSS.n199 0.0940701
R383 VSS.n181 VSS.n176 0.0936876
R384 VSS.n109 VSS.n93 0.0935007
R385 VSS.t94 VSS.n46 0.0833126
R386 VSS.n139 VSS.n76 0.0927738
R387 VSS.n60 VSS.n59 0.0927738
R388 VSS.n85 VSS.n82 0.0925656
R389 VSS.n141 VSS.n68 0.0925656
R390 VSS.t92 VSS.n175 0.092469
R391 VSS.n205 VSS.n198 0.0920071
R392 VSS.n101 VSS.n99 0.0918194
R393 VSS.n167 VSS.t61 0.0917235
R394 VSS.t23 VSS.n69 0.0917235
R395 VSS.n180 VSS.n177 0.0912432
R396 VSS.n108 VSS.n94 0.0910563
R397 VSS.n138 VSS.n77 0.0903294
R398 VSS.t32 VSS.n79 0.0903294
R399 VSS.n62 VSS.n61 0.0903294
R400 VSS.n64 VSS.t9 0.0903294
R401 VSS.n132 VSS.n81 0.0901212
R402 VSS.n142 VSS.n67 0.0901212
R403 VSS.n206 VSS.n197 0.0895627
R404 VSS.n102 VSS.n98 0.089375
R405 VSS.t108 VSS.n96 0.089375
R406 VSS.t79 VSS.n195 0.0891812
R407 VSS.n107 VSS.n95 0.0886118
R408 VSS.t108 VSS.n97 0.0886118
R409 VSS.n196 VSS.t79 0.0884223
R410 VSS.n179 VSS.n178 0.0884223
R411 VSS.n137 VSS.n78 0.0878849
R412 VSS.n134 VSS.n80 0.0878849
R413 VSS.n53 VSS.n63 0.0878849
R414 VSS.n66 VSS.n65 0.0878849
R415 VSS.t32 VSS.n78 0.0876767
R416 VSS.n133 VSS.n80 0.0876767
R417 VSS.t9 VSS.n53 0.0876767
R418 VSS.n143 VSS.n66 0.0876767
R419 VSS.n207 VSS.n196 0.0871182
R420 VSS.n194 VSS.n178 0.0871182
R421 VSS.n103 VSS.n97 0.0869305
R422 VSS.n106 VSS.n95 0.0869305
R423 VSS.n195 VSS.n194 0.0863543
R424 VSS.n106 VSS.n96 0.0861674
R425 VSS.n103 VSS.n98 0.0861674
R426 VSS.n207 VSS.n197 0.0859778
R427 VSS.n133 VSS.n81 0.0854405
R428 VSS.n143 VSS.n67 0.0854405
R429 VSS.n137 VSS.n77 0.0852323
R430 VSS.n134 VSS.n79 0.0852323
R431 VSS.n63 VSS.n62 0.0852323
R432 VSS.n65 VSS.n64 0.0852323
R433 VSS.n107 VSS.n94 0.0844861
R434 VSS.n179 VSS.n177 0.0842923
R435 VSS.n102 VSS.n99 0.083723
R436 VSS.t124 VSS.n200 0.0835557
R437 VSS.n206 VSS.n198 0.0835334
R438 VSS.n132 VSS.n82 0.082996
R439 VSS.n142 VSS.n68 0.082996
R440 VSS.n138 VSS.n76 0.0827878
R441 VSS.n61 VSS.n60 0.0827878
R442 VSS.t145 VSS.n30 0.0825618
R443 VSS.n108 VSS.n93 0.0820417
R444 VSS.n180 VSS.n176 0.0818479
R445 VSS.n205 VSS.n199 0.0814654
R446 VSS.n101 VSS.n100 0.0812785
R447 VSS.n167 VSS.n85 0.0805516
R448 VSS.n141 VSS.n69 0.0805516
R449 VSS.n139 VSS.n75 0.0803434
R450 VSS.n59 VSS.n40 0.0803434
R451 VSS.n181 VSS.n175 0.0797849
R452 VSS.n127 VSS.n126 0.0725217
R453 VSS.n153 VSS.n152 0.0725217
R454 VSS.n187 VSS.n186 0.0725217
R455 VSS.n88 VSS.n11 1.14629
R456 VSS.n89 VSS.n88 0.0467185
R457 VSS.n2 VSS.n1 0.708321
R458 VSS.n9 VSS.n11 1.17762
R459 VSS.t79 VSS.n52 0.0394177
R460 VSS.n136 VSS.t32 0.0394177
R461 VSS.n105 VSS.t108 0.0394177
R462 VSS.t9 VSS.n54 0.0394177
R463 VSS.n243 VSS.n54 0.0389615
R464 VSS.n136 VSS.n51 0.0389615
R465 VSS.t129 VSS.n169 0.0288491
R466 VSS.t144 VSS.n125 0.0238708
R467 VSS.t138 VSS.n74 0.0238708
R468 VSS.n169 VSS.n168 0.0201377
R469 VSS.n166 VSS.n131 0.0169553
R470 VSS.n131 VSS.n127 0.0169553
R471 VSS.n126 VSS.n86 0.0169553
R472 VSS.n122 VSS.n86 0.0169553
R473 VSS.n151 VSS.n147 0.0169553
R474 VSS.n152 VSS.n151 0.0169553
R475 VSS.n157 VSS.n153 0.0169553
R476 VSS.n158 VSS.n157 0.0169553
R477 VSS.n189 VSS.n188 0.0169553
R478 VSS.n188 VSS.n187 0.0169553
R479 VSS.n186 VSS.n185 0.0169553
R480 VSS.n185 VSS.n49 0.0169553
R481 VSS.n88 VSS.n15 0.0238324
R482 VSS.n88 VSS.n42 0.0154051
R483 VSS.n1 VSS.n9 0.00961299
R484 VSS.n9 VSS.n41 0.0154051
R485 VSS.t145 VSS.n92 0.0133922
R486 VSS.t124 VSS.n201 0.0133922
R487 VSS.n15 VSS.t141 0.0271108
R488 VSS.n129 VSS.n84 0.0116323
R489 VSS.n124 VSS.n45 0.0116323
R490 VSS.n149 VSS.n70 0.0116323
R491 VSS.n155 VSS.n73 0.0116323
R492 VSS.n183 VSS.n58 0.0116323
R493 VSS.n174 VSS.n173 0.0116323
R494 VSS.n182 VSS.t5 0.0109336
R495 VSS.n154 VSS.t38 0.0109336
R496 VSS.n148 VSS.t135 0.0109336
R497 VSS.t94 VSS.n47 0.0109336
R498 VSS.n128 VSS.t141 0.0109336
R499 VSS.n172 VSS.n171 0.0106355
R500 VSS.n125 VSS.n42 0.00922027
R501 VSS.n10 VSS.t132 0.0427235
R502 VSS.n74 VSS.n41 0.00922027
R503 VSS.n112 VSS.n91 0.00798582
R504 VSS.n112 VSS.n90 0.00798582
R505 VSS.n213 VSS.n202 0.00798582
R506 VSS.n213 VSS.n203 0.00798582
R507 VSS.n110 VSS.n92 0.00756994
R508 VSS.n110 VSS.n91 0.00756994
R509 VSS.n111 VSS.n90 0.00756994
R510 VSS.n214 VSS.n201 0.00756994
R511 VSS.n214 VSS.n202 0.00756994
R512 VSS.n215 VSS.n203 0.00756994
R513 VSS.t61 VSS.n84 0.00636434
R514 VSS.t144 VSS.n45 0.00636434
R515 VSS.t23 VSS.n70 0.00636434
R516 VSS.t138 VSS.n73 0.00636434
R517 VSS.t129 VSS.n170 0.00636434
R518 VSS.t132 VSS.n58 0.00636434
R519 VSS.t92 VSS.n174 0.00636434
R520 VSS.n130 VSS.n83 0.00606624
R521 VSS.n123 VSS.n87 0.00606624
R522 VSS.n128 VSS.n83 0.00606624
R523 VSS.n47 VSS.n87 0.00606624
R524 VSS.n172 VSS.n170 0.00606624
R525 VSS.n150 VSS.n71 0.00606624
R526 VSS.n184 VSS.n57 0.00606624
R527 VSS.n156 VSS.n72 0.00606624
R528 VSS.n148 VSS.n71 0.00606624
R529 VSS.n154 VSS.n72 0.00606624
R530 VSS.n182 VSS.n57 0.00606624
R531 VSS.n130 VSS.n129 0.00606604
R532 VSS.n124 VSS.n123 0.00606604
R533 VSS.n150 VSS.n149 0.00606604
R534 VSS.n156 VSS.n155 0.00606604
R535 VSS.n173 VSS.n171 0.00606604
R536 VSS.n184 VSS.n183 0.00606604
R537 VSS.n38 VSS.n17 0.0039599
R538 VSS.n217 VSS.n216 0.00390718
R539 VSS.n16 VSS.n43 0.00168
R540 VSS.n218 VSS.n217 0.00189631
R541 VSS.n219 VSS.n217 0.00189631
R542 VSS.n220 VSS.n217 0.00189631
R543 VSS.n221 VSS.n217 0.00189631
R544 VSS.n222 VSS.n217 0.00189631
R545 VSS.n223 VSS.n217 0.00189631
R546 VSS.n224 VSS.n217 0.00189631
R547 VSS.n225 VSS.n217 0.00189631
R548 VSS.n226 VSS.n217 0.00189631
R549 VSS.n228 VSS.n217 0.00189631
R550 VSS.n229 VSS.n217 0.00189631
R551 VSS.n230 VSS.n217 0.00189631
R552 VSS.n231 VSS.n217 0.00189631
R553 VSS.n232 VSS.n217 0.00189631
R554 VSS.n233 VSS.n217 0.00189631
R555 VSS.n234 VSS.n217 0.00189631
R556 VSS.n235 VSS.n217 0.00189631
R557 VSS.n236 VSS.n217 0.00189631
R558 VSS.n237 VSS.n217 0.00189631
R559 VSS.n38 VSS.n23 0.00187013
R560 VSS.n227 VSS.n217 0.00178861
R561 VSS.t125 VSS.n217 0.00178564
R562 VSS.n38 VSS.n22 0.00176257
R563 VSS.n38 VSS.n18 0.00162059
R564 VSS.n38 VSS.n19 0.00162059
R565 VSS.n38 VSS.n20 0.00162059
R566 VSS.n38 VSS.n21 0.00162059
R567 VSS.n38 VSS.n24 0.00162059
R568 VSS.n38 VSS.n26 0.00162059
R569 VSS.n38 VSS.n27 0.00162059
R570 VSS.n38 VSS.n28 0.00162059
R571 VSS.n38 VSS.n29 0.00110525
R572 VSS.n38 VSS.n31 0.00162059
R573 VSS.n38 VSS.n32 0.00162059
R574 VSS.n38 VSS.n34 0.00162059
R575 VSS.n38 VSS.n25 0.00161544
R576 VSS.n38 VSS.n33 0.00161544
R577 VSS.n38 VSS.n35 0.00161544
R578 VSS.n38 VSS.n36 0.00161544
R579 VSS.n38 VSS.n37 0.00161544
R580 VSS.n41 VSS.n8 4.25257
R581 VSS.n238 VSS.n217 0.00129342
R582 VSS.n38 VSS.t146 0.00127491
R583 VSS.n39 VSS.t143 7.8281
R584 VSS.n5 VSS.t46 107.974
R585 inverter_1.vin.n0 inverter_1.vin.t0 10.2939
R586 inverter_1.vin.n0 inverter_1.vin.t1 10.2939
R587 inverter_1.vin.n0 inverter_1.vin.t2 10.2939
R588 inverter_1.vin.n0 inverter_1.vin.t3 10.2939
R589 inverter_1.vin.n0 inverter_1.vin.t4 10.2939
R590 inverter_1.vin.n0 inverter_1.vin.t5 10.2939
R591 inverter_1.vin.n0 inverter_1.vin.t6 10.2939
R592 inverter_1.vin inverter_1.vin.t7 10.2939
R593 inverter_1.vin inverter_1.vin.t8 10.2939
R594 inverter_1.vin inverter_1.vin.t9 10.2939
R595 inverter_1.vin inverter_1.vin.t19 2.09074
R596 inverter_1.vin inverter_1.vin.t17 2.08909
R597 inverter_1.vin inverter_1.vin.t18 2.089
R598 inverter_1.vin.n0 inverter_1.vin.t15 2.08893
R599 inverter_1.vin.n0 inverter_1.vin.t16 2.08852
R600 inverter_1.vin.n0 inverter_1.vin.t14 2.0693
R601 inverter_1.vin.n0 inverter_1.vin.t12 2.06902
R602 inverter_1.vin.n0 inverter_1.vin.t13 2.06896
R603 inverter_1.vin.n0 inverter_1.vin.t11 2.06878
R604 inverter_1.vin.n0 inverter_1.vin.t10 2.06763
R605 inverter_1.vin.t21 inverter_1.vin 1.61676
R606 inverter_1.vin inverter_1.vin.n0 1.46365
R607 inverter_1.vin inverter_1.vin.t20 1.13653
R608 inverter_2.vin.n0 inverter_2.vin.t0 10.2939
R609 inverter_2.vin.n0 inverter_2.vin.t1 10.2939
R610 inverter_2.vin.n0 inverter_2.vin.t2 10.2939
R611 inverter_2.vin.n0 inverter_2.vin.t3 10.2939
R612 inverter_2.vin.n0 inverter_2.vin.t4 10.2939
R613 inverter_2.vin.n0 inverter_2.vin.t5 10.2939
R614 inverter_2.vin.n0 inverter_2.vin.t6 10.2939
R615 inverter_2.vin inverter_2.vin.t7 10.2939
R616 inverter_2.vin inverter_2.vin.t8 10.2939
R617 inverter_2.vin inverter_2.vin.t9 10.2939
R618 inverter_2.vin inverter_2.vin.t19 2.09074
R619 inverter_2.vin.n0 inverter_2.vin.t16 2.0884
R620 inverter_2.vin.n0 inverter_2.vin.t15 2.08833
R621 inverter_2.vin inverter_2.vin.t18 2.08808
R622 inverter_2.vin inverter_2.vin.t17 2.0874
R623 inverter_2.vin.n0 inverter_2.vin.t13 2.0701
R624 inverter_2.vin.n0 inverter_2.vin.t11 2.0693
R625 inverter_2.vin.n0 inverter_2.vin.t14 2.06922
R626 inverter_2.vin.n0 inverter_2.vin.t12 2.06901
R627 inverter_2.vin.n0 inverter_2.vin.t10 2.06749
R628 inverter_2.vin.t21 inverter_2.vin 1.61676
R629 inverter_2.vin inverter_2.vin.n0 1.46365
R630 inverter_2.vin inverter_2.vin.t20 1.13653
R631 inverter_0.vin.n0 inverter_0.vin.t10 10.2939
R632 inverter_0.vin.n0 inverter_0.vin.t11 10.2939
R633 inverter_0.vin.n0 inverter_0.vin.t12 10.2939
R634 inverter_0.vin.n0 inverter_0.vin.t13 10.2939
R635 inverter_0.vin.n0 inverter_0.vin.t14 10.2939
R636 inverter_0.vin.n0 inverter_0.vin.t15 10.2939
R637 inverter_0.vin.n0 inverter_0.vin.t16 10.2939
R638 inverter_0.vin inverter_0.vin.t17 10.2939
R639 inverter_0.vin inverter_0.vin.t18 10.2939
R640 inverter_0.vin inverter_0.vin.t19 10.2939
R641 inverter_0.vin inverter_0.vin.t9 2.09074
R642 inverter_0.vin.n0 inverter_0.vin.t5 2.08912
R643 inverter_0.vin.n0 inverter_0.vin.t6 2.08858
R644 inverter_0.vin inverter_0.vin.t7 2.08845
R645 inverter_0.vin inverter_0.vin.t8 2.08833
R646 inverter_0.vin.n0 inverter_0.vin.t1 2.06968
R647 inverter_0.vin.n0 inverter_0.vin.t4 2.06964
R648 inverter_0.vin.n0 inverter_0.vin.t2 2.06894
R649 inverter_0.vin.n0 inverter_0.vin.t3 2.0687
R650 inverter_0.vin.n0 inverter_0.vin.t0 2.06754
R651 inverter_0.vin.t22 inverter_0.vin 1.61676
R652 inverter_0.vin.t23 inverter_0.vin 1.61676
R653 inverter_0.vin inverter_0.vin.n0 1.46365
R654 inverter_0.vin inverter_0.vin.t20 1.13653
R655 inverter_0.vin inverter_0.vin.t21 1.13653
C0 inverter_0.vin VDD 64.847f
C1 inverter_1.vin inverter_2.vin 16.0541f
C2 VDD vout 11.2008f
C3 inverter_0.vin vout 16.0789f
C4 inverter_1.vin VDD 37.6992f
C5 inverter_1.vin inverter_0.vin 18.8685f
C6 VDD inverter_2.vin 37.689f
C7 inverter_0.vin inverter_2.vin 18.8493f
C8 vout VSS 18.06776f
C9 inverter_1.vin VSS 31.78636f
C10 inverter_2.vin VSS 31.92016f
C11 inverter_0.vin VSS 63.11665f
C12 inverter_0.vin.n0 VSS 19.1106f
C13 inverter_0.vin.t19 VSS 0.1395f
C14 inverter_0.vin.t8 VSS 0.99858f
C15 inverter_0.vin.t18 VSS 0.1395f
C16 inverter_0.vin.t7 VSS 11.91415f
C17 inverter_0.vin.t17 VSS 0.1395f
C18 inverter_0.vin.t6 VSS 0.99853f
C19 inverter_0.vin.t16 VSS 0.1395f
C20 inverter_0.vin.t5 VSS 0.99839f
C21 inverter_0.vin.t15 VSS 0.1395f
C22 inverter_0.vin.t4 VSS 0.99041f
C23 inverter_0.vin.t14 VSS 0.1395f
C24 inverter_0.vin.t3 VSS 0.99064f
C25 inverter_0.vin.t13 VSS 0.1395f
C26 inverter_0.vin.t2 VSS 0.99056f
C27 inverter_0.vin.t12 VSS 0.1395f
C28 inverter_0.vin.t1 VSS 0.99043f
C29 inverter_0.vin.t11 VSS 3.27542f
C30 inverter_0.vin.t0 VSS 0.99089f
C31 inverter_0.vin.t10 VSS 0.1395f
C32 inverter_0.vin.t9 VSS 0.99797f
C33 inverter_2.vin.n0 VSS 18.5029f
C34 inverter_2.vin.t9 VSS 0.13506f
C35 inverter_2.vin.t18 VSS 0.96687f
C36 inverter_2.vin.t8 VSS 0.13506f
C37 inverter_2.vin.t17 VSS 0.96704f
C38 inverter_2.vin.t7 VSS 0.13506f
C39 inverter_2.vin.t16 VSS 12.23538f
C40 inverter_2.vin.t6 VSS 0.13506f
C41 inverter_2.vin.t15 VSS 0.96683f
C42 inverter_2.vin.t5 VSS 3.3724f
C43 inverter_2.vin.t14 VSS 0.95902f
C44 inverter_2.vin.t4 VSS 0.13506f
C45 inverter_2.vin.t13 VSS 0.95881f
C46 inverter_2.vin.t3 VSS 0.13506f
C47 inverter_2.vin.t12 VSS 0.95904f
C48 inverter_2.vin.t2 VSS 0.13506f
C49 inverter_2.vin.t11 VSS 0.95901f
C50 inverter_2.vin.t1 VSS 0.13506f
C51 inverter_2.vin.t10 VSS 0.95938f
C52 inverter_2.vin.t0 VSS 0.13506f
C53 inverter_2.vin.t19 VSS 0.96624f
C54 inverter_1.vin.n0 VSS 18.5118f
C55 inverter_1.vin.t9 VSS 0.13513f
C56 inverter_1.vin.t18 VSS 0.96715f
C57 inverter_1.vin.t8 VSS 0.13513f
C58 inverter_1.vin.t17 VSS 0.96713f
C59 inverter_1.vin.t7 VSS 0.13513f
C60 inverter_1.vin.t16 VSS 0.96727f
C61 inverter_1.vin.t6 VSS 0.13513f
C62 inverter_1.vin.t15 VSS 11.87741f
C63 inverter_1.vin.t5 VSS 3.26953f
C64 inverter_1.vin.t14 VSS 0.95948f
C65 inverter_1.vin.t4 VSS 0.13513f
C66 inverter_1.vin.t13 VSS 0.95951f
C67 inverter_1.vin.t3 VSS 0.13513f
C68 inverter_1.vin.t12 VSS 0.9595f
C69 inverter_1.vin.t2 VSS 0.13513f
C70 inverter_1.vin.t11 VSS 0.9596f
C71 inverter_1.vin.t1 VSS 0.13513f
C72 inverter_1.vin.t10 VSS 0.95981f
C73 inverter_1.vin.t0 VSS 0.13513f
C74 inverter_1.vin.t19 VSS 0.96671f
C75 VSS.t20 VSS 3.1344f
C76 VSS.t99 VSS 3.23733f
C77 VSS.t40 VSS 3.13593f
C78 VSS.t79 VSS 3.23733f
.ends
