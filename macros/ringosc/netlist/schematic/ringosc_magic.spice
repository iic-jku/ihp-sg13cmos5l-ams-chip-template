** sch_path: /mnt/c/Users/si150/eda/designs/heichips26-analog-workshop/ringosc/schematic/xschem/ringosc.sch
.subckt ringosc vout VDD VSS
*.PININFO VDD:B VSS:B vout:O
x1 VDD vosc net1 VSS inverter
x2 VDD net1 net2 VSS inverter
x3 VDD net2 vosc VSS inverter
x4 VDD vosc vout VSS inverter
.ends

* expanding   symbol:  inverter.sym # of pins=4
** sym_path: /mnt/c/Users/si150/eda/designs/heichips26-analog-workshop/ringosc/schematic/xschem/inverter.sym
** sch_path: /mnt/c/Users/si150/eda/designs/heichips26-analog-workshop/ringosc/schematic/xschem/inverter.sch
.subckt inverter VDD vin vout VSS
*.PININFO vin:I VDD:B VSS:B vout:B
XMdummy1 VSS VSS VSS VSS sg13_lv_nmos w=2.0u l=1.0u ng=2 m=1 mm_ok=1
XMdummy2 VDD VDD VDD VDD sg13_lv_pmos w=12.0u l=1.0u ng=2 m=1 mm_ok=1
XM1 vout vin VSS VSS sg13_lv_nmos w=20.0u l=1.0u ng=20 m=1 mm_ok=1
XM2 vout vin VDD VDD sg13_lv_pmos w=120.0u l=1.0u ng=20 m=1 mm_ok=1
.ends
