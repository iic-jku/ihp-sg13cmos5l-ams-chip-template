* Extracted by KLayout with SG13CMOS5L LVS runset on : 05/08/2026 02:14

.SUBCKT ringosc VDD VSS vout
X$1 VSS VDD vout \$13 inverter
X$4 VSS VDD \$13 \$12 inverter
X$6 VSS VDD \$12 \$11 inverter
X$7 VSS VDD \$11 \$13 inverter
.ENDS ringosc

.SUBCKT inverter VSS VDD vout vin
M$1 VSS VSS VSS VSS sg13_lv_nmos L=1u W=2u AS=0.53p AD=0.53p PS=4.06u PD=4.06u
+ rfmode=0
M$2 VSS vin vout VSS sg13_lv_nmos L=1u W=20u AS=3.8p AD=3.8p PS=27.6u PD=27.6u
+ rfmode=0
M$23 VDD VDD VDD VDD sg13_lv_pmos L=1u W=12u AS=3.18p AD=3.18p PS=19.06u
+ PD=19.06u rfmode=0
M$24 VDD vin vout VDD sg13_lv_pmos L=1u W=120u AS=22.8p AD=22.8p PS=127.6u
+ PD=127.6u rfmode=0
.ENDS inverter
